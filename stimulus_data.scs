V_data_0 (Data\\<0\\> gnd!) vsource dc=1.2
V_data_1 (Data\\<1\\> gnd!) vsource dc=1.2
V_data_2 (Data\\<2\\> gnd!) vsource dc=1.2
V_data_3 (Data\\<3\\> gnd!) vsource dc=1.2
V_data_4 (Data\\<4\\> gnd!) vsource dc=1.2
V_data_5 (Data\\<5\\> gnd!) vsource dc=1.2
V_data_6 (Data\\<6\\> gnd!) vsource dc=1.2
V_data_7 (Data\\<7\\> gnd!) vsource dc=1.2
V_data_8 (Data\\<8\\> gnd!) vsource dc=0
V_data_9 (Data\\<9\\> gnd!) vsource dc=0
V_data_10 (Data\\<10\\> gnd!) vsource dc=0
V_data_11 (Data\\<11\\> gnd!) vsource dc=0
V_data_12 (Data\\<12\\> gnd!) vsource dc=0
V_data_13 (Data\\<13\\> gnd!) vsource dc=0
V_data_14 (Data\\<14\\> gnd!) vsource dc=0
V_data_15 (Data\\<15\\> gnd!) vsource dc=0
V_data_16 (Data\\<16\\> gnd!) vsource dc=1.2
V_data_17 (Data\\<17\\> gnd!) vsource dc=1.2
V_data_18 (Data\\<18\\> gnd!) vsource dc=1.2
V_data_19 (Data\\<19\\> gnd!) vsource dc=1.2
V_data_20 (Data\\<20\\> gnd!) vsource dc=1.2
V_data_21 (Data\\<21\\> gnd!) vsource dc=1.2
V_data_22 (Data\\<22\\> gnd!) vsource dc=1.2
V_data_23 (Data\\<23\\> gnd!) vsource dc=1.2
V_data_24 (Data\\<24\\> gnd!) vsource dc=0
V_data_25 (Data\\<25\\> gnd!) vsource dc=0
V_data_26 (Data\\<26\\> gnd!) vsource dc=0
V_data_27 (Data\\<27\\> gnd!) vsource dc=0
V_data_28 (Data\\<28\\> gnd!) vsource dc=0
V_data_29 (Data\\<29\\> gnd!) vsource dc=0
V_data_30 (Data\\<30\\> gnd!) vsource dc=0
V_data_31 (Data\\<31\\> gnd!) vsource dc=0
