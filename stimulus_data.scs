V_data_0 (Data\\<0\\> gnd!) vsource type=pwl wave=\[
+ 0    0.9
+ 2000p 0.9
+ 2010p -0.3
+ 4000p -0.3
+ 4010p 0.9
+ 6000p 0.9
+ 6010p -0.3
+ 8000p -0.3
+ 8010p 0.9
+ 10000p 0.9
+ 10010p -0.3
+ 12000p -0.3
+ 12010p 0.9
+ 14000p 0.9
+ 14010p -0.3
+ 16000p -0.3
+ 16010p 0.9
+ 18000p 0.9
+ 18010p -0.3
+ 20000p -0.3
+ 20010p 0.9
+ 22000p 0.9
+ 22010p -0.3
+ 24000p -0.3
+ 24010p 0.9
+ 26000p 0.9
+ 26010p -0.3
+ 28000p -0.3
+ 28010p 0.9
+ 30000p 0.9
+ 30010p -0.3
+ 32000p -0.3
+ 32010p 0.9
+ 34000p 0.9
+ 34010p -0.3
+ 36000p -0.3
+ 36010p 0.9
+ 38000p 0.9
+ 38010p -0.3
+ 40000p -0.3
+ 40010p 0.9
+ 42000p 0.9
+ 42010p -0.3
+ 44000p -0.3
+ 44010p 0.9
+ 46000p 0.9
+ 46010p -0.3
+ 48000p -0.3
+ 48010p 0.9
+ 50000p 0.9
+ 50010p -0.3
+ 52000p -0.3
+ 52010p 0.9
+ 54000p 0.9
+ 54010p -0.3
+ 56000p -0.3
+ 56010p 0.9
+ 58000p 0.9
+ 58010p -0.3
+ 60000p -0.3
+ 60010p 0.9
+ 62000p 0.9
+ 62010p -0.3
+ 64000p -0.3
+ 64010p 0.9
+ 66000p 0.9
+ 66010p -0.3
+ 68000p -0.3
+ 68010p 0.9
+ 70000p 0.9
+ 70010p -0.3
+ 72000p -0.3
+ 72010p 0.9
+ 74000p 0.9
+ 74010p -0.3
+ 76000p -0.3
+ 76010p 0.9
+ 78000p 0.9
+ 78010p -0.3
+ 80000p -0.3
+ 80010p 0.9
+ 82000p 0.9
+ 82010p -0.3
+ 84000p -0.3
+ 84010p 0.9
+ 86000p 0.9
+ 86010p -0.3
+ 88000p -0.3
+ 88010p 0.9
+ 90000p 0.9
+ 90010p -0.3
+ 92000p -0.3
+ 92010p 0.9
+ 94000p 0.9
+ 94010p -0.3
+ 96000p -0.3
+ 96010p 0.9
+ 98000p 0.9
+ 98010p -0.3
+ 100000p -0.3
+ 100010p 0.9
+ 102000p 0.9
+ 102010p -0.3
+ 104000p -0.3
+ 104010p 0.9
+ 106000p 0.9
+ 106010p -0.3
+ 108000p -0.3
+ 108010p 0.9
+ 110000p 0.9
+ 110010p -0.3
+ 112000p -0.3
+ 112010p 0.9
+ 114000p 0.9
+ 114010p -0.3
+ 116000p -0.3
+ 116010p 0.9
+ 118000p 0.9
+ 118010p -0.3
+ 120000p -0.3
+ 120010p 0.9
+ 122000p 0.9
+ 122010p -0.3
+ 124000p -0.3
+ 124010p 0.9
+ 126000p 0.9
+ 126010p -0.3
+ 128000p -0.3
+ 128010p 0.9
+ 130000p 0.9
+ 130010p -0.3
+ 132000p -0.3
+ 132010p 0.9
+ 134000p 0.9
+ 134010p -0.3
+ 136000p -0.3
+ 136010p 0.9
+ 138000p 0.9
+ 138010p -0.3
+ 140000p -0.3
+ 140010p 0.9
+ 142000p 0.9
+ 142010p -0.3
+ 144000p -0.3
+ 144010p 0.9
+ 146000p 0.9
+ 146010p -0.3
+ 148000p -0.3
+ 148010p 0.9
+ 150000p 0.9
+ 150010p -0.3
+ 152000p -0.3
+ 152010p 0.9
+ 154000p 0.9
+ 154010p -0.3
+ 156000p -0.3
+ 156010p 0.9
+ 158000p 0.9
+ 158010p -0.3
+ 160000p -0.3
+ 160010p 0.9
+ 162000p 0.9
+ 162010p -0.3
+ 164000p -0.3
+ 164010p 0.9
+ 166000p 0.9
+ 166010p -0.3
+ 168000p -0.3
+ 168010p 0.9
+ 170000p 0.9
+ 170010p -0.3
+ 172000p -0.3
+ 172010p 0.9
+ 174000p 0.9
+ 174010p -0.3
+ 176000p -0.3
+ 176010p 0.9
+ 178000p 0.9
+ 178010p -0.3
+ 180000p -0.3
+ 180010p 0.9
+ 182000p 0.9
+ 182010p -0.3
+ 184000p -0.3
+ 184010p 0.9
+ 186000p 0.9
+ 186010p -0.3
+ 188000p -0.3
+ 188010p 0.9
+ 190000p 0.9
+ 190010p -0.3
+ 192000p -0.3
+ 192010p 0.9
+ 194000p 0.9
+ 194010p -0.3
+ 196000p -0.3
+ 196010p 0.9
+ 198000p 0.9
+ 198010p -0.3
+ 200000p -0.3
+ 200010p 0.9
+ 202000p 0.9
+ 202010p -0.3
+ 204000p -0.3
+ 204010p 0.9
+ 206000p 0.9
+ 206010p -0.3
+ 208000p -0.3
+ 208010p 0.9
+ 210000p 0.9
+ 210010p -0.3
+ 212000p -0.3
+ 212010p 0.9
+ 214000p 0.9
+ 214010p -0.3
+ 216000p -0.3
+ 216010p 0.9
+ 218000p 0.9
+ 218010p -0.3
+ 220000p -0.3
+ 220010p 0.9
+ 222000p 0.9
+ 222010p -0.3
+ 224000p -0.3
+ 224010p 0.9
+ 226000p 0.9
+ 226010p -0.3
+ 228000p -0.3
+ 228010p 0.9
+ 230000p 0.9
+ 230010p -0.3
+ 232000p -0.3
+ 232010p 0.9
+ 234000p 0.9
+ 234010p -0.3
+ 236000p -0.3
+ 236010p 0.9
+ 238000p 0.9
+ 238010p -0.3
+ 240000p -0.3
+ 240010p 0.9
+ 242000p 0.9
+ 242010p -0.3
+ 244000p -0.3
+ 244010p 0.9
+ 246000p 0.9
+ 246010p -0.3
+ 248000p -0.3
+ 248010p 0.9
+ 250000p 0.9
+ 250010p -0.3
+ 252000p -0.3
+ 252010p 0.9
+ 254000p 0.9
+ 254010p -0.3
+ 256000p -0.3
+ 256010p 0.9
+ 258000p 0.9
+ 258010p -0.3
+ 260000p -0.3
+ 260010p 0.9
+ 262000p 0.9
+ 262010p -0.3
+ 264000p -0.3
+ 264010p 0.9
+ 266000p 0.9
+ 266010p -0.3
+ 268000p -0.3
+ 268010p 0.9
+ 270000p 0.9
+ 270010p -0.3
+ 272000p -0.3
+ 272010p 0.9
+ 274000p 0.9
+ 274010p -0.3
+ 276000p -0.3
+ 276010p 0.9
+ 278000p 0.9
+ 278010p -0.3
+ 280000p -0.3
+ 280010p 0.9
+ 282000p 0.9
+ 282010p -0.3
+ 284000p -0.3
+ 284010p 0.9
+ 286000p 0.9
+ 286010p -0.3
+ 288000p -0.3
+ 288010p 0.9
+ 290000p 0.9
+ 290010p -0.3
+ 292000p -0.3
+ 292010p 0.9
+ 294000p 0.9
+ 294010p -0.3
+ 296000p -0.3
+ 296010p 0.9
+ 298000p 0.9
+ 298010p -0.3
+ 300000p -0.3
+ 300010p 0.9
+ 302000p 0.9
+ 302010p -0.3
+ 304000p -0.3
+ 304010p 0.9
+ 306000p 0.9
+ 306010p -0.3
+ 308000p -0.3
+ 308010p 0.9
+ 310000p 0.9
+ 310010p -0.3
+ 312000p -0.3
+ 312010p 0.9
+ 314000p 0.9
+ 314010p -0.3
+ 316000p -0.3
+ 316010p 0.9
+ 318000p 0.9
+ 318010p -0.3
+ 320000p -0.3
+ 320010p 0.9
+ 322000p 0.9
+ 322010p -0.3
+ 324000p -0.3
+ 324010p 0.9
+ 326000p 0.9
+ 326010p -0.3
+ 328000p -0.3
+ 328010p 0.9
+ 330000p 0.9
+ 330010p -0.3
+ 332000p -0.3
+ 332010p 0.9
+ 334000p 0.9
+ 334010p -0.3
+ 336000p -0.3
+ 336010p 0.9
+ 338000p 0.9
+ 338010p -0.3
+ 340000p -0.3
+ 340010p 0.9
+ 342000p 0.9
+ 342010p -0.3
+ 344000p -0.3
+ 344010p 0.9
+ 346000p 0.9
+ 346010p -0.3
+ 348000p -0.3
+ 348010p 0.9
+ 350000p 0.9
+ 350010p -0.3
+ 352000p -0.3
+ 352010p 0.9
+ 354000p 0.9
+ 354010p -0.3
+ 356000p -0.3
+ 356010p 0.9
+ 358000p 0.9
+ 358010p -0.3
+ 360000p -0.3
+ 360010p 0.9
+ 362000p 0.9
+ 362010p -0.3
+ 364000p -0.3
+ 364010p 0.9
+ 366000p 0.9
+ 366010p -0.3
+ 368000p -0.3
+ 368010p 0.9
+ 370000p 0.9
+ 370010p -0.3
+ 372000p -0.3
+ 372010p 0.9
+ 374000p 0.9
+ 374010p -0.3
+ 376000p -0.3
+ 376010p 0.9
+ 378000p 0.9
+ 378010p -0.3
+ 380000p -0.3
+ 380010p 0.9
+ 382000p 0.9
+ 382010p -0.3
+ 384000p -0.3
+ 384010p 0.9
+ 386000p 0.9
+ 386010p -0.3
+ 388000p -0.3
+ 388010p 0.9
+ 390000p 0.9
+ 390010p -0.3
+ 392000p -0.3
+ 392010p 0.9
+ 394000p 0.9
+ 394010p -0.3
+ 396000p -0.3
+ 396010p 0.9
+ 398000p 0.9
+ 398010p -0.3
+ 400000p -0.3
+ 400010p 0.9
+ 402000p 0.9
+ 402010p -0.3
+ 404000p -0.3
+ 404010p 0.9
+ 406000p 0.9
+ 406010p -0.3
+ 408000p -0.3
+ 408010p 0.9
+ 410000p 0.9
+ 410010p -0.3
+ 412000p -0.3
+ 412010p 0.9
+ 414000p 0.9
+ 414010p -0.3
+ 416000p -0.3
+ 416010p 0.9
+ 418000p 0.9
+ 418010p -0.3
+ 420000p -0.3
+ 420010p 0.9
+ 422000p 0.9
+ 422010p -0.3
+ 424000p -0.3
+ 424010p 0.9
+ 426000p 0.9
+ 426010p -0.3
+ 428000p -0.3
+ 428010p 0.9
+ 430000p 0.9
+ 430010p -0.3
+ 432000p -0.3
+ 432010p 0.9
+ 434000p 0.9
+ 434010p -0.3
+ 436000p -0.3
+ 436010p 0.9
+ 438000p 0.9
+ 438010p -0.3
+ 440000p -0.3
+ 440010p 0.9
+ 442000p 0.9
+ 442010p -0.3
+ 444000p -0.3
+ 444010p 0.9
+ 446000p 0.9
+ 446010p -0.3
+ 448000p -0.3
+ 448010p 0.9
+ 450000p 0.9
+ 450010p -0.3
+ 452000p -0.3
+ 452010p 0.9
+ 454000p 0.9
+ 454010p -0.3
+ 456000p -0.3
+ 456010p 0.9
+ 458000p 0.9
+ 458010p -0.3
+ 460000p -0.3
+ 460010p 0.9
+ 462000p 0.9
+ 462010p -0.3
+ 464000p -0.3
+ 464010p 0.9
+ 466000p 0.9
+ 466010p -0.3
+ 468000p -0.3
+ 468010p 0.9
+ 470000p 0.9
+ 470010p -0.3
+ 472000p -0.3
+ 472010p 0.9
+ 474000p 0.9
+ 474010p -0.3
+ 476000p -0.3
+ 476010p 0.9
+ 478000p 0.9
+ 478010p -0.3
+ 480000p -0.3
+ 480010p 0.9
+ 482000p 0.9
+ 482010p -0.3
+ 484000p -0.3
+ 484010p 0.9
+ 486000p 0.9
+ 486010p -0.3
+ 488000p -0.3
+ 488010p 0.9
+ 490000p 0.9
+ 490010p -0.3
+ 492000p -0.3
+ 492010p 0.9
+ 494000p 0.9
+ 494010p -0.3
+ 496000p -0.3
+ 496010p 0.9
+ 498000p 0.9
+ 498010p -0.3
+ 500000p -0.3
+ 500010p 0.9
+ 502000p 0.9
+ 502010p -0.3
+ 504000p -0.3
+ 504010p 0.9
+ 506000p 0.9
+ 506010p -0.3
+ 508000p -0.3
+ 508010p 0.9
+ 510000p 0.9
+ 510010p -0.3
+ 512000p -0.3
+ 512010p 0.9
+ 514000p 0.9
+ 514010p -0.3
+ 516000p -0.3
+ 516010p 0.9
+ 518000p 0.9
+ 518010p -0.3
+ 520000p -0.3
+ 520010p 0.9
+ 522000p 0.9
+ 522010p -0.3
+ 524000p -0.3
+ 524010p 0.9
+ 526000p 0.9
+ 526010p -0.3
+ 528000p -0.3
+ 528010p 0.9
+ 530000p 0.9
+ 530010p -0.3
+ 532000p -0.3
+ 532010p 0.9
+ 534000p 0.9
+ 534010p -0.3
+ 536000p -0.3
+ 536010p 0.9
+ 538000p 0.9
+ 538010p -0.3
+ 540000p -0.3
+ 540010p 0.9
+ 542000p 0.9
+ 542010p -0.3
+ 544000p -0.3
+ 544010p 0.9
+ 546000p 0.9
+ 546010p -0.3
+ 548000p -0.3
+ 548010p 0.9
+ 550000p 0.9
+ 550010p -0.3
+ 552000p -0.3
+ 552010p 0.9
+ 554000p 0.9
+ 554010p -0.3
+ 556000p -0.3
+ 556010p 0.9
+ 558000p 0.9
+ 558010p -0.3
+ 560000p -0.3
+ 560010p 0.9
+ 562000p 0.9
+ 562010p -0.3
+ 564000p -0.3
+ 564010p 0.9
+ 566000p 0.9
+ 566010p -0.3
+ 568000p -0.3
+ 568010p 0.9
+ 570000p 0.9
+ 570010p -0.3
+ 572000p -0.3
+ 572010p 0.9
+ 574000p 0.9
+ 574010p -0.3
+ 576000p -0.3
+ 576010p 0.9
+ 578000p 0.9
+ 578010p -0.3
+ 580000p -0.3
+ 580010p 0.9
+ 582000p 0.9
+ 582010p -0.3
+ 584000p -0.3
+ 584010p 0.9
+ 586000p 0.9
+ 586010p -0.3
+ 588000p -0.3
+ 588010p 0.9
+ 590000p 0.9
+ 590010p -0.3
+ 592000p -0.3
+ 592010p 0.9
+ 594000p 0.9
+ 594010p -0.3
+ 596000p -0.3
+ 596010p 0.9
+ 598000p 0.9
+ 598010p -0.3
+ 600000p -0.3
+ 600010p 0.9
+ 602000p 0.9
+ 602010p -0.3
+ 604000p -0.3
+ 604010p 0.9
+ 606000p 0.9
+ 606010p -0.3
+ 608000p -0.3
+ 608010p 0.9
+ 610000p 0.9
+ 610010p -0.3
+ 612000p -0.3
+ 612010p 0.9
+ 614000p 0.9
+ 614010p -0.3
+ 616000p -0.3
+ 616010p 0.9
+ 618000p 0.9
+ 618010p -0.3
+ 620000p -0.3
+ 620010p 0.9
+ 622000p 0.9
+ 622010p -0.3
+ 624000p -0.3
+ 624010p 0.9
+ 626000p 0.9
+ 626010p -0.3
+ 628000p -0.3
+ 628010p 0.9
+ 630000p 0.9
+ 630010p -0.3
+ 632000p -0.3
+ 632010p 0.9
+ 634000p 0.9
+ 634010p -0.3
+ 636000p -0.3
+ 636010p 0.9
+ 638000p 0.9
+ 638010p -0.3
+ 640000p -0.3
+ 640010p 0.9
+ 642000p 0.9
+ 642010p -0.3
+ 644000p -0.3
+ 644010p 0.9
+ 646000p 0.9
+ 646010p -0.3
+ 648000p -0.3
+ 648010p 0.9
+ 650000p 0.9
+ 650010p -0.3
+ 652000p -0.3
+ 652010p 0.9
+ 654000p 0.9
+ 654010p -0.3
+ 656000p -0.3
+ 656010p 0.9
+ 658000p 0.9
+ 658010p -0.3
+ 660000p -0.3
+ 660010p 0.9
+ 662000p 0.9
+ 662010p -0.3
+ 664000p -0.3
+ 664010p 0.9
+ 666000p 0.9
+ 666010p -0.3
+ 668000p -0.3
+ 668010p 0.9
+ 670000p 0.9
+ 670010p -0.3
+ 672000p -0.3
+ 672010p 0.9
+ 674000p 0.9
+ 674010p -0.3
+ 676000p -0.3
+ 676010p 0.9
+ 678000p 0.9
+ 678010p -0.3
+ 680000p -0.3
+ 680010p 0.9
+ 682000p 0.9
+ 682010p -0.3
+ 684000p -0.3
+ 684010p 0.9
+ 686000p 0.9
+ 686010p -0.3
+ 688000p -0.3
+ 688010p 0.9
+ 690000p 0.9
+ 690010p -0.3
+ 692000p -0.3
+ 692010p 0.9
+ 694000p 0.9
+ 694010p -0.3
+ 696000p -0.3
+ 696010p 0.9
+ 698000p 0.9
+ 698010p -0.3
+ 700000p -0.3
+ 700010p 0.9
+ 702000p 0.9
+ 702010p -0.3
+ 704000p -0.3
+ 704010p 0.9
+ 706000p 0.9
+ 706010p -0.3
+ 708000p -0.3
+ 708010p 0.9
+ 710000p 0.9
+ 710010p -0.3
+ 712000p -0.3
+ 712010p 0.9
+ 714000p 0.9
+ 714010p -0.3
+ 716000p -0.3
+ 716010p 0.9
+ 718000p 0.9
+ 718010p -0.3
+ 720000p -0.3
+ 720010p 0.9
+ 722000p 0.9
+ 722010p -0.3
+ 724000p -0.3
+ 724010p 0.9
+ 726000p 0.9
+ 726010p -0.3
+ 728000p -0.3
+ 728010p 0.9
+ 730000p 0.9
+ 730010p -0.3
+ 732000p -0.3
+ 732010p 0.9
+ 734000p 0.9
+ 734010p -0.3
+ 736000p -0.3
+ 736010p 0.9
+ 738000p 0.9
+ 738010p -0.3
+ 740000p -0.3
+ 740010p 0.9
+ 742000p 0.9
+ 742010p -0.3
+ 744000p -0.3
+ 744010p 0.9
+ 746000p 0.9
+ 746010p -0.3
+ 748000p -0.3
+ 748010p 0.9
+ 750000p 0.9
+ 750010p -0.3
+ 752000p -0.3
+ 752010p 0.9
+ 754000p 0.9
+ 754010p -0.3
+ 756000p -0.3
+ 756010p 0.9
+ 758000p 0.9
+ 758010p -0.3
+ 760000p -0.3
+ 760010p 0.9
+ 762000p 0.9
+ 762010p -0.3
+ 764000p -0.3
+ 764010p 0.9
+ 766000p 0.9
+ 766010p -0.3
+ 768000p -0.3
+ 768010p 0.9
+ 770000p 0.9
+ 770010p -0.3
+ 772000p -0.3
+ 772010p 0.9
+ 774000p 0.9
+ 774010p -0.3
+ 776000p -0.3
+ 776010p 0.9
+ 778000p 0.9
+ 778010p -0.3
+ 780000p -0.3
+ 780010p 0.9
+ 782000p 0.9
+ 782010p -0.3
+ 784000p -0.3
+ 784010p 0.9
+ 786000p 0.9
+ 786010p -0.3
+ 788000p -0.3
+ 788010p 0.9
+ 790000p 0.9
+ 790010p -0.3
+ 792000p -0.3
+ 792010p 0.9
+ 794000p 0.9
+ 794010p -0.3
+ 796000p -0.3
+ 796010p 0.9
+ 798000p 0.9
+ 798010p -0.3
+ 800000p -0.3
+ 800010p 0.9
+ 802000p 0.9
+ 802010p -0.3
+ 804000p -0.3
+ 804010p 0.9
+ 806000p 0.9
+ 806010p -0.3
+ 808000p -0.3
+ 808010p 0.9
+ 810000p 0.9
+ 810010p -0.3
+ 812000p -0.3
+ 812010p 0.9
+ 814000p 0.9
+ 814010p -0.3
+ 816000p -0.3
+ 816010p 0.9
+ 818000p 0.9
+ 818010p -0.3
+ 820000p -0.3
+ 820010p 0.9
+ 822000p 0.9
+ 822010p -0.3
+ 824000p -0.3
+ 824010p 0.9
+ 826000p 0.9
+ 826010p -0.3
+ 828000p -0.3
+ 828010p 0.9
+ 830000p 0.9
+ 830010p -0.3
+ 832000p -0.3
+ 832010p 0.9
+ 834000p 0.9
+ 834010p -0.3
+ 836000p -0.3
+ 836010p 0.9
+ 838000p 0.9
+ 838010p -0.3
+ 840000p -0.3
+ 840010p 0.9
+ 842000p 0.9
+ 842010p -0.3
+ 844000p -0.3
+ 844010p 0.9
+ 846000p 0.9
+ 846010p -0.3
+ 848000p -0.3
+ 848010p 0.9
+ 850000p 0.9
+ 850010p -0.3
+ 852000p -0.3
+ 852010p 0.9
+ 854000p 0.9
+ 854010p -0.3
+ 856000p -0.3
+ 856010p 0.9
+ 858000p 0.9
+ 858010p -0.3
+ 860000p -0.3
+ 860010p 0.9
+ 862000p 0.9
+ 862010p -0.3
+ 864000p -0.3
+ 864010p 0.9
+ 866000p 0.9
+ 866010p -0.3
+ 868000p -0.3
+ 868010p 0.9
+ 870000p 0.9
+ 870010p -0.3
+ 872000p -0.3
+ 872010p 0.9
+ 874000p 0.9
+ 874010p -0.3
+ 876000p -0.3
+ 876010p 0.9
+ 878000p 0.9
+ 878010p -0.3
+ 880000p -0.3
+ 880010p 0.9
+ 882000p 0.9
+ 882010p -0.3
+ 884000p -0.3
+ 884010p 0.9
+ 886000p 0.9
+ 886010p -0.3
+ 888000p -0.3
+ 888010p 0.9
+ 890000p 0.9
+ 890010p -0.3
+ 892000p -0.3
+ 892010p 0.9
+ 894000p 0.9
+ 894010p -0.3
+ 896000p -0.3
+ 896010p 0.9
+ 898000p 0.9
+ 898010p -0.3
+ 900000p -0.3
+ 900010p 0.9
+ 902000p 0.9
+ 902010p -0.3
+ 904000p -0.3
+ 904010p 0.9
+ 906000p 0.9
+ 906010p -0.3
+ 908000p -0.3
+ 908010p 0.9
+ 910000p 0.9
+ 910010p -0.3
+ 912000p -0.3
+ 912010p 0.9
+ 914000p 0.9
+ 914010p -0.3
+ 916000p -0.3
+ 916010p 0.9
+ 918000p 0.9
+ 918010p -0.3
+ 920000p -0.3
+ 920010p 0.9
+ 922000p 0.9
+ 922010p -0.3
+ 924000p -0.3
+ 924010p 0.9
+ 926000p 0.9
+ 926010p -0.3
+ 928000p -0.3
+ 928010p 0.9
+ 930000p 0.9
+ 930010p -0.3
+ 932000p -0.3
+ 932010p 0.9
+ 934000p 0.9
+ 934010p -0.3
+ 936000p -0.3
+ 936010p 0.9
+ 938000p 0.9
+ 938010p -0.3
+ 940000p -0.3
+ 940010p 0.9
+ 942000p 0.9
+ 942010p -0.3
+ 944000p -0.3
+ 944010p 0.9
+ 946000p 0.9
+ 946010p -0.3
+ 948000p -0.3
+ 948010p 0.9
+ 950000p 0.9
+ 950010p -0.3
+ 952000p -0.3
+ 952010p 0.9
+ 954000p 0.9
+ 954010p -0.3
+ 956000p -0.3
+ 956010p 0.9
+ 958000p 0.9
+ 958010p -0.3
+ 960000p -0.3
+ 960010p 0.9
+ 962000p 0.9
+ 962010p -0.3
+ 964000p -0.3
+ 964010p 0.9
+ 966000p 0.9
+ 966010p -0.3
+ 968000p -0.3
+ 968010p 0.9
+ 970000p 0.9
+ 970010p -0.3
+ 972000p -0.3
+ 972010p 0.9
+ 974000p 0.9
+ 974010p -0.3
+ 976000p -0.3
+ 976010p 0.9
+ 978000p 0.9
+ 978010p -0.3
+ 980000p -0.3
+ 980010p 0.9
+ 982000p 0.9
+ 982010p -0.3
+ 984000p -0.3
+ 984010p 0.9
+ 986000p 0.9
+ 986010p -0.3
+ 988000p -0.3
+ 988010p 0.9
+ 990000p 0.9
+ 990010p -0.3
+ 992000p -0.3
+ 992010p 0.9
+ 994000p 0.9
+ 994010p -0.3
+ 996000p -0.3
+ 996010p 0.9
+ 998000p 0.9
+ 998010p -0.3
+ 1000000p -0.3
+ 1000010p 0.9
+ 1002000p 0.9
+ 1002010p -0.3
+ 1004000p -0.3
+ 1004010p 0.9
+ 1006000p 0.9
+ 1006010p -0.3
+ 1008000p -0.3
+ 1008010p 0.9
+ 1010000p 0.9
+ 1010010p -0.3
+ 1012000p -0.3
+ 1012010p 0.9
+ 1014000p 0.9
+ 1014010p -0.3
+ 1016000p -0.3
+ 1016010p 0.9
+ 1018000p 0.9
+ 1018010p -0.3
+ 1020000p -0.3
+ 1020010p 0.9
+ 1022000p 0.9
+ 1022010p -0.3
+ 1024000p -0.3
+ 1024010p 0.9
+ 1026000p 0.9
+ 1026010p -0.3
+ 1028000p -0.3
+ 1028010p 0.9
+ 1030000p 0.9
+ 1030010p -0.3
+ 1032000p -0.3
+ 1032010p 0.9
+ 1034000p 0.9
+ 1034010p -0.3
+ 1036000p -0.3
+ 1036010p 0.9
+ 1038000p 0.9
+ 1038010p -0.3
+ 1040000p -0.3
+ 1040010p 0.9
+ 1042000p 0.9
+ 1042010p -0.3
+ 1044000p -0.3
+ 1044010p 0.9
+ 1046000p 0.9
+ 1046010p -0.3
+ 1048000p -0.3
+ 1048010p 0.9
+ 1050000p 0.9
+ 1050010p -0.3
+ 1052000p -0.3
+ 1052010p 0.9
+ 1054000p 0.9
+ 1054010p -0.3
+ 1056000p -0.3
+ 1056010p 0.9
+ 1058000p 0.9
+ 1058010p -0.3
+ 1060000p -0.3
+ 1060010p 0.9
+ 1062000p 0.9
+ 1062010p -0.3
+ 1064000p -0.3
+ 1064010p 0.9
+ 1066000p 0.9
+ 1066010p -0.3
+ 1068000p -0.3
+ 1068010p 0.9
+ 1070000p 0.9
+ 1070010p -0.3
+ 1072000p -0.3
+ 1072010p 0.9
+ 1074000p 0.9
+ 1074010p -0.3
+ 1076000p -0.3
+ 1076010p 0.9
+ 1078000p 0.9
+ 1078010p -0.3
+ 1080000p -0.3
+ 1080010p 0.9
+ 1082000p 0.9
+ 1082010p -0.3
+ 1084000p -0.3
+ 1084010p 0.9
+ 1086000p 0.9
+ 1086010p -0.3
+ 1088000p -0.3
+ 1088010p 0.9
+ 1090000p 0.9
+ 1090010p -0.3
+ 1092000p -0.3
+ 1092010p 0.9
+ 1094000p 0.9
+ 1094010p -0.3
+ 1096000p -0.3
+ 1096010p 0.9
+ 1098000p 0.9
+ 1098010p -0.3
+ 1100000p -0.3
+ 1100010p 0.9
+ 1102000p 0.9
+ 1102010p -0.3
+ 1104000p -0.3
+ 1104010p 0.9
+ 1106000p 0.9
+ 1106010p -0.3
+ 1108000p -0.3
+ 1108010p 0.9
+ 1110000p 0.9
+ 1110010p -0.3
+ 1112000p -0.3
+ 1112010p 0.9
+ 1114000p 0.9
+ 1114010p -0.3
+ 1116000p -0.3
+ 1116010p 0.9
+ 1118000p 0.9
+ 1118010p -0.3
+ 1120000p -0.3
+ 1120010p 0.9
+ 1122000p 0.9
+ 1122010p -0.3
+ 1124000p -0.3
+ 1124010p 0.9
+ 1126000p 0.9
+ 1126010p -0.3
+ 1128000p -0.3
+ 1128010p 0.9
+ 1130000p 0.9
+ 1130010p -0.3
+ 1132000p -0.3
+ 1132010p 0.9
+ 1134000p 0.9
+ 1134010p -0.3
+ 1136000p -0.3
+ 1136010p 0.9
+ 1138000p 0.9
+ 1138010p -0.3
+ 1140000p -0.3
+ 1140010p 0.9
+ 1142000p 0.9
+ 1142010p -0.3
+ 1144000p -0.3
+ 1144010p 0.9
+ 1146000p 0.9
+ 1146010p -0.3
+ 1148000p -0.3
+ 1148010p 0.9
+ 1150000p 0.9
+ 1150010p -0.3
+ 1152000p -0.3
+ 1152010p 0.9
+ 1154000p 0.9
+ 1154010p -0.3
+ 1156000p -0.3
+ 1156010p 0.9
+ 1158000p 0.9
+ 1158010p -0.3
+ 1160000p -0.3
+ 1160010p 0.9
+ 1162000p 0.9
+ 1162010p -0.3
+ 1164000p -0.3
+ 1164010p 0.9
+ 1166000p 0.9
+ 1166010p -0.3
+ 1168000p -0.3
+ 1168010p 0.9
+ 1170000p 0.9
+ 1170010p -0.3
+ 1172000p -0.3
+ 1172010p 0.9
+ 1174000p 0.9
+ 1174010p -0.3
+ 1176000p -0.3
+ 1176010p 0.9
+ 1178000p 0.9
+ 1178010p -0.3
+ 1180000p -0.3
+ 1180010p 0.9
+ 1182000p 0.9
+ 1182010p -0.3
+ 1184000p -0.3
+ 1184010p 0.9
+ 1186000p 0.9
+ 1186010p -0.3
+ 1188000p -0.3
+ 1188010p 0.9
+ 1190000p 0.9
+ 1190010p -0.3
+ 1192000p -0.3
+ 1192010p 0.9
+ 1194000p 0.9
+ 1194010p -0.3
+ 1196000p -0.3
+ 1196010p 0.9
+ 1198000p 0.9
+ 1198010p -0.3
+ 1200000p -0.3
+ 1200010p 0.9
+ 1202000p 0.9
+ 1202010p -0.3
+ 1204000p -0.3
+ 1204010p 0.9
+ 1206000p 0.9
+ 1206010p -0.3
+ 1208000p -0.3
+ 1208010p 0.9
+ 1210000p 0.9
+ 1210010p -0.3
+ 1212000p -0.3
+ 1212010p 0.9
+ 1214000p 0.9
+ 1214010p -0.3
+ 1216000p -0.3
+ 1216010p 0.9
+ 1218000p 0.9
+ 1218010p -0.3
+ 1220000p -0.3
+ 1220010p 0.9
+ 1222000p 0.9
+ 1222010p -0.3
+ 1224000p -0.3
+ 1224010p 0.9
+ 1226000p 0.9
+ 1226010p -0.3
+ 1228000p -0.3
+ 1228010p 0.9
+ 1230000p 0.9
+ 1230010p -0.3
+ 1232000p -0.3
+ 1232010p 0.9
+ 1234000p 0.9
+ 1234010p -0.3
+ 1236000p -0.3
+ 1236010p 0.9
+ 1238000p 0.9
+ 1238010p -0.3
+ 1240000p -0.3
+ 1240010p 0.9
+ 1242000p 0.9
+ 1242010p -0.3
+ 1244000p -0.3
+ 1244010p 0.9
+ 1246000p 0.9
+ 1246010p -0.3
+ 1248000p -0.3
+ 1248010p 0.9
+ 1250000p 0.9
+ 1250010p -0.3
+ 1252000p -0.3
+ 1252010p 0.9
+ 1254000p 0.9
+ 1254010p -0.3
+ 1256000p -0.3
+ 1256010p 0.9
+ 1258000p 0.9
+ 1258010p -0.3
+ 1260000p -0.3
+ 1260010p 0.9
+ 1262000p 0.9
+ 1262010p -0.3
+ 1264000p -0.3
+ 1264010p 0.9
+ 1266000p 0.9
+ 1266010p -0.3
+ 1268000p -0.3
+ 1268010p 0.9
+ 1270000p 0.9
+ 1270010p -0.3
+ 1272000p -0.3
+ 1272010p 0.9
+ 1274000p 0.9
+ 1274010p -0.3
+ 1276000p -0.3
+ 1276010p 0.9
+ 1278000p 0.9
+ 1278010p -0.3
+ 1280000p -0.3
+ 1280010p 0.9
+ 1282000p 0.9
+ 1282010p -0.3
+ 1284000p -0.3
+ 1284010p 0.9
+ 1286000p 0.9
+ 1286010p -0.3
+ 1288000p -0.3
+ 1288010p 0.9
+ 1290000p 0.9
+ 1290010p -0.3
+ 1292000p -0.3
+ 1292010p 0.9
+ 1294000p 0.9
+ 1294010p -0.3
+ 1296000p -0.3
+ 1296010p 0.9
+ 1298000p 0.9
+ 1298010p -0.3
+ 1300000p -0.3
+ 1300010p 0.9
+ 1302000p 0.9
+ 1302010p -0.3
+ 1304000p -0.3
+ 1304010p 0.9
+ 1306000p 0.9
+ 1306010p -0.3
+ 1308000p -0.3
+ 1308010p 0.9
+ 1310000p 0.9
+ 1310010p -0.3
+ 1312000p -0.3
+ 1312010p 0.9
+ 1314000p 0.9
+ 1314010p -0.3
+ 1316000p -0.3
+ 1316010p 0.9
+ 1318000p 0.9
+ 1318010p -0.3
+ 1320000p -0.3
+ 1320010p 0.9
+ 1322000p 0.9
+ 1322010p -0.3
+ 1324000p -0.3
+ 1324010p 0.9
+ 1326000p 0.9
+ 1326010p -0.3
+ 1328000p -0.3
+ 1328010p 0.9
+ 1330000p 0.9
+ 1330010p -0.3
+ 1332000p -0.3
+ 1332010p 0.9
+ 1334000p 0.9
+ 1334010p -0.3
+ 1336000p -0.3
+ 1336010p 0.9
+ 1338000p 0.9
+ 1338010p -0.3
+ 1340000p -0.3
+ 1340010p 0.9
+ 1342000p 0.9
+ 1342010p -0.3
+ 1344000p -0.3
+ 1344010p 0.9
+ 1346000p 0.9
+ 1346010p -0.3
+ 1348000p -0.3
+ 1348010p 0.9
+ 1350000p 0.9
+ 1350010p -0.3
+ 1352000p -0.3
+ 1352010p 0.9
+ 1354000p 0.9
+ 1354010p -0.3
+ 1356000p -0.3
+ 1356010p 0.9
+ 1358000p 0.9
+ 1358010p -0.3
+ 1360000p -0.3
+ 1360010p 0.9
+ 1362000p 0.9
+ 1362010p -0.3
+ 1364000p -0.3
+ 1364010p 0.9
+ 1366000p 0.9
+ 1366010p -0.3
+ 1368000p -0.3
+ 1368010p 0.9
+ 1370000p 0.9
+ 1370010p -0.3
+ 1372000p -0.3
+ 1372010p 0.9
+ 1374000p 0.9
+ 1374010p -0.3
+ 1376000p -0.3
+ 1376010p 0.9
+ 1378000p 0.9
+ 1378010p -0.3
+ 1380000p -0.3
+ 1380010p 0.9
+ 1382000p 0.9
+ 1382010p -0.3
+ 1384000p -0.3
+ 1384010p 0.9
+ 1386000p 0.9
+ 1386010p -0.3
+ 1388000p -0.3
+ 1388010p 0.9
+ 1390000p 0.9
+ 1390010p -0.3
+ 1392000p -0.3
+ 1392010p 0.9
+ 1394000p 0.9
+ 1394010p -0.3
+ 1396000p -0.3
+ 1396010p 0.9
+ 1398000p 0.9
+ 1398010p -0.3
+ 1400000p -0.3
+ 1400010p 0.9
+ 1402000p 0.9
+ 1402010p -0.3
+ 1404000p -0.3
+ 1404010p 0.9
+ 1406000p 0.9
+ 1406010p -0.3
+ 1408000p -0.3
+ 1408010p 0.9
+ 1410000p 0.9
+ 1410010p -0.3
+ 1412000p -0.3
+ 1412010p 0.9
+ 1414000p 0.9
+ 1414010p -0.3
+ 1416000p -0.3
+ 1416010p 0.9
+ 1418000p 0.9
+ 1418010p -0.3
+ 1420000p -0.3
+ 1420010p 0.9
+ 1422000p 0.9
+ 1422010p -0.3
+ 1424000p -0.3
+ 1424010p 0.9
+ 1426000p 0.9
+ 1426010p -0.3
+ 1428000p -0.3
+ 1428010p 0.9
+ 1430000p 0.9
+ 1430010p -0.3
+ 1432000p -0.3
+ 1432010p 0.9
+ 1434000p 0.9
+ 1434010p -0.3
+ 1436000p -0.3
+ 1436010p 0.9
+ 1438000p 0.9
+ 1438010p -0.3
+ 1440000p -0.3
+ 1440010p 0.9
+ 1442000p 0.9
+ 1442010p -0.3
+ 1444000p -0.3
+ 1444010p 0.9
+ 1446000p 0.9
+ 1446010p -0.3
+ 1448000p -0.3
+ 1448010p 0.9
+ 1450000p 0.9
+ 1450010p -0.3
+ 1452000p -0.3
+ 1452010p 0.9
+ 1454000p 0.9
+ 1454010p -0.3
+ 1456000p -0.3
+ 1456010p 0.9
+ 1458000p 0.9
+ 1458010p -0.3
+ 1460000p -0.3
+ 1460010p 0.9
+ 1462000p 0.9
+ 1462010p -0.3
+ 1464000p -0.3
+ 1464010p 0.9
+ 1466000p 0.9
+ 1466010p -0.3
+ 1468000p -0.3
+ 1468010p 0.9
+ 1470000p 0.9
+ 1470010p -0.3
+ 1472000p -0.3
+ 1472010p 0.9
+ 1474000p 0.9
+ 1474010p -0.3
+ 1476000p -0.3
+ 1476010p 0.9
+ 1478000p 0.9
+ 1478010p -0.3
+ 1480000p -0.3
+ 1480010p 0.9
+ 1482000p 0.9
+ 1482010p -0.3
+ 1484000p -0.3
+ 1484010p 0.9
+ 1486000p 0.9
+ 1486010p -0.3
+ 1488000p -0.3
+ 1488010p 0.9
+ 1490000p 0.9
+ 1490010p -0.3
+ 1492000p -0.3
+ 1492010p 0.9
+ 1494000p 0.9
+ 1494010p -0.3
+ 1496000p -0.3
+ 1496010p 0.9
+ 1498000p 0.9
+ 1498010p -0.3
+ 1500000p -0.3
+ 1500010p 0.9
+ 1502000p 0.9
+ 1502010p -0.3
+ 1504000p -0.3
+ 1504010p 0.9
+ 1506000p 0.9
+ 1506010p -0.3
+ 1508000p -0.3
+ 1508010p 0.9
+ 1510000p 0.9
+ 1510010p -0.3
+ 1512000p -0.3
+ 1512010p 0.9
+ 1514000p 0.9
+ 1514010p -0.3
+ 1516000p -0.3
+ 1516010p 0.9
+ 1518000p 0.9
+ 1518010p -0.3
+ 1520000p -0.3
+ 1520010p 0.9
+ 1522000p 0.9
+ 1522010p -0.3
+ 1524000p -0.3
+ 1524010p 0.9
+ 1526000p 0.9
+ 1526010p -0.3
+ 1528000p -0.3
+ 1528010p 0.9
+ 1530000p 0.9
+ 1530010p -0.3
+ 1532000p -0.3
+ 1532010p 0.9
+ 1534000p 0.9
+ 1534010p -0.3
+ 1536000p -0.3
+ 1536010p 0.9
+ 1538000p 0.9
+ 1538010p -0.3
+ 1540000p -0.3
+ 1540010p 0.9
+ 1542000p 0.9
+ 1542010p -0.3
+ 1544000p -0.3
+ 1544010p 0.9
+ 1546000p 0.9
+ 1546010p -0.3
+ 1548000p -0.3
+ 1548010p 0.9
+ 1550000p 0.9
+ 1550010p -0.3
+ 1552000p -0.3
+ 1552010p 0.9
+ 1554000p 0.9
+ 1554010p -0.3
+ 1556000p -0.3
+ 1556010p 0.9
+ 1558000p 0.9
+ 1558010p -0.3
+ 1560000p -0.3
+ 1560010p 0.9
+ 1562000p 0.9
+ 1562010p -0.3
+ 1564000p -0.3
+ 1564010p 0.9
+ 1566000p 0.9
+ 1566010p -0.3
+ 1568000p -0.3
+ 1568010p 0.9
+ 1570000p 0.9
+ 1570010p -0.3
+ 1572000p -0.3
+ 1572010p 0.9
+ 1574000p 0.9
+ 1574010p -0.3
+ 1576000p -0.3
+ 1576010p 0.9
+ 1578000p 0.9
+ 1578010p -0.3
+ 1580000p -0.3
+ 1580010p 0.9
+ 1582000p 0.9
+ 1582010p -0.3
+ 1584000p -0.3
+ 1584010p 0.9
+ 1586000p 0.9
+ 1586010p -0.3
+ 1588000p -0.3
+ 1588010p 0.9
+ 1590000p 0.9
+ 1590010p -0.3
+ 1592000p -0.3
+ 1592010p 0.9
+ 1594000p 0.9
+ 1594010p -0.3
+ 1596000p -0.3
+ 1596010p 0.9
+ 1598000p 0.9
+ 1598010p -0.3
+ 1600000p -0.3
+ 1600010p 0.9
+ 1602000p 0.9
+ 1602010p -0.3
+ 1604000p -0.3
+ 1604010p 0.9
+ 1606000p 0.9
+ 1606010p -0.3
+ 1608000p -0.3
+ 1608010p 0.9
+ 1610000p 0.9
+ 1610010p -0.3
+ 1612000p -0.3
+ 1612010p 0.9
+ 1614000p 0.9
+ 1614010p -0.3
+ 1616000p -0.3
+ 1616010p 0.9
+ 1618000p 0.9
+ 1618010p -0.3
+ 1620000p -0.3
+ 1620010p 0.9
+ 1622000p 0.9
+ 1622010p -0.3
+ 1624000p -0.3
+ 1624010p 0.9
+ 1626000p 0.9
+ 1626010p -0.3
+ 1628000p -0.3
+ 1628010p 0.9
+ 1630000p 0.9
+ 1630010p -0.3
+ 1632000p -0.3
+ 1632010p 0.9
+ 1634000p 0.9
+ 1634010p -0.3
+ 1636000p -0.3
+ 1636010p 0.9
+ 1638000p 0.9
+ 1638010p -0.3
+ 1640000p -0.3
+ 1640010p 0.9
+ 1642000p 0.9
+ 1642010p -0.3
+ 1644000p -0.3
+ 1644010p 0.9
+ 1646000p 0.9
+ 1646010p -0.3
+ 1648000p -0.3
+ 1648010p 0.9
+ 1650000p 0.9
+ 1650010p -0.3
+ 1652000p -0.3
+ 1652010p 0.9
+ 1654000p 0.9
+ 1654010p -0.3
+ 1656000p -0.3
+ 1656010p 0.9
+ 1658000p 0.9
+ 1658010p -0.3
+ 1660000p -0.3
+ 1660010p 0.9
+ 1662000p 0.9
+ 1662010p -0.3
+ 1664000p -0.3
+ 1664010p 0.9
+ 1666000p 0.9
+ 1666010p -0.3
+ 1668000p -0.3
+ 1668010p 0.9
+ 1670000p 0.9
+ 1670010p -0.3
+ 1672000p -0.3
+ 1672010p 0.9
+ 1674000p 0.9
+ 1674010p -0.3
+ 1676000p -0.3
+ 1676010p 0.9
+ 1678000p 0.9
+ 1678010p -0.3
+ 1680000p -0.3
+ 1680010p 0.9
+ 1682000p 0.9
+ 1682010p -0.3
+ 1684000p -0.3
+ 1684010p 0.9
+ 1686000p 0.9
+ 1686010p -0.3
+ 1688000p -0.3
+ 1688010p 0.9
+ 1690000p 0.9
+ 1690010p -0.3
+ 1692000p -0.3
+ 1692010p 0.9
+ 1694000p 0.9
+ 1694010p -0.3
+ 1696000p -0.3
+ 1696010p 0.9
+ 1698000p 0.9
+ 1698010p -0.3
+ 1700000p -0.3
+ 1700010p 0.9
+ 1702000p 0.9
+ 1702010p -0.3
+ 1704000p -0.3
+ 1704010p 0.9
+ 1706000p 0.9
+ 1706010p -0.3
+ 1708000p -0.3
+ 1708010p 0.9
+ 1710000p 0.9
+ 1710010p -0.3
+ 1712000p -0.3
+ 1712010p 0.9
+ 1714000p 0.9
+ 1714010p -0.3
+ 1716000p -0.3
+ 1716010p 0.9
+ 1718000p 0.9
+ 1718010p -0.3
+ 1720000p -0.3
+ 1720010p 0.9
+ 1722000p 0.9
+ 1722010p -0.3
+ 1724000p -0.3
+ 1724010p 0.9
+ 1726000p 0.9
+ 1726010p -0.3
+ 1728000p -0.3
+ 1728010p 0.9
+ 1730000p 0.9
+ 1730010p -0.3
+ 1732000p -0.3
+ 1732010p 0.9
+ 1734000p 0.9
+ 1734010p -0.3
+ 1736000p -0.3
+ 1736010p 0.9
+ 1738000p 0.9
+ 1738010p -0.3
+ 1740000p -0.3
+ 1740010p 0.9
+ 1742000p 0.9
+ 1742010p -0.3
+ 1744000p -0.3
+ 1744010p 0.9
+ 1746000p 0.9
+ 1746010p -0.3
+ 1748000p -0.3
+ 1748010p 0.9
+ 1750000p 0.9
+ 1750010p -0.3
+ 1752000p -0.3
+ 1752010p 0.9
+ 1754000p 0.9
+ 1754010p -0.3
+ 1756000p -0.3
+ 1756010p 0.9
+ 1758000p 0.9
+ 1758010p -0.3
+ 1760000p -0.3
+ 1760010p 0.9
+ 1762000p 0.9
+ 1762010p -0.3
+ 1764000p -0.3
+ 1764010p 0.9
+ 1766000p 0.9
+ 1766010p -0.3
+ 1768000p -0.3
+ 1768010p 0.9
+ 1770000p 0.9
+ 1770010p -0.3
+ 1772000p -0.3
+ 1772010p 0.9
+ 1774000p 0.9
+ 1774010p -0.3
+ 1776000p -0.3
+ 1776010p 0.9
+ 1778000p 0.9
+ 1778010p -0.3
+ 1780000p -0.3
+ 1780010p 0.9
+ 1782000p 0.9
+ 1782010p -0.3
+ 1784000p -0.3
+ 1784010p 0.9
+ 1786000p 0.9
+ 1786010p -0.3
+ 1788000p -0.3
+ 1788010p 0.9
+ 1790000p 0.9
+ 1790010p -0.3
+ 1792000p -0.3
+ 1792010p 0.9
+ 1794000p 0.9
+ 1794010p -0.3
+ 1796000p -0.3
+ 1796010p 0.9
+ 1798000p 0.9
+ 1798010p -0.3
+ 1800000p -0.3
+ 1800010p 0.9
+ 1802000p 0.9
+ 1802010p -0.3
+ 1804000p -0.3
+ 1804010p 0.9
+ 1806000p 0.9
+ 1806010p -0.3
+ 1808000p -0.3
+ 1808010p 0.9
+ 1810000p 0.9
+ 1810010p -0.3
+ 1812000p -0.3
+ 1812010p 0.9
+ 1814000p 0.9
+ 1814010p -0.3
+ 1816000p -0.3
+ 1816010p 0.9
+ 1818000p 0.9
+ 1818010p -0.3
+ 1820000p -0.3
+ 1820010p 0.9
+ 1822000p 0.9
+ 1822010p -0.3
+ 1824000p -0.3
+ 1824010p 0.9
+ 1826000p 0.9
+ 1826010p -0.3
+ 1828000p -0.3
+ 1828010p 0.9
+ 1830000p 0.9
+ 1830010p -0.3
+ 1832000p -0.3
+ 1832010p 0.9
+ 1834000p 0.9
+ 1834010p -0.3
+ 1836000p -0.3
+ 1836010p 0.9
+ 1838000p 0.9
+ 1838010p -0.3
+ 1840000p -0.3
+ 1840010p 0.9
+ 1842000p 0.9
+ 1842010p -0.3
+ 1844000p -0.3
+ 1844010p 0.9
+ 1846000p 0.9
+ 1846010p -0.3
+ 1848000p -0.3
+ 1848010p 0.9
+ 1850000p 0.9
+ 1850010p -0.3
+ 1852000p -0.3
+ 1852010p 0.9
+ 1854000p 0.9
+ 1854010p -0.3
+ 1856000p -0.3
+ 1856010p 0.9
+ 1858000p 0.9
+ 1858010p -0.3
+ 1860000p -0.3
+ 1860010p 0.9
+ 1862000p 0.9
+ 1862010p -0.3
+ 1864000p -0.3
+ 1864010p 0.9
+ 1866000p 0.9
+ 1866010p -0.3
+ 1868000p -0.3
+ 1868010p 0.9
+ 1870000p 0.9
+ 1870010p -0.3
+ 1872000p -0.3
+ 1872010p 0.9
+ 1874000p 0.9
+ 1874010p -0.3
+ 1876000p -0.3
+ 1876010p 0.9
+ 1878000p 0.9
+ 1878010p -0.3
+ 1880000p -0.3
+ 1880010p 0.9
+ 1882000p 0.9
+ 1882010p -0.3
+ 1884000p -0.3
+ 1884010p 0.9
+ 1886000p 0.9
+ 1886010p -0.3
+ 1888000p -0.3
+ 1888010p 0.9
+ 1890000p 0.9
+ 1890010p -0.3
+ 1892000p -0.3
+ 1892010p 0.9
+ 1894000p 0.9
+ 1894010p -0.3
+ 1896000p -0.3
+ 1896010p 0.9
+ 1898000p 0.9
+ 1898010p -0.3
+ 1900000p -0.3
+ 1900010p 0.9
+ 1902000p 0.9
+ 1902010p -0.3
+ 1904000p -0.3
+ 1904010p 0.9
+ 1906000p 0.9
+ 1906010p -0.3
+ 1908000p -0.3
+ 1908010p 0.9
+ 1910000p 0.9
+ 1910010p -0.3
+ 1912000p -0.3
+ 1912010p 0.9
+ 1914000p 0.9
+ 1914010p -0.3
+ 1916000p -0.3
+ 1916010p 0.9
+ 1918000p 0.9
+ 1918010p -0.3
+ 1920000p -0.3
+ 1920010p 0.9
+ 1922000p 0.9
+ 1922010p -0.3
+ 1924000p -0.3
+ 1924010p 0.9
+ 1926000p 0.9
+ 1926010p -0.3
+ 1928000p -0.3
+ 1928010p 0.9
+ 1930000p 0.9
+ 1930010p -0.3
+ 1932000p -0.3
+ 1932010p 0.9
+ 1934000p 0.9
+ 1934010p -0.3
+ 1936000p -0.3
+ 1936010p 0.9
+ 1938000p 0.9
+ 1938010p -0.3
+ 1940000p -0.3
+ 1940010p 0.9
+ 1942000p 0.9
+ 1942010p -0.3
+ 1944000p -0.3
+ 1944010p 0.9
+ 1946000p 0.9
+ 1946010p -0.3
+ 1948000p -0.3
+ 1948010p 0.9
+ 1950000p 0.9
+ 1950010p -0.3
+ 1952000p -0.3
+ 1952010p 0.9
+ 1954000p 0.9
+ 1954010p -0.3
+ 1956000p -0.3
+ 1956010p 0.9
+ 1958000p 0.9
+ 1958010p -0.3
+ 1960000p -0.3
+ 1960010p 0.9
+ 1962000p 0.9
+ 1962010p -0.3
+ 1964000p -0.3
+ 1964010p 0.9
+ 1966000p 0.9
+ 1966010p -0.3
+ 1968000p -0.3
+ 1968010p 0.9
+ 1970000p 0.9
+ 1970010p -0.3
+ 1972000p -0.3
+ 1972010p 0.9
+ 1974000p 0.9
+ 1974010p -0.3
+ 1976000p -0.3
+ 1976010p 0.9
+ 1978000p 0.9
+ 1978010p -0.3
+ 1980000p -0.3
+ 1980010p 0.9
+ 1982000p 0.9
+ 1982010p -0.3
+ 1984000p -0.3
+ 1984010p 0.9
+ 1986000p 0.9
+ 1986010p -0.3
+ 1988000p -0.3
+ 1988010p 0.9
+ 1990000p 0.9
+ 1990010p -0.3
+ 1992000p -0.3
+ 1992010p 0.9
+ 1994000p 0.9
+ 1994010p -0.3
+ 1996000p -0.3
+ 1996010p 0.9
+ 1998000p 0.9
+ 1998010p -0.3
+ 2000000p -0.3
+ 2000010p 0.9
+ 2002000p 0.9
+ 2002010p -0.3
+ 2004000p -0.3
+ 2004010p 0.9
+ 2006000p 0.9
+ 2006010p -0.3
+ 2008000p -0.3
+ 2008010p 0.9
+ 2010000p 0.9
+ 2010010p -0.3
+ 2012000p -0.3
+ 2012010p 0.9
+ 2014000p 0.9
+ 2014010p -0.3
+ 2016000p -0.3
+ 2016010p 0.9
+ 2018000p 0.9
+ 2018010p -0.3
+ 2020000p -0.3
+ 2020010p 0.9
+ 2022000p 0.9
+ 2022010p -0.3
+ 2024000p -0.3
+ 2024010p 0.9
+ 2026000p 0.9
+ 2026010p -0.3
+ 2028000p -0.3
+ 2028010p 0.9
+ 2030000p 0.9
+ 2030010p -0.3
+ 2032000p -0.3
+ 2032010p 0.9
+ 2034000p 0.9
+ 2034010p -0.3
+ 2036000p -0.3
+ 2036010p 0.9
+ 2038000p 0.9
+ 2038010p -0.3
+ 2040000p -0.3
+ 2040010p 0.9
+ 2042000p 0.9
+ 2042010p -0.3
+ 2044000p -0.3
+ 2044010p 0.9
+ 2046000p 0.9
+ 2046010p -0.3
+ 2048000p -0.3
+ 2048010p 0.9
+ \]
V_data_bar_0 (Data_bar\\<0\\> gnd!) vsource type=pwl wave=\[
+ 0    -0.3
+ 2000p -0.3
+ 2010p 0.9
+ 4000p 0.9
+ 4010p -0.3
+ 6000p -0.3
+ 6010p 0.9
+ 8000p 0.9
+ 8010p -0.3
+ 10000p -0.3
+ 10010p 0.9
+ 12000p 0.9
+ 12010p -0.3
+ 14000p -0.3
+ 14010p 0.9
+ 16000p 0.9
+ 16010p -0.3
+ 18000p -0.3
+ 18010p 0.9
+ 20000p 0.9
+ 20010p -0.3
+ 22000p -0.3
+ 22010p 0.9
+ 24000p 0.9
+ 24010p -0.3
+ 26000p -0.3
+ 26010p 0.9
+ 28000p 0.9
+ 28010p -0.3
+ 30000p -0.3
+ 30010p 0.9
+ 32000p 0.9
+ 32010p -0.3
+ 34000p -0.3
+ 34010p 0.9
+ 36000p 0.9
+ 36010p -0.3
+ 38000p -0.3
+ 38010p 0.9
+ 40000p 0.9
+ 40010p -0.3
+ 42000p -0.3
+ 42010p 0.9
+ 44000p 0.9
+ 44010p -0.3
+ 46000p -0.3
+ 46010p 0.9
+ 48000p 0.9
+ 48010p -0.3
+ 50000p -0.3
+ 50010p 0.9
+ 52000p 0.9
+ 52010p -0.3
+ 54000p -0.3
+ 54010p 0.9
+ 56000p 0.9
+ 56010p -0.3
+ 58000p -0.3
+ 58010p 0.9
+ 60000p 0.9
+ 60010p -0.3
+ 62000p -0.3
+ 62010p 0.9
+ 64000p 0.9
+ 64010p -0.3
+ 66000p -0.3
+ 66010p 0.9
+ 68000p 0.9
+ 68010p -0.3
+ 70000p -0.3
+ 70010p 0.9
+ 72000p 0.9
+ 72010p -0.3
+ 74000p -0.3
+ 74010p 0.9
+ 76000p 0.9
+ 76010p -0.3
+ 78000p -0.3
+ 78010p 0.9
+ 80000p 0.9
+ 80010p -0.3
+ 82000p -0.3
+ 82010p 0.9
+ 84000p 0.9
+ 84010p -0.3
+ 86000p -0.3
+ 86010p 0.9
+ 88000p 0.9
+ 88010p -0.3
+ 90000p -0.3
+ 90010p 0.9
+ 92000p 0.9
+ 92010p -0.3
+ 94000p -0.3
+ 94010p 0.9
+ 96000p 0.9
+ 96010p -0.3
+ 98000p -0.3
+ 98010p 0.9
+ 100000p 0.9
+ 100010p -0.3
+ 102000p -0.3
+ 102010p 0.9
+ 104000p 0.9
+ 104010p -0.3
+ 106000p -0.3
+ 106010p 0.9
+ 108000p 0.9
+ 108010p -0.3
+ 110000p -0.3
+ 110010p 0.9
+ 112000p 0.9
+ 112010p -0.3
+ 114000p -0.3
+ 114010p 0.9
+ 116000p 0.9
+ 116010p -0.3
+ 118000p -0.3
+ 118010p 0.9
+ 120000p 0.9
+ 120010p -0.3
+ 122000p -0.3
+ 122010p 0.9
+ 124000p 0.9
+ 124010p -0.3
+ 126000p -0.3
+ 126010p 0.9
+ 128000p 0.9
+ 128010p -0.3
+ 130000p -0.3
+ 130010p 0.9
+ 132000p 0.9
+ 132010p -0.3
+ 134000p -0.3
+ 134010p 0.9
+ 136000p 0.9
+ 136010p -0.3
+ 138000p -0.3
+ 138010p 0.9
+ 140000p 0.9
+ 140010p -0.3
+ 142000p -0.3
+ 142010p 0.9
+ 144000p 0.9
+ 144010p -0.3
+ 146000p -0.3
+ 146010p 0.9
+ 148000p 0.9
+ 148010p -0.3
+ 150000p -0.3
+ 150010p 0.9
+ 152000p 0.9
+ 152010p -0.3
+ 154000p -0.3
+ 154010p 0.9
+ 156000p 0.9
+ 156010p -0.3
+ 158000p -0.3
+ 158010p 0.9
+ 160000p 0.9
+ 160010p -0.3
+ 162000p -0.3
+ 162010p 0.9
+ 164000p 0.9
+ 164010p -0.3
+ 166000p -0.3
+ 166010p 0.9
+ 168000p 0.9
+ 168010p -0.3
+ 170000p -0.3
+ 170010p 0.9
+ 172000p 0.9
+ 172010p -0.3
+ 174000p -0.3
+ 174010p 0.9
+ 176000p 0.9
+ 176010p -0.3
+ 178000p -0.3
+ 178010p 0.9
+ 180000p 0.9
+ 180010p -0.3
+ 182000p -0.3
+ 182010p 0.9
+ 184000p 0.9
+ 184010p -0.3
+ 186000p -0.3
+ 186010p 0.9
+ 188000p 0.9
+ 188010p -0.3
+ 190000p -0.3
+ 190010p 0.9
+ 192000p 0.9
+ 192010p -0.3
+ 194000p -0.3
+ 194010p 0.9
+ 196000p 0.9
+ 196010p -0.3
+ 198000p -0.3
+ 198010p 0.9
+ 200000p 0.9
+ 200010p -0.3
+ 202000p -0.3
+ 202010p 0.9
+ 204000p 0.9
+ 204010p -0.3
+ 206000p -0.3
+ 206010p 0.9
+ 208000p 0.9
+ 208010p -0.3
+ 210000p -0.3
+ 210010p 0.9
+ 212000p 0.9
+ 212010p -0.3
+ 214000p -0.3
+ 214010p 0.9
+ 216000p 0.9
+ 216010p -0.3
+ 218000p -0.3
+ 218010p 0.9
+ 220000p 0.9
+ 220010p -0.3
+ 222000p -0.3
+ 222010p 0.9
+ 224000p 0.9
+ 224010p -0.3
+ 226000p -0.3
+ 226010p 0.9
+ 228000p 0.9
+ 228010p -0.3
+ 230000p -0.3
+ 230010p 0.9
+ 232000p 0.9
+ 232010p -0.3
+ 234000p -0.3
+ 234010p 0.9
+ 236000p 0.9
+ 236010p -0.3
+ 238000p -0.3
+ 238010p 0.9
+ 240000p 0.9
+ 240010p -0.3
+ 242000p -0.3
+ 242010p 0.9
+ 244000p 0.9
+ 244010p -0.3
+ 246000p -0.3
+ 246010p 0.9
+ 248000p 0.9
+ 248010p -0.3
+ 250000p -0.3
+ 250010p 0.9
+ 252000p 0.9
+ 252010p -0.3
+ 254000p -0.3
+ 254010p 0.9
+ 256000p 0.9
+ 256010p -0.3
+ 258000p -0.3
+ 258010p 0.9
+ 260000p 0.9
+ 260010p -0.3
+ 262000p -0.3
+ 262010p 0.9
+ 264000p 0.9
+ 264010p -0.3
+ 266000p -0.3
+ 266010p 0.9
+ 268000p 0.9
+ 268010p -0.3
+ 270000p -0.3
+ 270010p 0.9
+ 272000p 0.9
+ 272010p -0.3
+ 274000p -0.3
+ 274010p 0.9
+ 276000p 0.9
+ 276010p -0.3
+ 278000p -0.3
+ 278010p 0.9
+ 280000p 0.9
+ 280010p -0.3
+ 282000p -0.3
+ 282010p 0.9
+ 284000p 0.9
+ 284010p -0.3
+ 286000p -0.3
+ 286010p 0.9
+ 288000p 0.9
+ 288010p -0.3
+ 290000p -0.3
+ 290010p 0.9
+ 292000p 0.9
+ 292010p -0.3
+ 294000p -0.3
+ 294010p 0.9
+ 296000p 0.9
+ 296010p -0.3
+ 298000p -0.3
+ 298010p 0.9
+ 300000p 0.9
+ 300010p -0.3
+ 302000p -0.3
+ 302010p 0.9
+ 304000p 0.9
+ 304010p -0.3
+ 306000p -0.3
+ 306010p 0.9
+ 308000p 0.9
+ 308010p -0.3
+ 310000p -0.3
+ 310010p 0.9
+ 312000p 0.9
+ 312010p -0.3
+ 314000p -0.3
+ 314010p 0.9
+ 316000p 0.9
+ 316010p -0.3
+ 318000p -0.3
+ 318010p 0.9
+ 320000p 0.9
+ 320010p -0.3
+ 322000p -0.3
+ 322010p 0.9
+ 324000p 0.9
+ 324010p -0.3
+ 326000p -0.3
+ 326010p 0.9
+ 328000p 0.9
+ 328010p -0.3
+ 330000p -0.3
+ 330010p 0.9
+ 332000p 0.9
+ 332010p -0.3
+ 334000p -0.3
+ 334010p 0.9
+ 336000p 0.9
+ 336010p -0.3
+ 338000p -0.3
+ 338010p 0.9
+ 340000p 0.9
+ 340010p -0.3
+ 342000p -0.3
+ 342010p 0.9
+ 344000p 0.9
+ 344010p -0.3
+ 346000p -0.3
+ 346010p 0.9
+ 348000p 0.9
+ 348010p -0.3
+ 350000p -0.3
+ 350010p 0.9
+ 352000p 0.9
+ 352010p -0.3
+ 354000p -0.3
+ 354010p 0.9
+ 356000p 0.9
+ 356010p -0.3
+ 358000p -0.3
+ 358010p 0.9
+ 360000p 0.9
+ 360010p -0.3
+ 362000p -0.3
+ 362010p 0.9
+ 364000p 0.9
+ 364010p -0.3
+ 366000p -0.3
+ 366010p 0.9
+ 368000p 0.9
+ 368010p -0.3
+ 370000p -0.3
+ 370010p 0.9
+ 372000p 0.9
+ 372010p -0.3
+ 374000p -0.3
+ 374010p 0.9
+ 376000p 0.9
+ 376010p -0.3
+ 378000p -0.3
+ 378010p 0.9
+ 380000p 0.9
+ 380010p -0.3
+ 382000p -0.3
+ 382010p 0.9
+ 384000p 0.9
+ 384010p -0.3
+ 386000p -0.3
+ 386010p 0.9
+ 388000p 0.9
+ 388010p -0.3
+ 390000p -0.3
+ 390010p 0.9
+ 392000p 0.9
+ 392010p -0.3
+ 394000p -0.3
+ 394010p 0.9
+ 396000p 0.9
+ 396010p -0.3
+ 398000p -0.3
+ 398010p 0.9
+ 400000p 0.9
+ 400010p -0.3
+ 402000p -0.3
+ 402010p 0.9
+ 404000p 0.9
+ 404010p -0.3
+ 406000p -0.3
+ 406010p 0.9
+ 408000p 0.9
+ 408010p -0.3
+ 410000p -0.3
+ 410010p 0.9
+ 412000p 0.9
+ 412010p -0.3
+ 414000p -0.3
+ 414010p 0.9
+ 416000p 0.9
+ 416010p -0.3
+ 418000p -0.3
+ 418010p 0.9
+ 420000p 0.9
+ 420010p -0.3
+ 422000p -0.3
+ 422010p 0.9
+ 424000p 0.9
+ 424010p -0.3
+ 426000p -0.3
+ 426010p 0.9
+ 428000p 0.9
+ 428010p -0.3
+ 430000p -0.3
+ 430010p 0.9
+ 432000p 0.9
+ 432010p -0.3
+ 434000p -0.3
+ 434010p 0.9
+ 436000p 0.9
+ 436010p -0.3
+ 438000p -0.3
+ 438010p 0.9
+ 440000p 0.9
+ 440010p -0.3
+ 442000p -0.3
+ 442010p 0.9
+ 444000p 0.9
+ 444010p -0.3
+ 446000p -0.3
+ 446010p 0.9
+ 448000p 0.9
+ 448010p -0.3
+ 450000p -0.3
+ 450010p 0.9
+ 452000p 0.9
+ 452010p -0.3
+ 454000p -0.3
+ 454010p 0.9
+ 456000p 0.9
+ 456010p -0.3
+ 458000p -0.3
+ 458010p 0.9
+ 460000p 0.9
+ 460010p -0.3
+ 462000p -0.3
+ 462010p 0.9
+ 464000p 0.9
+ 464010p -0.3
+ 466000p -0.3
+ 466010p 0.9
+ 468000p 0.9
+ 468010p -0.3
+ 470000p -0.3
+ 470010p 0.9
+ 472000p 0.9
+ 472010p -0.3
+ 474000p -0.3
+ 474010p 0.9
+ 476000p 0.9
+ 476010p -0.3
+ 478000p -0.3
+ 478010p 0.9
+ 480000p 0.9
+ 480010p -0.3
+ 482000p -0.3
+ 482010p 0.9
+ 484000p 0.9
+ 484010p -0.3
+ 486000p -0.3
+ 486010p 0.9
+ 488000p 0.9
+ 488010p -0.3
+ 490000p -0.3
+ 490010p 0.9
+ 492000p 0.9
+ 492010p -0.3
+ 494000p -0.3
+ 494010p 0.9
+ 496000p 0.9
+ 496010p -0.3
+ 498000p -0.3
+ 498010p 0.9
+ 500000p 0.9
+ 500010p -0.3
+ 502000p -0.3
+ 502010p 0.9
+ 504000p 0.9
+ 504010p -0.3
+ 506000p -0.3
+ 506010p 0.9
+ 508000p 0.9
+ 508010p -0.3
+ 510000p -0.3
+ 510010p 0.9
+ 512000p 0.9
+ 512010p -0.3
+ 514000p -0.3
+ 514010p 0.9
+ 516000p 0.9
+ 516010p -0.3
+ 518000p -0.3
+ 518010p 0.9
+ 520000p 0.9
+ 520010p -0.3
+ 522000p -0.3
+ 522010p 0.9
+ 524000p 0.9
+ 524010p -0.3
+ 526000p -0.3
+ 526010p 0.9
+ 528000p 0.9
+ 528010p -0.3
+ 530000p -0.3
+ 530010p 0.9
+ 532000p 0.9
+ 532010p -0.3
+ 534000p -0.3
+ 534010p 0.9
+ 536000p 0.9
+ 536010p -0.3
+ 538000p -0.3
+ 538010p 0.9
+ 540000p 0.9
+ 540010p -0.3
+ 542000p -0.3
+ 542010p 0.9
+ 544000p 0.9
+ 544010p -0.3
+ 546000p -0.3
+ 546010p 0.9
+ 548000p 0.9
+ 548010p -0.3
+ 550000p -0.3
+ 550010p 0.9
+ 552000p 0.9
+ 552010p -0.3
+ 554000p -0.3
+ 554010p 0.9
+ 556000p 0.9
+ 556010p -0.3
+ 558000p -0.3
+ 558010p 0.9
+ 560000p 0.9
+ 560010p -0.3
+ 562000p -0.3
+ 562010p 0.9
+ 564000p 0.9
+ 564010p -0.3
+ 566000p -0.3
+ 566010p 0.9
+ 568000p 0.9
+ 568010p -0.3
+ 570000p -0.3
+ 570010p 0.9
+ 572000p 0.9
+ 572010p -0.3
+ 574000p -0.3
+ 574010p 0.9
+ 576000p 0.9
+ 576010p -0.3
+ 578000p -0.3
+ 578010p 0.9
+ 580000p 0.9
+ 580010p -0.3
+ 582000p -0.3
+ 582010p 0.9
+ 584000p 0.9
+ 584010p -0.3
+ 586000p -0.3
+ 586010p 0.9
+ 588000p 0.9
+ 588010p -0.3
+ 590000p -0.3
+ 590010p 0.9
+ 592000p 0.9
+ 592010p -0.3
+ 594000p -0.3
+ 594010p 0.9
+ 596000p 0.9
+ 596010p -0.3
+ 598000p -0.3
+ 598010p 0.9
+ 600000p 0.9
+ 600010p -0.3
+ 602000p -0.3
+ 602010p 0.9
+ 604000p 0.9
+ 604010p -0.3
+ 606000p -0.3
+ 606010p 0.9
+ 608000p 0.9
+ 608010p -0.3
+ 610000p -0.3
+ 610010p 0.9
+ 612000p 0.9
+ 612010p -0.3
+ 614000p -0.3
+ 614010p 0.9
+ 616000p 0.9
+ 616010p -0.3
+ 618000p -0.3
+ 618010p 0.9
+ 620000p 0.9
+ 620010p -0.3
+ 622000p -0.3
+ 622010p 0.9
+ 624000p 0.9
+ 624010p -0.3
+ 626000p -0.3
+ 626010p 0.9
+ 628000p 0.9
+ 628010p -0.3
+ 630000p -0.3
+ 630010p 0.9
+ 632000p 0.9
+ 632010p -0.3
+ 634000p -0.3
+ 634010p 0.9
+ 636000p 0.9
+ 636010p -0.3
+ 638000p -0.3
+ 638010p 0.9
+ 640000p 0.9
+ 640010p -0.3
+ 642000p -0.3
+ 642010p 0.9
+ 644000p 0.9
+ 644010p -0.3
+ 646000p -0.3
+ 646010p 0.9
+ 648000p 0.9
+ 648010p -0.3
+ 650000p -0.3
+ 650010p 0.9
+ 652000p 0.9
+ 652010p -0.3
+ 654000p -0.3
+ 654010p 0.9
+ 656000p 0.9
+ 656010p -0.3
+ 658000p -0.3
+ 658010p 0.9
+ 660000p 0.9
+ 660010p -0.3
+ 662000p -0.3
+ 662010p 0.9
+ 664000p 0.9
+ 664010p -0.3
+ 666000p -0.3
+ 666010p 0.9
+ 668000p 0.9
+ 668010p -0.3
+ 670000p -0.3
+ 670010p 0.9
+ 672000p 0.9
+ 672010p -0.3
+ 674000p -0.3
+ 674010p 0.9
+ 676000p 0.9
+ 676010p -0.3
+ 678000p -0.3
+ 678010p 0.9
+ 680000p 0.9
+ 680010p -0.3
+ 682000p -0.3
+ 682010p 0.9
+ 684000p 0.9
+ 684010p -0.3
+ 686000p -0.3
+ 686010p 0.9
+ 688000p 0.9
+ 688010p -0.3
+ 690000p -0.3
+ 690010p 0.9
+ 692000p 0.9
+ 692010p -0.3
+ 694000p -0.3
+ 694010p 0.9
+ 696000p 0.9
+ 696010p -0.3
+ 698000p -0.3
+ 698010p 0.9
+ 700000p 0.9
+ 700010p -0.3
+ 702000p -0.3
+ 702010p 0.9
+ 704000p 0.9
+ 704010p -0.3
+ 706000p -0.3
+ 706010p 0.9
+ 708000p 0.9
+ 708010p -0.3
+ 710000p -0.3
+ 710010p 0.9
+ 712000p 0.9
+ 712010p -0.3
+ 714000p -0.3
+ 714010p 0.9
+ 716000p 0.9
+ 716010p -0.3
+ 718000p -0.3
+ 718010p 0.9
+ 720000p 0.9
+ 720010p -0.3
+ 722000p -0.3
+ 722010p 0.9
+ 724000p 0.9
+ 724010p -0.3
+ 726000p -0.3
+ 726010p 0.9
+ 728000p 0.9
+ 728010p -0.3
+ 730000p -0.3
+ 730010p 0.9
+ 732000p 0.9
+ 732010p -0.3
+ 734000p -0.3
+ 734010p 0.9
+ 736000p 0.9
+ 736010p -0.3
+ 738000p -0.3
+ 738010p 0.9
+ 740000p 0.9
+ 740010p -0.3
+ 742000p -0.3
+ 742010p 0.9
+ 744000p 0.9
+ 744010p -0.3
+ 746000p -0.3
+ 746010p 0.9
+ 748000p 0.9
+ 748010p -0.3
+ 750000p -0.3
+ 750010p 0.9
+ 752000p 0.9
+ 752010p -0.3
+ 754000p -0.3
+ 754010p 0.9
+ 756000p 0.9
+ 756010p -0.3
+ 758000p -0.3
+ 758010p 0.9
+ 760000p 0.9
+ 760010p -0.3
+ 762000p -0.3
+ 762010p 0.9
+ 764000p 0.9
+ 764010p -0.3
+ 766000p -0.3
+ 766010p 0.9
+ 768000p 0.9
+ 768010p -0.3
+ 770000p -0.3
+ 770010p 0.9
+ 772000p 0.9
+ 772010p -0.3
+ 774000p -0.3
+ 774010p 0.9
+ 776000p 0.9
+ 776010p -0.3
+ 778000p -0.3
+ 778010p 0.9
+ 780000p 0.9
+ 780010p -0.3
+ 782000p -0.3
+ 782010p 0.9
+ 784000p 0.9
+ 784010p -0.3
+ 786000p -0.3
+ 786010p 0.9
+ 788000p 0.9
+ 788010p -0.3
+ 790000p -0.3
+ 790010p 0.9
+ 792000p 0.9
+ 792010p -0.3
+ 794000p -0.3
+ 794010p 0.9
+ 796000p 0.9
+ 796010p -0.3
+ 798000p -0.3
+ 798010p 0.9
+ 800000p 0.9
+ 800010p -0.3
+ 802000p -0.3
+ 802010p 0.9
+ 804000p 0.9
+ 804010p -0.3
+ 806000p -0.3
+ 806010p 0.9
+ 808000p 0.9
+ 808010p -0.3
+ 810000p -0.3
+ 810010p 0.9
+ 812000p 0.9
+ 812010p -0.3
+ 814000p -0.3
+ 814010p 0.9
+ 816000p 0.9
+ 816010p -0.3
+ 818000p -0.3
+ 818010p 0.9
+ 820000p 0.9
+ 820010p -0.3
+ 822000p -0.3
+ 822010p 0.9
+ 824000p 0.9
+ 824010p -0.3
+ 826000p -0.3
+ 826010p 0.9
+ 828000p 0.9
+ 828010p -0.3
+ 830000p -0.3
+ 830010p 0.9
+ 832000p 0.9
+ 832010p -0.3
+ 834000p -0.3
+ 834010p 0.9
+ 836000p 0.9
+ 836010p -0.3
+ 838000p -0.3
+ 838010p 0.9
+ 840000p 0.9
+ 840010p -0.3
+ 842000p -0.3
+ 842010p 0.9
+ 844000p 0.9
+ 844010p -0.3
+ 846000p -0.3
+ 846010p 0.9
+ 848000p 0.9
+ 848010p -0.3
+ 850000p -0.3
+ 850010p 0.9
+ 852000p 0.9
+ 852010p -0.3
+ 854000p -0.3
+ 854010p 0.9
+ 856000p 0.9
+ 856010p -0.3
+ 858000p -0.3
+ 858010p 0.9
+ 860000p 0.9
+ 860010p -0.3
+ 862000p -0.3
+ 862010p 0.9
+ 864000p 0.9
+ 864010p -0.3
+ 866000p -0.3
+ 866010p 0.9
+ 868000p 0.9
+ 868010p -0.3
+ 870000p -0.3
+ 870010p 0.9
+ 872000p 0.9
+ 872010p -0.3
+ 874000p -0.3
+ 874010p 0.9
+ 876000p 0.9
+ 876010p -0.3
+ 878000p -0.3
+ 878010p 0.9
+ 880000p 0.9
+ 880010p -0.3
+ 882000p -0.3
+ 882010p 0.9
+ 884000p 0.9
+ 884010p -0.3
+ 886000p -0.3
+ 886010p 0.9
+ 888000p 0.9
+ 888010p -0.3
+ 890000p -0.3
+ 890010p 0.9
+ 892000p 0.9
+ 892010p -0.3
+ 894000p -0.3
+ 894010p 0.9
+ 896000p 0.9
+ 896010p -0.3
+ 898000p -0.3
+ 898010p 0.9
+ 900000p 0.9
+ 900010p -0.3
+ 902000p -0.3
+ 902010p 0.9
+ 904000p 0.9
+ 904010p -0.3
+ 906000p -0.3
+ 906010p 0.9
+ 908000p 0.9
+ 908010p -0.3
+ 910000p -0.3
+ 910010p 0.9
+ 912000p 0.9
+ 912010p -0.3
+ 914000p -0.3
+ 914010p 0.9
+ 916000p 0.9
+ 916010p -0.3
+ 918000p -0.3
+ 918010p 0.9
+ 920000p 0.9
+ 920010p -0.3
+ 922000p -0.3
+ 922010p 0.9
+ 924000p 0.9
+ 924010p -0.3
+ 926000p -0.3
+ 926010p 0.9
+ 928000p 0.9
+ 928010p -0.3
+ 930000p -0.3
+ 930010p 0.9
+ 932000p 0.9
+ 932010p -0.3
+ 934000p -0.3
+ 934010p 0.9
+ 936000p 0.9
+ 936010p -0.3
+ 938000p -0.3
+ 938010p 0.9
+ 940000p 0.9
+ 940010p -0.3
+ 942000p -0.3
+ 942010p 0.9
+ 944000p 0.9
+ 944010p -0.3
+ 946000p -0.3
+ 946010p 0.9
+ 948000p 0.9
+ 948010p -0.3
+ 950000p -0.3
+ 950010p 0.9
+ 952000p 0.9
+ 952010p -0.3
+ 954000p -0.3
+ 954010p 0.9
+ 956000p 0.9
+ 956010p -0.3
+ 958000p -0.3
+ 958010p 0.9
+ 960000p 0.9
+ 960010p -0.3
+ 962000p -0.3
+ 962010p 0.9
+ 964000p 0.9
+ 964010p -0.3
+ 966000p -0.3
+ 966010p 0.9
+ 968000p 0.9
+ 968010p -0.3
+ 970000p -0.3
+ 970010p 0.9
+ 972000p 0.9
+ 972010p -0.3
+ 974000p -0.3
+ 974010p 0.9
+ 976000p 0.9
+ 976010p -0.3
+ 978000p -0.3
+ 978010p 0.9
+ 980000p 0.9
+ 980010p -0.3
+ 982000p -0.3
+ 982010p 0.9
+ 984000p 0.9
+ 984010p -0.3
+ 986000p -0.3
+ 986010p 0.9
+ 988000p 0.9
+ 988010p -0.3
+ 990000p -0.3
+ 990010p 0.9
+ 992000p 0.9
+ 992010p -0.3
+ 994000p -0.3
+ 994010p 0.9
+ 996000p 0.9
+ 996010p -0.3
+ 998000p -0.3
+ 998010p 0.9
+ 1000000p 0.9
+ 1000010p -0.3
+ 1002000p -0.3
+ 1002010p 0.9
+ 1004000p 0.9
+ 1004010p -0.3
+ 1006000p -0.3
+ 1006010p 0.9
+ 1008000p 0.9
+ 1008010p -0.3
+ 1010000p -0.3
+ 1010010p 0.9
+ 1012000p 0.9
+ 1012010p -0.3
+ 1014000p -0.3
+ 1014010p 0.9
+ 1016000p 0.9
+ 1016010p -0.3
+ 1018000p -0.3
+ 1018010p 0.9
+ 1020000p 0.9
+ 1020010p -0.3
+ 1022000p -0.3
+ 1022010p 0.9
+ 1024000p 0.9
+ 1024010p -0.3
+ 1026000p -0.3
+ 1026010p 0.9
+ 1028000p 0.9
+ 1028010p -0.3
+ 1030000p -0.3
+ 1030010p 0.9
+ 1032000p 0.9
+ 1032010p -0.3
+ 1034000p -0.3
+ 1034010p 0.9
+ 1036000p 0.9
+ 1036010p -0.3
+ 1038000p -0.3
+ 1038010p 0.9
+ 1040000p 0.9
+ 1040010p -0.3
+ 1042000p -0.3
+ 1042010p 0.9
+ 1044000p 0.9
+ 1044010p -0.3
+ 1046000p -0.3
+ 1046010p 0.9
+ 1048000p 0.9
+ 1048010p -0.3
+ 1050000p -0.3
+ 1050010p 0.9
+ 1052000p 0.9
+ 1052010p -0.3
+ 1054000p -0.3
+ 1054010p 0.9
+ 1056000p 0.9
+ 1056010p -0.3
+ 1058000p -0.3
+ 1058010p 0.9
+ 1060000p 0.9
+ 1060010p -0.3
+ 1062000p -0.3
+ 1062010p 0.9
+ 1064000p 0.9
+ 1064010p -0.3
+ 1066000p -0.3
+ 1066010p 0.9
+ 1068000p 0.9
+ 1068010p -0.3
+ 1070000p -0.3
+ 1070010p 0.9
+ 1072000p 0.9
+ 1072010p -0.3
+ 1074000p -0.3
+ 1074010p 0.9
+ 1076000p 0.9
+ 1076010p -0.3
+ 1078000p -0.3
+ 1078010p 0.9
+ 1080000p 0.9
+ 1080010p -0.3
+ 1082000p -0.3
+ 1082010p 0.9
+ 1084000p 0.9
+ 1084010p -0.3
+ 1086000p -0.3
+ 1086010p 0.9
+ 1088000p 0.9
+ 1088010p -0.3
+ 1090000p -0.3
+ 1090010p 0.9
+ 1092000p 0.9
+ 1092010p -0.3
+ 1094000p -0.3
+ 1094010p 0.9
+ 1096000p 0.9
+ 1096010p -0.3
+ 1098000p -0.3
+ 1098010p 0.9
+ 1100000p 0.9
+ 1100010p -0.3
+ 1102000p -0.3
+ 1102010p 0.9
+ 1104000p 0.9
+ 1104010p -0.3
+ 1106000p -0.3
+ 1106010p 0.9
+ 1108000p 0.9
+ 1108010p -0.3
+ 1110000p -0.3
+ 1110010p 0.9
+ 1112000p 0.9
+ 1112010p -0.3
+ 1114000p -0.3
+ 1114010p 0.9
+ 1116000p 0.9
+ 1116010p -0.3
+ 1118000p -0.3
+ 1118010p 0.9
+ 1120000p 0.9
+ 1120010p -0.3
+ 1122000p -0.3
+ 1122010p 0.9
+ 1124000p 0.9
+ 1124010p -0.3
+ 1126000p -0.3
+ 1126010p 0.9
+ 1128000p 0.9
+ 1128010p -0.3
+ 1130000p -0.3
+ 1130010p 0.9
+ 1132000p 0.9
+ 1132010p -0.3
+ 1134000p -0.3
+ 1134010p 0.9
+ 1136000p 0.9
+ 1136010p -0.3
+ 1138000p -0.3
+ 1138010p 0.9
+ 1140000p 0.9
+ 1140010p -0.3
+ 1142000p -0.3
+ 1142010p 0.9
+ 1144000p 0.9
+ 1144010p -0.3
+ 1146000p -0.3
+ 1146010p 0.9
+ 1148000p 0.9
+ 1148010p -0.3
+ 1150000p -0.3
+ 1150010p 0.9
+ 1152000p 0.9
+ 1152010p -0.3
+ 1154000p -0.3
+ 1154010p 0.9
+ 1156000p 0.9
+ 1156010p -0.3
+ 1158000p -0.3
+ 1158010p 0.9
+ 1160000p 0.9
+ 1160010p -0.3
+ 1162000p -0.3
+ 1162010p 0.9
+ 1164000p 0.9
+ 1164010p -0.3
+ 1166000p -0.3
+ 1166010p 0.9
+ 1168000p 0.9
+ 1168010p -0.3
+ 1170000p -0.3
+ 1170010p 0.9
+ 1172000p 0.9
+ 1172010p -0.3
+ 1174000p -0.3
+ 1174010p 0.9
+ 1176000p 0.9
+ 1176010p -0.3
+ 1178000p -0.3
+ 1178010p 0.9
+ 1180000p 0.9
+ 1180010p -0.3
+ 1182000p -0.3
+ 1182010p 0.9
+ 1184000p 0.9
+ 1184010p -0.3
+ 1186000p -0.3
+ 1186010p 0.9
+ 1188000p 0.9
+ 1188010p -0.3
+ 1190000p -0.3
+ 1190010p 0.9
+ 1192000p 0.9
+ 1192010p -0.3
+ 1194000p -0.3
+ 1194010p 0.9
+ 1196000p 0.9
+ 1196010p -0.3
+ 1198000p -0.3
+ 1198010p 0.9
+ 1200000p 0.9
+ 1200010p -0.3
+ 1202000p -0.3
+ 1202010p 0.9
+ 1204000p 0.9
+ 1204010p -0.3
+ 1206000p -0.3
+ 1206010p 0.9
+ 1208000p 0.9
+ 1208010p -0.3
+ 1210000p -0.3
+ 1210010p 0.9
+ 1212000p 0.9
+ 1212010p -0.3
+ 1214000p -0.3
+ 1214010p 0.9
+ 1216000p 0.9
+ 1216010p -0.3
+ 1218000p -0.3
+ 1218010p 0.9
+ 1220000p 0.9
+ 1220010p -0.3
+ 1222000p -0.3
+ 1222010p 0.9
+ 1224000p 0.9
+ 1224010p -0.3
+ 1226000p -0.3
+ 1226010p 0.9
+ 1228000p 0.9
+ 1228010p -0.3
+ 1230000p -0.3
+ 1230010p 0.9
+ 1232000p 0.9
+ 1232010p -0.3
+ 1234000p -0.3
+ 1234010p 0.9
+ 1236000p 0.9
+ 1236010p -0.3
+ 1238000p -0.3
+ 1238010p 0.9
+ 1240000p 0.9
+ 1240010p -0.3
+ 1242000p -0.3
+ 1242010p 0.9
+ 1244000p 0.9
+ 1244010p -0.3
+ 1246000p -0.3
+ 1246010p 0.9
+ 1248000p 0.9
+ 1248010p -0.3
+ 1250000p -0.3
+ 1250010p 0.9
+ 1252000p 0.9
+ 1252010p -0.3
+ 1254000p -0.3
+ 1254010p 0.9
+ 1256000p 0.9
+ 1256010p -0.3
+ 1258000p -0.3
+ 1258010p 0.9
+ 1260000p 0.9
+ 1260010p -0.3
+ 1262000p -0.3
+ 1262010p 0.9
+ 1264000p 0.9
+ 1264010p -0.3
+ 1266000p -0.3
+ 1266010p 0.9
+ 1268000p 0.9
+ 1268010p -0.3
+ 1270000p -0.3
+ 1270010p 0.9
+ 1272000p 0.9
+ 1272010p -0.3
+ 1274000p -0.3
+ 1274010p 0.9
+ 1276000p 0.9
+ 1276010p -0.3
+ 1278000p -0.3
+ 1278010p 0.9
+ 1280000p 0.9
+ 1280010p -0.3
+ 1282000p -0.3
+ 1282010p 0.9
+ 1284000p 0.9
+ 1284010p -0.3
+ 1286000p -0.3
+ 1286010p 0.9
+ 1288000p 0.9
+ 1288010p -0.3
+ 1290000p -0.3
+ 1290010p 0.9
+ 1292000p 0.9
+ 1292010p -0.3
+ 1294000p -0.3
+ 1294010p 0.9
+ 1296000p 0.9
+ 1296010p -0.3
+ 1298000p -0.3
+ 1298010p 0.9
+ 1300000p 0.9
+ 1300010p -0.3
+ 1302000p -0.3
+ 1302010p 0.9
+ 1304000p 0.9
+ 1304010p -0.3
+ 1306000p -0.3
+ 1306010p 0.9
+ 1308000p 0.9
+ 1308010p -0.3
+ 1310000p -0.3
+ 1310010p 0.9
+ 1312000p 0.9
+ 1312010p -0.3
+ 1314000p -0.3
+ 1314010p 0.9
+ 1316000p 0.9
+ 1316010p -0.3
+ 1318000p -0.3
+ 1318010p 0.9
+ 1320000p 0.9
+ 1320010p -0.3
+ 1322000p -0.3
+ 1322010p 0.9
+ 1324000p 0.9
+ 1324010p -0.3
+ 1326000p -0.3
+ 1326010p 0.9
+ 1328000p 0.9
+ 1328010p -0.3
+ 1330000p -0.3
+ 1330010p 0.9
+ 1332000p 0.9
+ 1332010p -0.3
+ 1334000p -0.3
+ 1334010p 0.9
+ 1336000p 0.9
+ 1336010p -0.3
+ 1338000p -0.3
+ 1338010p 0.9
+ 1340000p 0.9
+ 1340010p -0.3
+ 1342000p -0.3
+ 1342010p 0.9
+ 1344000p 0.9
+ 1344010p -0.3
+ 1346000p -0.3
+ 1346010p 0.9
+ 1348000p 0.9
+ 1348010p -0.3
+ 1350000p -0.3
+ 1350010p 0.9
+ 1352000p 0.9
+ 1352010p -0.3
+ 1354000p -0.3
+ 1354010p 0.9
+ 1356000p 0.9
+ 1356010p -0.3
+ 1358000p -0.3
+ 1358010p 0.9
+ 1360000p 0.9
+ 1360010p -0.3
+ 1362000p -0.3
+ 1362010p 0.9
+ 1364000p 0.9
+ 1364010p -0.3
+ 1366000p -0.3
+ 1366010p 0.9
+ 1368000p 0.9
+ 1368010p -0.3
+ 1370000p -0.3
+ 1370010p 0.9
+ 1372000p 0.9
+ 1372010p -0.3
+ 1374000p -0.3
+ 1374010p 0.9
+ 1376000p 0.9
+ 1376010p -0.3
+ 1378000p -0.3
+ 1378010p 0.9
+ 1380000p 0.9
+ 1380010p -0.3
+ 1382000p -0.3
+ 1382010p 0.9
+ 1384000p 0.9
+ 1384010p -0.3
+ 1386000p -0.3
+ 1386010p 0.9
+ 1388000p 0.9
+ 1388010p -0.3
+ 1390000p -0.3
+ 1390010p 0.9
+ 1392000p 0.9
+ 1392010p -0.3
+ 1394000p -0.3
+ 1394010p 0.9
+ 1396000p 0.9
+ 1396010p -0.3
+ 1398000p -0.3
+ 1398010p 0.9
+ 1400000p 0.9
+ 1400010p -0.3
+ 1402000p -0.3
+ 1402010p 0.9
+ 1404000p 0.9
+ 1404010p -0.3
+ 1406000p -0.3
+ 1406010p 0.9
+ 1408000p 0.9
+ 1408010p -0.3
+ 1410000p -0.3
+ 1410010p 0.9
+ 1412000p 0.9
+ 1412010p -0.3
+ 1414000p -0.3
+ 1414010p 0.9
+ 1416000p 0.9
+ 1416010p -0.3
+ 1418000p -0.3
+ 1418010p 0.9
+ 1420000p 0.9
+ 1420010p -0.3
+ 1422000p -0.3
+ 1422010p 0.9
+ 1424000p 0.9
+ 1424010p -0.3
+ 1426000p -0.3
+ 1426010p 0.9
+ 1428000p 0.9
+ 1428010p -0.3
+ 1430000p -0.3
+ 1430010p 0.9
+ 1432000p 0.9
+ 1432010p -0.3
+ 1434000p -0.3
+ 1434010p 0.9
+ 1436000p 0.9
+ 1436010p -0.3
+ 1438000p -0.3
+ 1438010p 0.9
+ 1440000p 0.9
+ 1440010p -0.3
+ 1442000p -0.3
+ 1442010p 0.9
+ 1444000p 0.9
+ 1444010p -0.3
+ 1446000p -0.3
+ 1446010p 0.9
+ 1448000p 0.9
+ 1448010p -0.3
+ 1450000p -0.3
+ 1450010p 0.9
+ 1452000p 0.9
+ 1452010p -0.3
+ 1454000p -0.3
+ 1454010p 0.9
+ 1456000p 0.9
+ 1456010p -0.3
+ 1458000p -0.3
+ 1458010p 0.9
+ 1460000p 0.9
+ 1460010p -0.3
+ 1462000p -0.3
+ 1462010p 0.9
+ 1464000p 0.9
+ 1464010p -0.3
+ 1466000p -0.3
+ 1466010p 0.9
+ 1468000p 0.9
+ 1468010p -0.3
+ 1470000p -0.3
+ 1470010p 0.9
+ 1472000p 0.9
+ 1472010p -0.3
+ 1474000p -0.3
+ 1474010p 0.9
+ 1476000p 0.9
+ 1476010p -0.3
+ 1478000p -0.3
+ 1478010p 0.9
+ 1480000p 0.9
+ 1480010p -0.3
+ 1482000p -0.3
+ 1482010p 0.9
+ 1484000p 0.9
+ 1484010p -0.3
+ 1486000p -0.3
+ 1486010p 0.9
+ 1488000p 0.9
+ 1488010p -0.3
+ 1490000p -0.3
+ 1490010p 0.9
+ 1492000p 0.9
+ 1492010p -0.3
+ 1494000p -0.3
+ 1494010p 0.9
+ 1496000p 0.9
+ 1496010p -0.3
+ 1498000p -0.3
+ 1498010p 0.9
+ 1500000p 0.9
+ 1500010p -0.3
+ 1502000p -0.3
+ 1502010p 0.9
+ 1504000p 0.9
+ 1504010p -0.3
+ 1506000p -0.3
+ 1506010p 0.9
+ 1508000p 0.9
+ 1508010p -0.3
+ 1510000p -0.3
+ 1510010p 0.9
+ 1512000p 0.9
+ 1512010p -0.3
+ 1514000p -0.3
+ 1514010p 0.9
+ 1516000p 0.9
+ 1516010p -0.3
+ 1518000p -0.3
+ 1518010p 0.9
+ 1520000p 0.9
+ 1520010p -0.3
+ 1522000p -0.3
+ 1522010p 0.9
+ 1524000p 0.9
+ 1524010p -0.3
+ 1526000p -0.3
+ 1526010p 0.9
+ 1528000p 0.9
+ 1528010p -0.3
+ 1530000p -0.3
+ 1530010p 0.9
+ 1532000p 0.9
+ 1532010p -0.3
+ 1534000p -0.3
+ 1534010p 0.9
+ 1536000p 0.9
+ 1536010p -0.3
+ 1538000p -0.3
+ 1538010p 0.9
+ 1540000p 0.9
+ 1540010p -0.3
+ 1542000p -0.3
+ 1542010p 0.9
+ 1544000p 0.9
+ 1544010p -0.3
+ 1546000p -0.3
+ 1546010p 0.9
+ 1548000p 0.9
+ 1548010p -0.3
+ 1550000p -0.3
+ 1550010p 0.9
+ 1552000p 0.9
+ 1552010p -0.3
+ 1554000p -0.3
+ 1554010p 0.9
+ 1556000p 0.9
+ 1556010p -0.3
+ 1558000p -0.3
+ 1558010p 0.9
+ 1560000p 0.9
+ 1560010p -0.3
+ 1562000p -0.3
+ 1562010p 0.9
+ 1564000p 0.9
+ 1564010p -0.3
+ 1566000p -0.3
+ 1566010p 0.9
+ 1568000p 0.9
+ 1568010p -0.3
+ 1570000p -0.3
+ 1570010p 0.9
+ 1572000p 0.9
+ 1572010p -0.3
+ 1574000p -0.3
+ 1574010p 0.9
+ 1576000p 0.9
+ 1576010p -0.3
+ 1578000p -0.3
+ 1578010p 0.9
+ 1580000p 0.9
+ 1580010p -0.3
+ 1582000p -0.3
+ 1582010p 0.9
+ 1584000p 0.9
+ 1584010p -0.3
+ 1586000p -0.3
+ 1586010p 0.9
+ 1588000p 0.9
+ 1588010p -0.3
+ 1590000p -0.3
+ 1590010p 0.9
+ 1592000p 0.9
+ 1592010p -0.3
+ 1594000p -0.3
+ 1594010p 0.9
+ 1596000p 0.9
+ 1596010p -0.3
+ 1598000p -0.3
+ 1598010p 0.9
+ 1600000p 0.9
+ 1600010p -0.3
+ 1602000p -0.3
+ 1602010p 0.9
+ 1604000p 0.9
+ 1604010p -0.3
+ 1606000p -0.3
+ 1606010p 0.9
+ 1608000p 0.9
+ 1608010p -0.3
+ 1610000p -0.3
+ 1610010p 0.9
+ 1612000p 0.9
+ 1612010p -0.3
+ 1614000p -0.3
+ 1614010p 0.9
+ 1616000p 0.9
+ 1616010p -0.3
+ 1618000p -0.3
+ 1618010p 0.9
+ 1620000p 0.9
+ 1620010p -0.3
+ 1622000p -0.3
+ 1622010p 0.9
+ 1624000p 0.9
+ 1624010p -0.3
+ 1626000p -0.3
+ 1626010p 0.9
+ 1628000p 0.9
+ 1628010p -0.3
+ 1630000p -0.3
+ 1630010p 0.9
+ 1632000p 0.9
+ 1632010p -0.3
+ 1634000p -0.3
+ 1634010p 0.9
+ 1636000p 0.9
+ 1636010p -0.3
+ 1638000p -0.3
+ 1638010p 0.9
+ 1640000p 0.9
+ 1640010p -0.3
+ 1642000p -0.3
+ 1642010p 0.9
+ 1644000p 0.9
+ 1644010p -0.3
+ 1646000p -0.3
+ 1646010p 0.9
+ 1648000p 0.9
+ 1648010p -0.3
+ 1650000p -0.3
+ 1650010p 0.9
+ 1652000p 0.9
+ 1652010p -0.3
+ 1654000p -0.3
+ 1654010p 0.9
+ 1656000p 0.9
+ 1656010p -0.3
+ 1658000p -0.3
+ 1658010p 0.9
+ 1660000p 0.9
+ 1660010p -0.3
+ 1662000p -0.3
+ 1662010p 0.9
+ 1664000p 0.9
+ 1664010p -0.3
+ 1666000p -0.3
+ 1666010p 0.9
+ 1668000p 0.9
+ 1668010p -0.3
+ 1670000p -0.3
+ 1670010p 0.9
+ 1672000p 0.9
+ 1672010p -0.3
+ 1674000p -0.3
+ 1674010p 0.9
+ 1676000p 0.9
+ 1676010p -0.3
+ 1678000p -0.3
+ 1678010p 0.9
+ 1680000p 0.9
+ 1680010p -0.3
+ 1682000p -0.3
+ 1682010p 0.9
+ 1684000p 0.9
+ 1684010p -0.3
+ 1686000p -0.3
+ 1686010p 0.9
+ 1688000p 0.9
+ 1688010p -0.3
+ 1690000p -0.3
+ 1690010p 0.9
+ 1692000p 0.9
+ 1692010p -0.3
+ 1694000p -0.3
+ 1694010p 0.9
+ 1696000p 0.9
+ 1696010p -0.3
+ 1698000p -0.3
+ 1698010p 0.9
+ 1700000p 0.9
+ 1700010p -0.3
+ 1702000p -0.3
+ 1702010p 0.9
+ 1704000p 0.9
+ 1704010p -0.3
+ 1706000p -0.3
+ 1706010p 0.9
+ 1708000p 0.9
+ 1708010p -0.3
+ 1710000p -0.3
+ 1710010p 0.9
+ 1712000p 0.9
+ 1712010p -0.3
+ 1714000p -0.3
+ 1714010p 0.9
+ 1716000p 0.9
+ 1716010p -0.3
+ 1718000p -0.3
+ 1718010p 0.9
+ 1720000p 0.9
+ 1720010p -0.3
+ 1722000p -0.3
+ 1722010p 0.9
+ 1724000p 0.9
+ 1724010p -0.3
+ 1726000p -0.3
+ 1726010p 0.9
+ 1728000p 0.9
+ 1728010p -0.3
+ 1730000p -0.3
+ 1730010p 0.9
+ 1732000p 0.9
+ 1732010p -0.3
+ 1734000p -0.3
+ 1734010p 0.9
+ 1736000p 0.9
+ 1736010p -0.3
+ 1738000p -0.3
+ 1738010p 0.9
+ 1740000p 0.9
+ 1740010p -0.3
+ 1742000p -0.3
+ 1742010p 0.9
+ 1744000p 0.9
+ 1744010p -0.3
+ 1746000p -0.3
+ 1746010p 0.9
+ 1748000p 0.9
+ 1748010p -0.3
+ 1750000p -0.3
+ 1750010p 0.9
+ 1752000p 0.9
+ 1752010p -0.3
+ 1754000p -0.3
+ 1754010p 0.9
+ 1756000p 0.9
+ 1756010p -0.3
+ 1758000p -0.3
+ 1758010p 0.9
+ 1760000p 0.9
+ 1760010p -0.3
+ 1762000p -0.3
+ 1762010p 0.9
+ 1764000p 0.9
+ 1764010p -0.3
+ 1766000p -0.3
+ 1766010p 0.9
+ 1768000p 0.9
+ 1768010p -0.3
+ 1770000p -0.3
+ 1770010p 0.9
+ 1772000p 0.9
+ 1772010p -0.3
+ 1774000p -0.3
+ 1774010p 0.9
+ 1776000p 0.9
+ 1776010p -0.3
+ 1778000p -0.3
+ 1778010p 0.9
+ 1780000p 0.9
+ 1780010p -0.3
+ 1782000p -0.3
+ 1782010p 0.9
+ 1784000p 0.9
+ 1784010p -0.3
+ 1786000p -0.3
+ 1786010p 0.9
+ 1788000p 0.9
+ 1788010p -0.3
+ 1790000p -0.3
+ 1790010p 0.9
+ 1792000p 0.9
+ 1792010p -0.3
+ 1794000p -0.3
+ 1794010p 0.9
+ 1796000p 0.9
+ 1796010p -0.3
+ 1798000p -0.3
+ 1798010p 0.9
+ 1800000p 0.9
+ 1800010p -0.3
+ 1802000p -0.3
+ 1802010p 0.9
+ 1804000p 0.9
+ 1804010p -0.3
+ 1806000p -0.3
+ 1806010p 0.9
+ 1808000p 0.9
+ 1808010p -0.3
+ 1810000p -0.3
+ 1810010p 0.9
+ 1812000p 0.9
+ 1812010p -0.3
+ 1814000p -0.3
+ 1814010p 0.9
+ 1816000p 0.9
+ 1816010p -0.3
+ 1818000p -0.3
+ 1818010p 0.9
+ 1820000p 0.9
+ 1820010p -0.3
+ 1822000p -0.3
+ 1822010p 0.9
+ 1824000p 0.9
+ 1824010p -0.3
+ 1826000p -0.3
+ 1826010p 0.9
+ 1828000p 0.9
+ 1828010p -0.3
+ 1830000p -0.3
+ 1830010p 0.9
+ 1832000p 0.9
+ 1832010p -0.3
+ 1834000p -0.3
+ 1834010p 0.9
+ 1836000p 0.9
+ 1836010p -0.3
+ 1838000p -0.3
+ 1838010p 0.9
+ 1840000p 0.9
+ 1840010p -0.3
+ 1842000p -0.3
+ 1842010p 0.9
+ 1844000p 0.9
+ 1844010p -0.3
+ 1846000p -0.3
+ 1846010p 0.9
+ 1848000p 0.9
+ 1848010p -0.3
+ 1850000p -0.3
+ 1850010p 0.9
+ 1852000p 0.9
+ 1852010p -0.3
+ 1854000p -0.3
+ 1854010p 0.9
+ 1856000p 0.9
+ 1856010p -0.3
+ 1858000p -0.3
+ 1858010p 0.9
+ 1860000p 0.9
+ 1860010p -0.3
+ 1862000p -0.3
+ 1862010p 0.9
+ 1864000p 0.9
+ 1864010p -0.3
+ 1866000p -0.3
+ 1866010p 0.9
+ 1868000p 0.9
+ 1868010p -0.3
+ 1870000p -0.3
+ 1870010p 0.9
+ 1872000p 0.9
+ 1872010p -0.3
+ 1874000p -0.3
+ 1874010p 0.9
+ 1876000p 0.9
+ 1876010p -0.3
+ 1878000p -0.3
+ 1878010p 0.9
+ 1880000p 0.9
+ 1880010p -0.3
+ 1882000p -0.3
+ 1882010p 0.9
+ 1884000p 0.9
+ 1884010p -0.3
+ 1886000p -0.3
+ 1886010p 0.9
+ 1888000p 0.9
+ 1888010p -0.3
+ 1890000p -0.3
+ 1890010p 0.9
+ 1892000p 0.9
+ 1892010p -0.3
+ 1894000p -0.3
+ 1894010p 0.9
+ 1896000p 0.9
+ 1896010p -0.3
+ 1898000p -0.3
+ 1898010p 0.9
+ 1900000p 0.9
+ 1900010p -0.3
+ 1902000p -0.3
+ 1902010p 0.9
+ 1904000p 0.9
+ 1904010p -0.3
+ 1906000p -0.3
+ 1906010p 0.9
+ 1908000p 0.9
+ 1908010p -0.3
+ 1910000p -0.3
+ 1910010p 0.9
+ 1912000p 0.9
+ 1912010p -0.3
+ 1914000p -0.3
+ 1914010p 0.9
+ 1916000p 0.9
+ 1916010p -0.3
+ 1918000p -0.3
+ 1918010p 0.9
+ 1920000p 0.9
+ 1920010p -0.3
+ 1922000p -0.3
+ 1922010p 0.9
+ 1924000p 0.9
+ 1924010p -0.3
+ 1926000p -0.3
+ 1926010p 0.9
+ 1928000p 0.9
+ 1928010p -0.3
+ 1930000p -0.3
+ 1930010p 0.9
+ 1932000p 0.9
+ 1932010p -0.3
+ 1934000p -0.3
+ 1934010p 0.9
+ 1936000p 0.9
+ 1936010p -0.3
+ 1938000p -0.3
+ 1938010p 0.9
+ 1940000p 0.9
+ 1940010p -0.3
+ 1942000p -0.3
+ 1942010p 0.9
+ 1944000p 0.9
+ 1944010p -0.3
+ 1946000p -0.3
+ 1946010p 0.9
+ 1948000p 0.9
+ 1948010p -0.3
+ 1950000p -0.3
+ 1950010p 0.9
+ 1952000p 0.9
+ 1952010p -0.3
+ 1954000p -0.3
+ 1954010p 0.9
+ 1956000p 0.9
+ 1956010p -0.3
+ 1958000p -0.3
+ 1958010p 0.9
+ 1960000p 0.9
+ 1960010p -0.3
+ 1962000p -0.3
+ 1962010p 0.9
+ 1964000p 0.9
+ 1964010p -0.3
+ 1966000p -0.3
+ 1966010p 0.9
+ 1968000p 0.9
+ 1968010p -0.3
+ 1970000p -0.3
+ 1970010p 0.9
+ 1972000p 0.9
+ 1972010p -0.3
+ 1974000p -0.3
+ 1974010p 0.9
+ 1976000p 0.9
+ 1976010p -0.3
+ 1978000p -0.3
+ 1978010p 0.9
+ 1980000p 0.9
+ 1980010p -0.3
+ 1982000p -0.3
+ 1982010p 0.9
+ 1984000p 0.9
+ 1984010p -0.3
+ 1986000p -0.3
+ 1986010p 0.9
+ 1988000p 0.9
+ 1988010p -0.3
+ 1990000p -0.3
+ 1990010p 0.9
+ 1992000p 0.9
+ 1992010p -0.3
+ 1994000p -0.3
+ 1994010p 0.9
+ 1996000p 0.9
+ 1996010p -0.3
+ 1998000p -0.3
+ 1998010p 0.9
+ 2000000p 0.9
+ 2000010p -0.3
+ 2002000p -0.3
+ 2002010p 0.9
+ 2004000p 0.9
+ 2004010p -0.3
+ 2006000p -0.3
+ 2006010p 0.9
+ 2008000p 0.9
+ 2008010p -0.3
+ 2010000p -0.3
+ 2010010p 0.9
+ 2012000p 0.9
+ 2012010p -0.3
+ 2014000p -0.3
+ 2014010p 0.9
+ 2016000p 0.9
+ 2016010p -0.3
+ 2018000p -0.3
+ 2018010p 0.9
+ 2020000p 0.9
+ 2020010p -0.3
+ 2022000p -0.3
+ 2022010p 0.9
+ 2024000p 0.9
+ 2024010p -0.3
+ 2026000p -0.3
+ 2026010p 0.9
+ 2028000p 0.9
+ 2028010p -0.3
+ 2030000p -0.3
+ 2030010p 0.9
+ 2032000p 0.9
+ 2032010p -0.3
+ 2034000p -0.3
+ 2034010p 0.9
+ 2036000p 0.9
+ 2036010p -0.3
+ 2038000p -0.3
+ 2038010p 0.9
+ 2040000p 0.9
+ 2040010p -0.3
+ 2042000p -0.3
+ 2042010p 0.9
+ 2044000p 0.9
+ 2044010p -0.3
+ 2046000p -0.3
+ 2046010p 0.9
+ 2048000p 0.9
+ 2048010p -0.3
+ \]
V_data_1 (Data\\<1\\> gnd!) vsource type=pwl wave=\[
+ 0    0.9
+ 2000p 0.9
+ 2010p -0.3
+ 4000p -0.3
+ 4010p 0.9
+ 6000p 0.9
+ 6010p -0.3
+ 8000p -0.3
+ 8010p 0.9
+ 10000p 0.9
+ 10010p -0.3
+ 12000p -0.3
+ 12010p 0.9
+ 14000p 0.9
+ 14010p -0.3
+ 16000p -0.3
+ 16010p 0.9
+ 18000p 0.9
+ 18010p -0.3
+ 20000p -0.3
+ 20010p 0.9
+ 22000p 0.9
+ 22010p -0.3
+ 24000p -0.3
+ 24010p 0.9
+ 26000p 0.9
+ 26010p -0.3
+ 28000p -0.3
+ 28010p 0.9
+ 30000p 0.9
+ 30010p -0.3
+ 32000p -0.3
+ 32010p 0.9
+ 34000p 0.9
+ 34010p -0.3
+ 36000p -0.3
+ 36010p 0.9
+ 38000p 0.9
+ 38010p -0.3
+ 40000p -0.3
+ 40010p 0.9
+ 42000p 0.9
+ 42010p -0.3
+ 44000p -0.3
+ 44010p 0.9
+ 46000p 0.9
+ 46010p -0.3
+ 48000p -0.3
+ 48010p 0.9
+ 50000p 0.9
+ 50010p -0.3
+ 52000p -0.3
+ 52010p 0.9
+ 54000p 0.9
+ 54010p -0.3
+ 56000p -0.3
+ 56010p 0.9
+ 58000p 0.9
+ 58010p -0.3
+ 60000p -0.3
+ 60010p 0.9
+ 62000p 0.9
+ 62010p -0.3
+ 64000p -0.3
+ 64010p 0.9
+ 66000p 0.9
+ 66010p -0.3
+ 68000p -0.3
+ 68010p 0.9
+ 70000p 0.9
+ 70010p -0.3
+ 72000p -0.3
+ 72010p 0.9
+ 74000p 0.9
+ 74010p -0.3
+ 76000p -0.3
+ 76010p 0.9
+ 78000p 0.9
+ 78010p -0.3
+ 80000p -0.3
+ 80010p 0.9
+ 82000p 0.9
+ 82010p -0.3
+ 84000p -0.3
+ 84010p 0.9
+ 86000p 0.9
+ 86010p -0.3
+ 88000p -0.3
+ 88010p 0.9
+ 90000p 0.9
+ 90010p -0.3
+ 92000p -0.3
+ 92010p 0.9
+ 94000p 0.9
+ 94010p -0.3
+ 96000p -0.3
+ 96010p 0.9
+ 98000p 0.9
+ 98010p -0.3
+ 100000p -0.3
+ 100010p 0.9
+ 102000p 0.9
+ 102010p -0.3
+ 104000p -0.3
+ 104010p 0.9
+ 106000p 0.9
+ 106010p -0.3
+ 108000p -0.3
+ 108010p 0.9
+ 110000p 0.9
+ 110010p -0.3
+ 112000p -0.3
+ 112010p 0.9
+ 114000p 0.9
+ 114010p -0.3
+ 116000p -0.3
+ 116010p 0.9
+ 118000p 0.9
+ 118010p -0.3
+ 120000p -0.3
+ 120010p 0.9
+ 122000p 0.9
+ 122010p -0.3
+ 124000p -0.3
+ 124010p 0.9
+ 126000p 0.9
+ 126010p -0.3
+ 128000p -0.3
+ 128010p 0.9
+ 130000p 0.9
+ 130010p -0.3
+ 132000p -0.3
+ 132010p 0.9
+ 134000p 0.9
+ 134010p -0.3
+ 136000p -0.3
+ 136010p 0.9
+ 138000p 0.9
+ 138010p -0.3
+ 140000p -0.3
+ 140010p 0.9
+ 142000p 0.9
+ 142010p -0.3
+ 144000p -0.3
+ 144010p 0.9
+ 146000p 0.9
+ 146010p -0.3
+ 148000p -0.3
+ 148010p 0.9
+ 150000p 0.9
+ 150010p -0.3
+ 152000p -0.3
+ 152010p 0.9
+ 154000p 0.9
+ 154010p -0.3
+ 156000p -0.3
+ 156010p 0.9
+ 158000p 0.9
+ 158010p -0.3
+ 160000p -0.3
+ 160010p 0.9
+ 162000p 0.9
+ 162010p -0.3
+ 164000p -0.3
+ 164010p 0.9
+ 166000p 0.9
+ 166010p -0.3
+ 168000p -0.3
+ 168010p 0.9
+ 170000p 0.9
+ 170010p -0.3
+ 172000p -0.3
+ 172010p 0.9
+ 174000p 0.9
+ 174010p -0.3
+ 176000p -0.3
+ 176010p 0.9
+ 178000p 0.9
+ 178010p -0.3
+ 180000p -0.3
+ 180010p 0.9
+ 182000p 0.9
+ 182010p -0.3
+ 184000p -0.3
+ 184010p 0.9
+ 186000p 0.9
+ 186010p -0.3
+ 188000p -0.3
+ 188010p 0.9
+ 190000p 0.9
+ 190010p -0.3
+ 192000p -0.3
+ 192010p 0.9
+ 194000p 0.9
+ 194010p -0.3
+ 196000p -0.3
+ 196010p 0.9
+ 198000p 0.9
+ 198010p -0.3
+ 200000p -0.3
+ 200010p 0.9
+ 202000p 0.9
+ 202010p -0.3
+ 204000p -0.3
+ 204010p 0.9
+ 206000p 0.9
+ 206010p -0.3
+ 208000p -0.3
+ 208010p 0.9
+ 210000p 0.9
+ 210010p -0.3
+ 212000p -0.3
+ 212010p 0.9
+ 214000p 0.9
+ 214010p -0.3
+ 216000p -0.3
+ 216010p 0.9
+ 218000p 0.9
+ 218010p -0.3
+ 220000p -0.3
+ 220010p 0.9
+ 222000p 0.9
+ 222010p -0.3
+ 224000p -0.3
+ 224010p 0.9
+ 226000p 0.9
+ 226010p -0.3
+ 228000p -0.3
+ 228010p 0.9
+ 230000p 0.9
+ 230010p -0.3
+ 232000p -0.3
+ 232010p 0.9
+ 234000p 0.9
+ 234010p -0.3
+ 236000p -0.3
+ 236010p 0.9
+ 238000p 0.9
+ 238010p -0.3
+ 240000p -0.3
+ 240010p 0.9
+ 242000p 0.9
+ 242010p -0.3
+ 244000p -0.3
+ 244010p 0.9
+ 246000p 0.9
+ 246010p -0.3
+ 248000p -0.3
+ 248010p 0.9
+ 250000p 0.9
+ 250010p -0.3
+ 252000p -0.3
+ 252010p 0.9
+ 254000p 0.9
+ 254010p -0.3
+ 256000p -0.3
+ 256010p 0.9
+ 258000p 0.9
+ 258010p -0.3
+ 260000p -0.3
+ 260010p 0.9
+ 262000p 0.9
+ 262010p -0.3
+ 264000p -0.3
+ 264010p 0.9
+ 266000p 0.9
+ 266010p -0.3
+ 268000p -0.3
+ 268010p 0.9
+ 270000p 0.9
+ 270010p -0.3
+ 272000p -0.3
+ 272010p 0.9
+ 274000p 0.9
+ 274010p -0.3
+ 276000p -0.3
+ 276010p 0.9
+ 278000p 0.9
+ 278010p -0.3
+ 280000p -0.3
+ 280010p 0.9
+ 282000p 0.9
+ 282010p -0.3
+ 284000p -0.3
+ 284010p 0.9
+ 286000p 0.9
+ 286010p -0.3
+ 288000p -0.3
+ 288010p 0.9
+ 290000p 0.9
+ 290010p -0.3
+ 292000p -0.3
+ 292010p 0.9
+ 294000p 0.9
+ 294010p -0.3
+ 296000p -0.3
+ 296010p 0.9
+ 298000p 0.9
+ 298010p -0.3
+ 300000p -0.3
+ 300010p 0.9
+ 302000p 0.9
+ 302010p -0.3
+ 304000p -0.3
+ 304010p 0.9
+ 306000p 0.9
+ 306010p -0.3
+ 308000p -0.3
+ 308010p 0.9
+ 310000p 0.9
+ 310010p -0.3
+ 312000p -0.3
+ 312010p 0.9
+ 314000p 0.9
+ 314010p -0.3
+ 316000p -0.3
+ 316010p 0.9
+ 318000p 0.9
+ 318010p -0.3
+ 320000p -0.3
+ 320010p 0.9
+ 322000p 0.9
+ 322010p -0.3
+ 324000p -0.3
+ 324010p 0.9
+ 326000p 0.9
+ 326010p -0.3
+ 328000p -0.3
+ 328010p 0.9
+ 330000p 0.9
+ 330010p -0.3
+ 332000p -0.3
+ 332010p 0.9
+ 334000p 0.9
+ 334010p -0.3
+ 336000p -0.3
+ 336010p 0.9
+ 338000p 0.9
+ 338010p -0.3
+ 340000p -0.3
+ 340010p 0.9
+ 342000p 0.9
+ 342010p -0.3
+ 344000p -0.3
+ 344010p 0.9
+ 346000p 0.9
+ 346010p -0.3
+ 348000p -0.3
+ 348010p 0.9
+ 350000p 0.9
+ 350010p -0.3
+ 352000p -0.3
+ 352010p 0.9
+ 354000p 0.9
+ 354010p -0.3
+ 356000p -0.3
+ 356010p 0.9
+ 358000p 0.9
+ 358010p -0.3
+ 360000p -0.3
+ 360010p 0.9
+ 362000p 0.9
+ 362010p -0.3
+ 364000p -0.3
+ 364010p 0.9
+ 366000p 0.9
+ 366010p -0.3
+ 368000p -0.3
+ 368010p 0.9
+ 370000p 0.9
+ 370010p -0.3
+ 372000p -0.3
+ 372010p 0.9
+ 374000p 0.9
+ 374010p -0.3
+ 376000p -0.3
+ 376010p 0.9
+ 378000p 0.9
+ 378010p -0.3
+ 380000p -0.3
+ 380010p 0.9
+ 382000p 0.9
+ 382010p -0.3
+ 384000p -0.3
+ 384010p 0.9
+ 386000p 0.9
+ 386010p -0.3
+ 388000p -0.3
+ 388010p 0.9
+ 390000p 0.9
+ 390010p -0.3
+ 392000p -0.3
+ 392010p 0.9
+ 394000p 0.9
+ 394010p -0.3
+ 396000p -0.3
+ 396010p 0.9
+ 398000p 0.9
+ 398010p -0.3
+ 400000p -0.3
+ 400010p 0.9
+ 402000p 0.9
+ 402010p -0.3
+ 404000p -0.3
+ 404010p 0.9
+ 406000p 0.9
+ 406010p -0.3
+ 408000p -0.3
+ 408010p 0.9
+ 410000p 0.9
+ 410010p -0.3
+ 412000p -0.3
+ 412010p 0.9
+ 414000p 0.9
+ 414010p -0.3
+ 416000p -0.3
+ 416010p 0.9
+ 418000p 0.9
+ 418010p -0.3
+ 420000p -0.3
+ 420010p 0.9
+ 422000p 0.9
+ 422010p -0.3
+ 424000p -0.3
+ 424010p 0.9
+ 426000p 0.9
+ 426010p -0.3
+ 428000p -0.3
+ 428010p 0.9
+ 430000p 0.9
+ 430010p -0.3
+ 432000p -0.3
+ 432010p 0.9
+ 434000p 0.9
+ 434010p -0.3
+ 436000p -0.3
+ 436010p 0.9
+ 438000p 0.9
+ 438010p -0.3
+ 440000p -0.3
+ 440010p 0.9
+ 442000p 0.9
+ 442010p -0.3
+ 444000p -0.3
+ 444010p 0.9
+ 446000p 0.9
+ 446010p -0.3
+ 448000p -0.3
+ 448010p 0.9
+ 450000p 0.9
+ 450010p -0.3
+ 452000p -0.3
+ 452010p 0.9
+ 454000p 0.9
+ 454010p -0.3
+ 456000p -0.3
+ 456010p 0.9
+ 458000p 0.9
+ 458010p -0.3
+ 460000p -0.3
+ 460010p 0.9
+ 462000p 0.9
+ 462010p -0.3
+ 464000p -0.3
+ 464010p 0.9
+ 466000p 0.9
+ 466010p -0.3
+ 468000p -0.3
+ 468010p 0.9
+ 470000p 0.9
+ 470010p -0.3
+ 472000p -0.3
+ 472010p 0.9
+ 474000p 0.9
+ 474010p -0.3
+ 476000p -0.3
+ 476010p 0.9
+ 478000p 0.9
+ 478010p -0.3
+ 480000p -0.3
+ 480010p 0.9
+ 482000p 0.9
+ 482010p -0.3
+ 484000p -0.3
+ 484010p 0.9
+ 486000p 0.9
+ 486010p -0.3
+ 488000p -0.3
+ 488010p 0.9
+ 490000p 0.9
+ 490010p -0.3
+ 492000p -0.3
+ 492010p 0.9
+ 494000p 0.9
+ 494010p -0.3
+ 496000p -0.3
+ 496010p 0.9
+ 498000p 0.9
+ 498010p -0.3
+ 500000p -0.3
+ 500010p 0.9
+ 502000p 0.9
+ 502010p -0.3
+ 504000p -0.3
+ 504010p 0.9
+ 506000p 0.9
+ 506010p -0.3
+ 508000p -0.3
+ 508010p 0.9
+ 510000p 0.9
+ 510010p -0.3
+ 512000p -0.3
+ 512010p 0.9
+ 514000p 0.9
+ 514010p -0.3
+ 516000p -0.3
+ 516010p 0.9
+ 518000p 0.9
+ 518010p -0.3
+ 520000p -0.3
+ 520010p 0.9
+ 522000p 0.9
+ 522010p -0.3
+ 524000p -0.3
+ 524010p 0.9
+ 526000p 0.9
+ 526010p -0.3
+ 528000p -0.3
+ 528010p 0.9
+ 530000p 0.9
+ 530010p -0.3
+ 532000p -0.3
+ 532010p 0.9
+ 534000p 0.9
+ 534010p -0.3
+ 536000p -0.3
+ 536010p 0.9
+ 538000p 0.9
+ 538010p -0.3
+ 540000p -0.3
+ 540010p 0.9
+ 542000p 0.9
+ 542010p -0.3
+ 544000p -0.3
+ 544010p 0.9
+ 546000p 0.9
+ 546010p -0.3
+ 548000p -0.3
+ 548010p 0.9
+ 550000p 0.9
+ 550010p -0.3
+ 552000p -0.3
+ 552010p 0.9
+ 554000p 0.9
+ 554010p -0.3
+ 556000p -0.3
+ 556010p 0.9
+ 558000p 0.9
+ 558010p -0.3
+ 560000p -0.3
+ 560010p 0.9
+ 562000p 0.9
+ 562010p -0.3
+ 564000p -0.3
+ 564010p 0.9
+ 566000p 0.9
+ 566010p -0.3
+ 568000p -0.3
+ 568010p 0.9
+ 570000p 0.9
+ 570010p -0.3
+ 572000p -0.3
+ 572010p 0.9
+ 574000p 0.9
+ 574010p -0.3
+ 576000p -0.3
+ 576010p 0.9
+ 578000p 0.9
+ 578010p -0.3
+ 580000p -0.3
+ 580010p 0.9
+ 582000p 0.9
+ 582010p -0.3
+ 584000p -0.3
+ 584010p 0.9
+ 586000p 0.9
+ 586010p -0.3
+ 588000p -0.3
+ 588010p 0.9
+ 590000p 0.9
+ 590010p -0.3
+ 592000p -0.3
+ 592010p 0.9
+ 594000p 0.9
+ 594010p -0.3
+ 596000p -0.3
+ 596010p 0.9
+ 598000p 0.9
+ 598010p -0.3
+ 600000p -0.3
+ 600010p 0.9
+ 602000p 0.9
+ 602010p -0.3
+ 604000p -0.3
+ 604010p 0.9
+ 606000p 0.9
+ 606010p -0.3
+ 608000p -0.3
+ 608010p 0.9
+ 610000p 0.9
+ 610010p -0.3
+ 612000p -0.3
+ 612010p 0.9
+ 614000p 0.9
+ 614010p -0.3
+ 616000p -0.3
+ 616010p 0.9
+ 618000p 0.9
+ 618010p -0.3
+ 620000p -0.3
+ 620010p 0.9
+ 622000p 0.9
+ 622010p -0.3
+ 624000p -0.3
+ 624010p 0.9
+ 626000p 0.9
+ 626010p -0.3
+ 628000p -0.3
+ 628010p 0.9
+ 630000p 0.9
+ 630010p -0.3
+ 632000p -0.3
+ 632010p 0.9
+ 634000p 0.9
+ 634010p -0.3
+ 636000p -0.3
+ 636010p 0.9
+ 638000p 0.9
+ 638010p -0.3
+ 640000p -0.3
+ 640010p 0.9
+ 642000p 0.9
+ 642010p -0.3
+ 644000p -0.3
+ 644010p 0.9
+ 646000p 0.9
+ 646010p -0.3
+ 648000p -0.3
+ 648010p 0.9
+ 650000p 0.9
+ 650010p -0.3
+ 652000p -0.3
+ 652010p 0.9
+ 654000p 0.9
+ 654010p -0.3
+ 656000p -0.3
+ 656010p 0.9
+ 658000p 0.9
+ 658010p -0.3
+ 660000p -0.3
+ 660010p 0.9
+ 662000p 0.9
+ 662010p -0.3
+ 664000p -0.3
+ 664010p 0.9
+ 666000p 0.9
+ 666010p -0.3
+ 668000p -0.3
+ 668010p 0.9
+ 670000p 0.9
+ 670010p -0.3
+ 672000p -0.3
+ 672010p 0.9
+ 674000p 0.9
+ 674010p -0.3
+ 676000p -0.3
+ 676010p 0.9
+ 678000p 0.9
+ 678010p -0.3
+ 680000p -0.3
+ 680010p 0.9
+ 682000p 0.9
+ 682010p -0.3
+ 684000p -0.3
+ 684010p 0.9
+ 686000p 0.9
+ 686010p -0.3
+ 688000p -0.3
+ 688010p 0.9
+ 690000p 0.9
+ 690010p -0.3
+ 692000p -0.3
+ 692010p 0.9
+ 694000p 0.9
+ 694010p -0.3
+ 696000p -0.3
+ 696010p 0.9
+ 698000p 0.9
+ 698010p -0.3
+ 700000p -0.3
+ 700010p 0.9
+ 702000p 0.9
+ 702010p -0.3
+ 704000p -0.3
+ 704010p 0.9
+ 706000p 0.9
+ 706010p -0.3
+ 708000p -0.3
+ 708010p 0.9
+ 710000p 0.9
+ 710010p -0.3
+ 712000p -0.3
+ 712010p 0.9
+ 714000p 0.9
+ 714010p -0.3
+ 716000p -0.3
+ 716010p 0.9
+ 718000p 0.9
+ 718010p -0.3
+ 720000p -0.3
+ 720010p 0.9
+ 722000p 0.9
+ 722010p -0.3
+ 724000p -0.3
+ 724010p 0.9
+ 726000p 0.9
+ 726010p -0.3
+ 728000p -0.3
+ 728010p 0.9
+ 730000p 0.9
+ 730010p -0.3
+ 732000p -0.3
+ 732010p 0.9
+ 734000p 0.9
+ 734010p -0.3
+ 736000p -0.3
+ 736010p 0.9
+ 738000p 0.9
+ 738010p -0.3
+ 740000p -0.3
+ 740010p 0.9
+ 742000p 0.9
+ 742010p -0.3
+ 744000p -0.3
+ 744010p 0.9
+ 746000p 0.9
+ 746010p -0.3
+ 748000p -0.3
+ 748010p 0.9
+ 750000p 0.9
+ 750010p -0.3
+ 752000p -0.3
+ 752010p 0.9
+ 754000p 0.9
+ 754010p -0.3
+ 756000p -0.3
+ 756010p 0.9
+ 758000p 0.9
+ 758010p -0.3
+ 760000p -0.3
+ 760010p 0.9
+ 762000p 0.9
+ 762010p -0.3
+ 764000p -0.3
+ 764010p 0.9
+ 766000p 0.9
+ 766010p -0.3
+ 768000p -0.3
+ 768010p 0.9
+ 770000p 0.9
+ 770010p -0.3
+ 772000p -0.3
+ 772010p 0.9
+ 774000p 0.9
+ 774010p -0.3
+ 776000p -0.3
+ 776010p 0.9
+ 778000p 0.9
+ 778010p -0.3
+ 780000p -0.3
+ 780010p 0.9
+ 782000p 0.9
+ 782010p -0.3
+ 784000p -0.3
+ 784010p 0.9
+ 786000p 0.9
+ 786010p -0.3
+ 788000p -0.3
+ 788010p 0.9
+ 790000p 0.9
+ 790010p -0.3
+ 792000p -0.3
+ 792010p 0.9
+ 794000p 0.9
+ 794010p -0.3
+ 796000p -0.3
+ 796010p 0.9
+ 798000p 0.9
+ 798010p -0.3
+ 800000p -0.3
+ 800010p 0.9
+ 802000p 0.9
+ 802010p -0.3
+ 804000p -0.3
+ 804010p 0.9
+ 806000p 0.9
+ 806010p -0.3
+ 808000p -0.3
+ 808010p 0.9
+ 810000p 0.9
+ 810010p -0.3
+ 812000p -0.3
+ 812010p 0.9
+ 814000p 0.9
+ 814010p -0.3
+ 816000p -0.3
+ 816010p 0.9
+ 818000p 0.9
+ 818010p -0.3
+ 820000p -0.3
+ 820010p 0.9
+ 822000p 0.9
+ 822010p -0.3
+ 824000p -0.3
+ 824010p 0.9
+ 826000p 0.9
+ 826010p -0.3
+ 828000p -0.3
+ 828010p 0.9
+ 830000p 0.9
+ 830010p -0.3
+ 832000p -0.3
+ 832010p 0.9
+ 834000p 0.9
+ 834010p -0.3
+ 836000p -0.3
+ 836010p 0.9
+ 838000p 0.9
+ 838010p -0.3
+ 840000p -0.3
+ 840010p 0.9
+ 842000p 0.9
+ 842010p -0.3
+ 844000p -0.3
+ 844010p 0.9
+ 846000p 0.9
+ 846010p -0.3
+ 848000p -0.3
+ 848010p 0.9
+ 850000p 0.9
+ 850010p -0.3
+ 852000p -0.3
+ 852010p 0.9
+ 854000p 0.9
+ 854010p -0.3
+ 856000p -0.3
+ 856010p 0.9
+ 858000p 0.9
+ 858010p -0.3
+ 860000p -0.3
+ 860010p 0.9
+ 862000p 0.9
+ 862010p -0.3
+ 864000p -0.3
+ 864010p 0.9
+ 866000p 0.9
+ 866010p -0.3
+ 868000p -0.3
+ 868010p 0.9
+ 870000p 0.9
+ 870010p -0.3
+ 872000p -0.3
+ 872010p 0.9
+ 874000p 0.9
+ 874010p -0.3
+ 876000p -0.3
+ 876010p 0.9
+ 878000p 0.9
+ 878010p -0.3
+ 880000p -0.3
+ 880010p 0.9
+ 882000p 0.9
+ 882010p -0.3
+ 884000p -0.3
+ 884010p 0.9
+ 886000p 0.9
+ 886010p -0.3
+ 888000p -0.3
+ 888010p 0.9
+ 890000p 0.9
+ 890010p -0.3
+ 892000p -0.3
+ 892010p 0.9
+ 894000p 0.9
+ 894010p -0.3
+ 896000p -0.3
+ 896010p 0.9
+ 898000p 0.9
+ 898010p -0.3
+ 900000p -0.3
+ 900010p 0.9
+ 902000p 0.9
+ 902010p -0.3
+ 904000p -0.3
+ 904010p 0.9
+ 906000p 0.9
+ 906010p -0.3
+ 908000p -0.3
+ 908010p 0.9
+ 910000p 0.9
+ 910010p -0.3
+ 912000p -0.3
+ 912010p 0.9
+ 914000p 0.9
+ 914010p -0.3
+ 916000p -0.3
+ 916010p 0.9
+ 918000p 0.9
+ 918010p -0.3
+ 920000p -0.3
+ 920010p 0.9
+ 922000p 0.9
+ 922010p -0.3
+ 924000p -0.3
+ 924010p 0.9
+ 926000p 0.9
+ 926010p -0.3
+ 928000p -0.3
+ 928010p 0.9
+ 930000p 0.9
+ 930010p -0.3
+ 932000p -0.3
+ 932010p 0.9
+ 934000p 0.9
+ 934010p -0.3
+ 936000p -0.3
+ 936010p 0.9
+ 938000p 0.9
+ 938010p -0.3
+ 940000p -0.3
+ 940010p 0.9
+ 942000p 0.9
+ 942010p -0.3
+ 944000p -0.3
+ 944010p 0.9
+ 946000p 0.9
+ 946010p -0.3
+ 948000p -0.3
+ 948010p 0.9
+ 950000p 0.9
+ 950010p -0.3
+ 952000p -0.3
+ 952010p 0.9
+ 954000p 0.9
+ 954010p -0.3
+ 956000p -0.3
+ 956010p 0.9
+ 958000p 0.9
+ 958010p -0.3
+ 960000p -0.3
+ 960010p 0.9
+ 962000p 0.9
+ 962010p -0.3
+ 964000p -0.3
+ 964010p 0.9
+ 966000p 0.9
+ 966010p -0.3
+ 968000p -0.3
+ 968010p 0.9
+ 970000p 0.9
+ 970010p -0.3
+ 972000p -0.3
+ 972010p 0.9
+ 974000p 0.9
+ 974010p -0.3
+ 976000p -0.3
+ 976010p 0.9
+ 978000p 0.9
+ 978010p -0.3
+ 980000p -0.3
+ 980010p 0.9
+ 982000p 0.9
+ 982010p -0.3
+ 984000p -0.3
+ 984010p 0.9
+ 986000p 0.9
+ 986010p -0.3
+ 988000p -0.3
+ 988010p 0.9
+ 990000p 0.9
+ 990010p -0.3
+ 992000p -0.3
+ 992010p 0.9
+ 994000p 0.9
+ 994010p -0.3
+ 996000p -0.3
+ 996010p 0.9
+ 998000p 0.9
+ 998010p -0.3
+ 1000000p -0.3
+ 1000010p 0.9
+ 1002000p 0.9
+ 1002010p -0.3
+ 1004000p -0.3
+ 1004010p 0.9
+ 1006000p 0.9
+ 1006010p -0.3
+ 1008000p -0.3
+ 1008010p 0.9
+ 1010000p 0.9
+ 1010010p -0.3
+ 1012000p -0.3
+ 1012010p 0.9
+ 1014000p 0.9
+ 1014010p -0.3
+ 1016000p -0.3
+ 1016010p 0.9
+ 1018000p 0.9
+ 1018010p -0.3
+ 1020000p -0.3
+ 1020010p 0.9
+ 1022000p 0.9
+ 1022010p -0.3
+ 1024000p -0.3
+ 1024010p 0.9
+ 1026000p 0.9
+ 1026010p -0.3
+ 1028000p -0.3
+ 1028010p 0.9
+ 1030000p 0.9
+ 1030010p -0.3
+ 1032000p -0.3
+ 1032010p 0.9
+ 1034000p 0.9
+ 1034010p -0.3
+ 1036000p -0.3
+ 1036010p 0.9
+ 1038000p 0.9
+ 1038010p -0.3
+ 1040000p -0.3
+ 1040010p 0.9
+ 1042000p 0.9
+ 1042010p -0.3
+ 1044000p -0.3
+ 1044010p 0.9
+ 1046000p 0.9
+ 1046010p -0.3
+ 1048000p -0.3
+ 1048010p 0.9
+ 1050000p 0.9
+ 1050010p -0.3
+ 1052000p -0.3
+ 1052010p 0.9
+ 1054000p 0.9
+ 1054010p -0.3
+ 1056000p -0.3
+ 1056010p 0.9
+ 1058000p 0.9
+ 1058010p -0.3
+ 1060000p -0.3
+ 1060010p 0.9
+ 1062000p 0.9
+ 1062010p -0.3
+ 1064000p -0.3
+ 1064010p 0.9
+ 1066000p 0.9
+ 1066010p -0.3
+ 1068000p -0.3
+ 1068010p 0.9
+ 1070000p 0.9
+ 1070010p -0.3
+ 1072000p -0.3
+ 1072010p 0.9
+ 1074000p 0.9
+ 1074010p -0.3
+ 1076000p -0.3
+ 1076010p 0.9
+ 1078000p 0.9
+ 1078010p -0.3
+ 1080000p -0.3
+ 1080010p 0.9
+ 1082000p 0.9
+ 1082010p -0.3
+ 1084000p -0.3
+ 1084010p 0.9
+ 1086000p 0.9
+ 1086010p -0.3
+ 1088000p -0.3
+ 1088010p 0.9
+ 1090000p 0.9
+ 1090010p -0.3
+ 1092000p -0.3
+ 1092010p 0.9
+ 1094000p 0.9
+ 1094010p -0.3
+ 1096000p -0.3
+ 1096010p 0.9
+ 1098000p 0.9
+ 1098010p -0.3
+ 1100000p -0.3
+ 1100010p 0.9
+ 1102000p 0.9
+ 1102010p -0.3
+ 1104000p -0.3
+ 1104010p 0.9
+ 1106000p 0.9
+ 1106010p -0.3
+ 1108000p -0.3
+ 1108010p 0.9
+ 1110000p 0.9
+ 1110010p -0.3
+ 1112000p -0.3
+ 1112010p 0.9
+ 1114000p 0.9
+ 1114010p -0.3
+ 1116000p -0.3
+ 1116010p 0.9
+ 1118000p 0.9
+ 1118010p -0.3
+ 1120000p -0.3
+ 1120010p 0.9
+ 1122000p 0.9
+ 1122010p -0.3
+ 1124000p -0.3
+ 1124010p 0.9
+ 1126000p 0.9
+ 1126010p -0.3
+ 1128000p -0.3
+ 1128010p 0.9
+ 1130000p 0.9
+ 1130010p -0.3
+ 1132000p -0.3
+ 1132010p 0.9
+ 1134000p 0.9
+ 1134010p -0.3
+ 1136000p -0.3
+ 1136010p 0.9
+ 1138000p 0.9
+ 1138010p -0.3
+ 1140000p -0.3
+ 1140010p 0.9
+ 1142000p 0.9
+ 1142010p -0.3
+ 1144000p -0.3
+ 1144010p 0.9
+ 1146000p 0.9
+ 1146010p -0.3
+ 1148000p -0.3
+ 1148010p 0.9
+ 1150000p 0.9
+ 1150010p -0.3
+ 1152000p -0.3
+ 1152010p 0.9
+ 1154000p 0.9
+ 1154010p -0.3
+ 1156000p -0.3
+ 1156010p 0.9
+ 1158000p 0.9
+ 1158010p -0.3
+ 1160000p -0.3
+ 1160010p 0.9
+ 1162000p 0.9
+ 1162010p -0.3
+ 1164000p -0.3
+ 1164010p 0.9
+ 1166000p 0.9
+ 1166010p -0.3
+ 1168000p -0.3
+ 1168010p 0.9
+ 1170000p 0.9
+ 1170010p -0.3
+ 1172000p -0.3
+ 1172010p 0.9
+ 1174000p 0.9
+ 1174010p -0.3
+ 1176000p -0.3
+ 1176010p 0.9
+ 1178000p 0.9
+ 1178010p -0.3
+ 1180000p -0.3
+ 1180010p 0.9
+ 1182000p 0.9
+ 1182010p -0.3
+ 1184000p -0.3
+ 1184010p 0.9
+ 1186000p 0.9
+ 1186010p -0.3
+ 1188000p -0.3
+ 1188010p 0.9
+ 1190000p 0.9
+ 1190010p -0.3
+ 1192000p -0.3
+ 1192010p 0.9
+ 1194000p 0.9
+ 1194010p -0.3
+ 1196000p -0.3
+ 1196010p 0.9
+ 1198000p 0.9
+ 1198010p -0.3
+ 1200000p -0.3
+ 1200010p 0.9
+ 1202000p 0.9
+ 1202010p -0.3
+ 1204000p -0.3
+ 1204010p 0.9
+ 1206000p 0.9
+ 1206010p -0.3
+ 1208000p -0.3
+ 1208010p 0.9
+ 1210000p 0.9
+ 1210010p -0.3
+ 1212000p -0.3
+ 1212010p 0.9
+ 1214000p 0.9
+ 1214010p -0.3
+ 1216000p -0.3
+ 1216010p 0.9
+ 1218000p 0.9
+ 1218010p -0.3
+ 1220000p -0.3
+ 1220010p 0.9
+ 1222000p 0.9
+ 1222010p -0.3
+ 1224000p -0.3
+ 1224010p 0.9
+ 1226000p 0.9
+ 1226010p -0.3
+ 1228000p -0.3
+ 1228010p 0.9
+ 1230000p 0.9
+ 1230010p -0.3
+ 1232000p -0.3
+ 1232010p 0.9
+ 1234000p 0.9
+ 1234010p -0.3
+ 1236000p -0.3
+ 1236010p 0.9
+ 1238000p 0.9
+ 1238010p -0.3
+ 1240000p -0.3
+ 1240010p 0.9
+ 1242000p 0.9
+ 1242010p -0.3
+ 1244000p -0.3
+ 1244010p 0.9
+ 1246000p 0.9
+ 1246010p -0.3
+ 1248000p -0.3
+ 1248010p 0.9
+ 1250000p 0.9
+ 1250010p -0.3
+ 1252000p -0.3
+ 1252010p 0.9
+ 1254000p 0.9
+ 1254010p -0.3
+ 1256000p -0.3
+ 1256010p 0.9
+ 1258000p 0.9
+ 1258010p -0.3
+ 1260000p -0.3
+ 1260010p 0.9
+ 1262000p 0.9
+ 1262010p -0.3
+ 1264000p -0.3
+ 1264010p 0.9
+ 1266000p 0.9
+ 1266010p -0.3
+ 1268000p -0.3
+ 1268010p 0.9
+ 1270000p 0.9
+ 1270010p -0.3
+ 1272000p -0.3
+ 1272010p 0.9
+ 1274000p 0.9
+ 1274010p -0.3
+ 1276000p -0.3
+ 1276010p 0.9
+ 1278000p 0.9
+ 1278010p -0.3
+ 1280000p -0.3
+ 1280010p 0.9
+ 1282000p 0.9
+ 1282010p -0.3
+ 1284000p -0.3
+ 1284010p 0.9
+ 1286000p 0.9
+ 1286010p -0.3
+ 1288000p -0.3
+ 1288010p 0.9
+ 1290000p 0.9
+ 1290010p -0.3
+ 1292000p -0.3
+ 1292010p 0.9
+ 1294000p 0.9
+ 1294010p -0.3
+ 1296000p -0.3
+ 1296010p 0.9
+ 1298000p 0.9
+ 1298010p -0.3
+ 1300000p -0.3
+ 1300010p 0.9
+ 1302000p 0.9
+ 1302010p -0.3
+ 1304000p -0.3
+ 1304010p 0.9
+ 1306000p 0.9
+ 1306010p -0.3
+ 1308000p -0.3
+ 1308010p 0.9
+ 1310000p 0.9
+ 1310010p -0.3
+ 1312000p -0.3
+ 1312010p 0.9
+ 1314000p 0.9
+ 1314010p -0.3
+ 1316000p -0.3
+ 1316010p 0.9
+ 1318000p 0.9
+ 1318010p -0.3
+ 1320000p -0.3
+ 1320010p 0.9
+ 1322000p 0.9
+ 1322010p -0.3
+ 1324000p -0.3
+ 1324010p 0.9
+ 1326000p 0.9
+ 1326010p -0.3
+ 1328000p -0.3
+ 1328010p 0.9
+ 1330000p 0.9
+ 1330010p -0.3
+ 1332000p -0.3
+ 1332010p 0.9
+ 1334000p 0.9
+ 1334010p -0.3
+ 1336000p -0.3
+ 1336010p 0.9
+ 1338000p 0.9
+ 1338010p -0.3
+ 1340000p -0.3
+ 1340010p 0.9
+ 1342000p 0.9
+ 1342010p -0.3
+ 1344000p -0.3
+ 1344010p 0.9
+ 1346000p 0.9
+ 1346010p -0.3
+ 1348000p -0.3
+ 1348010p 0.9
+ 1350000p 0.9
+ 1350010p -0.3
+ 1352000p -0.3
+ 1352010p 0.9
+ 1354000p 0.9
+ 1354010p -0.3
+ 1356000p -0.3
+ 1356010p 0.9
+ 1358000p 0.9
+ 1358010p -0.3
+ 1360000p -0.3
+ 1360010p 0.9
+ 1362000p 0.9
+ 1362010p -0.3
+ 1364000p -0.3
+ 1364010p 0.9
+ 1366000p 0.9
+ 1366010p -0.3
+ 1368000p -0.3
+ 1368010p 0.9
+ 1370000p 0.9
+ 1370010p -0.3
+ 1372000p -0.3
+ 1372010p 0.9
+ 1374000p 0.9
+ 1374010p -0.3
+ 1376000p -0.3
+ 1376010p 0.9
+ 1378000p 0.9
+ 1378010p -0.3
+ 1380000p -0.3
+ 1380010p 0.9
+ 1382000p 0.9
+ 1382010p -0.3
+ 1384000p -0.3
+ 1384010p 0.9
+ 1386000p 0.9
+ 1386010p -0.3
+ 1388000p -0.3
+ 1388010p 0.9
+ 1390000p 0.9
+ 1390010p -0.3
+ 1392000p -0.3
+ 1392010p 0.9
+ 1394000p 0.9
+ 1394010p -0.3
+ 1396000p -0.3
+ 1396010p 0.9
+ 1398000p 0.9
+ 1398010p -0.3
+ 1400000p -0.3
+ 1400010p 0.9
+ 1402000p 0.9
+ 1402010p -0.3
+ 1404000p -0.3
+ 1404010p 0.9
+ 1406000p 0.9
+ 1406010p -0.3
+ 1408000p -0.3
+ 1408010p 0.9
+ 1410000p 0.9
+ 1410010p -0.3
+ 1412000p -0.3
+ 1412010p 0.9
+ 1414000p 0.9
+ 1414010p -0.3
+ 1416000p -0.3
+ 1416010p 0.9
+ 1418000p 0.9
+ 1418010p -0.3
+ 1420000p -0.3
+ 1420010p 0.9
+ 1422000p 0.9
+ 1422010p -0.3
+ 1424000p -0.3
+ 1424010p 0.9
+ 1426000p 0.9
+ 1426010p -0.3
+ 1428000p -0.3
+ 1428010p 0.9
+ 1430000p 0.9
+ 1430010p -0.3
+ 1432000p -0.3
+ 1432010p 0.9
+ 1434000p 0.9
+ 1434010p -0.3
+ 1436000p -0.3
+ 1436010p 0.9
+ 1438000p 0.9
+ 1438010p -0.3
+ 1440000p -0.3
+ 1440010p 0.9
+ 1442000p 0.9
+ 1442010p -0.3
+ 1444000p -0.3
+ 1444010p 0.9
+ 1446000p 0.9
+ 1446010p -0.3
+ 1448000p -0.3
+ 1448010p 0.9
+ 1450000p 0.9
+ 1450010p -0.3
+ 1452000p -0.3
+ 1452010p 0.9
+ 1454000p 0.9
+ 1454010p -0.3
+ 1456000p -0.3
+ 1456010p 0.9
+ 1458000p 0.9
+ 1458010p -0.3
+ 1460000p -0.3
+ 1460010p 0.9
+ 1462000p 0.9
+ 1462010p -0.3
+ 1464000p -0.3
+ 1464010p 0.9
+ 1466000p 0.9
+ 1466010p -0.3
+ 1468000p -0.3
+ 1468010p 0.9
+ 1470000p 0.9
+ 1470010p -0.3
+ 1472000p -0.3
+ 1472010p 0.9
+ 1474000p 0.9
+ 1474010p -0.3
+ 1476000p -0.3
+ 1476010p 0.9
+ 1478000p 0.9
+ 1478010p -0.3
+ 1480000p -0.3
+ 1480010p 0.9
+ 1482000p 0.9
+ 1482010p -0.3
+ 1484000p -0.3
+ 1484010p 0.9
+ 1486000p 0.9
+ 1486010p -0.3
+ 1488000p -0.3
+ 1488010p 0.9
+ 1490000p 0.9
+ 1490010p -0.3
+ 1492000p -0.3
+ 1492010p 0.9
+ 1494000p 0.9
+ 1494010p -0.3
+ 1496000p -0.3
+ 1496010p 0.9
+ 1498000p 0.9
+ 1498010p -0.3
+ 1500000p -0.3
+ 1500010p 0.9
+ 1502000p 0.9
+ 1502010p -0.3
+ 1504000p -0.3
+ 1504010p 0.9
+ 1506000p 0.9
+ 1506010p -0.3
+ 1508000p -0.3
+ 1508010p 0.9
+ 1510000p 0.9
+ 1510010p -0.3
+ 1512000p -0.3
+ 1512010p 0.9
+ 1514000p 0.9
+ 1514010p -0.3
+ 1516000p -0.3
+ 1516010p 0.9
+ 1518000p 0.9
+ 1518010p -0.3
+ 1520000p -0.3
+ 1520010p 0.9
+ 1522000p 0.9
+ 1522010p -0.3
+ 1524000p -0.3
+ 1524010p 0.9
+ 1526000p 0.9
+ 1526010p -0.3
+ 1528000p -0.3
+ 1528010p 0.9
+ 1530000p 0.9
+ 1530010p -0.3
+ 1532000p -0.3
+ 1532010p 0.9
+ 1534000p 0.9
+ 1534010p -0.3
+ 1536000p -0.3
+ 1536010p 0.9
+ 1538000p 0.9
+ 1538010p -0.3
+ 1540000p -0.3
+ 1540010p 0.9
+ 1542000p 0.9
+ 1542010p -0.3
+ 1544000p -0.3
+ 1544010p 0.9
+ 1546000p 0.9
+ 1546010p -0.3
+ 1548000p -0.3
+ 1548010p 0.9
+ 1550000p 0.9
+ 1550010p -0.3
+ 1552000p -0.3
+ 1552010p 0.9
+ 1554000p 0.9
+ 1554010p -0.3
+ 1556000p -0.3
+ 1556010p 0.9
+ 1558000p 0.9
+ 1558010p -0.3
+ 1560000p -0.3
+ 1560010p 0.9
+ 1562000p 0.9
+ 1562010p -0.3
+ 1564000p -0.3
+ 1564010p 0.9
+ 1566000p 0.9
+ 1566010p -0.3
+ 1568000p -0.3
+ 1568010p 0.9
+ 1570000p 0.9
+ 1570010p -0.3
+ 1572000p -0.3
+ 1572010p 0.9
+ 1574000p 0.9
+ 1574010p -0.3
+ 1576000p -0.3
+ 1576010p 0.9
+ 1578000p 0.9
+ 1578010p -0.3
+ 1580000p -0.3
+ 1580010p 0.9
+ 1582000p 0.9
+ 1582010p -0.3
+ 1584000p -0.3
+ 1584010p 0.9
+ 1586000p 0.9
+ 1586010p -0.3
+ 1588000p -0.3
+ 1588010p 0.9
+ 1590000p 0.9
+ 1590010p -0.3
+ 1592000p -0.3
+ 1592010p 0.9
+ 1594000p 0.9
+ 1594010p -0.3
+ 1596000p -0.3
+ 1596010p 0.9
+ 1598000p 0.9
+ 1598010p -0.3
+ 1600000p -0.3
+ 1600010p 0.9
+ 1602000p 0.9
+ 1602010p -0.3
+ 1604000p -0.3
+ 1604010p 0.9
+ 1606000p 0.9
+ 1606010p -0.3
+ 1608000p -0.3
+ 1608010p 0.9
+ 1610000p 0.9
+ 1610010p -0.3
+ 1612000p -0.3
+ 1612010p 0.9
+ 1614000p 0.9
+ 1614010p -0.3
+ 1616000p -0.3
+ 1616010p 0.9
+ 1618000p 0.9
+ 1618010p -0.3
+ 1620000p -0.3
+ 1620010p 0.9
+ 1622000p 0.9
+ 1622010p -0.3
+ 1624000p -0.3
+ 1624010p 0.9
+ 1626000p 0.9
+ 1626010p -0.3
+ 1628000p -0.3
+ 1628010p 0.9
+ 1630000p 0.9
+ 1630010p -0.3
+ 1632000p -0.3
+ 1632010p 0.9
+ 1634000p 0.9
+ 1634010p -0.3
+ 1636000p -0.3
+ 1636010p 0.9
+ 1638000p 0.9
+ 1638010p -0.3
+ 1640000p -0.3
+ 1640010p 0.9
+ 1642000p 0.9
+ 1642010p -0.3
+ 1644000p -0.3
+ 1644010p 0.9
+ 1646000p 0.9
+ 1646010p -0.3
+ 1648000p -0.3
+ 1648010p 0.9
+ 1650000p 0.9
+ 1650010p -0.3
+ 1652000p -0.3
+ 1652010p 0.9
+ 1654000p 0.9
+ 1654010p -0.3
+ 1656000p -0.3
+ 1656010p 0.9
+ 1658000p 0.9
+ 1658010p -0.3
+ 1660000p -0.3
+ 1660010p 0.9
+ 1662000p 0.9
+ 1662010p -0.3
+ 1664000p -0.3
+ 1664010p 0.9
+ 1666000p 0.9
+ 1666010p -0.3
+ 1668000p -0.3
+ 1668010p 0.9
+ 1670000p 0.9
+ 1670010p -0.3
+ 1672000p -0.3
+ 1672010p 0.9
+ 1674000p 0.9
+ 1674010p -0.3
+ 1676000p -0.3
+ 1676010p 0.9
+ 1678000p 0.9
+ 1678010p -0.3
+ 1680000p -0.3
+ 1680010p 0.9
+ 1682000p 0.9
+ 1682010p -0.3
+ 1684000p -0.3
+ 1684010p 0.9
+ 1686000p 0.9
+ 1686010p -0.3
+ 1688000p -0.3
+ 1688010p 0.9
+ 1690000p 0.9
+ 1690010p -0.3
+ 1692000p -0.3
+ 1692010p 0.9
+ 1694000p 0.9
+ 1694010p -0.3
+ 1696000p -0.3
+ 1696010p 0.9
+ 1698000p 0.9
+ 1698010p -0.3
+ 1700000p -0.3
+ 1700010p 0.9
+ 1702000p 0.9
+ 1702010p -0.3
+ 1704000p -0.3
+ 1704010p 0.9
+ 1706000p 0.9
+ 1706010p -0.3
+ 1708000p -0.3
+ 1708010p 0.9
+ 1710000p 0.9
+ 1710010p -0.3
+ 1712000p -0.3
+ 1712010p 0.9
+ 1714000p 0.9
+ 1714010p -0.3
+ 1716000p -0.3
+ 1716010p 0.9
+ 1718000p 0.9
+ 1718010p -0.3
+ 1720000p -0.3
+ 1720010p 0.9
+ 1722000p 0.9
+ 1722010p -0.3
+ 1724000p -0.3
+ 1724010p 0.9
+ 1726000p 0.9
+ 1726010p -0.3
+ 1728000p -0.3
+ 1728010p 0.9
+ 1730000p 0.9
+ 1730010p -0.3
+ 1732000p -0.3
+ 1732010p 0.9
+ 1734000p 0.9
+ 1734010p -0.3
+ 1736000p -0.3
+ 1736010p 0.9
+ 1738000p 0.9
+ 1738010p -0.3
+ 1740000p -0.3
+ 1740010p 0.9
+ 1742000p 0.9
+ 1742010p -0.3
+ 1744000p -0.3
+ 1744010p 0.9
+ 1746000p 0.9
+ 1746010p -0.3
+ 1748000p -0.3
+ 1748010p 0.9
+ 1750000p 0.9
+ 1750010p -0.3
+ 1752000p -0.3
+ 1752010p 0.9
+ 1754000p 0.9
+ 1754010p -0.3
+ 1756000p -0.3
+ 1756010p 0.9
+ 1758000p 0.9
+ 1758010p -0.3
+ 1760000p -0.3
+ 1760010p 0.9
+ 1762000p 0.9
+ 1762010p -0.3
+ 1764000p -0.3
+ 1764010p 0.9
+ 1766000p 0.9
+ 1766010p -0.3
+ 1768000p -0.3
+ 1768010p 0.9
+ 1770000p 0.9
+ 1770010p -0.3
+ 1772000p -0.3
+ 1772010p 0.9
+ 1774000p 0.9
+ 1774010p -0.3
+ 1776000p -0.3
+ 1776010p 0.9
+ 1778000p 0.9
+ 1778010p -0.3
+ 1780000p -0.3
+ 1780010p 0.9
+ 1782000p 0.9
+ 1782010p -0.3
+ 1784000p -0.3
+ 1784010p 0.9
+ 1786000p 0.9
+ 1786010p -0.3
+ 1788000p -0.3
+ 1788010p 0.9
+ 1790000p 0.9
+ 1790010p -0.3
+ 1792000p -0.3
+ 1792010p 0.9
+ 1794000p 0.9
+ 1794010p -0.3
+ 1796000p -0.3
+ 1796010p 0.9
+ 1798000p 0.9
+ 1798010p -0.3
+ 1800000p -0.3
+ 1800010p 0.9
+ 1802000p 0.9
+ 1802010p -0.3
+ 1804000p -0.3
+ 1804010p 0.9
+ 1806000p 0.9
+ 1806010p -0.3
+ 1808000p -0.3
+ 1808010p 0.9
+ 1810000p 0.9
+ 1810010p -0.3
+ 1812000p -0.3
+ 1812010p 0.9
+ 1814000p 0.9
+ 1814010p -0.3
+ 1816000p -0.3
+ 1816010p 0.9
+ 1818000p 0.9
+ 1818010p -0.3
+ 1820000p -0.3
+ 1820010p 0.9
+ 1822000p 0.9
+ 1822010p -0.3
+ 1824000p -0.3
+ 1824010p 0.9
+ 1826000p 0.9
+ 1826010p -0.3
+ 1828000p -0.3
+ 1828010p 0.9
+ 1830000p 0.9
+ 1830010p -0.3
+ 1832000p -0.3
+ 1832010p 0.9
+ 1834000p 0.9
+ 1834010p -0.3
+ 1836000p -0.3
+ 1836010p 0.9
+ 1838000p 0.9
+ 1838010p -0.3
+ 1840000p -0.3
+ 1840010p 0.9
+ 1842000p 0.9
+ 1842010p -0.3
+ 1844000p -0.3
+ 1844010p 0.9
+ 1846000p 0.9
+ 1846010p -0.3
+ 1848000p -0.3
+ 1848010p 0.9
+ 1850000p 0.9
+ 1850010p -0.3
+ 1852000p -0.3
+ 1852010p 0.9
+ 1854000p 0.9
+ 1854010p -0.3
+ 1856000p -0.3
+ 1856010p 0.9
+ 1858000p 0.9
+ 1858010p -0.3
+ 1860000p -0.3
+ 1860010p 0.9
+ 1862000p 0.9
+ 1862010p -0.3
+ 1864000p -0.3
+ 1864010p 0.9
+ 1866000p 0.9
+ 1866010p -0.3
+ 1868000p -0.3
+ 1868010p 0.9
+ 1870000p 0.9
+ 1870010p -0.3
+ 1872000p -0.3
+ 1872010p 0.9
+ 1874000p 0.9
+ 1874010p -0.3
+ 1876000p -0.3
+ 1876010p 0.9
+ 1878000p 0.9
+ 1878010p -0.3
+ 1880000p -0.3
+ 1880010p 0.9
+ 1882000p 0.9
+ 1882010p -0.3
+ 1884000p -0.3
+ 1884010p 0.9
+ 1886000p 0.9
+ 1886010p -0.3
+ 1888000p -0.3
+ 1888010p 0.9
+ 1890000p 0.9
+ 1890010p -0.3
+ 1892000p -0.3
+ 1892010p 0.9
+ 1894000p 0.9
+ 1894010p -0.3
+ 1896000p -0.3
+ 1896010p 0.9
+ 1898000p 0.9
+ 1898010p -0.3
+ 1900000p -0.3
+ 1900010p 0.9
+ 1902000p 0.9
+ 1902010p -0.3
+ 1904000p -0.3
+ 1904010p 0.9
+ 1906000p 0.9
+ 1906010p -0.3
+ 1908000p -0.3
+ 1908010p 0.9
+ 1910000p 0.9
+ 1910010p -0.3
+ 1912000p -0.3
+ 1912010p 0.9
+ 1914000p 0.9
+ 1914010p -0.3
+ 1916000p -0.3
+ 1916010p 0.9
+ 1918000p 0.9
+ 1918010p -0.3
+ 1920000p -0.3
+ 1920010p 0.9
+ 1922000p 0.9
+ 1922010p -0.3
+ 1924000p -0.3
+ 1924010p 0.9
+ 1926000p 0.9
+ 1926010p -0.3
+ 1928000p -0.3
+ 1928010p 0.9
+ 1930000p 0.9
+ 1930010p -0.3
+ 1932000p -0.3
+ 1932010p 0.9
+ 1934000p 0.9
+ 1934010p -0.3
+ 1936000p -0.3
+ 1936010p 0.9
+ 1938000p 0.9
+ 1938010p -0.3
+ 1940000p -0.3
+ 1940010p 0.9
+ 1942000p 0.9
+ 1942010p -0.3
+ 1944000p -0.3
+ 1944010p 0.9
+ 1946000p 0.9
+ 1946010p -0.3
+ 1948000p -0.3
+ 1948010p 0.9
+ 1950000p 0.9
+ 1950010p -0.3
+ 1952000p -0.3
+ 1952010p 0.9
+ 1954000p 0.9
+ 1954010p -0.3
+ 1956000p -0.3
+ 1956010p 0.9
+ 1958000p 0.9
+ 1958010p -0.3
+ 1960000p -0.3
+ 1960010p 0.9
+ 1962000p 0.9
+ 1962010p -0.3
+ 1964000p -0.3
+ 1964010p 0.9
+ 1966000p 0.9
+ 1966010p -0.3
+ 1968000p -0.3
+ 1968010p 0.9
+ 1970000p 0.9
+ 1970010p -0.3
+ 1972000p -0.3
+ 1972010p 0.9
+ 1974000p 0.9
+ 1974010p -0.3
+ 1976000p -0.3
+ 1976010p 0.9
+ 1978000p 0.9
+ 1978010p -0.3
+ 1980000p -0.3
+ 1980010p 0.9
+ 1982000p 0.9
+ 1982010p -0.3
+ 1984000p -0.3
+ 1984010p 0.9
+ 1986000p 0.9
+ 1986010p -0.3
+ 1988000p -0.3
+ 1988010p 0.9
+ 1990000p 0.9
+ 1990010p -0.3
+ 1992000p -0.3
+ 1992010p 0.9
+ 1994000p 0.9
+ 1994010p -0.3
+ 1996000p -0.3
+ 1996010p 0.9
+ 1998000p 0.9
+ 1998010p -0.3
+ 2000000p -0.3
+ 2000010p 0.9
+ 2002000p 0.9
+ 2002010p -0.3
+ 2004000p -0.3
+ 2004010p 0.9
+ 2006000p 0.9
+ 2006010p -0.3
+ 2008000p -0.3
+ 2008010p 0.9
+ 2010000p 0.9
+ 2010010p -0.3
+ 2012000p -0.3
+ 2012010p 0.9
+ 2014000p 0.9
+ 2014010p -0.3
+ 2016000p -0.3
+ 2016010p 0.9
+ 2018000p 0.9
+ 2018010p -0.3
+ 2020000p -0.3
+ 2020010p 0.9
+ 2022000p 0.9
+ 2022010p -0.3
+ 2024000p -0.3
+ 2024010p 0.9
+ 2026000p 0.9
+ 2026010p -0.3
+ 2028000p -0.3
+ 2028010p 0.9
+ 2030000p 0.9
+ 2030010p -0.3
+ 2032000p -0.3
+ 2032010p 0.9
+ 2034000p 0.9
+ 2034010p -0.3
+ 2036000p -0.3
+ 2036010p 0.9
+ 2038000p 0.9
+ 2038010p -0.3
+ 2040000p -0.3
+ 2040010p 0.9
+ 2042000p 0.9
+ 2042010p -0.3
+ 2044000p -0.3
+ 2044010p 0.9
+ 2046000p 0.9
+ 2046010p -0.3
+ 2048000p -0.3
+ 2048010p 0.9
+ \]
V_data_bar_1 (Data_bar\\<1\\> gnd!) vsource type=pwl wave=\[
+ 0    -0.3
+ 2000p -0.3
+ 2010p 0.9
+ 4000p 0.9
+ 4010p -0.3
+ 6000p -0.3
+ 6010p 0.9
+ 8000p 0.9
+ 8010p -0.3
+ 10000p -0.3
+ 10010p 0.9
+ 12000p 0.9
+ 12010p -0.3
+ 14000p -0.3
+ 14010p 0.9
+ 16000p 0.9
+ 16010p -0.3
+ 18000p -0.3
+ 18010p 0.9
+ 20000p 0.9
+ 20010p -0.3
+ 22000p -0.3
+ 22010p 0.9
+ 24000p 0.9
+ 24010p -0.3
+ 26000p -0.3
+ 26010p 0.9
+ 28000p 0.9
+ 28010p -0.3
+ 30000p -0.3
+ 30010p 0.9
+ 32000p 0.9
+ 32010p -0.3
+ 34000p -0.3
+ 34010p 0.9
+ 36000p 0.9
+ 36010p -0.3
+ 38000p -0.3
+ 38010p 0.9
+ 40000p 0.9
+ 40010p -0.3
+ 42000p -0.3
+ 42010p 0.9
+ 44000p 0.9
+ 44010p -0.3
+ 46000p -0.3
+ 46010p 0.9
+ 48000p 0.9
+ 48010p -0.3
+ 50000p -0.3
+ 50010p 0.9
+ 52000p 0.9
+ 52010p -0.3
+ 54000p -0.3
+ 54010p 0.9
+ 56000p 0.9
+ 56010p -0.3
+ 58000p -0.3
+ 58010p 0.9
+ 60000p 0.9
+ 60010p -0.3
+ 62000p -0.3
+ 62010p 0.9
+ 64000p 0.9
+ 64010p -0.3
+ 66000p -0.3
+ 66010p 0.9
+ 68000p 0.9
+ 68010p -0.3
+ 70000p -0.3
+ 70010p 0.9
+ 72000p 0.9
+ 72010p -0.3
+ 74000p -0.3
+ 74010p 0.9
+ 76000p 0.9
+ 76010p -0.3
+ 78000p -0.3
+ 78010p 0.9
+ 80000p 0.9
+ 80010p -0.3
+ 82000p -0.3
+ 82010p 0.9
+ 84000p 0.9
+ 84010p -0.3
+ 86000p -0.3
+ 86010p 0.9
+ 88000p 0.9
+ 88010p -0.3
+ 90000p -0.3
+ 90010p 0.9
+ 92000p 0.9
+ 92010p -0.3
+ 94000p -0.3
+ 94010p 0.9
+ 96000p 0.9
+ 96010p -0.3
+ 98000p -0.3
+ 98010p 0.9
+ 100000p 0.9
+ 100010p -0.3
+ 102000p -0.3
+ 102010p 0.9
+ 104000p 0.9
+ 104010p -0.3
+ 106000p -0.3
+ 106010p 0.9
+ 108000p 0.9
+ 108010p -0.3
+ 110000p -0.3
+ 110010p 0.9
+ 112000p 0.9
+ 112010p -0.3
+ 114000p -0.3
+ 114010p 0.9
+ 116000p 0.9
+ 116010p -0.3
+ 118000p -0.3
+ 118010p 0.9
+ 120000p 0.9
+ 120010p -0.3
+ 122000p -0.3
+ 122010p 0.9
+ 124000p 0.9
+ 124010p -0.3
+ 126000p -0.3
+ 126010p 0.9
+ 128000p 0.9
+ 128010p -0.3
+ 130000p -0.3
+ 130010p 0.9
+ 132000p 0.9
+ 132010p -0.3
+ 134000p -0.3
+ 134010p 0.9
+ 136000p 0.9
+ 136010p -0.3
+ 138000p -0.3
+ 138010p 0.9
+ 140000p 0.9
+ 140010p -0.3
+ 142000p -0.3
+ 142010p 0.9
+ 144000p 0.9
+ 144010p -0.3
+ 146000p -0.3
+ 146010p 0.9
+ 148000p 0.9
+ 148010p -0.3
+ 150000p -0.3
+ 150010p 0.9
+ 152000p 0.9
+ 152010p -0.3
+ 154000p -0.3
+ 154010p 0.9
+ 156000p 0.9
+ 156010p -0.3
+ 158000p -0.3
+ 158010p 0.9
+ 160000p 0.9
+ 160010p -0.3
+ 162000p -0.3
+ 162010p 0.9
+ 164000p 0.9
+ 164010p -0.3
+ 166000p -0.3
+ 166010p 0.9
+ 168000p 0.9
+ 168010p -0.3
+ 170000p -0.3
+ 170010p 0.9
+ 172000p 0.9
+ 172010p -0.3
+ 174000p -0.3
+ 174010p 0.9
+ 176000p 0.9
+ 176010p -0.3
+ 178000p -0.3
+ 178010p 0.9
+ 180000p 0.9
+ 180010p -0.3
+ 182000p -0.3
+ 182010p 0.9
+ 184000p 0.9
+ 184010p -0.3
+ 186000p -0.3
+ 186010p 0.9
+ 188000p 0.9
+ 188010p -0.3
+ 190000p -0.3
+ 190010p 0.9
+ 192000p 0.9
+ 192010p -0.3
+ 194000p -0.3
+ 194010p 0.9
+ 196000p 0.9
+ 196010p -0.3
+ 198000p -0.3
+ 198010p 0.9
+ 200000p 0.9
+ 200010p -0.3
+ 202000p -0.3
+ 202010p 0.9
+ 204000p 0.9
+ 204010p -0.3
+ 206000p -0.3
+ 206010p 0.9
+ 208000p 0.9
+ 208010p -0.3
+ 210000p -0.3
+ 210010p 0.9
+ 212000p 0.9
+ 212010p -0.3
+ 214000p -0.3
+ 214010p 0.9
+ 216000p 0.9
+ 216010p -0.3
+ 218000p -0.3
+ 218010p 0.9
+ 220000p 0.9
+ 220010p -0.3
+ 222000p -0.3
+ 222010p 0.9
+ 224000p 0.9
+ 224010p -0.3
+ 226000p -0.3
+ 226010p 0.9
+ 228000p 0.9
+ 228010p -0.3
+ 230000p -0.3
+ 230010p 0.9
+ 232000p 0.9
+ 232010p -0.3
+ 234000p -0.3
+ 234010p 0.9
+ 236000p 0.9
+ 236010p -0.3
+ 238000p -0.3
+ 238010p 0.9
+ 240000p 0.9
+ 240010p -0.3
+ 242000p -0.3
+ 242010p 0.9
+ 244000p 0.9
+ 244010p -0.3
+ 246000p -0.3
+ 246010p 0.9
+ 248000p 0.9
+ 248010p -0.3
+ 250000p -0.3
+ 250010p 0.9
+ 252000p 0.9
+ 252010p -0.3
+ 254000p -0.3
+ 254010p 0.9
+ 256000p 0.9
+ 256010p -0.3
+ 258000p -0.3
+ 258010p 0.9
+ 260000p 0.9
+ 260010p -0.3
+ 262000p -0.3
+ 262010p 0.9
+ 264000p 0.9
+ 264010p -0.3
+ 266000p -0.3
+ 266010p 0.9
+ 268000p 0.9
+ 268010p -0.3
+ 270000p -0.3
+ 270010p 0.9
+ 272000p 0.9
+ 272010p -0.3
+ 274000p -0.3
+ 274010p 0.9
+ 276000p 0.9
+ 276010p -0.3
+ 278000p -0.3
+ 278010p 0.9
+ 280000p 0.9
+ 280010p -0.3
+ 282000p -0.3
+ 282010p 0.9
+ 284000p 0.9
+ 284010p -0.3
+ 286000p -0.3
+ 286010p 0.9
+ 288000p 0.9
+ 288010p -0.3
+ 290000p -0.3
+ 290010p 0.9
+ 292000p 0.9
+ 292010p -0.3
+ 294000p -0.3
+ 294010p 0.9
+ 296000p 0.9
+ 296010p -0.3
+ 298000p -0.3
+ 298010p 0.9
+ 300000p 0.9
+ 300010p -0.3
+ 302000p -0.3
+ 302010p 0.9
+ 304000p 0.9
+ 304010p -0.3
+ 306000p -0.3
+ 306010p 0.9
+ 308000p 0.9
+ 308010p -0.3
+ 310000p -0.3
+ 310010p 0.9
+ 312000p 0.9
+ 312010p -0.3
+ 314000p -0.3
+ 314010p 0.9
+ 316000p 0.9
+ 316010p -0.3
+ 318000p -0.3
+ 318010p 0.9
+ 320000p 0.9
+ 320010p -0.3
+ 322000p -0.3
+ 322010p 0.9
+ 324000p 0.9
+ 324010p -0.3
+ 326000p -0.3
+ 326010p 0.9
+ 328000p 0.9
+ 328010p -0.3
+ 330000p -0.3
+ 330010p 0.9
+ 332000p 0.9
+ 332010p -0.3
+ 334000p -0.3
+ 334010p 0.9
+ 336000p 0.9
+ 336010p -0.3
+ 338000p -0.3
+ 338010p 0.9
+ 340000p 0.9
+ 340010p -0.3
+ 342000p -0.3
+ 342010p 0.9
+ 344000p 0.9
+ 344010p -0.3
+ 346000p -0.3
+ 346010p 0.9
+ 348000p 0.9
+ 348010p -0.3
+ 350000p -0.3
+ 350010p 0.9
+ 352000p 0.9
+ 352010p -0.3
+ 354000p -0.3
+ 354010p 0.9
+ 356000p 0.9
+ 356010p -0.3
+ 358000p -0.3
+ 358010p 0.9
+ 360000p 0.9
+ 360010p -0.3
+ 362000p -0.3
+ 362010p 0.9
+ 364000p 0.9
+ 364010p -0.3
+ 366000p -0.3
+ 366010p 0.9
+ 368000p 0.9
+ 368010p -0.3
+ 370000p -0.3
+ 370010p 0.9
+ 372000p 0.9
+ 372010p -0.3
+ 374000p -0.3
+ 374010p 0.9
+ 376000p 0.9
+ 376010p -0.3
+ 378000p -0.3
+ 378010p 0.9
+ 380000p 0.9
+ 380010p -0.3
+ 382000p -0.3
+ 382010p 0.9
+ 384000p 0.9
+ 384010p -0.3
+ 386000p -0.3
+ 386010p 0.9
+ 388000p 0.9
+ 388010p -0.3
+ 390000p -0.3
+ 390010p 0.9
+ 392000p 0.9
+ 392010p -0.3
+ 394000p -0.3
+ 394010p 0.9
+ 396000p 0.9
+ 396010p -0.3
+ 398000p -0.3
+ 398010p 0.9
+ 400000p 0.9
+ 400010p -0.3
+ 402000p -0.3
+ 402010p 0.9
+ 404000p 0.9
+ 404010p -0.3
+ 406000p -0.3
+ 406010p 0.9
+ 408000p 0.9
+ 408010p -0.3
+ 410000p -0.3
+ 410010p 0.9
+ 412000p 0.9
+ 412010p -0.3
+ 414000p -0.3
+ 414010p 0.9
+ 416000p 0.9
+ 416010p -0.3
+ 418000p -0.3
+ 418010p 0.9
+ 420000p 0.9
+ 420010p -0.3
+ 422000p -0.3
+ 422010p 0.9
+ 424000p 0.9
+ 424010p -0.3
+ 426000p -0.3
+ 426010p 0.9
+ 428000p 0.9
+ 428010p -0.3
+ 430000p -0.3
+ 430010p 0.9
+ 432000p 0.9
+ 432010p -0.3
+ 434000p -0.3
+ 434010p 0.9
+ 436000p 0.9
+ 436010p -0.3
+ 438000p -0.3
+ 438010p 0.9
+ 440000p 0.9
+ 440010p -0.3
+ 442000p -0.3
+ 442010p 0.9
+ 444000p 0.9
+ 444010p -0.3
+ 446000p -0.3
+ 446010p 0.9
+ 448000p 0.9
+ 448010p -0.3
+ 450000p -0.3
+ 450010p 0.9
+ 452000p 0.9
+ 452010p -0.3
+ 454000p -0.3
+ 454010p 0.9
+ 456000p 0.9
+ 456010p -0.3
+ 458000p -0.3
+ 458010p 0.9
+ 460000p 0.9
+ 460010p -0.3
+ 462000p -0.3
+ 462010p 0.9
+ 464000p 0.9
+ 464010p -0.3
+ 466000p -0.3
+ 466010p 0.9
+ 468000p 0.9
+ 468010p -0.3
+ 470000p -0.3
+ 470010p 0.9
+ 472000p 0.9
+ 472010p -0.3
+ 474000p -0.3
+ 474010p 0.9
+ 476000p 0.9
+ 476010p -0.3
+ 478000p -0.3
+ 478010p 0.9
+ 480000p 0.9
+ 480010p -0.3
+ 482000p -0.3
+ 482010p 0.9
+ 484000p 0.9
+ 484010p -0.3
+ 486000p -0.3
+ 486010p 0.9
+ 488000p 0.9
+ 488010p -0.3
+ 490000p -0.3
+ 490010p 0.9
+ 492000p 0.9
+ 492010p -0.3
+ 494000p -0.3
+ 494010p 0.9
+ 496000p 0.9
+ 496010p -0.3
+ 498000p -0.3
+ 498010p 0.9
+ 500000p 0.9
+ 500010p -0.3
+ 502000p -0.3
+ 502010p 0.9
+ 504000p 0.9
+ 504010p -0.3
+ 506000p -0.3
+ 506010p 0.9
+ 508000p 0.9
+ 508010p -0.3
+ 510000p -0.3
+ 510010p 0.9
+ 512000p 0.9
+ 512010p -0.3
+ 514000p -0.3
+ 514010p 0.9
+ 516000p 0.9
+ 516010p -0.3
+ 518000p -0.3
+ 518010p 0.9
+ 520000p 0.9
+ 520010p -0.3
+ 522000p -0.3
+ 522010p 0.9
+ 524000p 0.9
+ 524010p -0.3
+ 526000p -0.3
+ 526010p 0.9
+ 528000p 0.9
+ 528010p -0.3
+ 530000p -0.3
+ 530010p 0.9
+ 532000p 0.9
+ 532010p -0.3
+ 534000p -0.3
+ 534010p 0.9
+ 536000p 0.9
+ 536010p -0.3
+ 538000p -0.3
+ 538010p 0.9
+ 540000p 0.9
+ 540010p -0.3
+ 542000p -0.3
+ 542010p 0.9
+ 544000p 0.9
+ 544010p -0.3
+ 546000p -0.3
+ 546010p 0.9
+ 548000p 0.9
+ 548010p -0.3
+ 550000p -0.3
+ 550010p 0.9
+ 552000p 0.9
+ 552010p -0.3
+ 554000p -0.3
+ 554010p 0.9
+ 556000p 0.9
+ 556010p -0.3
+ 558000p -0.3
+ 558010p 0.9
+ 560000p 0.9
+ 560010p -0.3
+ 562000p -0.3
+ 562010p 0.9
+ 564000p 0.9
+ 564010p -0.3
+ 566000p -0.3
+ 566010p 0.9
+ 568000p 0.9
+ 568010p -0.3
+ 570000p -0.3
+ 570010p 0.9
+ 572000p 0.9
+ 572010p -0.3
+ 574000p -0.3
+ 574010p 0.9
+ 576000p 0.9
+ 576010p -0.3
+ 578000p -0.3
+ 578010p 0.9
+ 580000p 0.9
+ 580010p -0.3
+ 582000p -0.3
+ 582010p 0.9
+ 584000p 0.9
+ 584010p -0.3
+ 586000p -0.3
+ 586010p 0.9
+ 588000p 0.9
+ 588010p -0.3
+ 590000p -0.3
+ 590010p 0.9
+ 592000p 0.9
+ 592010p -0.3
+ 594000p -0.3
+ 594010p 0.9
+ 596000p 0.9
+ 596010p -0.3
+ 598000p -0.3
+ 598010p 0.9
+ 600000p 0.9
+ 600010p -0.3
+ 602000p -0.3
+ 602010p 0.9
+ 604000p 0.9
+ 604010p -0.3
+ 606000p -0.3
+ 606010p 0.9
+ 608000p 0.9
+ 608010p -0.3
+ 610000p -0.3
+ 610010p 0.9
+ 612000p 0.9
+ 612010p -0.3
+ 614000p -0.3
+ 614010p 0.9
+ 616000p 0.9
+ 616010p -0.3
+ 618000p -0.3
+ 618010p 0.9
+ 620000p 0.9
+ 620010p -0.3
+ 622000p -0.3
+ 622010p 0.9
+ 624000p 0.9
+ 624010p -0.3
+ 626000p -0.3
+ 626010p 0.9
+ 628000p 0.9
+ 628010p -0.3
+ 630000p -0.3
+ 630010p 0.9
+ 632000p 0.9
+ 632010p -0.3
+ 634000p -0.3
+ 634010p 0.9
+ 636000p 0.9
+ 636010p -0.3
+ 638000p -0.3
+ 638010p 0.9
+ 640000p 0.9
+ 640010p -0.3
+ 642000p -0.3
+ 642010p 0.9
+ 644000p 0.9
+ 644010p -0.3
+ 646000p -0.3
+ 646010p 0.9
+ 648000p 0.9
+ 648010p -0.3
+ 650000p -0.3
+ 650010p 0.9
+ 652000p 0.9
+ 652010p -0.3
+ 654000p -0.3
+ 654010p 0.9
+ 656000p 0.9
+ 656010p -0.3
+ 658000p -0.3
+ 658010p 0.9
+ 660000p 0.9
+ 660010p -0.3
+ 662000p -0.3
+ 662010p 0.9
+ 664000p 0.9
+ 664010p -0.3
+ 666000p -0.3
+ 666010p 0.9
+ 668000p 0.9
+ 668010p -0.3
+ 670000p -0.3
+ 670010p 0.9
+ 672000p 0.9
+ 672010p -0.3
+ 674000p -0.3
+ 674010p 0.9
+ 676000p 0.9
+ 676010p -0.3
+ 678000p -0.3
+ 678010p 0.9
+ 680000p 0.9
+ 680010p -0.3
+ 682000p -0.3
+ 682010p 0.9
+ 684000p 0.9
+ 684010p -0.3
+ 686000p -0.3
+ 686010p 0.9
+ 688000p 0.9
+ 688010p -0.3
+ 690000p -0.3
+ 690010p 0.9
+ 692000p 0.9
+ 692010p -0.3
+ 694000p -0.3
+ 694010p 0.9
+ 696000p 0.9
+ 696010p -0.3
+ 698000p -0.3
+ 698010p 0.9
+ 700000p 0.9
+ 700010p -0.3
+ 702000p -0.3
+ 702010p 0.9
+ 704000p 0.9
+ 704010p -0.3
+ 706000p -0.3
+ 706010p 0.9
+ 708000p 0.9
+ 708010p -0.3
+ 710000p -0.3
+ 710010p 0.9
+ 712000p 0.9
+ 712010p -0.3
+ 714000p -0.3
+ 714010p 0.9
+ 716000p 0.9
+ 716010p -0.3
+ 718000p -0.3
+ 718010p 0.9
+ 720000p 0.9
+ 720010p -0.3
+ 722000p -0.3
+ 722010p 0.9
+ 724000p 0.9
+ 724010p -0.3
+ 726000p -0.3
+ 726010p 0.9
+ 728000p 0.9
+ 728010p -0.3
+ 730000p -0.3
+ 730010p 0.9
+ 732000p 0.9
+ 732010p -0.3
+ 734000p -0.3
+ 734010p 0.9
+ 736000p 0.9
+ 736010p -0.3
+ 738000p -0.3
+ 738010p 0.9
+ 740000p 0.9
+ 740010p -0.3
+ 742000p -0.3
+ 742010p 0.9
+ 744000p 0.9
+ 744010p -0.3
+ 746000p -0.3
+ 746010p 0.9
+ 748000p 0.9
+ 748010p -0.3
+ 750000p -0.3
+ 750010p 0.9
+ 752000p 0.9
+ 752010p -0.3
+ 754000p -0.3
+ 754010p 0.9
+ 756000p 0.9
+ 756010p -0.3
+ 758000p -0.3
+ 758010p 0.9
+ 760000p 0.9
+ 760010p -0.3
+ 762000p -0.3
+ 762010p 0.9
+ 764000p 0.9
+ 764010p -0.3
+ 766000p -0.3
+ 766010p 0.9
+ 768000p 0.9
+ 768010p -0.3
+ 770000p -0.3
+ 770010p 0.9
+ 772000p 0.9
+ 772010p -0.3
+ 774000p -0.3
+ 774010p 0.9
+ 776000p 0.9
+ 776010p -0.3
+ 778000p -0.3
+ 778010p 0.9
+ 780000p 0.9
+ 780010p -0.3
+ 782000p -0.3
+ 782010p 0.9
+ 784000p 0.9
+ 784010p -0.3
+ 786000p -0.3
+ 786010p 0.9
+ 788000p 0.9
+ 788010p -0.3
+ 790000p -0.3
+ 790010p 0.9
+ 792000p 0.9
+ 792010p -0.3
+ 794000p -0.3
+ 794010p 0.9
+ 796000p 0.9
+ 796010p -0.3
+ 798000p -0.3
+ 798010p 0.9
+ 800000p 0.9
+ 800010p -0.3
+ 802000p -0.3
+ 802010p 0.9
+ 804000p 0.9
+ 804010p -0.3
+ 806000p -0.3
+ 806010p 0.9
+ 808000p 0.9
+ 808010p -0.3
+ 810000p -0.3
+ 810010p 0.9
+ 812000p 0.9
+ 812010p -0.3
+ 814000p -0.3
+ 814010p 0.9
+ 816000p 0.9
+ 816010p -0.3
+ 818000p -0.3
+ 818010p 0.9
+ 820000p 0.9
+ 820010p -0.3
+ 822000p -0.3
+ 822010p 0.9
+ 824000p 0.9
+ 824010p -0.3
+ 826000p -0.3
+ 826010p 0.9
+ 828000p 0.9
+ 828010p -0.3
+ 830000p -0.3
+ 830010p 0.9
+ 832000p 0.9
+ 832010p -0.3
+ 834000p -0.3
+ 834010p 0.9
+ 836000p 0.9
+ 836010p -0.3
+ 838000p -0.3
+ 838010p 0.9
+ 840000p 0.9
+ 840010p -0.3
+ 842000p -0.3
+ 842010p 0.9
+ 844000p 0.9
+ 844010p -0.3
+ 846000p -0.3
+ 846010p 0.9
+ 848000p 0.9
+ 848010p -0.3
+ 850000p -0.3
+ 850010p 0.9
+ 852000p 0.9
+ 852010p -0.3
+ 854000p -0.3
+ 854010p 0.9
+ 856000p 0.9
+ 856010p -0.3
+ 858000p -0.3
+ 858010p 0.9
+ 860000p 0.9
+ 860010p -0.3
+ 862000p -0.3
+ 862010p 0.9
+ 864000p 0.9
+ 864010p -0.3
+ 866000p -0.3
+ 866010p 0.9
+ 868000p 0.9
+ 868010p -0.3
+ 870000p -0.3
+ 870010p 0.9
+ 872000p 0.9
+ 872010p -0.3
+ 874000p -0.3
+ 874010p 0.9
+ 876000p 0.9
+ 876010p -0.3
+ 878000p -0.3
+ 878010p 0.9
+ 880000p 0.9
+ 880010p -0.3
+ 882000p -0.3
+ 882010p 0.9
+ 884000p 0.9
+ 884010p -0.3
+ 886000p -0.3
+ 886010p 0.9
+ 888000p 0.9
+ 888010p -0.3
+ 890000p -0.3
+ 890010p 0.9
+ 892000p 0.9
+ 892010p -0.3
+ 894000p -0.3
+ 894010p 0.9
+ 896000p 0.9
+ 896010p -0.3
+ 898000p -0.3
+ 898010p 0.9
+ 900000p 0.9
+ 900010p -0.3
+ 902000p -0.3
+ 902010p 0.9
+ 904000p 0.9
+ 904010p -0.3
+ 906000p -0.3
+ 906010p 0.9
+ 908000p 0.9
+ 908010p -0.3
+ 910000p -0.3
+ 910010p 0.9
+ 912000p 0.9
+ 912010p -0.3
+ 914000p -0.3
+ 914010p 0.9
+ 916000p 0.9
+ 916010p -0.3
+ 918000p -0.3
+ 918010p 0.9
+ 920000p 0.9
+ 920010p -0.3
+ 922000p -0.3
+ 922010p 0.9
+ 924000p 0.9
+ 924010p -0.3
+ 926000p -0.3
+ 926010p 0.9
+ 928000p 0.9
+ 928010p -0.3
+ 930000p -0.3
+ 930010p 0.9
+ 932000p 0.9
+ 932010p -0.3
+ 934000p -0.3
+ 934010p 0.9
+ 936000p 0.9
+ 936010p -0.3
+ 938000p -0.3
+ 938010p 0.9
+ 940000p 0.9
+ 940010p -0.3
+ 942000p -0.3
+ 942010p 0.9
+ 944000p 0.9
+ 944010p -0.3
+ 946000p -0.3
+ 946010p 0.9
+ 948000p 0.9
+ 948010p -0.3
+ 950000p -0.3
+ 950010p 0.9
+ 952000p 0.9
+ 952010p -0.3
+ 954000p -0.3
+ 954010p 0.9
+ 956000p 0.9
+ 956010p -0.3
+ 958000p -0.3
+ 958010p 0.9
+ 960000p 0.9
+ 960010p -0.3
+ 962000p -0.3
+ 962010p 0.9
+ 964000p 0.9
+ 964010p -0.3
+ 966000p -0.3
+ 966010p 0.9
+ 968000p 0.9
+ 968010p -0.3
+ 970000p -0.3
+ 970010p 0.9
+ 972000p 0.9
+ 972010p -0.3
+ 974000p -0.3
+ 974010p 0.9
+ 976000p 0.9
+ 976010p -0.3
+ 978000p -0.3
+ 978010p 0.9
+ 980000p 0.9
+ 980010p -0.3
+ 982000p -0.3
+ 982010p 0.9
+ 984000p 0.9
+ 984010p -0.3
+ 986000p -0.3
+ 986010p 0.9
+ 988000p 0.9
+ 988010p -0.3
+ 990000p -0.3
+ 990010p 0.9
+ 992000p 0.9
+ 992010p -0.3
+ 994000p -0.3
+ 994010p 0.9
+ 996000p 0.9
+ 996010p -0.3
+ 998000p -0.3
+ 998010p 0.9
+ 1000000p 0.9
+ 1000010p -0.3
+ 1002000p -0.3
+ 1002010p 0.9
+ 1004000p 0.9
+ 1004010p -0.3
+ 1006000p -0.3
+ 1006010p 0.9
+ 1008000p 0.9
+ 1008010p -0.3
+ 1010000p -0.3
+ 1010010p 0.9
+ 1012000p 0.9
+ 1012010p -0.3
+ 1014000p -0.3
+ 1014010p 0.9
+ 1016000p 0.9
+ 1016010p -0.3
+ 1018000p -0.3
+ 1018010p 0.9
+ 1020000p 0.9
+ 1020010p -0.3
+ 1022000p -0.3
+ 1022010p 0.9
+ 1024000p 0.9
+ 1024010p -0.3
+ 1026000p -0.3
+ 1026010p 0.9
+ 1028000p 0.9
+ 1028010p -0.3
+ 1030000p -0.3
+ 1030010p 0.9
+ 1032000p 0.9
+ 1032010p -0.3
+ 1034000p -0.3
+ 1034010p 0.9
+ 1036000p 0.9
+ 1036010p -0.3
+ 1038000p -0.3
+ 1038010p 0.9
+ 1040000p 0.9
+ 1040010p -0.3
+ 1042000p -0.3
+ 1042010p 0.9
+ 1044000p 0.9
+ 1044010p -0.3
+ 1046000p -0.3
+ 1046010p 0.9
+ 1048000p 0.9
+ 1048010p -0.3
+ 1050000p -0.3
+ 1050010p 0.9
+ 1052000p 0.9
+ 1052010p -0.3
+ 1054000p -0.3
+ 1054010p 0.9
+ 1056000p 0.9
+ 1056010p -0.3
+ 1058000p -0.3
+ 1058010p 0.9
+ 1060000p 0.9
+ 1060010p -0.3
+ 1062000p -0.3
+ 1062010p 0.9
+ 1064000p 0.9
+ 1064010p -0.3
+ 1066000p -0.3
+ 1066010p 0.9
+ 1068000p 0.9
+ 1068010p -0.3
+ 1070000p -0.3
+ 1070010p 0.9
+ 1072000p 0.9
+ 1072010p -0.3
+ 1074000p -0.3
+ 1074010p 0.9
+ 1076000p 0.9
+ 1076010p -0.3
+ 1078000p -0.3
+ 1078010p 0.9
+ 1080000p 0.9
+ 1080010p -0.3
+ 1082000p -0.3
+ 1082010p 0.9
+ 1084000p 0.9
+ 1084010p -0.3
+ 1086000p -0.3
+ 1086010p 0.9
+ 1088000p 0.9
+ 1088010p -0.3
+ 1090000p -0.3
+ 1090010p 0.9
+ 1092000p 0.9
+ 1092010p -0.3
+ 1094000p -0.3
+ 1094010p 0.9
+ 1096000p 0.9
+ 1096010p -0.3
+ 1098000p -0.3
+ 1098010p 0.9
+ 1100000p 0.9
+ 1100010p -0.3
+ 1102000p -0.3
+ 1102010p 0.9
+ 1104000p 0.9
+ 1104010p -0.3
+ 1106000p -0.3
+ 1106010p 0.9
+ 1108000p 0.9
+ 1108010p -0.3
+ 1110000p -0.3
+ 1110010p 0.9
+ 1112000p 0.9
+ 1112010p -0.3
+ 1114000p -0.3
+ 1114010p 0.9
+ 1116000p 0.9
+ 1116010p -0.3
+ 1118000p -0.3
+ 1118010p 0.9
+ 1120000p 0.9
+ 1120010p -0.3
+ 1122000p -0.3
+ 1122010p 0.9
+ 1124000p 0.9
+ 1124010p -0.3
+ 1126000p -0.3
+ 1126010p 0.9
+ 1128000p 0.9
+ 1128010p -0.3
+ 1130000p -0.3
+ 1130010p 0.9
+ 1132000p 0.9
+ 1132010p -0.3
+ 1134000p -0.3
+ 1134010p 0.9
+ 1136000p 0.9
+ 1136010p -0.3
+ 1138000p -0.3
+ 1138010p 0.9
+ 1140000p 0.9
+ 1140010p -0.3
+ 1142000p -0.3
+ 1142010p 0.9
+ 1144000p 0.9
+ 1144010p -0.3
+ 1146000p -0.3
+ 1146010p 0.9
+ 1148000p 0.9
+ 1148010p -0.3
+ 1150000p -0.3
+ 1150010p 0.9
+ 1152000p 0.9
+ 1152010p -0.3
+ 1154000p -0.3
+ 1154010p 0.9
+ 1156000p 0.9
+ 1156010p -0.3
+ 1158000p -0.3
+ 1158010p 0.9
+ 1160000p 0.9
+ 1160010p -0.3
+ 1162000p -0.3
+ 1162010p 0.9
+ 1164000p 0.9
+ 1164010p -0.3
+ 1166000p -0.3
+ 1166010p 0.9
+ 1168000p 0.9
+ 1168010p -0.3
+ 1170000p -0.3
+ 1170010p 0.9
+ 1172000p 0.9
+ 1172010p -0.3
+ 1174000p -0.3
+ 1174010p 0.9
+ 1176000p 0.9
+ 1176010p -0.3
+ 1178000p -0.3
+ 1178010p 0.9
+ 1180000p 0.9
+ 1180010p -0.3
+ 1182000p -0.3
+ 1182010p 0.9
+ 1184000p 0.9
+ 1184010p -0.3
+ 1186000p -0.3
+ 1186010p 0.9
+ 1188000p 0.9
+ 1188010p -0.3
+ 1190000p -0.3
+ 1190010p 0.9
+ 1192000p 0.9
+ 1192010p -0.3
+ 1194000p -0.3
+ 1194010p 0.9
+ 1196000p 0.9
+ 1196010p -0.3
+ 1198000p -0.3
+ 1198010p 0.9
+ 1200000p 0.9
+ 1200010p -0.3
+ 1202000p -0.3
+ 1202010p 0.9
+ 1204000p 0.9
+ 1204010p -0.3
+ 1206000p -0.3
+ 1206010p 0.9
+ 1208000p 0.9
+ 1208010p -0.3
+ 1210000p -0.3
+ 1210010p 0.9
+ 1212000p 0.9
+ 1212010p -0.3
+ 1214000p -0.3
+ 1214010p 0.9
+ 1216000p 0.9
+ 1216010p -0.3
+ 1218000p -0.3
+ 1218010p 0.9
+ 1220000p 0.9
+ 1220010p -0.3
+ 1222000p -0.3
+ 1222010p 0.9
+ 1224000p 0.9
+ 1224010p -0.3
+ 1226000p -0.3
+ 1226010p 0.9
+ 1228000p 0.9
+ 1228010p -0.3
+ 1230000p -0.3
+ 1230010p 0.9
+ 1232000p 0.9
+ 1232010p -0.3
+ 1234000p -0.3
+ 1234010p 0.9
+ 1236000p 0.9
+ 1236010p -0.3
+ 1238000p -0.3
+ 1238010p 0.9
+ 1240000p 0.9
+ 1240010p -0.3
+ 1242000p -0.3
+ 1242010p 0.9
+ 1244000p 0.9
+ 1244010p -0.3
+ 1246000p -0.3
+ 1246010p 0.9
+ 1248000p 0.9
+ 1248010p -0.3
+ 1250000p -0.3
+ 1250010p 0.9
+ 1252000p 0.9
+ 1252010p -0.3
+ 1254000p -0.3
+ 1254010p 0.9
+ 1256000p 0.9
+ 1256010p -0.3
+ 1258000p -0.3
+ 1258010p 0.9
+ 1260000p 0.9
+ 1260010p -0.3
+ 1262000p -0.3
+ 1262010p 0.9
+ 1264000p 0.9
+ 1264010p -0.3
+ 1266000p -0.3
+ 1266010p 0.9
+ 1268000p 0.9
+ 1268010p -0.3
+ 1270000p -0.3
+ 1270010p 0.9
+ 1272000p 0.9
+ 1272010p -0.3
+ 1274000p -0.3
+ 1274010p 0.9
+ 1276000p 0.9
+ 1276010p -0.3
+ 1278000p -0.3
+ 1278010p 0.9
+ 1280000p 0.9
+ 1280010p -0.3
+ 1282000p -0.3
+ 1282010p 0.9
+ 1284000p 0.9
+ 1284010p -0.3
+ 1286000p -0.3
+ 1286010p 0.9
+ 1288000p 0.9
+ 1288010p -0.3
+ 1290000p -0.3
+ 1290010p 0.9
+ 1292000p 0.9
+ 1292010p -0.3
+ 1294000p -0.3
+ 1294010p 0.9
+ 1296000p 0.9
+ 1296010p -0.3
+ 1298000p -0.3
+ 1298010p 0.9
+ 1300000p 0.9
+ 1300010p -0.3
+ 1302000p -0.3
+ 1302010p 0.9
+ 1304000p 0.9
+ 1304010p -0.3
+ 1306000p -0.3
+ 1306010p 0.9
+ 1308000p 0.9
+ 1308010p -0.3
+ 1310000p -0.3
+ 1310010p 0.9
+ 1312000p 0.9
+ 1312010p -0.3
+ 1314000p -0.3
+ 1314010p 0.9
+ 1316000p 0.9
+ 1316010p -0.3
+ 1318000p -0.3
+ 1318010p 0.9
+ 1320000p 0.9
+ 1320010p -0.3
+ 1322000p -0.3
+ 1322010p 0.9
+ 1324000p 0.9
+ 1324010p -0.3
+ 1326000p -0.3
+ 1326010p 0.9
+ 1328000p 0.9
+ 1328010p -0.3
+ 1330000p -0.3
+ 1330010p 0.9
+ 1332000p 0.9
+ 1332010p -0.3
+ 1334000p -0.3
+ 1334010p 0.9
+ 1336000p 0.9
+ 1336010p -0.3
+ 1338000p -0.3
+ 1338010p 0.9
+ 1340000p 0.9
+ 1340010p -0.3
+ 1342000p -0.3
+ 1342010p 0.9
+ 1344000p 0.9
+ 1344010p -0.3
+ 1346000p -0.3
+ 1346010p 0.9
+ 1348000p 0.9
+ 1348010p -0.3
+ 1350000p -0.3
+ 1350010p 0.9
+ 1352000p 0.9
+ 1352010p -0.3
+ 1354000p -0.3
+ 1354010p 0.9
+ 1356000p 0.9
+ 1356010p -0.3
+ 1358000p -0.3
+ 1358010p 0.9
+ 1360000p 0.9
+ 1360010p -0.3
+ 1362000p -0.3
+ 1362010p 0.9
+ 1364000p 0.9
+ 1364010p -0.3
+ 1366000p -0.3
+ 1366010p 0.9
+ 1368000p 0.9
+ 1368010p -0.3
+ 1370000p -0.3
+ 1370010p 0.9
+ 1372000p 0.9
+ 1372010p -0.3
+ 1374000p -0.3
+ 1374010p 0.9
+ 1376000p 0.9
+ 1376010p -0.3
+ 1378000p -0.3
+ 1378010p 0.9
+ 1380000p 0.9
+ 1380010p -0.3
+ 1382000p -0.3
+ 1382010p 0.9
+ 1384000p 0.9
+ 1384010p -0.3
+ 1386000p -0.3
+ 1386010p 0.9
+ 1388000p 0.9
+ 1388010p -0.3
+ 1390000p -0.3
+ 1390010p 0.9
+ 1392000p 0.9
+ 1392010p -0.3
+ 1394000p -0.3
+ 1394010p 0.9
+ 1396000p 0.9
+ 1396010p -0.3
+ 1398000p -0.3
+ 1398010p 0.9
+ 1400000p 0.9
+ 1400010p -0.3
+ 1402000p -0.3
+ 1402010p 0.9
+ 1404000p 0.9
+ 1404010p -0.3
+ 1406000p -0.3
+ 1406010p 0.9
+ 1408000p 0.9
+ 1408010p -0.3
+ 1410000p -0.3
+ 1410010p 0.9
+ 1412000p 0.9
+ 1412010p -0.3
+ 1414000p -0.3
+ 1414010p 0.9
+ 1416000p 0.9
+ 1416010p -0.3
+ 1418000p -0.3
+ 1418010p 0.9
+ 1420000p 0.9
+ 1420010p -0.3
+ 1422000p -0.3
+ 1422010p 0.9
+ 1424000p 0.9
+ 1424010p -0.3
+ 1426000p -0.3
+ 1426010p 0.9
+ 1428000p 0.9
+ 1428010p -0.3
+ 1430000p -0.3
+ 1430010p 0.9
+ 1432000p 0.9
+ 1432010p -0.3
+ 1434000p -0.3
+ 1434010p 0.9
+ 1436000p 0.9
+ 1436010p -0.3
+ 1438000p -0.3
+ 1438010p 0.9
+ 1440000p 0.9
+ 1440010p -0.3
+ 1442000p -0.3
+ 1442010p 0.9
+ 1444000p 0.9
+ 1444010p -0.3
+ 1446000p -0.3
+ 1446010p 0.9
+ 1448000p 0.9
+ 1448010p -0.3
+ 1450000p -0.3
+ 1450010p 0.9
+ 1452000p 0.9
+ 1452010p -0.3
+ 1454000p -0.3
+ 1454010p 0.9
+ 1456000p 0.9
+ 1456010p -0.3
+ 1458000p -0.3
+ 1458010p 0.9
+ 1460000p 0.9
+ 1460010p -0.3
+ 1462000p -0.3
+ 1462010p 0.9
+ 1464000p 0.9
+ 1464010p -0.3
+ 1466000p -0.3
+ 1466010p 0.9
+ 1468000p 0.9
+ 1468010p -0.3
+ 1470000p -0.3
+ 1470010p 0.9
+ 1472000p 0.9
+ 1472010p -0.3
+ 1474000p -0.3
+ 1474010p 0.9
+ 1476000p 0.9
+ 1476010p -0.3
+ 1478000p -0.3
+ 1478010p 0.9
+ 1480000p 0.9
+ 1480010p -0.3
+ 1482000p -0.3
+ 1482010p 0.9
+ 1484000p 0.9
+ 1484010p -0.3
+ 1486000p -0.3
+ 1486010p 0.9
+ 1488000p 0.9
+ 1488010p -0.3
+ 1490000p -0.3
+ 1490010p 0.9
+ 1492000p 0.9
+ 1492010p -0.3
+ 1494000p -0.3
+ 1494010p 0.9
+ 1496000p 0.9
+ 1496010p -0.3
+ 1498000p -0.3
+ 1498010p 0.9
+ 1500000p 0.9
+ 1500010p -0.3
+ 1502000p -0.3
+ 1502010p 0.9
+ 1504000p 0.9
+ 1504010p -0.3
+ 1506000p -0.3
+ 1506010p 0.9
+ 1508000p 0.9
+ 1508010p -0.3
+ 1510000p -0.3
+ 1510010p 0.9
+ 1512000p 0.9
+ 1512010p -0.3
+ 1514000p -0.3
+ 1514010p 0.9
+ 1516000p 0.9
+ 1516010p -0.3
+ 1518000p -0.3
+ 1518010p 0.9
+ 1520000p 0.9
+ 1520010p -0.3
+ 1522000p -0.3
+ 1522010p 0.9
+ 1524000p 0.9
+ 1524010p -0.3
+ 1526000p -0.3
+ 1526010p 0.9
+ 1528000p 0.9
+ 1528010p -0.3
+ 1530000p -0.3
+ 1530010p 0.9
+ 1532000p 0.9
+ 1532010p -0.3
+ 1534000p -0.3
+ 1534010p 0.9
+ 1536000p 0.9
+ 1536010p -0.3
+ 1538000p -0.3
+ 1538010p 0.9
+ 1540000p 0.9
+ 1540010p -0.3
+ 1542000p -0.3
+ 1542010p 0.9
+ 1544000p 0.9
+ 1544010p -0.3
+ 1546000p -0.3
+ 1546010p 0.9
+ 1548000p 0.9
+ 1548010p -0.3
+ 1550000p -0.3
+ 1550010p 0.9
+ 1552000p 0.9
+ 1552010p -0.3
+ 1554000p -0.3
+ 1554010p 0.9
+ 1556000p 0.9
+ 1556010p -0.3
+ 1558000p -0.3
+ 1558010p 0.9
+ 1560000p 0.9
+ 1560010p -0.3
+ 1562000p -0.3
+ 1562010p 0.9
+ 1564000p 0.9
+ 1564010p -0.3
+ 1566000p -0.3
+ 1566010p 0.9
+ 1568000p 0.9
+ 1568010p -0.3
+ 1570000p -0.3
+ 1570010p 0.9
+ 1572000p 0.9
+ 1572010p -0.3
+ 1574000p -0.3
+ 1574010p 0.9
+ 1576000p 0.9
+ 1576010p -0.3
+ 1578000p -0.3
+ 1578010p 0.9
+ 1580000p 0.9
+ 1580010p -0.3
+ 1582000p -0.3
+ 1582010p 0.9
+ 1584000p 0.9
+ 1584010p -0.3
+ 1586000p -0.3
+ 1586010p 0.9
+ 1588000p 0.9
+ 1588010p -0.3
+ 1590000p -0.3
+ 1590010p 0.9
+ 1592000p 0.9
+ 1592010p -0.3
+ 1594000p -0.3
+ 1594010p 0.9
+ 1596000p 0.9
+ 1596010p -0.3
+ 1598000p -0.3
+ 1598010p 0.9
+ 1600000p 0.9
+ 1600010p -0.3
+ 1602000p -0.3
+ 1602010p 0.9
+ 1604000p 0.9
+ 1604010p -0.3
+ 1606000p -0.3
+ 1606010p 0.9
+ 1608000p 0.9
+ 1608010p -0.3
+ 1610000p -0.3
+ 1610010p 0.9
+ 1612000p 0.9
+ 1612010p -0.3
+ 1614000p -0.3
+ 1614010p 0.9
+ 1616000p 0.9
+ 1616010p -0.3
+ 1618000p -0.3
+ 1618010p 0.9
+ 1620000p 0.9
+ 1620010p -0.3
+ 1622000p -0.3
+ 1622010p 0.9
+ 1624000p 0.9
+ 1624010p -0.3
+ 1626000p -0.3
+ 1626010p 0.9
+ 1628000p 0.9
+ 1628010p -0.3
+ 1630000p -0.3
+ 1630010p 0.9
+ 1632000p 0.9
+ 1632010p -0.3
+ 1634000p -0.3
+ 1634010p 0.9
+ 1636000p 0.9
+ 1636010p -0.3
+ 1638000p -0.3
+ 1638010p 0.9
+ 1640000p 0.9
+ 1640010p -0.3
+ 1642000p -0.3
+ 1642010p 0.9
+ 1644000p 0.9
+ 1644010p -0.3
+ 1646000p -0.3
+ 1646010p 0.9
+ 1648000p 0.9
+ 1648010p -0.3
+ 1650000p -0.3
+ 1650010p 0.9
+ 1652000p 0.9
+ 1652010p -0.3
+ 1654000p -0.3
+ 1654010p 0.9
+ 1656000p 0.9
+ 1656010p -0.3
+ 1658000p -0.3
+ 1658010p 0.9
+ 1660000p 0.9
+ 1660010p -0.3
+ 1662000p -0.3
+ 1662010p 0.9
+ 1664000p 0.9
+ 1664010p -0.3
+ 1666000p -0.3
+ 1666010p 0.9
+ 1668000p 0.9
+ 1668010p -0.3
+ 1670000p -0.3
+ 1670010p 0.9
+ 1672000p 0.9
+ 1672010p -0.3
+ 1674000p -0.3
+ 1674010p 0.9
+ 1676000p 0.9
+ 1676010p -0.3
+ 1678000p -0.3
+ 1678010p 0.9
+ 1680000p 0.9
+ 1680010p -0.3
+ 1682000p -0.3
+ 1682010p 0.9
+ 1684000p 0.9
+ 1684010p -0.3
+ 1686000p -0.3
+ 1686010p 0.9
+ 1688000p 0.9
+ 1688010p -0.3
+ 1690000p -0.3
+ 1690010p 0.9
+ 1692000p 0.9
+ 1692010p -0.3
+ 1694000p -0.3
+ 1694010p 0.9
+ 1696000p 0.9
+ 1696010p -0.3
+ 1698000p -0.3
+ 1698010p 0.9
+ 1700000p 0.9
+ 1700010p -0.3
+ 1702000p -0.3
+ 1702010p 0.9
+ 1704000p 0.9
+ 1704010p -0.3
+ 1706000p -0.3
+ 1706010p 0.9
+ 1708000p 0.9
+ 1708010p -0.3
+ 1710000p -0.3
+ 1710010p 0.9
+ 1712000p 0.9
+ 1712010p -0.3
+ 1714000p -0.3
+ 1714010p 0.9
+ 1716000p 0.9
+ 1716010p -0.3
+ 1718000p -0.3
+ 1718010p 0.9
+ 1720000p 0.9
+ 1720010p -0.3
+ 1722000p -0.3
+ 1722010p 0.9
+ 1724000p 0.9
+ 1724010p -0.3
+ 1726000p -0.3
+ 1726010p 0.9
+ 1728000p 0.9
+ 1728010p -0.3
+ 1730000p -0.3
+ 1730010p 0.9
+ 1732000p 0.9
+ 1732010p -0.3
+ 1734000p -0.3
+ 1734010p 0.9
+ 1736000p 0.9
+ 1736010p -0.3
+ 1738000p -0.3
+ 1738010p 0.9
+ 1740000p 0.9
+ 1740010p -0.3
+ 1742000p -0.3
+ 1742010p 0.9
+ 1744000p 0.9
+ 1744010p -0.3
+ 1746000p -0.3
+ 1746010p 0.9
+ 1748000p 0.9
+ 1748010p -0.3
+ 1750000p -0.3
+ 1750010p 0.9
+ 1752000p 0.9
+ 1752010p -0.3
+ 1754000p -0.3
+ 1754010p 0.9
+ 1756000p 0.9
+ 1756010p -0.3
+ 1758000p -0.3
+ 1758010p 0.9
+ 1760000p 0.9
+ 1760010p -0.3
+ 1762000p -0.3
+ 1762010p 0.9
+ 1764000p 0.9
+ 1764010p -0.3
+ 1766000p -0.3
+ 1766010p 0.9
+ 1768000p 0.9
+ 1768010p -0.3
+ 1770000p -0.3
+ 1770010p 0.9
+ 1772000p 0.9
+ 1772010p -0.3
+ 1774000p -0.3
+ 1774010p 0.9
+ 1776000p 0.9
+ 1776010p -0.3
+ 1778000p -0.3
+ 1778010p 0.9
+ 1780000p 0.9
+ 1780010p -0.3
+ 1782000p -0.3
+ 1782010p 0.9
+ 1784000p 0.9
+ 1784010p -0.3
+ 1786000p -0.3
+ 1786010p 0.9
+ 1788000p 0.9
+ 1788010p -0.3
+ 1790000p -0.3
+ 1790010p 0.9
+ 1792000p 0.9
+ 1792010p -0.3
+ 1794000p -0.3
+ 1794010p 0.9
+ 1796000p 0.9
+ 1796010p -0.3
+ 1798000p -0.3
+ 1798010p 0.9
+ 1800000p 0.9
+ 1800010p -0.3
+ 1802000p -0.3
+ 1802010p 0.9
+ 1804000p 0.9
+ 1804010p -0.3
+ 1806000p -0.3
+ 1806010p 0.9
+ 1808000p 0.9
+ 1808010p -0.3
+ 1810000p -0.3
+ 1810010p 0.9
+ 1812000p 0.9
+ 1812010p -0.3
+ 1814000p -0.3
+ 1814010p 0.9
+ 1816000p 0.9
+ 1816010p -0.3
+ 1818000p -0.3
+ 1818010p 0.9
+ 1820000p 0.9
+ 1820010p -0.3
+ 1822000p -0.3
+ 1822010p 0.9
+ 1824000p 0.9
+ 1824010p -0.3
+ 1826000p -0.3
+ 1826010p 0.9
+ 1828000p 0.9
+ 1828010p -0.3
+ 1830000p -0.3
+ 1830010p 0.9
+ 1832000p 0.9
+ 1832010p -0.3
+ 1834000p -0.3
+ 1834010p 0.9
+ 1836000p 0.9
+ 1836010p -0.3
+ 1838000p -0.3
+ 1838010p 0.9
+ 1840000p 0.9
+ 1840010p -0.3
+ 1842000p -0.3
+ 1842010p 0.9
+ 1844000p 0.9
+ 1844010p -0.3
+ 1846000p -0.3
+ 1846010p 0.9
+ 1848000p 0.9
+ 1848010p -0.3
+ 1850000p -0.3
+ 1850010p 0.9
+ 1852000p 0.9
+ 1852010p -0.3
+ 1854000p -0.3
+ 1854010p 0.9
+ 1856000p 0.9
+ 1856010p -0.3
+ 1858000p -0.3
+ 1858010p 0.9
+ 1860000p 0.9
+ 1860010p -0.3
+ 1862000p -0.3
+ 1862010p 0.9
+ 1864000p 0.9
+ 1864010p -0.3
+ 1866000p -0.3
+ 1866010p 0.9
+ 1868000p 0.9
+ 1868010p -0.3
+ 1870000p -0.3
+ 1870010p 0.9
+ 1872000p 0.9
+ 1872010p -0.3
+ 1874000p -0.3
+ 1874010p 0.9
+ 1876000p 0.9
+ 1876010p -0.3
+ 1878000p -0.3
+ 1878010p 0.9
+ 1880000p 0.9
+ 1880010p -0.3
+ 1882000p -0.3
+ 1882010p 0.9
+ 1884000p 0.9
+ 1884010p -0.3
+ 1886000p -0.3
+ 1886010p 0.9
+ 1888000p 0.9
+ 1888010p -0.3
+ 1890000p -0.3
+ 1890010p 0.9
+ 1892000p 0.9
+ 1892010p -0.3
+ 1894000p -0.3
+ 1894010p 0.9
+ 1896000p 0.9
+ 1896010p -0.3
+ 1898000p -0.3
+ 1898010p 0.9
+ 1900000p 0.9
+ 1900010p -0.3
+ 1902000p -0.3
+ 1902010p 0.9
+ 1904000p 0.9
+ 1904010p -0.3
+ 1906000p -0.3
+ 1906010p 0.9
+ 1908000p 0.9
+ 1908010p -0.3
+ 1910000p -0.3
+ 1910010p 0.9
+ 1912000p 0.9
+ 1912010p -0.3
+ 1914000p -0.3
+ 1914010p 0.9
+ 1916000p 0.9
+ 1916010p -0.3
+ 1918000p -0.3
+ 1918010p 0.9
+ 1920000p 0.9
+ 1920010p -0.3
+ 1922000p -0.3
+ 1922010p 0.9
+ 1924000p 0.9
+ 1924010p -0.3
+ 1926000p -0.3
+ 1926010p 0.9
+ 1928000p 0.9
+ 1928010p -0.3
+ 1930000p -0.3
+ 1930010p 0.9
+ 1932000p 0.9
+ 1932010p -0.3
+ 1934000p -0.3
+ 1934010p 0.9
+ 1936000p 0.9
+ 1936010p -0.3
+ 1938000p -0.3
+ 1938010p 0.9
+ 1940000p 0.9
+ 1940010p -0.3
+ 1942000p -0.3
+ 1942010p 0.9
+ 1944000p 0.9
+ 1944010p -0.3
+ 1946000p -0.3
+ 1946010p 0.9
+ 1948000p 0.9
+ 1948010p -0.3
+ 1950000p -0.3
+ 1950010p 0.9
+ 1952000p 0.9
+ 1952010p -0.3
+ 1954000p -0.3
+ 1954010p 0.9
+ 1956000p 0.9
+ 1956010p -0.3
+ 1958000p -0.3
+ 1958010p 0.9
+ 1960000p 0.9
+ 1960010p -0.3
+ 1962000p -0.3
+ 1962010p 0.9
+ 1964000p 0.9
+ 1964010p -0.3
+ 1966000p -0.3
+ 1966010p 0.9
+ 1968000p 0.9
+ 1968010p -0.3
+ 1970000p -0.3
+ 1970010p 0.9
+ 1972000p 0.9
+ 1972010p -0.3
+ 1974000p -0.3
+ 1974010p 0.9
+ 1976000p 0.9
+ 1976010p -0.3
+ 1978000p -0.3
+ 1978010p 0.9
+ 1980000p 0.9
+ 1980010p -0.3
+ 1982000p -0.3
+ 1982010p 0.9
+ 1984000p 0.9
+ 1984010p -0.3
+ 1986000p -0.3
+ 1986010p 0.9
+ 1988000p 0.9
+ 1988010p -0.3
+ 1990000p -0.3
+ 1990010p 0.9
+ 1992000p 0.9
+ 1992010p -0.3
+ 1994000p -0.3
+ 1994010p 0.9
+ 1996000p 0.9
+ 1996010p -0.3
+ 1998000p -0.3
+ 1998010p 0.9
+ 2000000p 0.9
+ 2000010p -0.3
+ 2002000p -0.3
+ 2002010p 0.9
+ 2004000p 0.9
+ 2004010p -0.3
+ 2006000p -0.3
+ 2006010p 0.9
+ 2008000p 0.9
+ 2008010p -0.3
+ 2010000p -0.3
+ 2010010p 0.9
+ 2012000p 0.9
+ 2012010p -0.3
+ 2014000p -0.3
+ 2014010p 0.9
+ 2016000p 0.9
+ 2016010p -0.3
+ 2018000p -0.3
+ 2018010p 0.9
+ 2020000p 0.9
+ 2020010p -0.3
+ 2022000p -0.3
+ 2022010p 0.9
+ 2024000p 0.9
+ 2024010p -0.3
+ 2026000p -0.3
+ 2026010p 0.9
+ 2028000p 0.9
+ 2028010p -0.3
+ 2030000p -0.3
+ 2030010p 0.9
+ 2032000p 0.9
+ 2032010p -0.3
+ 2034000p -0.3
+ 2034010p 0.9
+ 2036000p 0.9
+ 2036010p -0.3
+ 2038000p -0.3
+ 2038010p 0.9
+ 2040000p 0.9
+ 2040010p -0.3
+ 2042000p -0.3
+ 2042010p 0.9
+ 2044000p 0.9
+ 2044010p -0.3
+ 2046000p -0.3
+ 2046010p 0.9
+ 2048000p 0.9
+ 2048010p -0.3
+ \]
V_data_2 (Data\\<2\\> gnd!) vsource type=pwl wave=\[
+ 0    0.9
+ 2000p 0.9
+ 2010p -0.3
+ 4000p -0.3
+ 4010p 0.9
+ 6000p 0.9
+ 6010p -0.3
+ 8000p -0.3
+ 8010p 0.9
+ 10000p 0.9
+ 10010p -0.3
+ 12000p -0.3
+ 12010p 0.9
+ 14000p 0.9
+ 14010p -0.3
+ 16000p -0.3
+ 16010p 0.9
+ 18000p 0.9
+ 18010p -0.3
+ 20000p -0.3
+ 20010p 0.9
+ 22000p 0.9
+ 22010p -0.3
+ 24000p -0.3
+ 24010p 0.9
+ 26000p 0.9
+ 26010p -0.3
+ 28000p -0.3
+ 28010p 0.9
+ 30000p 0.9
+ 30010p -0.3
+ 32000p -0.3
+ 32010p 0.9
+ 34000p 0.9
+ 34010p -0.3
+ 36000p -0.3
+ 36010p 0.9
+ 38000p 0.9
+ 38010p -0.3
+ 40000p -0.3
+ 40010p 0.9
+ 42000p 0.9
+ 42010p -0.3
+ 44000p -0.3
+ 44010p 0.9
+ 46000p 0.9
+ 46010p -0.3
+ 48000p -0.3
+ 48010p 0.9
+ 50000p 0.9
+ 50010p -0.3
+ 52000p -0.3
+ 52010p 0.9
+ 54000p 0.9
+ 54010p -0.3
+ 56000p -0.3
+ 56010p 0.9
+ 58000p 0.9
+ 58010p -0.3
+ 60000p -0.3
+ 60010p 0.9
+ 62000p 0.9
+ 62010p -0.3
+ 64000p -0.3
+ 64010p 0.9
+ 66000p 0.9
+ 66010p -0.3
+ 68000p -0.3
+ 68010p 0.9
+ 70000p 0.9
+ 70010p -0.3
+ 72000p -0.3
+ 72010p 0.9
+ 74000p 0.9
+ 74010p -0.3
+ 76000p -0.3
+ 76010p 0.9
+ 78000p 0.9
+ 78010p -0.3
+ 80000p -0.3
+ 80010p 0.9
+ 82000p 0.9
+ 82010p -0.3
+ 84000p -0.3
+ 84010p 0.9
+ 86000p 0.9
+ 86010p -0.3
+ 88000p -0.3
+ 88010p 0.9
+ 90000p 0.9
+ 90010p -0.3
+ 92000p -0.3
+ 92010p 0.9
+ 94000p 0.9
+ 94010p -0.3
+ 96000p -0.3
+ 96010p 0.9
+ 98000p 0.9
+ 98010p -0.3
+ 100000p -0.3
+ 100010p 0.9
+ 102000p 0.9
+ 102010p -0.3
+ 104000p -0.3
+ 104010p 0.9
+ 106000p 0.9
+ 106010p -0.3
+ 108000p -0.3
+ 108010p 0.9
+ 110000p 0.9
+ 110010p -0.3
+ 112000p -0.3
+ 112010p 0.9
+ 114000p 0.9
+ 114010p -0.3
+ 116000p -0.3
+ 116010p 0.9
+ 118000p 0.9
+ 118010p -0.3
+ 120000p -0.3
+ 120010p 0.9
+ 122000p 0.9
+ 122010p -0.3
+ 124000p -0.3
+ 124010p 0.9
+ 126000p 0.9
+ 126010p -0.3
+ 128000p -0.3
+ 128010p 0.9
+ 130000p 0.9
+ 130010p -0.3
+ 132000p -0.3
+ 132010p 0.9
+ 134000p 0.9
+ 134010p -0.3
+ 136000p -0.3
+ 136010p 0.9
+ 138000p 0.9
+ 138010p -0.3
+ 140000p -0.3
+ 140010p 0.9
+ 142000p 0.9
+ 142010p -0.3
+ 144000p -0.3
+ 144010p 0.9
+ 146000p 0.9
+ 146010p -0.3
+ 148000p -0.3
+ 148010p 0.9
+ 150000p 0.9
+ 150010p -0.3
+ 152000p -0.3
+ 152010p 0.9
+ 154000p 0.9
+ 154010p -0.3
+ 156000p -0.3
+ 156010p 0.9
+ 158000p 0.9
+ 158010p -0.3
+ 160000p -0.3
+ 160010p 0.9
+ 162000p 0.9
+ 162010p -0.3
+ 164000p -0.3
+ 164010p 0.9
+ 166000p 0.9
+ 166010p -0.3
+ 168000p -0.3
+ 168010p 0.9
+ 170000p 0.9
+ 170010p -0.3
+ 172000p -0.3
+ 172010p 0.9
+ 174000p 0.9
+ 174010p -0.3
+ 176000p -0.3
+ 176010p 0.9
+ 178000p 0.9
+ 178010p -0.3
+ 180000p -0.3
+ 180010p 0.9
+ 182000p 0.9
+ 182010p -0.3
+ 184000p -0.3
+ 184010p 0.9
+ 186000p 0.9
+ 186010p -0.3
+ 188000p -0.3
+ 188010p 0.9
+ 190000p 0.9
+ 190010p -0.3
+ 192000p -0.3
+ 192010p 0.9
+ 194000p 0.9
+ 194010p -0.3
+ 196000p -0.3
+ 196010p 0.9
+ 198000p 0.9
+ 198010p -0.3
+ 200000p -0.3
+ 200010p 0.9
+ 202000p 0.9
+ 202010p -0.3
+ 204000p -0.3
+ 204010p 0.9
+ 206000p 0.9
+ 206010p -0.3
+ 208000p -0.3
+ 208010p 0.9
+ 210000p 0.9
+ 210010p -0.3
+ 212000p -0.3
+ 212010p 0.9
+ 214000p 0.9
+ 214010p -0.3
+ 216000p -0.3
+ 216010p 0.9
+ 218000p 0.9
+ 218010p -0.3
+ 220000p -0.3
+ 220010p 0.9
+ 222000p 0.9
+ 222010p -0.3
+ 224000p -0.3
+ 224010p 0.9
+ 226000p 0.9
+ 226010p -0.3
+ 228000p -0.3
+ 228010p 0.9
+ 230000p 0.9
+ 230010p -0.3
+ 232000p -0.3
+ 232010p 0.9
+ 234000p 0.9
+ 234010p -0.3
+ 236000p -0.3
+ 236010p 0.9
+ 238000p 0.9
+ 238010p -0.3
+ 240000p -0.3
+ 240010p 0.9
+ 242000p 0.9
+ 242010p -0.3
+ 244000p -0.3
+ 244010p 0.9
+ 246000p 0.9
+ 246010p -0.3
+ 248000p -0.3
+ 248010p 0.9
+ 250000p 0.9
+ 250010p -0.3
+ 252000p -0.3
+ 252010p 0.9
+ 254000p 0.9
+ 254010p -0.3
+ 256000p -0.3
+ 256010p 0.9
+ 258000p 0.9
+ 258010p -0.3
+ 260000p -0.3
+ 260010p 0.9
+ 262000p 0.9
+ 262010p -0.3
+ 264000p -0.3
+ 264010p 0.9
+ 266000p 0.9
+ 266010p -0.3
+ 268000p -0.3
+ 268010p 0.9
+ 270000p 0.9
+ 270010p -0.3
+ 272000p -0.3
+ 272010p 0.9
+ 274000p 0.9
+ 274010p -0.3
+ 276000p -0.3
+ 276010p 0.9
+ 278000p 0.9
+ 278010p -0.3
+ 280000p -0.3
+ 280010p 0.9
+ 282000p 0.9
+ 282010p -0.3
+ 284000p -0.3
+ 284010p 0.9
+ 286000p 0.9
+ 286010p -0.3
+ 288000p -0.3
+ 288010p 0.9
+ 290000p 0.9
+ 290010p -0.3
+ 292000p -0.3
+ 292010p 0.9
+ 294000p 0.9
+ 294010p -0.3
+ 296000p -0.3
+ 296010p 0.9
+ 298000p 0.9
+ 298010p -0.3
+ 300000p -0.3
+ 300010p 0.9
+ 302000p 0.9
+ 302010p -0.3
+ 304000p -0.3
+ 304010p 0.9
+ 306000p 0.9
+ 306010p -0.3
+ 308000p -0.3
+ 308010p 0.9
+ 310000p 0.9
+ 310010p -0.3
+ 312000p -0.3
+ 312010p 0.9
+ 314000p 0.9
+ 314010p -0.3
+ 316000p -0.3
+ 316010p 0.9
+ 318000p 0.9
+ 318010p -0.3
+ 320000p -0.3
+ 320010p 0.9
+ 322000p 0.9
+ 322010p -0.3
+ 324000p -0.3
+ 324010p 0.9
+ 326000p 0.9
+ 326010p -0.3
+ 328000p -0.3
+ 328010p 0.9
+ 330000p 0.9
+ 330010p -0.3
+ 332000p -0.3
+ 332010p 0.9
+ 334000p 0.9
+ 334010p -0.3
+ 336000p -0.3
+ 336010p 0.9
+ 338000p 0.9
+ 338010p -0.3
+ 340000p -0.3
+ 340010p 0.9
+ 342000p 0.9
+ 342010p -0.3
+ 344000p -0.3
+ 344010p 0.9
+ 346000p 0.9
+ 346010p -0.3
+ 348000p -0.3
+ 348010p 0.9
+ 350000p 0.9
+ 350010p -0.3
+ 352000p -0.3
+ 352010p 0.9
+ 354000p 0.9
+ 354010p -0.3
+ 356000p -0.3
+ 356010p 0.9
+ 358000p 0.9
+ 358010p -0.3
+ 360000p -0.3
+ 360010p 0.9
+ 362000p 0.9
+ 362010p -0.3
+ 364000p -0.3
+ 364010p 0.9
+ 366000p 0.9
+ 366010p -0.3
+ 368000p -0.3
+ 368010p 0.9
+ 370000p 0.9
+ 370010p -0.3
+ 372000p -0.3
+ 372010p 0.9
+ 374000p 0.9
+ 374010p -0.3
+ 376000p -0.3
+ 376010p 0.9
+ 378000p 0.9
+ 378010p -0.3
+ 380000p -0.3
+ 380010p 0.9
+ 382000p 0.9
+ 382010p -0.3
+ 384000p -0.3
+ 384010p 0.9
+ 386000p 0.9
+ 386010p -0.3
+ 388000p -0.3
+ 388010p 0.9
+ 390000p 0.9
+ 390010p -0.3
+ 392000p -0.3
+ 392010p 0.9
+ 394000p 0.9
+ 394010p -0.3
+ 396000p -0.3
+ 396010p 0.9
+ 398000p 0.9
+ 398010p -0.3
+ 400000p -0.3
+ 400010p 0.9
+ 402000p 0.9
+ 402010p -0.3
+ 404000p -0.3
+ 404010p 0.9
+ 406000p 0.9
+ 406010p -0.3
+ 408000p -0.3
+ 408010p 0.9
+ 410000p 0.9
+ 410010p -0.3
+ 412000p -0.3
+ 412010p 0.9
+ 414000p 0.9
+ 414010p -0.3
+ 416000p -0.3
+ 416010p 0.9
+ 418000p 0.9
+ 418010p -0.3
+ 420000p -0.3
+ 420010p 0.9
+ 422000p 0.9
+ 422010p -0.3
+ 424000p -0.3
+ 424010p 0.9
+ 426000p 0.9
+ 426010p -0.3
+ 428000p -0.3
+ 428010p 0.9
+ 430000p 0.9
+ 430010p -0.3
+ 432000p -0.3
+ 432010p 0.9
+ 434000p 0.9
+ 434010p -0.3
+ 436000p -0.3
+ 436010p 0.9
+ 438000p 0.9
+ 438010p -0.3
+ 440000p -0.3
+ 440010p 0.9
+ 442000p 0.9
+ 442010p -0.3
+ 444000p -0.3
+ 444010p 0.9
+ 446000p 0.9
+ 446010p -0.3
+ 448000p -0.3
+ 448010p 0.9
+ 450000p 0.9
+ 450010p -0.3
+ 452000p -0.3
+ 452010p 0.9
+ 454000p 0.9
+ 454010p -0.3
+ 456000p -0.3
+ 456010p 0.9
+ 458000p 0.9
+ 458010p -0.3
+ 460000p -0.3
+ 460010p 0.9
+ 462000p 0.9
+ 462010p -0.3
+ 464000p -0.3
+ 464010p 0.9
+ 466000p 0.9
+ 466010p -0.3
+ 468000p -0.3
+ 468010p 0.9
+ 470000p 0.9
+ 470010p -0.3
+ 472000p -0.3
+ 472010p 0.9
+ 474000p 0.9
+ 474010p -0.3
+ 476000p -0.3
+ 476010p 0.9
+ 478000p 0.9
+ 478010p -0.3
+ 480000p -0.3
+ 480010p 0.9
+ 482000p 0.9
+ 482010p -0.3
+ 484000p -0.3
+ 484010p 0.9
+ 486000p 0.9
+ 486010p -0.3
+ 488000p -0.3
+ 488010p 0.9
+ 490000p 0.9
+ 490010p -0.3
+ 492000p -0.3
+ 492010p 0.9
+ 494000p 0.9
+ 494010p -0.3
+ 496000p -0.3
+ 496010p 0.9
+ 498000p 0.9
+ 498010p -0.3
+ 500000p -0.3
+ 500010p 0.9
+ 502000p 0.9
+ 502010p -0.3
+ 504000p -0.3
+ 504010p 0.9
+ 506000p 0.9
+ 506010p -0.3
+ 508000p -0.3
+ 508010p 0.9
+ 510000p 0.9
+ 510010p -0.3
+ 512000p -0.3
+ 512010p 0.9
+ 514000p 0.9
+ 514010p -0.3
+ 516000p -0.3
+ 516010p 0.9
+ 518000p 0.9
+ 518010p -0.3
+ 520000p -0.3
+ 520010p 0.9
+ 522000p 0.9
+ 522010p -0.3
+ 524000p -0.3
+ 524010p 0.9
+ 526000p 0.9
+ 526010p -0.3
+ 528000p -0.3
+ 528010p 0.9
+ 530000p 0.9
+ 530010p -0.3
+ 532000p -0.3
+ 532010p 0.9
+ 534000p 0.9
+ 534010p -0.3
+ 536000p -0.3
+ 536010p 0.9
+ 538000p 0.9
+ 538010p -0.3
+ 540000p -0.3
+ 540010p 0.9
+ 542000p 0.9
+ 542010p -0.3
+ 544000p -0.3
+ 544010p 0.9
+ 546000p 0.9
+ 546010p -0.3
+ 548000p -0.3
+ 548010p 0.9
+ 550000p 0.9
+ 550010p -0.3
+ 552000p -0.3
+ 552010p 0.9
+ 554000p 0.9
+ 554010p -0.3
+ 556000p -0.3
+ 556010p 0.9
+ 558000p 0.9
+ 558010p -0.3
+ 560000p -0.3
+ 560010p 0.9
+ 562000p 0.9
+ 562010p -0.3
+ 564000p -0.3
+ 564010p 0.9
+ 566000p 0.9
+ 566010p -0.3
+ 568000p -0.3
+ 568010p 0.9
+ 570000p 0.9
+ 570010p -0.3
+ 572000p -0.3
+ 572010p 0.9
+ 574000p 0.9
+ 574010p -0.3
+ 576000p -0.3
+ 576010p 0.9
+ 578000p 0.9
+ 578010p -0.3
+ 580000p -0.3
+ 580010p 0.9
+ 582000p 0.9
+ 582010p -0.3
+ 584000p -0.3
+ 584010p 0.9
+ 586000p 0.9
+ 586010p -0.3
+ 588000p -0.3
+ 588010p 0.9
+ 590000p 0.9
+ 590010p -0.3
+ 592000p -0.3
+ 592010p 0.9
+ 594000p 0.9
+ 594010p -0.3
+ 596000p -0.3
+ 596010p 0.9
+ 598000p 0.9
+ 598010p -0.3
+ 600000p -0.3
+ 600010p 0.9
+ 602000p 0.9
+ 602010p -0.3
+ 604000p -0.3
+ 604010p 0.9
+ 606000p 0.9
+ 606010p -0.3
+ 608000p -0.3
+ 608010p 0.9
+ 610000p 0.9
+ 610010p -0.3
+ 612000p -0.3
+ 612010p 0.9
+ 614000p 0.9
+ 614010p -0.3
+ 616000p -0.3
+ 616010p 0.9
+ 618000p 0.9
+ 618010p -0.3
+ 620000p -0.3
+ 620010p 0.9
+ 622000p 0.9
+ 622010p -0.3
+ 624000p -0.3
+ 624010p 0.9
+ 626000p 0.9
+ 626010p -0.3
+ 628000p -0.3
+ 628010p 0.9
+ 630000p 0.9
+ 630010p -0.3
+ 632000p -0.3
+ 632010p 0.9
+ 634000p 0.9
+ 634010p -0.3
+ 636000p -0.3
+ 636010p 0.9
+ 638000p 0.9
+ 638010p -0.3
+ 640000p -0.3
+ 640010p 0.9
+ 642000p 0.9
+ 642010p -0.3
+ 644000p -0.3
+ 644010p 0.9
+ 646000p 0.9
+ 646010p -0.3
+ 648000p -0.3
+ 648010p 0.9
+ 650000p 0.9
+ 650010p -0.3
+ 652000p -0.3
+ 652010p 0.9
+ 654000p 0.9
+ 654010p -0.3
+ 656000p -0.3
+ 656010p 0.9
+ 658000p 0.9
+ 658010p -0.3
+ 660000p -0.3
+ 660010p 0.9
+ 662000p 0.9
+ 662010p -0.3
+ 664000p -0.3
+ 664010p 0.9
+ 666000p 0.9
+ 666010p -0.3
+ 668000p -0.3
+ 668010p 0.9
+ 670000p 0.9
+ 670010p -0.3
+ 672000p -0.3
+ 672010p 0.9
+ 674000p 0.9
+ 674010p -0.3
+ 676000p -0.3
+ 676010p 0.9
+ 678000p 0.9
+ 678010p -0.3
+ 680000p -0.3
+ 680010p 0.9
+ 682000p 0.9
+ 682010p -0.3
+ 684000p -0.3
+ 684010p 0.9
+ 686000p 0.9
+ 686010p -0.3
+ 688000p -0.3
+ 688010p 0.9
+ 690000p 0.9
+ 690010p -0.3
+ 692000p -0.3
+ 692010p 0.9
+ 694000p 0.9
+ 694010p -0.3
+ 696000p -0.3
+ 696010p 0.9
+ 698000p 0.9
+ 698010p -0.3
+ 700000p -0.3
+ 700010p 0.9
+ 702000p 0.9
+ 702010p -0.3
+ 704000p -0.3
+ 704010p 0.9
+ 706000p 0.9
+ 706010p -0.3
+ 708000p -0.3
+ 708010p 0.9
+ 710000p 0.9
+ 710010p -0.3
+ 712000p -0.3
+ 712010p 0.9
+ 714000p 0.9
+ 714010p -0.3
+ 716000p -0.3
+ 716010p 0.9
+ 718000p 0.9
+ 718010p -0.3
+ 720000p -0.3
+ 720010p 0.9
+ 722000p 0.9
+ 722010p -0.3
+ 724000p -0.3
+ 724010p 0.9
+ 726000p 0.9
+ 726010p -0.3
+ 728000p -0.3
+ 728010p 0.9
+ 730000p 0.9
+ 730010p -0.3
+ 732000p -0.3
+ 732010p 0.9
+ 734000p 0.9
+ 734010p -0.3
+ 736000p -0.3
+ 736010p 0.9
+ 738000p 0.9
+ 738010p -0.3
+ 740000p -0.3
+ 740010p 0.9
+ 742000p 0.9
+ 742010p -0.3
+ 744000p -0.3
+ 744010p 0.9
+ 746000p 0.9
+ 746010p -0.3
+ 748000p -0.3
+ 748010p 0.9
+ 750000p 0.9
+ 750010p -0.3
+ 752000p -0.3
+ 752010p 0.9
+ 754000p 0.9
+ 754010p -0.3
+ 756000p -0.3
+ 756010p 0.9
+ 758000p 0.9
+ 758010p -0.3
+ 760000p -0.3
+ 760010p 0.9
+ 762000p 0.9
+ 762010p -0.3
+ 764000p -0.3
+ 764010p 0.9
+ 766000p 0.9
+ 766010p -0.3
+ 768000p -0.3
+ 768010p 0.9
+ 770000p 0.9
+ 770010p -0.3
+ 772000p -0.3
+ 772010p 0.9
+ 774000p 0.9
+ 774010p -0.3
+ 776000p -0.3
+ 776010p 0.9
+ 778000p 0.9
+ 778010p -0.3
+ 780000p -0.3
+ 780010p 0.9
+ 782000p 0.9
+ 782010p -0.3
+ 784000p -0.3
+ 784010p 0.9
+ 786000p 0.9
+ 786010p -0.3
+ 788000p -0.3
+ 788010p 0.9
+ 790000p 0.9
+ 790010p -0.3
+ 792000p -0.3
+ 792010p 0.9
+ 794000p 0.9
+ 794010p -0.3
+ 796000p -0.3
+ 796010p 0.9
+ 798000p 0.9
+ 798010p -0.3
+ 800000p -0.3
+ 800010p 0.9
+ 802000p 0.9
+ 802010p -0.3
+ 804000p -0.3
+ 804010p 0.9
+ 806000p 0.9
+ 806010p -0.3
+ 808000p -0.3
+ 808010p 0.9
+ 810000p 0.9
+ 810010p -0.3
+ 812000p -0.3
+ 812010p 0.9
+ 814000p 0.9
+ 814010p -0.3
+ 816000p -0.3
+ 816010p 0.9
+ 818000p 0.9
+ 818010p -0.3
+ 820000p -0.3
+ 820010p 0.9
+ 822000p 0.9
+ 822010p -0.3
+ 824000p -0.3
+ 824010p 0.9
+ 826000p 0.9
+ 826010p -0.3
+ 828000p -0.3
+ 828010p 0.9
+ 830000p 0.9
+ 830010p -0.3
+ 832000p -0.3
+ 832010p 0.9
+ 834000p 0.9
+ 834010p -0.3
+ 836000p -0.3
+ 836010p 0.9
+ 838000p 0.9
+ 838010p -0.3
+ 840000p -0.3
+ 840010p 0.9
+ 842000p 0.9
+ 842010p -0.3
+ 844000p -0.3
+ 844010p 0.9
+ 846000p 0.9
+ 846010p -0.3
+ 848000p -0.3
+ 848010p 0.9
+ 850000p 0.9
+ 850010p -0.3
+ 852000p -0.3
+ 852010p 0.9
+ 854000p 0.9
+ 854010p -0.3
+ 856000p -0.3
+ 856010p 0.9
+ 858000p 0.9
+ 858010p -0.3
+ 860000p -0.3
+ 860010p 0.9
+ 862000p 0.9
+ 862010p -0.3
+ 864000p -0.3
+ 864010p 0.9
+ 866000p 0.9
+ 866010p -0.3
+ 868000p -0.3
+ 868010p 0.9
+ 870000p 0.9
+ 870010p -0.3
+ 872000p -0.3
+ 872010p 0.9
+ 874000p 0.9
+ 874010p -0.3
+ 876000p -0.3
+ 876010p 0.9
+ 878000p 0.9
+ 878010p -0.3
+ 880000p -0.3
+ 880010p 0.9
+ 882000p 0.9
+ 882010p -0.3
+ 884000p -0.3
+ 884010p 0.9
+ 886000p 0.9
+ 886010p -0.3
+ 888000p -0.3
+ 888010p 0.9
+ 890000p 0.9
+ 890010p -0.3
+ 892000p -0.3
+ 892010p 0.9
+ 894000p 0.9
+ 894010p -0.3
+ 896000p -0.3
+ 896010p 0.9
+ 898000p 0.9
+ 898010p -0.3
+ 900000p -0.3
+ 900010p 0.9
+ 902000p 0.9
+ 902010p -0.3
+ 904000p -0.3
+ 904010p 0.9
+ 906000p 0.9
+ 906010p -0.3
+ 908000p -0.3
+ 908010p 0.9
+ 910000p 0.9
+ 910010p -0.3
+ 912000p -0.3
+ 912010p 0.9
+ 914000p 0.9
+ 914010p -0.3
+ 916000p -0.3
+ 916010p 0.9
+ 918000p 0.9
+ 918010p -0.3
+ 920000p -0.3
+ 920010p 0.9
+ 922000p 0.9
+ 922010p -0.3
+ 924000p -0.3
+ 924010p 0.9
+ 926000p 0.9
+ 926010p -0.3
+ 928000p -0.3
+ 928010p 0.9
+ 930000p 0.9
+ 930010p -0.3
+ 932000p -0.3
+ 932010p 0.9
+ 934000p 0.9
+ 934010p -0.3
+ 936000p -0.3
+ 936010p 0.9
+ 938000p 0.9
+ 938010p -0.3
+ 940000p -0.3
+ 940010p 0.9
+ 942000p 0.9
+ 942010p -0.3
+ 944000p -0.3
+ 944010p 0.9
+ 946000p 0.9
+ 946010p -0.3
+ 948000p -0.3
+ 948010p 0.9
+ 950000p 0.9
+ 950010p -0.3
+ 952000p -0.3
+ 952010p 0.9
+ 954000p 0.9
+ 954010p -0.3
+ 956000p -0.3
+ 956010p 0.9
+ 958000p 0.9
+ 958010p -0.3
+ 960000p -0.3
+ 960010p 0.9
+ 962000p 0.9
+ 962010p -0.3
+ 964000p -0.3
+ 964010p 0.9
+ 966000p 0.9
+ 966010p -0.3
+ 968000p -0.3
+ 968010p 0.9
+ 970000p 0.9
+ 970010p -0.3
+ 972000p -0.3
+ 972010p 0.9
+ 974000p 0.9
+ 974010p -0.3
+ 976000p -0.3
+ 976010p 0.9
+ 978000p 0.9
+ 978010p -0.3
+ 980000p -0.3
+ 980010p 0.9
+ 982000p 0.9
+ 982010p -0.3
+ 984000p -0.3
+ 984010p 0.9
+ 986000p 0.9
+ 986010p -0.3
+ 988000p -0.3
+ 988010p 0.9
+ 990000p 0.9
+ 990010p -0.3
+ 992000p -0.3
+ 992010p 0.9
+ 994000p 0.9
+ 994010p -0.3
+ 996000p -0.3
+ 996010p 0.9
+ 998000p 0.9
+ 998010p -0.3
+ 1000000p -0.3
+ 1000010p 0.9
+ 1002000p 0.9
+ 1002010p -0.3
+ 1004000p -0.3
+ 1004010p 0.9
+ 1006000p 0.9
+ 1006010p -0.3
+ 1008000p -0.3
+ 1008010p 0.9
+ 1010000p 0.9
+ 1010010p -0.3
+ 1012000p -0.3
+ 1012010p 0.9
+ 1014000p 0.9
+ 1014010p -0.3
+ 1016000p -0.3
+ 1016010p 0.9
+ 1018000p 0.9
+ 1018010p -0.3
+ 1020000p -0.3
+ 1020010p 0.9
+ 1022000p 0.9
+ 1022010p -0.3
+ 1024000p -0.3
+ 1024010p 0.9
+ 1026000p 0.9
+ 1026010p -0.3
+ 1028000p -0.3
+ 1028010p 0.9
+ 1030000p 0.9
+ 1030010p -0.3
+ 1032000p -0.3
+ 1032010p 0.9
+ 1034000p 0.9
+ 1034010p -0.3
+ 1036000p -0.3
+ 1036010p 0.9
+ 1038000p 0.9
+ 1038010p -0.3
+ 1040000p -0.3
+ 1040010p 0.9
+ 1042000p 0.9
+ 1042010p -0.3
+ 1044000p -0.3
+ 1044010p 0.9
+ 1046000p 0.9
+ 1046010p -0.3
+ 1048000p -0.3
+ 1048010p 0.9
+ 1050000p 0.9
+ 1050010p -0.3
+ 1052000p -0.3
+ 1052010p 0.9
+ 1054000p 0.9
+ 1054010p -0.3
+ 1056000p -0.3
+ 1056010p 0.9
+ 1058000p 0.9
+ 1058010p -0.3
+ 1060000p -0.3
+ 1060010p 0.9
+ 1062000p 0.9
+ 1062010p -0.3
+ 1064000p -0.3
+ 1064010p 0.9
+ 1066000p 0.9
+ 1066010p -0.3
+ 1068000p -0.3
+ 1068010p 0.9
+ 1070000p 0.9
+ 1070010p -0.3
+ 1072000p -0.3
+ 1072010p 0.9
+ 1074000p 0.9
+ 1074010p -0.3
+ 1076000p -0.3
+ 1076010p 0.9
+ 1078000p 0.9
+ 1078010p -0.3
+ 1080000p -0.3
+ 1080010p 0.9
+ 1082000p 0.9
+ 1082010p -0.3
+ 1084000p -0.3
+ 1084010p 0.9
+ 1086000p 0.9
+ 1086010p -0.3
+ 1088000p -0.3
+ 1088010p 0.9
+ 1090000p 0.9
+ 1090010p -0.3
+ 1092000p -0.3
+ 1092010p 0.9
+ 1094000p 0.9
+ 1094010p -0.3
+ 1096000p -0.3
+ 1096010p 0.9
+ 1098000p 0.9
+ 1098010p -0.3
+ 1100000p -0.3
+ 1100010p 0.9
+ 1102000p 0.9
+ 1102010p -0.3
+ 1104000p -0.3
+ 1104010p 0.9
+ 1106000p 0.9
+ 1106010p -0.3
+ 1108000p -0.3
+ 1108010p 0.9
+ 1110000p 0.9
+ 1110010p -0.3
+ 1112000p -0.3
+ 1112010p 0.9
+ 1114000p 0.9
+ 1114010p -0.3
+ 1116000p -0.3
+ 1116010p 0.9
+ 1118000p 0.9
+ 1118010p -0.3
+ 1120000p -0.3
+ 1120010p 0.9
+ 1122000p 0.9
+ 1122010p -0.3
+ 1124000p -0.3
+ 1124010p 0.9
+ 1126000p 0.9
+ 1126010p -0.3
+ 1128000p -0.3
+ 1128010p 0.9
+ 1130000p 0.9
+ 1130010p -0.3
+ 1132000p -0.3
+ 1132010p 0.9
+ 1134000p 0.9
+ 1134010p -0.3
+ 1136000p -0.3
+ 1136010p 0.9
+ 1138000p 0.9
+ 1138010p -0.3
+ 1140000p -0.3
+ 1140010p 0.9
+ 1142000p 0.9
+ 1142010p -0.3
+ 1144000p -0.3
+ 1144010p 0.9
+ 1146000p 0.9
+ 1146010p -0.3
+ 1148000p -0.3
+ 1148010p 0.9
+ 1150000p 0.9
+ 1150010p -0.3
+ 1152000p -0.3
+ 1152010p 0.9
+ 1154000p 0.9
+ 1154010p -0.3
+ 1156000p -0.3
+ 1156010p 0.9
+ 1158000p 0.9
+ 1158010p -0.3
+ 1160000p -0.3
+ 1160010p 0.9
+ 1162000p 0.9
+ 1162010p -0.3
+ 1164000p -0.3
+ 1164010p 0.9
+ 1166000p 0.9
+ 1166010p -0.3
+ 1168000p -0.3
+ 1168010p 0.9
+ 1170000p 0.9
+ 1170010p -0.3
+ 1172000p -0.3
+ 1172010p 0.9
+ 1174000p 0.9
+ 1174010p -0.3
+ 1176000p -0.3
+ 1176010p 0.9
+ 1178000p 0.9
+ 1178010p -0.3
+ 1180000p -0.3
+ 1180010p 0.9
+ 1182000p 0.9
+ 1182010p -0.3
+ 1184000p -0.3
+ 1184010p 0.9
+ 1186000p 0.9
+ 1186010p -0.3
+ 1188000p -0.3
+ 1188010p 0.9
+ 1190000p 0.9
+ 1190010p -0.3
+ 1192000p -0.3
+ 1192010p 0.9
+ 1194000p 0.9
+ 1194010p -0.3
+ 1196000p -0.3
+ 1196010p 0.9
+ 1198000p 0.9
+ 1198010p -0.3
+ 1200000p -0.3
+ 1200010p 0.9
+ 1202000p 0.9
+ 1202010p -0.3
+ 1204000p -0.3
+ 1204010p 0.9
+ 1206000p 0.9
+ 1206010p -0.3
+ 1208000p -0.3
+ 1208010p 0.9
+ 1210000p 0.9
+ 1210010p -0.3
+ 1212000p -0.3
+ 1212010p 0.9
+ 1214000p 0.9
+ 1214010p -0.3
+ 1216000p -0.3
+ 1216010p 0.9
+ 1218000p 0.9
+ 1218010p -0.3
+ 1220000p -0.3
+ 1220010p 0.9
+ 1222000p 0.9
+ 1222010p -0.3
+ 1224000p -0.3
+ 1224010p 0.9
+ 1226000p 0.9
+ 1226010p -0.3
+ 1228000p -0.3
+ 1228010p 0.9
+ 1230000p 0.9
+ 1230010p -0.3
+ 1232000p -0.3
+ 1232010p 0.9
+ 1234000p 0.9
+ 1234010p -0.3
+ 1236000p -0.3
+ 1236010p 0.9
+ 1238000p 0.9
+ 1238010p -0.3
+ 1240000p -0.3
+ 1240010p 0.9
+ 1242000p 0.9
+ 1242010p -0.3
+ 1244000p -0.3
+ 1244010p 0.9
+ 1246000p 0.9
+ 1246010p -0.3
+ 1248000p -0.3
+ 1248010p 0.9
+ 1250000p 0.9
+ 1250010p -0.3
+ 1252000p -0.3
+ 1252010p 0.9
+ 1254000p 0.9
+ 1254010p -0.3
+ 1256000p -0.3
+ 1256010p 0.9
+ 1258000p 0.9
+ 1258010p -0.3
+ 1260000p -0.3
+ 1260010p 0.9
+ 1262000p 0.9
+ 1262010p -0.3
+ 1264000p -0.3
+ 1264010p 0.9
+ 1266000p 0.9
+ 1266010p -0.3
+ 1268000p -0.3
+ 1268010p 0.9
+ 1270000p 0.9
+ 1270010p -0.3
+ 1272000p -0.3
+ 1272010p 0.9
+ 1274000p 0.9
+ 1274010p -0.3
+ 1276000p -0.3
+ 1276010p 0.9
+ 1278000p 0.9
+ 1278010p -0.3
+ 1280000p -0.3
+ 1280010p 0.9
+ 1282000p 0.9
+ 1282010p -0.3
+ 1284000p -0.3
+ 1284010p 0.9
+ 1286000p 0.9
+ 1286010p -0.3
+ 1288000p -0.3
+ 1288010p 0.9
+ 1290000p 0.9
+ 1290010p -0.3
+ 1292000p -0.3
+ 1292010p 0.9
+ 1294000p 0.9
+ 1294010p -0.3
+ 1296000p -0.3
+ 1296010p 0.9
+ 1298000p 0.9
+ 1298010p -0.3
+ 1300000p -0.3
+ 1300010p 0.9
+ 1302000p 0.9
+ 1302010p -0.3
+ 1304000p -0.3
+ 1304010p 0.9
+ 1306000p 0.9
+ 1306010p -0.3
+ 1308000p -0.3
+ 1308010p 0.9
+ 1310000p 0.9
+ 1310010p -0.3
+ 1312000p -0.3
+ 1312010p 0.9
+ 1314000p 0.9
+ 1314010p -0.3
+ 1316000p -0.3
+ 1316010p 0.9
+ 1318000p 0.9
+ 1318010p -0.3
+ 1320000p -0.3
+ 1320010p 0.9
+ 1322000p 0.9
+ 1322010p -0.3
+ 1324000p -0.3
+ 1324010p 0.9
+ 1326000p 0.9
+ 1326010p -0.3
+ 1328000p -0.3
+ 1328010p 0.9
+ 1330000p 0.9
+ 1330010p -0.3
+ 1332000p -0.3
+ 1332010p 0.9
+ 1334000p 0.9
+ 1334010p -0.3
+ 1336000p -0.3
+ 1336010p 0.9
+ 1338000p 0.9
+ 1338010p -0.3
+ 1340000p -0.3
+ 1340010p 0.9
+ 1342000p 0.9
+ 1342010p -0.3
+ 1344000p -0.3
+ 1344010p 0.9
+ 1346000p 0.9
+ 1346010p -0.3
+ 1348000p -0.3
+ 1348010p 0.9
+ 1350000p 0.9
+ 1350010p -0.3
+ 1352000p -0.3
+ 1352010p 0.9
+ 1354000p 0.9
+ 1354010p -0.3
+ 1356000p -0.3
+ 1356010p 0.9
+ 1358000p 0.9
+ 1358010p -0.3
+ 1360000p -0.3
+ 1360010p 0.9
+ 1362000p 0.9
+ 1362010p -0.3
+ 1364000p -0.3
+ 1364010p 0.9
+ 1366000p 0.9
+ 1366010p -0.3
+ 1368000p -0.3
+ 1368010p 0.9
+ 1370000p 0.9
+ 1370010p -0.3
+ 1372000p -0.3
+ 1372010p 0.9
+ 1374000p 0.9
+ 1374010p -0.3
+ 1376000p -0.3
+ 1376010p 0.9
+ 1378000p 0.9
+ 1378010p -0.3
+ 1380000p -0.3
+ 1380010p 0.9
+ 1382000p 0.9
+ 1382010p -0.3
+ 1384000p -0.3
+ 1384010p 0.9
+ 1386000p 0.9
+ 1386010p -0.3
+ 1388000p -0.3
+ 1388010p 0.9
+ 1390000p 0.9
+ 1390010p -0.3
+ 1392000p -0.3
+ 1392010p 0.9
+ 1394000p 0.9
+ 1394010p -0.3
+ 1396000p -0.3
+ 1396010p 0.9
+ 1398000p 0.9
+ 1398010p -0.3
+ 1400000p -0.3
+ 1400010p 0.9
+ 1402000p 0.9
+ 1402010p -0.3
+ 1404000p -0.3
+ 1404010p 0.9
+ 1406000p 0.9
+ 1406010p -0.3
+ 1408000p -0.3
+ 1408010p 0.9
+ 1410000p 0.9
+ 1410010p -0.3
+ 1412000p -0.3
+ 1412010p 0.9
+ 1414000p 0.9
+ 1414010p -0.3
+ 1416000p -0.3
+ 1416010p 0.9
+ 1418000p 0.9
+ 1418010p -0.3
+ 1420000p -0.3
+ 1420010p 0.9
+ 1422000p 0.9
+ 1422010p -0.3
+ 1424000p -0.3
+ 1424010p 0.9
+ 1426000p 0.9
+ 1426010p -0.3
+ 1428000p -0.3
+ 1428010p 0.9
+ 1430000p 0.9
+ 1430010p -0.3
+ 1432000p -0.3
+ 1432010p 0.9
+ 1434000p 0.9
+ 1434010p -0.3
+ 1436000p -0.3
+ 1436010p 0.9
+ 1438000p 0.9
+ 1438010p -0.3
+ 1440000p -0.3
+ 1440010p 0.9
+ 1442000p 0.9
+ 1442010p -0.3
+ 1444000p -0.3
+ 1444010p 0.9
+ 1446000p 0.9
+ 1446010p -0.3
+ 1448000p -0.3
+ 1448010p 0.9
+ 1450000p 0.9
+ 1450010p -0.3
+ 1452000p -0.3
+ 1452010p 0.9
+ 1454000p 0.9
+ 1454010p -0.3
+ 1456000p -0.3
+ 1456010p 0.9
+ 1458000p 0.9
+ 1458010p -0.3
+ 1460000p -0.3
+ 1460010p 0.9
+ 1462000p 0.9
+ 1462010p -0.3
+ 1464000p -0.3
+ 1464010p 0.9
+ 1466000p 0.9
+ 1466010p -0.3
+ 1468000p -0.3
+ 1468010p 0.9
+ 1470000p 0.9
+ 1470010p -0.3
+ 1472000p -0.3
+ 1472010p 0.9
+ 1474000p 0.9
+ 1474010p -0.3
+ 1476000p -0.3
+ 1476010p 0.9
+ 1478000p 0.9
+ 1478010p -0.3
+ 1480000p -0.3
+ 1480010p 0.9
+ 1482000p 0.9
+ 1482010p -0.3
+ 1484000p -0.3
+ 1484010p 0.9
+ 1486000p 0.9
+ 1486010p -0.3
+ 1488000p -0.3
+ 1488010p 0.9
+ 1490000p 0.9
+ 1490010p -0.3
+ 1492000p -0.3
+ 1492010p 0.9
+ 1494000p 0.9
+ 1494010p -0.3
+ 1496000p -0.3
+ 1496010p 0.9
+ 1498000p 0.9
+ 1498010p -0.3
+ 1500000p -0.3
+ 1500010p 0.9
+ 1502000p 0.9
+ 1502010p -0.3
+ 1504000p -0.3
+ 1504010p 0.9
+ 1506000p 0.9
+ 1506010p -0.3
+ 1508000p -0.3
+ 1508010p 0.9
+ 1510000p 0.9
+ 1510010p -0.3
+ 1512000p -0.3
+ 1512010p 0.9
+ 1514000p 0.9
+ 1514010p -0.3
+ 1516000p -0.3
+ 1516010p 0.9
+ 1518000p 0.9
+ 1518010p -0.3
+ 1520000p -0.3
+ 1520010p 0.9
+ 1522000p 0.9
+ 1522010p -0.3
+ 1524000p -0.3
+ 1524010p 0.9
+ 1526000p 0.9
+ 1526010p -0.3
+ 1528000p -0.3
+ 1528010p 0.9
+ 1530000p 0.9
+ 1530010p -0.3
+ 1532000p -0.3
+ 1532010p 0.9
+ 1534000p 0.9
+ 1534010p -0.3
+ 1536000p -0.3
+ 1536010p 0.9
+ 1538000p 0.9
+ 1538010p -0.3
+ 1540000p -0.3
+ 1540010p 0.9
+ 1542000p 0.9
+ 1542010p -0.3
+ 1544000p -0.3
+ 1544010p 0.9
+ 1546000p 0.9
+ 1546010p -0.3
+ 1548000p -0.3
+ 1548010p 0.9
+ 1550000p 0.9
+ 1550010p -0.3
+ 1552000p -0.3
+ 1552010p 0.9
+ 1554000p 0.9
+ 1554010p -0.3
+ 1556000p -0.3
+ 1556010p 0.9
+ 1558000p 0.9
+ 1558010p -0.3
+ 1560000p -0.3
+ 1560010p 0.9
+ 1562000p 0.9
+ 1562010p -0.3
+ 1564000p -0.3
+ 1564010p 0.9
+ 1566000p 0.9
+ 1566010p -0.3
+ 1568000p -0.3
+ 1568010p 0.9
+ 1570000p 0.9
+ 1570010p -0.3
+ 1572000p -0.3
+ 1572010p 0.9
+ 1574000p 0.9
+ 1574010p -0.3
+ 1576000p -0.3
+ 1576010p 0.9
+ 1578000p 0.9
+ 1578010p -0.3
+ 1580000p -0.3
+ 1580010p 0.9
+ 1582000p 0.9
+ 1582010p -0.3
+ 1584000p -0.3
+ 1584010p 0.9
+ 1586000p 0.9
+ 1586010p -0.3
+ 1588000p -0.3
+ 1588010p 0.9
+ 1590000p 0.9
+ 1590010p -0.3
+ 1592000p -0.3
+ 1592010p 0.9
+ 1594000p 0.9
+ 1594010p -0.3
+ 1596000p -0.3
+ 1596010p 0.9
+ 1598000p 0.9
+ 1598010p -0.3
+ 1600000p -0.3
+ 1600010p 0.9
+ 1602000p 0.9
+ 1602010p -0.3
+ 1604000p -0.3
+ 1604010p 0.9
+ 1606000p 0.9
+ 1606010p -0.3
+ 1608000p -0.3
+ 1608010p 0.9
+ 1610000p 0.9
+ 1610010p -0.3
+ 1612000p -0.3
+ 1612010p 0.9
+ 1614000p 0.9
+ 1614010p -0.3
+ 1616000p -0.3
+ 1616010p 0.9
+ 1618000p 0.9
+ 1618010p -0.3
+ 1620000p -0.3
+ 1620010p 0.9
+ 1622000p 0.9
+ 1622010p -0.3
+ 1624000p -0.3
+ 1624010p 0.9
+ 1626000p 0.9
+ 1626010p -0.3
+ 1628000p -0.3
+ 1628010p 0.9
+ 1630000p 0.9
+ 1630010p -0.3
+ 1632000p -0.3
+ 1632010p 0.9
+ 1634000p 0.9
+ 1634010p -0.3
+ 1636000p -0.3
+ 1636010p 0.9
+ 1638000p 0.9
+ 1638010p -0.3
+ 1640000p -0.3
+ 1640010p 0.9
+ 1642000p 0.9
+ 1642010p -0.3
+ 1644000p -0.3
+ 1644010p 0.9
+ 1646000p 0.9
+ 1646010p -0.3
+ 1648000p -0.3
+ 1648010p 0.9
+ 1650000p 0.9
+ 1650010p -0.3
+ 1652000p -0.3
+ 1652010p 0.9
+ 1654000p 0.9
+ 1654010p -0.3
+ 1656000p -0.3
+ 1656010p 0.9
+ 1658000p 0.9
+ 1658010p -0.3
+ 1660000p -0.3
+ 1660010p 0.9
+ 1662000p 0.9
+ 1662010p -0.3
+ 1664000p -0.3
+ 1664010p 0.9
+ 1666000p 0.9
+ 1666010p -0.3
+ 1668000p -0.3
+ 1668010p 0.9
+ 1670000p 0.9
+ 1670010p -0.3
+ 1672000p -0.3
+ 1672010p 0.9
+ 1674000p 0.9
+ 1674010p -0.3
+ 1676000p -0.3
+ 1676010p 0.9
+ 1678000p 0.9
+ 1678010p -0.3
+ 1680000p -0.3
+ 1680010p 0.9
+ 1682000p 0.9
+ 1682010p -0.3
+ 1684000p -0.3
+ 1684010p 0.9
+ 1686000p 0.9
+ 1686010p -0.3
+ 1688000p -0.3
+ 1688010p 0.9
+ 1690000p 0.9
+ 1690010p -0.3
+ 1692000p -0.3
+ 1692010p 0.9
+ 1694000p 0.9
+ 1694010p -0.3
+ 1696000p -0.3
+ 1696010p 0.9
+ 1698000p 0.9
+ 1698010p -0.3
+ 1700000p -0.3
+ 1700010p 0.9
+ 1702000p 0.9
+ 1702010p -0.3
+ 1704000p -0.3
+ 1704010p 0.9
+ 1706000p 0.9
+ 1706010p -0.3
+ 1708000p -0.3
+ 1708010p 0.9
+ 1710000p 0.9
+ 1710010p -0.3
+ 1712000p -0.3
+ 1712010p 0.9
+ 1714000p 0.9
+ 1714010p -0.3
+ 1716000p -0.3
+ 1716010p 0.9
+ 1718000p 0.9
+ 1718010p -0.3
+ 1720000p -0.3
+ 1720010p 0.9
+ 1722000p 0.9
+ 1722010p -0.3
+ 1724000p -0.3
+ 1724010p 0.9
+ 1726000p 0.9
+ 1726010p -0.3
+ 1728000p -0.3
+ 1728010p 0.9
+ 1730000p 0.9
+ 1730010p -0.3
+ 1732000p -0.3
+ 1732010p 0.9
+ 1734000p 0.9
+ 1734010p -0.3
+ 1736000p -0.3
+ 1736010p 0.9
+ 1738000p 0.9
+ 1738010p -0.3
+ 1740000p -0.3
+ 1740010p 0.9
+ 1742000p 0.9
+ 1742010p -0.3
+ 1744000p -0.3
+ 1744010p 0.9
+ 1746000p 0.9
+ 1746010p -0.3
+ 1748000p -0.3
+ 1748010p 0.9
+ 1750000p 0.9
+ 1750010p -0.3
+ 1752000p -0.3
+ 1752010p 0.9
+ 1754000p 0.9
+ 1754010p -0.3
+ 1756000p -0.3
+ 1756010p 0.9
+ 1758000p 0.9
+ 1758010p -0.3
+ 1760000p -0.3
+ 1760010p 0.9
+ 1762000p 0.9
+ 1762010p -0.3
+ 1764000p -0.3
+ 1764010p 0.9
+ 1766000p 0.9
+ 1766010p -0.3
+ 1768000p -0.3
+ 1768010p 0.9
+ 1770000p 0.9
+ 1770010p -0.3
+ 1772000p -0.3
+ 1772010p 0.9
+ 1774000p 0.9
+ 1774010p -0.3
+ 1776000p -0.3
+ 1776010p 0.9
+ 1778000p 0.9
+ 1778010p -0.3
+ 1780000p -0.3
+ 1780010p 0.9
+ 1782000p 0.9
+ 1782010p -0.3
+ 1784000p -0.3
+ 1784010p 0.9
+ 1786000p 0.9
+ 1786010p -0.3
+ 1788000p -0.3
+ 1788010p 0.9
+ 1790000p 0.9
+ 1790010p -0.3
+ 1792000p -0.3
+ 1792010p 0.9
+ 1794000p 0.9
+ 1794010p -0.3
+ 1796000p -0.3
+ 1796010p 0.9
+ 1798000p 0.9
+ 1798010p -0.3
+ 1800000p -0.3
+ 1800010p 0.9
+ 1802000p 0.9
+ 1802010p -0.3
+ 1804000p -0.3
+ 1804010p 0.9
+ 1806000p 0.9
+ 1806010p -0.3
+ 1808000p -0.3
+ 1808010p 0.9
+ 1810000p 0.9
+ 1810010p -0.3
+ 1812000p -0.3
+ 1812010p 0.9
+ 1814000p 0.9
+ 1814010p -0.3
+ 1816000p -0.3
+ 1816010p 0.9
+ 1818000p 0.9
+ 1818010p -0.3
+ 1820000p -0.3
+ 1820010p 0.9
+ 1822000p 0.9
+ 1822010p -0.3
+ 1824000p -0.3
+ 1824010p 0.9
+ 1826000p 0.9
+ 1826010p -0.3
+ 1828000p -0.3
+ 1828010p 0.9
+ 1830000p 0.9
+ 1830010p -0.3
+ 1832000p -0.3
+ 1832010p 0.9
+ 1834000p 0.9
+ 1834010p -0.3
+ 1836000p -0.3
+ 1836010p 0.9
+ 1838000p 0.9
+ 1838010p -0.3
+ 1840000p -0.3
+ 1840010p 0.9
+ 1842000p 0.9
+ 1842010p -0.3
+ 1844000p -0.3
+ 1844010p 0.9
+ 1846000p 0.9
+ 1846010p -0.3
+ 1848000p -0.3
+ 1848010p 0.9
+ 1850000p 0.9
+ 1850010p -0.3
+ 1852000p -0.3
+ 1852010p 0.9
+ 1854000p 0.9
+ 1854010p -0.3
+ 1856000p -0.3
+ 1856010p 0.9
+ 1858000p 0.9
+ 1858010p -0.3
+ 1860000p -0.3
+ 1860010p 0.9
+ 1862000p 0.9
+ 1862010p -0.3
+ 1864000p -0.3
+ 1864010p 0.9
+ 1866000p 0.9
+ 1866010p -0.3
+ 1868000p -0.3
+ 1868010p 0.9
+ 1870000p 0.9
+ 1870010p -0.3
+ 1872000p -0.3
+ 1872010p 0.9
+ 1874000p 0.9
+ 1874010p -0.3
+ 1876000p -0.3
+ 1876010p 0.9
+ 1878000p 0.9
+ 1878010p -0.3
+ 1880000p -0.3
+ 1880010p 0.9
+ 1882000p 0.9
+ 1882010p -0.3
+ 1884000p -0.3
+ 1884010p 0.9
+ 1886000p 0.9
+ 1886010p -0.3
+ 1888000p -0.3
+ 1888010p 0.9
+ 1890000p 0.9
+ 1890010p -0.3
+ 1892000p -0.3
+ 1892010p 0.9
+ 1894000p 0.9
+ 1894010p -0.3
+ 1896000p -0.3
+ 1896010p 0.9
+ 1898000p 0.9
+ 1898010p -0.3
+ 1900000p -0.3
+ 1900010p 0.9
+ 1902000p 0.9
+ 1902010p -0.3
+ 1904000p -0.3
+ 1904010p 0.9
+ 1906000p 0.9
+ 1906010p -0.3
+ 1908000p -0.3
+ 1908010p 0.9
+ 1910000p 0.9
+ 1910010p -0.3
+ 1912000p -0.3
+ 1912010p 0.9
+ 1914000p 0.9
+ 1914010p -0.3
+ 1916000p -0.3
+ 1916010p 0.9
+ 1918000p 0.9
+ 1918010p -0.3
+ 1920000p -0.3
+ 1920010p 0.9
+ 1922000p 0.9
+ 1922010p -0.3
+ 1924000p -0.3
+ 1924010p 0.9
+ 1926000p 0.9
+ 1926010p -0.3
+ 1928000p -0.3
+ 1928010p 0.9
+ 1930000p 0.9
+ 1930010p -0.3
+ 1932000p -0.3
+ 1932010p 0.9
+ 1934000p 0.9
+ 1934010p -0.3
+ 1936000p -0.3
+ 1936010p 0.9
+ 1938000p 0.9
+ 1938010p -0.3
+ 1940000p -0.3
+ 1940010p 0.9
+ 1942000p 0.9
+ 1942010p -0.3
+ 1944000p -0.3
+ 1944010p 0.9
+ 1946000p 0.9
+ 1946010p -0.3
+ 1948000p -0.3
+ 1948010p 0.9
+ 1950000p 0.9
+ 1950010p -0.3
+ 1952000p -0.3
+ 1952010p 0.9
+ 1954000p 0.9
+ 1954010p -0.3
+ 1956000p -0.3
+ 1956010p 0.9
+ 1958000p 0.9
+ 1958010p -0.3
+ 1960000p -0.3
+ 1960010p 0.9
+ 1962000p 0.9
+ 1962010p -0.3
+ 1964000p -0.3
+ 1964010p 0.9
+ 1966000p 0.9
+ 1966010p -0.3
+ 1968000p -0.3
+ 1968010p 0.9
+ 1970000p 0.9
+ 1970010p -0.3
+ 1972000p -0.3
+ 1972010p 0.9
+ 1974000p 0.9
+ 1974010p -0.3
+ 1976000p -0.3
+ 1976010p 0.9
+ 1978000p 0.9
+ 1978010p -0.3
+ 1980000p -0.3
+ 1980010p 0.9
+ 1982000p 0.9
+ 1982010p -0.3
+ 1984000p -0.3
+ 1984010p 0.9
+ 1986000p 0.9
+ 1986010p -0.3
+ 1988000p -0.3
+ 1988010p 0.9
+ 1990000p 0.9
+ 1990010p -0.3
+ 1992000p -0.3
+ 1992010p 0.9
+ 1994000p 0.9
+ 1994010p -0.3
+ 1996000p -0.3
+ 1996010p 0.9
+ 1998000p 0.9
+ 1998010p -0.3
+ 2000000p -0.3
+ 2000010p 0.9
+ 2002000p 0.9
+ 2002010p -0.3
+ 2004000p -0.3
+ 2004010p 0.9
+ 2006000p 0.9
+ 2006010p -0.3
+ 2008000p -0.3
+ 2008010p 0.9
+ 2010000p 0.9
+ 2010010p -0.3
+ 2012000p -0.3
+ 2012010p 0.9
+ 2014000p 0.9
+ 2014010p -0.3
+ 2016000p -0.3
+ 2016010p 0.9
+ 2018000p 0.9
+ 2018010p -0.3
+ 2020000p -0.3
+ 2020010p 0.9
+ 2022000p 0.9
+ 2022010p -0.3
+ 2024000p -0.3
+ 2024010p 0.9
+ 2026000p 0.9
+ 2026010p -0.3
+ 2028000p -0.3
+ 2028010p 0.9
+ 2030000p 0.9
+ 2030010p -0.3
+ 2032000p -0.3
+ 2032010p 0.9
+ 2034000p 0.9
+ 2034010p -0.3
+ 2036000p -0.3
+ 2036010p 0.9
+ 2038000p 0.9
+ 2038010p -0.3
+ 2040000p -0.3
+ 2040010p 0.9
+ 2042000p 0.9
+ 2042010p -0.3
+ 2044000p -0.3
+ 2044010p 0.9
+ 2046000p 0.9
+ 2046010p -0.3
+ 2048000p -0.3
+ 2048010p 0.9
+ \]
V_data_bar_2 (Data_bar\\<2\\> gnd!) vsource type=pwl wave=\[
+ 0    -0.3
+ 2000p -0.3
+ 2010p 0.9
+ 4000p 0.9
+ 4010p -0.3
+ 6000p -0.3
+ 6010p 0.9
+ 8000p 0.9
+ 8010p -0.3
+ 10000p -0.3
+ 10010p 0.9
+ 12000p 0.9
+ 12010p -0.3
+ 14000p -0.3
+ 14010p 0.9
+ 16000p 0.9
+ 16010p -0.3
+ 18000p -0.3
+ 18010p 0.9
+ 20000p 0.9
+ 20010p -0.3
+ 22000p -0.3
+ 22010p 0.9
+ 24000p 0.9
+ 24010p -0.3
+ 26000p -0.3
+ 26010p 0.9
+ 28000p 0.9
+ 28010p -0.3
+ 30000p -0.3
+ 30010p 0.9
+ 32000p 0.9
+ 32010p -0.3
+ 34000p -0.3
+ 34010p 0.9
+ 36000p 0.9
+ 36010p -0.3
+ 38000p -0.3
+ 38010p 0.9
+ 40000p 0.9
+ 40010p -0.3
+ 42000p -0.3
+ 42010p 0.9
+ 44000p 0.9
+ 44010p -0.3
+ 46000p -0.3
+ 46010p 0.9
+ 48000p 0.9
+ 48010p -0.3
+ 50000p -0.3
+ 50010p 0.9
+ 52000p 0.9
+ 52010p -0.3
+ 54000p -0.3
+ 54010p 0.9
+ 56000p 0.9
+ 56010p -0.3
+ 58000p -0.3
+ 58010p 0.9
+ 60000p 0.9
+ 60010p -0.3
+ 62000p -0.3
+ 62010p 0.9
+ 64000p 0.9
+ 64010p -0.3
+ 66000p -0.3
+ 66010p 0.9
+ 68000p 0.9
+ 68010p -0.3
+ 70000p -0.3
+ 70010p 0.9
+ 72000p 0.9
+ 72010p -0.3
+ 74000p -0.3
+ 74010p 0.9
+ 76000p 0.9
+ 76010p -0.3
+ 78000p -0.3
+ 78010p 0.9
+ 80000p 0.9
+ 80010p -0.3
+ 82000p -0.3
+ 82010p 0.9
+ 84000p 0.9
+ 84010p -0.3
+ 86000p -0.3
+ 86010p 0.9
+ 88000p 0.9
+ 88010p -0.3
+ 90000p -0.3
+ 90010p 0.9
+ 92000p 0.9
+ 92010p -0.3
+ 94000p -0.3
+ 94010p 0.9
+ 96000p 0.9
+ 96010p -0.3
+ 98000p -0.3
+ 98010p 0.9
+ 100000p 0.9
+ 100010p -0.3
+ 102000p -0.3
+ 102010p 0.9
+ 104000p 0.9
+ 104010p -0.3
+ 106000p -0.3
+ 106010p 0.9
+ 108000p 0.9
+ 108010p -0.3
+ 110000p -0.3
+ 110010p 0.9
+ 112000p 0.9
+ 112010p -0.3
+ 114000p -0.3
+ 114010p 0.9
+ 116000p 0.9
+ 116010p -0.3
+ 118000p -0.3
+ 118010p 0.9
+ 120000p 0.9
+ 120010p -0.3
+ 122000p -0.3
+ 122010p 0.9
+ 124000p 0.9
+ 124010p -0.3
+ 126000p -0.3
+ 126010p 0.9
+ 128000p 0.9
+ 128010p -0.3
+ 130000p -0.3
+ 130010p 0.9
+ 132000p 0.9
+ 132010p -0.3
+ 134000p -0.3
+ 134010p 0.9
+ 136000p 0.9
+ 136010p -0.3
+ 138000p -0.3
+ 138010p 0.9
+ 140000p 0.9
+ 140010p -0.3
+ 142000p -0.3
+ 142010p 0.9
+ 144000p 0.9
+ 144010p -0.3
+ 146000p -0.3
+ 146010p 0.9
+ 148000p 0.9
+ 148010p -0.3
+ 150000p -0.3
+ 150010p 0.9
+ 152000p 0.9
+ 152010p -0.3
+ 154000p -0.3
+ 154010p 0.9
+ 156000p 0.9
+ 156010p -0.3
+ 158000p -0.3
+ 158010p 0.9
+ 160000p 0.9
+ 160010p -0.3
+ 162000p -0.3
+ 162010p 0.9
+ 164000p 0.9
+ 164010p -0.3
+ 166000p -0.3
+ 166010p 0.9
+ 168000p 0.9
+ 168010p -0.3
+ 170000p -0.3
+ 170010p 0.9
+ 172000p 0.9
+ 172010p -0.3
+ 174000p -0.3
+ 174010p 0.9
+ 176000p 0.9
+ 176010p -0.3
+ 178000p -0.3
+ 178010p 0.9
+ 180000p 0.9
+ 180010p -0.3
+ 182000p -0.3
+ 182010p 0.9
+ 184000p 0.9
+ 184010p -0.3
+ 186000p -0.3
+ 186010p 0.9
+ 188000p 0.9
+ 188010p -0.3
+ 190000p -0.3
+ 190010p 0.9
+ 192000p 0.9
+ 192010p -0.3
+ 194000p -0.3
+ 194010p 0.9
+ 196000p 0.9
+ 196010p -0.3
+ 198000p -0.3
+ 198010p 0.9
+ 200000p 0.9
+ 200010p -0.3
+ 202000p -0.3
+ 202010p 0.9
+ 204000p 0.9
+ 204010p -0.3
+ 206000p -0.3
+ 206010p 0.9
+ 208000p 0.9
+ 208010p -0.3
+ 210000p -0.3
+ 210010p 0.9
+ 212000p 0.9
+ 212010p -0.3
+ 214000p -0.3
+ 214010p 0.9
+ 216000p 0.9
+ 216010p -0.3
+ 218000p -0.3
+ 218010p 0.9
+ 220000p 0.9
+ 220010p -0.3
+ 222000p -0.3
+ 222010p 0.9
+ 224000p 0.9
+ 224010p -0.3
+ 226000p -0.3
+ 226010p 0.9
+ 228000p 0.9
+ 228010p -0.3
+ 230000p -0.3
+ 230010p 0.9
+ 232000p 0.9
+ 232010p -0.3
+ 234000p -0.3
+ 234010p 0.9
+ 236000p 0.9
+ 236010p -0.3
+ 238000p -0.3
+ 238010p 0.9
+ 240000p 0.9
+ 240010p -0.3
+ 242000p -0.3
+ 242010p 0.9
+ 244000p 0.9
+ 244010p -0.3
+ 246000p -0.3
+ 246010p 0.9
+ 248000p 0.9
+ 248010p -0.3
+ 250000p -0.3
+ 250010p 0.9
+ 252000p 0.9
+ 252010p -0.3
+ 254000p -0.3
+ 254010p 0.9
+ 256000p 0.9
+ 256010p -0.3
+ 258000p -0.3
+ 258010p 0.9
+ 260000p 0.9
+ 260010p -0.3
+ 262000p -0.3
+ 262010p 0.9
+ 264000p 0.9
+ 264010p -0.3
+ 266000p -0.3
+ 266010p 0.9
+ 268000p 0.9
+ 268010p -0.3
+ 270000p -0.3
+ 270010p 0.9
+ 272000p 0.9
+ 272010p -0.3
+ 274000p -0.3
+ 274010p 0.9
+ 276000p 0.9
+ 276010p -0.3
+ 278000p -0.3
+ 278010p 0.9
+ 280000p 0.9
+ 280010p -0.3
+ 282000p -0.3
+ 282010p 0.9
+ 284000p 0.9
+ 284010p -0.3
+ 286000p -0.3
+ 286010p 0.9
+ 288000p 0.9
+ 288010p -0.3
+ 290000p -0.3
+ 290010p 0.9
+ 292000p 0.9
+ 292010p -0.3
+ 294000p -0.3
+ 294010p 0.9
+ 296000p 0.9
+ 296010p -0.3
+ 298000p -0.3
+ 298010p 0.9
+ 300000p 0.9
+ 300010p -0.3
+ 302000p -0.3
+ 302010p 0.9
+ 304000p 0.9
+ 304010p -0.3
+ 306000p -0.3
+ 306010p 0.9
+ 308000p 0.9
+ 308010p -0.3
+ 310000p -0.3
+ 310010p 0.9
+ 312000p 0.9
+ 312010p -0.3
+ 314000p -0.3
+ 314010p 0.9
+ 316000p 0.9
+ 316010p -0.3
+ 318000p -0.3
+ 318010p 0.9
+ 320000p 0.9
+ 320010p -0.3
+ 322000p -0.3
+ 322010p 0.9
+ 324000p 0.9
+ 324010p -0.3
+ 326000p -0.3
+ 326010p 0.9
+ 328000p 0.9
+ 328010p -0.3
+ 330000p -0.3
+ 330010p 0.9
+ 332000p 0.9
+ 332010p -0.3
+ 334000p -0.3
+ 334010p 0.9
+ 336000p 0.9
+ 336010p -0.3
+ 338000p -0.3
+ 338010p 0.9
+ 340000p 0.9
+ 340010p -0.3
+ 342000p -0.3
+ 342010p 0.9
+ 344000p 0.9
+ 344010p -0.3
+ 346000p -0.3
+ 346010p 0.9
+ 348000p 0.9
+ 348010p -0.3
+ 350000p -0.3
+ 350010p 0.9
+ 352000p 0.9
+ 352010p -0.3
+ 354000p -0.3
+ 354010p 0.9
+ 356000p 0.9
+ 356010p -0.3
+ 358000p -0.3
+ 358010p 0.9
+ 360000p 0.9
+ 360010p -0.3
+ 362000p -0.3
+ 362010p 0.9
+ 364000p 0.9
+ 364010p -0.3
+ 366000p -0.3
+ 366010p 0.9
+ 368000p 0.9
+ 368010p -0.3
+ 370000p -0.3
+ 370010p 0.9
+ 372000p 0.9
+ 372010p -0.3
+ 374000p -0.3
+ 374010p 0.9
+ 376000p 0.9
+ 376010p -0.3
+ 378000p -0.3
+ 378010p 0.9
+ 380000p 0.9
+ 380010p -0.3
+ 382000p -0.3
+ 382010p 0.9
+ 384000p 0.9
+ 384010p -0.3
+ 386000p -0.3
+ 386010p 0.9
+ 388000p 0.9
+ 388010p -0.3
+ 390000p -0.3
+ 390010p 0.9
+ 392000p 0.9
+ 392010p -0.3
+ 394000p -0.3
+ 394010p 0.9
+ 396000p 0.9
+ 396010p -0.3
+ 398000p -0.3
+ 398010p 0.9
+ 400000p 0.9
+ 400010p -0.3
+ 402000p -0.3
+ 402010p 0.9
+ 404000p 0.9
+ 404010p -0.3
+ 406000p -0.3
+ 406010p 0.9
+ 408000p 0.9
+ 408010p -0.3
+ 410000p -0.3
+ 410010p 0.9
+ 412000p 0.9
+ 412010p -0.3
+ 414000p -0.3
+ 414010p 0.9
+ 416000p 0.9
+ 416010p -0.3
+ 418000p -0.3
+ 418010p 0.9
+ 420000p 0.9
+ 420010p -0.3
+ 422000p -0.3
+ 422010p 0.9
+ 424000p 0.9
+ 424010p -0.3
+ 426000p -0.3
+ 426010p 0.9
+ 428000p 0.9
+ 428010p -0.3
+ 430000p -0.3
+ 430010p 0.9
+ 432000p 0.9
+ 432010p -0.3
+ 434000p -0.3
+ 434010p 0.9
+ 436000p 0.9
+ 436010p -0.3
+ 438000p -0.3
+ 438010p 0.9
+ 440000p 0.9
+ 440010p -0.3
+ 442000p -0.3
+ 442010p 0.9
+ 444000p 0.9
+ 444010p -0.3
+ 446000p -0.3
+ 446010p 0.9
+ 448000p 0.9
+ 448010p -0.3
+ 450000p -0.3
+ 450010p 0.9
+ 452000p 0.9
+ 452010p -0.3
+ 454000p -0.3
+ 454010p 0.9
+ 456000p 0.9
+ 456010p -0.3
+ 458000p -0.3
+ 458010p 0.9
+ 460000p 0.9
+ 460010p -0.3
+ 462000p -0.3
+ 462010p 0.9
+ 464000p 0.9
+ 464010p -0.3
+ 466000p -0.3
+ 466010p 0.9
+ 468000p 0.9
+ 468010p -0.3
+ 470000p -0.3
+ 470010p 0.9
+ 472000p 0.9
+ 472010p -0.3
+ 474000p -0.3
+ 474010p 0.9
+ 476000p 0.9
+ 476010p -0.3
+ 478000p -0.3
+ 478010p 0.9
+ 480000p 0.9
+ 480010p -0.3
+ 482000p -0.3
+ 482010p 0.9
+ 484000p 0.9
+ 484010p -0.3
+ 486000p -0.3
+ 486010p 0.9
+ 488000p 0.9
+ 488010p -0.3
+ 490000p -0.3
+ 490010p 0.9
+ 492000p 0.9
+ 492010p -0.3
+ 494000p -0.3
+ 494010p 0.9
+ 496000p 0.9
+ 496010p -0.3
+ 498000p -0.3
+ 498010p 0.9
+ 500000p 0.9
+ 500010p -0.3
+ 502000p -0.3
+ 502010p 0.9
+ 504000p 0.9
+ 504010p -0.3
+ 506000p -0.3
+ 506010p 0.9
+ 508000p 0.9
+ 508010p -0.3
+ 510000p -0.3
+ 510010p 0.9
+ 512000p 0.9
+ 512010p -0.3
+ 514000p -0.3
+ 514010p 0.9
+ 516000p 0.9
+ 516010p -0.3
+ 518000p -0.3
+ 518010p 0.9
+ 520000p 0.9
+ 520010p -0.3
+ 522000p -0.3
+ 522010p 0.9
+ 524000p 0.9
+ 524010p -0.3
+ 526000p -0.3
+ 526010p 0.9
+ 528000p 0.9
+ 528010p -0.3
+ 530000p -0.3
+ 530010p 0.9
+ 532000p 0.9
+ 532010p -0.3
+ 534000p -0.3
+ 534010p 0.9
+ 536000p 0.9
+ 536010p -0.3
+ 538000p -0.3
+ 538010p 0.9
+ 540000p 0.9
+ 540010p -0.3
+ 542000p -0.3
+ 542010p 0.9
+ 544000p 0.9
+ 544010p -0.3
+ 546000p -0.3
+ 546010p 0.9
+ 548000p 0.9
+ 548010p -0.3
+ 550000p -0.3
+ 550010p 0.9
+ 552000p 0.9
+ 552010p -0.3
+ 554000p -0.3
+ 554010p 0.9
+ 556000p 0.9
+ 556010p -0.3
+ 558000p -0.3
+ 558010p 0.9
+ 560000p 0.9
+ 560010p -0.3
+ 562000p -0.3
+ 562010p 0.9
+ 564000p 0.9
+ 564010p -0.3
+ 566000p -0.3
+ 566010p 0.9
+ 568000p 0.9
+ 568010p -0.3
+ 570000p -0.3
+ 570010p 0.9
+ 572000p 0.9
+ 572010p -0.3
+ 574000p -0.3
+ 574010p 0.9
+ 576000p 0.9
+ 576010p -0.3
+ 578000p -0.3
+ 578010p 0.9
+ 580000p 0.9
+ 580010p -0.3
+ 582000p -0.3
+ 582010p 0.9
+ 584000p 0.9
+ 584010p -0.3
+ 586000p -0.3
+ 586010p 0.9
+ 588000p 0.9
+ 588010p -0.3
+ 590000p -0.3
+ 590010p 0.9
+ 592000p 0.9
+ 592010p -0.3
+ 594000p -0.3
+ 594010p 0.9
+ 596000p 0.9
+ 596010p -0.3
+ 598000p -0.3
+ 598010p 0.9
+ 600000p 0.9
+ 600010p -0.3
+ 602000p -0.3
+ 602010p 0.9
+ 604000p 0.9
+ 604010p -0.3
+ 606000p -0.3
+ 606010p 0.9
+ 608000p 0.9
+ 608010p -0.3
+ 610000p -0.3
+ 610010p 0.9
+ 612000p 0.9
+ 612010p -0.3
+ 614000p -0.3
+ 614010p 0.9
+ 616000p 0.9
+ 616010p -0.3
+ 618000p -0.3
+ 618010p 0.9
+ 620000p 0.9
+ 620010p -0.3
+ 622000p -0.3
+ 622010p 0.9
+ 624000p 0.9
+ 624010p -0.3
+ 626000p -0.3
+ 626010p 0.9
+ 628000p 0.9
+ 628010p -0.3
+ 630000p -0.3
+ 630010p 0.9
+ 632000p 0.9
+ 632010p -0.3
+ 634000p -0.3
+ 634010p 0.9
+ 636000p 0.9
+ 636010p -0.3
+ 638000p -0.3
+ 638010p 0.9
+ 640000p 0.9
+ 640010p -0.3
+ 642000p -0.3
+ 642010p 0.9
+ 644000p 0.9
+ 644010p -0.3
+ 646000p -0.3
+ 646010p 0.9
+ 648000p 0.9
+ 648010p -0.3
+ 650000p -0.3
+ 650010p 0.9
+ 652000p 0.9
+ 652010p -0.3
+ 654000p -0.3
+ 654010p 0.9
+ 656000p 0.9
+ 656010p -0.3
+ 658000p -0.3
+ 658010p 0.9
+ 660000p 0.9
+ 660010p -0.3
+ 662000p -0.3
+ 662010p 0.9
+ 664000p 0.9
+ 664010p -0.3
+ 666000p -0.3
+ 666010p 0.9
+ 668000p 0.9
+ 668010p -0.3
+ 670000p -0.3
+ 670010p 0.9
+ 672000p 0.9
+ 672010p -0.3
+ 674000p -0.3
+ 674010p 0.9
+ 676000p 0.9
+ 676010p -0.3
+ 678000p -0.3
+ 678010p 0.9
+ 680000p 0.9
+ 680010p -0.3
+ 682000p -0.3
+ 682010p 0.9
+ 684000p 0.9
+ 684010p -0.3
+ 686000p -0.3
+ 686010p 0.9
+ 688000p 0.9
+ 688010p -0.3
+ 690000p -0.3
+ 690010p 0.9
+ 692000p 0.9
+ 692010p -0.3
+ 694000p -0.3
+ 694010p 0.9
+ 696000p 0.9
+ 696010p -0.3
+ 698000p -0.3
+ 698010p 0.9
+ 700000p 0.9
+ 700010p -0.3
+ 702000p -0.3
+ 702010p 0.9
+ 704000p 0.9
+ 704010p -0.3
+ 706000p -0.3
+ 706010p 0.9
+ 708000p 0.9
+ 708010p -0.3
+ 710000p -0.3
+ 710010p 0.9
+ 712000p 0.9
+ 712010p -0.3
+ 714000p -0.3
+ 714010p 0.9
+ 716000p 0.9
+ 716010p -0.3
+ 718000p -0.3
+ 718010p 0.9
+ 720000p 0.9
+ 720010p -0.3
+ 722000p -0.3
+ 722010p 0.9
+ 724000p 0.9
+ 724010p -0.3
+ 726000p -0.3
+ 726010p 0.9
+ 728000p 0.9
+ 728010p -0.3
+ 730000p -0.3
+ 730010p 0.9
+ 732000p 0.9
+ 732010p -0.3
+ 734000p -0.3
+ 734010p 0.9
+ 736000p 0.9
+ 736010p -0.3
+ 738000p -0.3
+ 738010p 0.9
+ 740000p 0.9
+ 740010p -0.3
+ 742000p -0.3
+ 742010p 0.9
+ 744000p 0.9
+ 744010p -0.3
+ 746000p -0.3
+ 746010p 0.9
+ 748000p 0.9
+ 748010p -0.3
+ 750000p -0.3
+ 750010p 0.9
+ 752000p 0.9
+ 752010p -0.3
+ 754000p -0.3
+ 754010p 0.9
+ 756000p 0.9
+ 756010p -0.3
+ 758000p -0.3
+ 758010p 0.9
+ 760000p 0.9
+ 760010p -0.3
+ 762000p -0.3
+ 762010p 0.9
+ 764000p 0.9
+ 764010p -0.3
+ 766000p -0.3
+ 766010p 0.9
+ 768000p 0.9
+ 768010p -0.3
+ 770000p -0.3
+ 770010p 0.9
+ 772000p 0.9
+ 772010p -0.3
+ 774000p -0.3
+ 774010p 0.9
+ 776000p 0.9
+ 776010p -0.3
+ 778000p -0.3
+ 778010p 0.9
+ 780000p 0.9
+ 780010p -0.3
+ 782000p -0.3
+ 782010p 0.9
+ 784000p 0.9
+ 784010p -0.3
+ 786000p -0.3
+ 786010p 0.9
+ 788000p 0.9
+ 788010p -0.3
+ 790000p -0.3
+ 790010p 0.9
+ 792000p 0.9
+ 792010p -0.3
+ 794000p -0.3
+ 794010p 0.9
+ 796000p 0.9
+ 796010p -0.3
+ 798000p -0.3
+ 798010p 0.9
+ 800000p 0.9
+ 800010p -0.3
+ 802000p -0.3
+ 802010p 0.9
+ 804000p 0.9
+ 804010p -0.3
+ 806000p -0.3
+ 806010p 0.9
+ 808000p 0.9
+ 808010p -0.3
+ 810000p -0.3
+ 810010p 0.9
+ 812000p 0.9
+ 812010p -0.3
+ 814000p -0.3
+ 814010p 0.9
+ 816000p 0.9
+ 816010p -0.3
+ 818000p -0.3
+ 818010p 0.9
+ 820000p 0.9
+ 820010p -0.3
+ 822000p -0.3
+ 822010p 0.9
+ 824000p 0.9
+ 824010p -0.3
+ 826000p -0.3
+ 826010p 0.9
+ 828000p 0.9
+ 828010p -0.3
+ 830000p -0.3
+ 830010p 0.9
+ 832000p 0.9
+ 832010p -0.3
+ 834000p -0.3
+ 834010p 0.9
+ 836000p 0.9
+ 836010p -0.3
+ 838000p -0.3
+ 838010p 0.9
+ 840000p 0.9
+ 840010p -0.3
+ 842000p -0.3
+ 842010p 0.9
+ 844000p 0.9
+ 844010p -0.3
+ 846000p -0.3
+ 846010p 0.9
+ 848000p 0.9
+ 848010p -0.3
+ 850000p -0.3
+ 850010p 0.9
+ 852000p 0.9
+ 852010p -0.3
+ 854000p -0.3
+ 854010p 0.9
+ 856000p 0.9
+ 856010p -0.3
+ 858000p -0.3
+ 858010p 0.9
+ 860000p 0.9
+ 860010p -0.3
+ 862000p -0.3
+ 862010p 0.9
+ 864000p 0.9
+ 864010p -0.3
+ 866000p -0.3
+ 866010p 0.9
+ 868000p 0.9
+ 868010p -0.3
+ 870000p -0.3
+ 870010p 0.9
+ 872000p 0.9
+ 872010p -0.3
+ 874000p -0.3
+ 874010p 0.9
+ 876000p 0.9
+ 876010p -0.3
+ 878000p -0.3
+ 878010p 0.9
+ 880000p 0.9
+ 880010p -0.3
+ 882000p -0.3
+ 882010p 0.9
+ 884000p 0.9
+ 884010p -0.3
+ 886000p -0.3
+ 886010p 0.9
+ 888000p 0.9
+ 888010p -0.3
+ 890000p -0.3
+ 890010p 0.9
+ 892000p 0.9
+ 892010p -0.3
+ 894000p -0.3
+ 894010p 0.9
+ 896000p 0.9
+ 896010p -0.3
+ 898000p -0.3
+ 898010p 0.9
+ 900000p 0.9
+ 900010p -0.3
+ 902000p -0.3
+ 902010p 0.9
+ 904000p 0.9
+ 904010p -0.3
+ 906000p -0.3
+ 906010p 0.9
+ 908000p 0.9
+ 908010p -0.3
+ 910000p -0.3
+ 910010p 0.9
+ 912000p 0.9
+ 912010p -0.3
+ 914000p -0.3
+ 914010p 0.9
+ 916000p 0.9
+ 916010p -0.3
+ 918000p -0.3
+ 918010p 0.9
+ 920000p 0.9
+ 920010p -0.3
+ 922000p -0.3
+ 922010p 0.9
+ 924000p 0.9
+ 924010p -0.3
+ 926000p -0.3
+ 926010p 0.9
+ 928000p 0.9
+ 928010p -0.3
+ 930000p -0.3
+ 930010p 0.9
+ 932000p 0.9
+ 932010p -0.3
+ 934000p -0.3
+ 934010p 0.9
+ 936000p 0.9
+ 936010p -0.3
+ 938000p -0.3
+ 938010p 0.9
+ 940000p 0.9
+ 940010p -0.3
+ 942000p -0.3
+ 942010p 0.9
+ 944000p 0.9
+ 944010p -0.3
+ 946000p -0.3
+ 946010p 0.9
+ 948000p 0.9
+ 948010p -0.3
+ 950000p -0.3
+ 950010p 0.9
+ 952000p 0.9
+ 952010p -0.3
+ 954000p -0.3
+ 954010p 0.9
+ 956000p 0.9
+ 956010p -0.3
+ 958000p -0.3
+ 958010p 0.9
+ 960000p 0.9
+ 960010p -0.3
+ 962000p -0.3
+ 962010p 0.9
+ 964000p 0.9
+ 964010p -0.3
+ 966000p -0.3
+ 966010p 0.9
+ 968000p 0.9
+ 968010p -0.3
+ 970000p -0.3
+ 970010p 0.9
+ 972000p 0.9
+ 972010p -0.3
+ 974000p -0.3
+ 974010p 0.9
+ 976000p 0.9
+ 976010p -0.3
+ 978000p -0.3
+ 978010p 0.9
+ 980000p 0.9
+ 980010p -0.3
+ 982000p -0.3
+ 982010p 0.9
+ 984000p 0.9
+ 984010p -0.3
+ 986000p -0.3
+ 986010p 0.9
+ 988000p 0.9
+ 988010p -0.3
+ 990000p -0.3
+ 990010p 0.9
+ 992000p 0.9
+ 992010p -0.3
+ 994000p -0.3
+ 994010p 0.9
+ 996000p 0.9
+ 996010p -0.3
+ 998000p -0.3
+ 998010p 0.9
+ 1000000p 0.9
+ 1000010p -0.3
+ 1002000p -0.3
+ 1002010p 0.9
+ 1004000p 0.9
+ 1004010p -0.3
+ 1006000p -0.3
+ 1006010p 0.9
+ 1008000p 0.9
+ 1008010p -0.3
+ 1010000p -0.3
+ 1010010p 0.9
+ 1012000p 0.9
+ 1012010p -0.3
+ 1014000p -0.3
+ 1014010p 0.9
+ 1016000p 0.9
+ 1016010p -0.3
+ 1018000p -0.3
+ 1018010p 0.9
+ 1020000p 0.9
+ 1020010p -0.3
+ 1022000p -0.3
+ 1022010p 0.9
+ 1024000p 0.9
+ 1024010p -0.3
+ 1026000p -0.3
+ 1026010p 0.9
+ 1028000p 0.9
+ 1028010p -0.3
+ 1030000p -0.3
+ 1030010p 0.9
+ 1032000p 0.9
+ 1032010p -0.3
+ 1034000p -0.3
+ 1034010p 0.9
+ 1036000p 0.9
+ 1036010p -0.3
+ 1038000p -0.3
+ 1038010p 0.9
+ 1040000p 0.9
+ 1040010p -0.3
+ 1042000p -0.3
+ 1042010p 0.9
+ 1044000p 0.9
+ 1044010p -0.3
+ 1046000p -0.3
+ 1046010p 0.9
+ 1048000p 0.9
+ 1048010p -0.3
+ 1050000p -0.3
+ 1050010p 0.9
+ 1052000p 0.9
+ 1052010p -0.3
+ 1054000p -0.3
+ 1054010p 0.9
+ 1056000p 0.9
+ 1056010p -0.3
+ 1058000p -0.3
+ 1058010p 0.9
+ 1060000p 0.9
+ 1060010p -0.3
+ 1062000p -0.3
+ 1062010p 0.9
+ 1064000p 0.9
+ 1064010p -0.3
+ 1066000p -0.3
+ 1066010p 0.9
+ 1068000p 0.9
+ 1068010p -0.3
+ 1070000p -0.3
+ 1070010p 0.9
+ 1072000p 0.9
+ 1072010p -0.3
+ 1074000p -0.3
+ 1074010p 0.9
+ 1076000p 0.9
+ 1076010p -0.3
+ 1078000p -0.3
+ 1078010p 0.9
+ 1080000p 0.9
+ 1080010p -0.3
+ 1082000p -0.3
+ 1082010p 0.9
+ 1084000p 0.9
+ 1084010p -0.3
+ 1086000p -0.3
+ 1086010p 0.9
+ 1088000p 0.9
+ 1088010p -0.3
+ 1090000p -0.3
+ 1090010p 0.9
+ 1092000p 0.9
+ 1092010p -0.3
+ 1094000p -0.3
+ 1094010p 0.9
+ 1096000p 0.9
+ 1096010p -0.3
+ 1098000p -0.3
+ 1098010p 0.9
+ 1100000p 0.9
+ 1100010p -0.3
+ 1102000p -0.3
+ 1102010p 0.9
+ 1104000p 0.9
+ 1104010p -0.3
+ 1106000p -0.3
+ 1106010p 0.9
+ 1108000p 0.9
+ 1108010p -0.3
+ 1110000p -0.3
+ 1110010p 0.9
+ 1112000p 0.9
+ 1112010p -0.3
+ 1114000p -0.3
+ 1114010p 0.9
+ 1116000p 0.9
+ 1116010p -0.3
+ 1118000p -0.3
+ 1118010p 0.9
+ 1120000p 0.9
+ 1120010p -0.3
+ 1122000p -0.3
+ 1122010p 0.9
+ 1124000p 0.9
+ 1124010p -0.3
+ 1126000p -0.3
+ 1126010p 0.9
+ 1128000p 0.9
+ 1128010p -0.3
+ 1130000p -0.3
+ 1130010p 0.9
+ 1132000p 0.9
+ 1132010p -0.3
+ 1134000p -0.3
+ 1134010p 0.9
+ 1136000p 0.9
+ 1136010p -0.3
+ 1138000p -0.3
+ 1138010p 0.9
+ 1140000p 0.9
+ 1140010p -0.3
+ 1142000p -0.3
+ 1142010p 0.9
+ 1144000p 0.9
+ 1144010p -0.3
+ 1146000p -0.3
+ 1146010p 0.9
+ 1148000p 0.9
+ 1148010p -0.3
+ 1150000p -0.3
+ 1150010p 0.9
+ 1152000p 0.9
+ 1152010p -0.3
+ 1154000p -0.3
+ 1154010p 0.9
+ 1156000p 0.9
+ 1156010p -0.3
+ 1158000p -0.3
+ 1158010p 0.9
+ 1160000p 0.9
+ 1160010p -0.3
+ 1162000p -0.3
+ 1162010p 0.9
+ 1164000p 0.9
+ 1164010p -0.3
+ 1166000p -0.3
+ 1166010p 0.9
+ 1168000p 0.9
+ 1168010p -0.3
+ 1170000p -0.3
+ 1170010p 0.9
+ 1172000p 0.9
+ 1172010p -0.3
+ 1174000p -0.3
+ 1174010p 0.9
+ 1176000p 0.9
+ 1176010p -0.3
+ 1178000p -0.3
+ 1178010p 0.9
+ 1180000p 0.9
+ 1180010p -0.3
+ 1182000p -0.3
+ 1182010p 0.9
+ 1184000p 0.9
+ 1184010p -0.3
+ 1186000p -0.3
+ 1186010p 0.9
+ 1188000p 0.9
+ 1188010p -0.3
+ 1190000p -0.3
+ 1190010p 0.9
+ 1192000p 0.9
+ 1192010p -0.3
+ 1194000p -0.3
+ 1194010p 0.9
+ 1196000p 0.9
+ 1196010p -0.3
+ 1198000p -0.3
+ 1198010p 0.9
+ 1200000p 0.9
+ 1200010p -0.3
+ 1202000p -0.3
+ 1202010p 0.9
+ 1204000p 0.9
+ 1204010p -0.3
+ 1206000p -0.3
+ 1206010p 0.9
+ 1208000p 0.9
+ 1208010p -0.3
+ 1210000p -0.3
+ 1210010p 0.9
+ 1212000p 0.9
+ 1212010p -0.3
+ 1214000p -0.3
+ 1214010p 0.9
+ 1216000p 0.9
+ 1216010p -0.3
+ 1218000p -0.3
+ 1218010p 0.9
+ 1220000p 0.9
+ 1220010p -0.3
+ 1222000p -0.3
+ 1222010p 0.9
+ 1224000p 0.9
+ 1224010p -0.3
+ 1226000p -0.3
+ 1226010p 0.9
+ 1228000p 0.9
+ 1228010p -0.3
+ 1230000p -0.3
+ 1230010p 0.9
+ 1232000p 0.9
+ 1232010p -0.3
+ 1234000p -0.3
+ 1234010p 0.9
+ 1236000p 0.9
+ 1236010p -0.3
+ 1238000p -0.3
+ 1238010p 0.9
+ 1240000p 0.9
+ 1240010p -0.3
+ 1242000p -0.3
+ 1242010p 0.9
+ 1244000p 0.9
+ 1244010p -0.3
+ 1246000p -0.3
+ 1246010p 0.9
+ 1248000p 0.9
+ 1248010p -0.3
+ 1250000p -0.3
+ 1250010p 0.9
+ 1252000p 0.9
+ 1252010p -0.3
+ 1254000p -0.3
+ 1254010p 0.9
+ 1256000p 0.9
+ 1256010p -0.3
+ 1258000p -0.3
+ 1258010p 0.9
+ 1260000p 0.9
+ 1260010p -0.3
+ 1262000p -0.3
+ 1262010p 0.9
+ 1264000p 0.9
+ 1264010p -0.3
+ 1266000p -0.3
+ 1266010p 0.9
+ 1268000p 0.9
+ 1268010p -0.3
+ 1270000p -0.3
+ 1270010p 0.9
+ 1272000p 0.9
+ 1272010p -0.3
+ 1274000p -0.3
+ 1274010p 0.9
+ 1276000p 0.9
+ 1276010p -0.3
+ 1278000p -0.3
+ 1278010p 0.9
+ 1280000p 0.9
+ 1280010p -0.3
+ 1282000p -0.3
+ 1282010p 0.9
+ 1284000p 0.9
+ 1284010p -0.3
+ 1286000p -0.3
+ 1286010p 0.9
+ 1288000p 0.9
+ 1288010p -0.3
+ 1290000p -0.3
+ 1290010p 0.9
+ 1292000p 0.9
+ 1292010p -0.3
+ 1294000p -0.3
+ 1294010p 0.9
+ 1296000p 0.9
+ 1296010p -0.3
+ 1298000p -0.3
+ 1298010p 0.9
+ 1300000p 0.9
+ 1300010p -0.3
+ 1302000p -0.3
+ 1302010p 0.9
+ 1304000p 0.9
+ 1304010p -0.3
+ 1306000p -0.3
+ 1306010p 0.9
+ 1308000p 0.9
+ 1308010p -0.3
+ 1310000p -0.3
+ 1310010p 0.9
+ 1312000p 0.9
+ 1312010p -0.3
+ 1314000p -0.3
+ 1314010p 0.9
+ 1316000p 0.9
+ 1316010p -0.3
+ 1318000p -0.3
+ 1318010p 0.9
+ 1320000p 0.9
+ 1320010p -0.3
+ 1322000p -0.3
+ 1322010p 0.9
+ 1324000p 0.9
+ 1324010p -0.3
+ 1326000p -0.3
+ 1326010p 0.9
+ 1328000p 0.9
+ 1328010p -0.3
+ 1330000p -0.3
+ 1330010p 0.9
+ 1332000p 0.9
+ 1332010p -0.3
+ 1334000p -0.3
+ 1334010p 0.9
+ 1336000p 0.9
+ 1336010p -0.3
+ 1338000p -0.3
+ 1338010p 0.9
+ 1340000p 0.9
+ 1340010p -0.3
+ 1342000p -0.3
+ 1342010p 0.9
+ 1344000p 0.9
+ 1344010p -0.3
+ 1346000p -0.3
+ 1346010p 0.9
+ 1348000p 0.9
+ 1348010p -0.3
+ 1350000p -0.3
+ 1350010p 0.9
+ 1352000p 0.9
+ 1352010p -0.3
+ 1354000p -0.3
+ 1354010p 0.9
+ 1356000p 0.9
+ 1356010p -0.3
+ 1358000p -0.3
+ 1358010p 0.9
+ 1360000p 0.9
+ 1360010p -0.3
+ 1362000p -0.3
+ 1362010p 0.9
+ 1364000p 0.9
+ 1364010p -0.3
+ 1366000p -0.3
+ 1366010p 0.9
+ 1368000p 0.9
+ 1368010p -0.3
+ 1370000p -0.3
+ 1370010p 0.9
+ 1372000p 0.9
+ 1372010p -0.3
+ 1374000p -0.3
+ 1374010p 0.9
+ 1376000p 0.9
+ 1376010p -0.3
+ 1378000p -0.3
+ 1378010p 0.9
+ 1380000p 0.9
+ 1380010p -0.3
+ 1382000p -0.3
+ 1382010p 0.9
+ 1384000p 0.9
+ 1384010p -0.3
+ 1386000p -0.3
+ 1386010p 0.9
+ 1388000p 0.9
+ 1388010p -0.3
+ 1390000p -0.3
+ 1390010p 0.9
+ 1392000p 0.9
+ 1392010p -0.3
+ 1394000p -0.3
+ 1394010p 0.9
+ 1396000p 0.9
+ 1396010p -0.3
+ 1398000p -0.3
+ 1398010p 0.9
+ 1400000p 0.9
+ 1400010p -0.3
+ 1402000p -0.3
+ 1402010p 0.9
+ 1404000p 0.9
+ 1404010p -0.3
+ 1406000p -0.3
+ 1406010p 0.9
+ 1408000p 0.9
+ 1408010p -0.3
+ 1410000p -0.3
+ 1410010p 0.9
+ 1412000p 0.9
+ 1412010p -0.3
+ 1414000p -0.3
+ 1414010p 0.9
+ 1416000p 0.9
+ 1416010p -0.3
+ 1418000p -0.3
+ 1418010p 0.9
+ 1420000p 0.9
+ 1420010p -0.3
+ 1422000p -0.3
+ 1422010p 0.9
+ 1424000p 0.9
+ 1424010p -0.3
+ 1426000p -0.3
+ 1426010p 0.9
+ 1428000p 0.9
+ 1428010p -0.3
+ 1430000p -0.3
+ 1430010p 0.9
+ 1432000p 0.9
+ 1432010p -0.3
+ 1434000p -0.3
+ 1434010p 0.9
+ 1436000p 0.9
+ 1436010p -0.3
+ 1438000p -0.3
+ 1438010p 0.9
+ 1440000p 0.9
+ 1440010p -0.3
+ 1442000p -0.3
+ 1442010p 0.9
+ 1444000p 0.9
+ 1444010p -0.3
+ 1446000p -0.3
+ 1446010p 0.9
+ 1448000p 0.9
+ 1448010p -0.3
+ 1450000p -0.3
+ 1450010p 0.9
+ 1452000p 0.9
+ 1452010p -0.3
+ 1454000p -0.3
+ 1454010p 0.9
+ 1456000p 0.9
+ 1456010p -0.3
+ 1458000p -0.3
+ 1458010p 0.9
+ 1460000p 0.9
+ 1460010p -0.3
+ 1462000p -0.3
+ 1462010p 0.9
+ 1464000p 0.9
+ 1464010p -0.3
+ 1466000p -0.3
+ 1466010p 0.9
+ 1468000p 0.9
+ 1468010p -0.3
+ 1470000p -0.3
+ 1470010p 0.9
+ 1472000p 0.9
+ 1472010p -0.3
+ 1474000p -0.3
+ 1474010p 0.9
+ 1476000p 0.9
+ 1476010p -0.3
+ 1478000p -0.3
+ 1478010p 0.9
+ 1480000p 0.9
+ 1480010p -0.3
+ 1482000p -0.3
+ 1482010p 0.9
+ 1484000p 0.9
+ 1484010p -0.3
+ 1486000p -0.3
+ 1486010p 0.9
+ 1488000p 0.9
+ 1488010p -0.3
+ 1490000p -0.3
+ 1490010p 0.9
+ 1492000p 0.9
+ 1492010p -0.3
+ 1494000p -0.3
+ 1494010p 0.9
+ 1496000p 0.9
+ 1496010p -0.3
+ 1498000p -0.3
+ 1498010p 0.9
+ 1500000p 0.9
+ 1500010p -0.3
+ 1502000p -0.3
+ 1502010p 0.9
+ 1504000p 0.9
+ 1504010p -0.3
+ 1506000p -0.3
+ 1506010p 0.9
+ 1508000p 0.9
+ 1508010p -0.3
+ 1510000p -0.3
+ 1510010p 0.9
+ 1512000p 0.9
+ 1512010p -0.3
+ 1514000p -0.3
+ 1514010p 0.9
+ 1516000p 0.9
+ 1516010p -0.3
+ 1518000p -0.3
+ 1518010p 0.9
+ 1520000p 0.9
+ 1520010p -0.3
+ 1522000p -0.3
+ 1522010p 0.9
+ 1524000p 0.9
+ 1524010p -0.3
+ 1526000p -0.3
+ 1526010p 0.9
+ 1528000p 0.9
+ 1528010p -0.3
+ 1530000p -0.3
+ 1530010p 0.9
+ 1532000p 0.9
+ 1532010p -0.3
+ 1534000p -0.3
+ 1534010p 0.9
+ 1536000p 0.9
+ 1536010p -0.3
+ 1538000p -0.3
+ 1538010p 0.9
+ 1540000p 0.9
+ 1540010p -0.3
+ 1542000p -0.3
+ 1542010p 0.9
+ 1544000p 0.9
+ 1544010p -0.3
+ 1546000p -0.3
+ 1546010p 0.9
+ 1548000p 0.9
+ 1548010p -0.3
+ 1550000p -0.3
+ 1550010p 0.9
+ 1552000p 0.9
+ 1552010p -0.3
+ 1554000p -0.3
+ 1554010p 0.9
+ 1556000p 0.9
+ 1556010p -0.3
+ 1558000p -0.3
+ 1558010p 0.9
+ 1560000p 0.9
+ 1560010p -0.3
+ 1562000p -0.3
+ 1562010p 0.9
+ 1564000p 0.9
+ 1564010p -0.3
+ 1566000p -0.3
+ 1566010p 0.9
+ 1568000p 0.9
+ 1568010p -0.3
+ 1570000p -0.3
+ 1570010p 0.9
+ 1572000p 0.9
+ 1572010p -0.3
+ 1574000p -0.3
+ 1574010p 0.9
+ 1576000p 0.9
+ 1576010p -0.3
+ 1578000p -0.3
+ 1578010p 0.9
+ 1580000p 0.9
+ 1580010p -0.3
+ 1582000p -0.3
+ 1582010p 0.9
+ 1584000p 0.9
+ 1584010p -0.3
+ 1586000p -0.3
+ 1586010p 0.9
+ 1588000p 0.9
+ 1588010p -0.3
+ 1590000p -0.3
+ 1590010p 0.9
+ 1592000p 0.9
+ 1592010p -0.3
+ 1594000p -0.3
+ 1594010p 0.9
+ 1596000p 0.9
+ 1596010p -0.3
+ 1598000p -0.3
+ 1598010p 0.9
+ 1600000p 0.9
+ 1600010p -0.3
+ 1602000p -0.3
+ 1602010p 0.9
+ 1604000p 0.9
+ 1604010p -0.3
+ 1606000p -0.3
+ 1606010p 0.9
+ 1608000p 0.9
+ 1608010p -0.3
+ 1610000p -0.3
+ 1610010p 0.9
+ 1612000p 0.9
+ 1612010p -0.3
+ 1614000p -0.3
+ 1614010p 0.9
+ 1616000p 0.9
+ 1616010p -0.3
+ 1618000p -0.3
+ 1618010p 0.9
+ 1620000p 0.9
+ 1620010p -0.3
+ 1622000p -0.3
+ 1622010p 0.9
+ 1624000p 0.9
+ 1624010p -0.3
+ 1626000p -0.3
+ 1626010p 0.9
+ 1628000p 0.9
+ 1628010p -0.3
+ 1630000p -0.3
+ 1630010p 0.9
+ 1632000p 0.9
+ 1632010p -0.3
+ 1634000p -0.3
+ 1634010p 0.9
+ 1636000p 0.9
+ 1636010p -0.3
+ 1638000p -0.3
+ 1638010p 0.9
+ 1640000p 0.9
+ 1640010p -0.3
+ 1642000p -0.3
+ 1642010p 0.9
+ 1644000p 0.9
+ 1644010p -0.3
+ 1646000p -0.3
+ 1646010p 0.9
+ 1648000p 0.9
+ 1648010p -0.3
+ 1650000p -0.3
+ 1650010p 0.9
+ 1652000p 0.9
+ 1652010p -0.3
+ 1654000p -0.3
+ 1654010p 0.9
+ 1656000p 0.9
+ 1656010p -0.3
+ 1658000p -0.3
+ 1658010p 0.9
+ 1660000p 0.9
+ 1660010p -0.3
+ 1662000p -0.3
+ 1662010p 0.9
+ 1664000p 0.9
+ 1664010p -0.3
+ 1666000p -0.3
+ 1666010p 0.9
+ 1668000p 0.9
+ 1668010p -0.3
+ 1670000p -0.3
+ 1670010p 0.9
+ 1672000p 0.9
+ 1672010p -0.3
+ 1674000p -0.3
+ 1674010p 0.9
+ 1676000p 0.9
+ 1676010p -0.3
+ 1678000p -0.3
+ 1678010p 0.9
+ 1680000p 0.9
+ 1680010p -0.3
+ 1682000p -0.3
+ 1682010p 0.9
+ 1684000p 0.9
+ 1684010p -0.3
+ 1686000p -0.3
+ 1686010p 0.9
+ 1688000p 0.9
+ 1688010p -0.3
+ 1690000p -0.3
+ 1690010p 0.9
+ 1692000p 0.9
+ 1692010p -0.3
+ 1694000p -0.3
+ 1694010p 0.9
+ 1696000p 0.9
+ 1696010p -0.3
+ 1698000p -0.3
+ 1698010p 0.9
+ 1700000p 0.9
+ 1700010p -0.3
+ 1702000p -0.3
+ 1702010p 0.9
+ 1704000p 0.9
+ 1704010p -0.3
+ 1706000p -0.3
+ 1706010p 0.9
+ 1708000p 0.9
+ 1708010p -0.3
+ 1710000p -0.3
+ 1710010p 0.9
+ 1712000p 0.9
+ 1712010p -0.3
+ 1714000p -0.3
+ 1714010p 0.9
+ 1716000p 0.9
+ 1716010p -0.3
+ 1718000p -0.3
+ 1718010p 0.9
+ 1720000p 0.9
+ 1720010p -0.3
+ 1722000p -0.3
+ 1722010p 0.9
+ 1724000p 0.9
+ 1724010p -0.3
+ 1726000p -0.3
+ 1726010p 0.9
+ 1728000p 0.9
+ 1728010p -0.3
+ 1730000p -0.3
+ 1730010p 0.9
+ 1732000p 0.9
+ 1732010p -0.3
+ 1734000p -0.3
+ 1734010p 0.9
+ 1736000p 0.9
+ 1736010p -0.3
+ 1738000p -0.3
+ 1738010p 0.9
+ 1740000p 0.9
+ 1740010p -0.3
+ 1742000p -0.3
+ 1742010p 0.9
+ 1744000p 0.9
+ 1744010p -0.3
+ 1746000p -0.3
+ 1746010p 0.9
+ 1748000p 0.9
+ 1748010p -0.3
+ 1750000p -0.3
+ 1750010p 0.9
+ 1752000p 0.9
+ 1752010p -0.3
+ 1754000p -0.3
+ 1754010p 0.9
+ 1756000p 0.9
+ 1756010p -0.3
+ 1758000p -0.3
+ 1758010p 0.9
+ 1760000p 0.9
+ 1760010p -0.3
+ 1762000p -0.3
+ 1762010p 0.9
+ 1764000p 0.9
+ 1764010p -0.3
+ 1766000p -0.3
+ 1766010p 0.9
+ 1768000p 0.9
+ 1768010p -0.3
+ 1770000p -0.3
+ 1770010p 0.9
+ 1772000p 0.9
+ 1772010p -0.3
+ 1774000p -0.3
+ 1774010p 0.9
+ 1776000p 0.9
+ 1776010p -0.3
+ 1778000p -0.3
+ 1778010p 0.9
+ 1780000p 0.9
+ 1780010p -0.3
+ 1782000p -0.3
+ 1782010p 0.9
+ 1784000p 0.9
+ 1784010p -0.3
+ 1786000p -0.3
+ 1786010p 0.9
+ 1788000p 0.9
+ 1788010p -0.3
+ 1790000p -0.3
+ 1790010p 0.9
+ 1792000p 0.9
+ 1792010p -0.3
+ 1794000p -0.3
+ 1794010p 0.9
+ 1796000p 0.9
+ 1796010p -0.3
+ 1798000p -0.3
+ 1798010p 0.9
+ 1800000p 0.9
+ 1800010p -0.3
+ 1802000p -0.3
+ 1802010p 0.9
+ 1804000p 0.9
+ 1804010p -0.3
+ 1806000p -0.3
+ 1806010p 0.9
+ 1808000p 0.9
+ 1808010p -0.3
+ 1810000p -0.3
+ 1810010p 0.9
+ 1812000p 0.9
+ 1812010p -0.3
+ 1814000p -0.3
+ 1814010p 0.9
+ 1816000p 0.9
+ 1816010p -0.3
+ 1818000p -0.3
+ 1818010p 0.9
+ 1820000p 0.9
+ 1820010p -0.3
+ 1822000p -0.3
+ 1822010p 0.9
+ 1824000p 0.9
+ 1824010p -0.3
+ 1826000p -0.3
+ 1826010p 0.9
+ 1828000p 0.9
+ 1828010p -0.3
+ 1830000p -0.3
+ 1830010p 0.9
+ 1832000p 0.9
+ 1832010p -0.3
+ 1834000p -0.3
+ 1834010p 0.9
+ 1836000p 0.9
+ 1836010p -0.3
+ 1838000p -0.3
+ 1838010p 0.9
+ 1840000p 0.9
+ 1840010p -0.3
+ 1842000p -0.3
+ 1842010p 0.9
+ 1844000p 0.9
+ 1844010p -0.3
+ 1846000p -0.3
+ 1846010p 0.9
+ 1848000p 0.9
+ 1848010p -0.3
+ 1850000p -0.3
+ 1850010p 0.9
+ 1852000p 0.9
+ 1852010p -0.3
+ 1854000p -0.3
+ 1854010p 0.9
+ 1856000p 0.9
+ 1856010p -0.3
+ 1858000p -0.3
+ 1858010p 0.9
+ 1860000p 0.9
+ 1860010p -0.3
+ 1862000p -0.3
+ 1862010p 0.9
+ 1864000p 0.9
+ 1864010p -0.3
+ 1866000p -0.3
+ 1866010p 0.9
+ 1868000p 0.9
+ 1868010p -0.3
+ 1870000p -0.3
+ 1870010p 0.9
+ 1872000p 0.9
+ 1872010p -0.3
+ 1874000p -0.3
+ 1874010p 0.9
+ 1876000p 0.9
+ 1876010p -0.3
+ 1878000p -0.3
+ 1878010p 0.9
+ 1880000p 0.9
+ 1880010p -0.3
+ 1882000p -0.3
+ 1882010p 0.9
+ 1884000p 0.9
+ 1884010p -0.3
+ 1886000p -0.3
+ 1886010p 0.9
+ 1888000p 0.9
+ 1888010p -0.3
+ 1890000p -0.3
+ 1890010p 0.9
+ 1892000p 0.9
+ 1892010p -0.3
+ 1894000p -0.3
+ 1894010p 0.9
+ 1896000p 0.9
+ 1896010p -0.3
+ 1898000p -0.3
+ 1898010p 0.9
+ 1900000p 0.9
+ 1900010p -0.3
+ 1902000p -0.3
+ 1902010p 0.9
+ 1904000p 0.9
+ 1904010p -0.3
+ 1906000p -0.3
+ 1906010p 0.9
+ 1908000p 0.9
+ 1908010p -0.3
+ 1910000p -0.3
+ 1910010p 0.9
+ 1912000p 0.9
+ 1912010p -0.3
+ 1914000p -0.3
+ 1914010p 0.9
+ 1916000p 0.9
+ 1916010p -0.3
+ 1918000p -0.3
+ 1918010p 0.9
+ 1920000p 0.9
+ 1920010p -0.3
+ 1922000p -0.3
+ 1922010p 0.9
+ 1924000p 0.9
+ 1924010p -0.3
+ 1926000p -0.3
+ 1926010p 0.9
+ 1928000p 0.9
+ 1928010p -0.3
+ 1930000p -0.3
+ 1930010p 0.9
+ 1932000p 0.9
+ 1932010p -0.3
+ 1934000p -0.3
+ 1934010p 0.9
+ 1936000p 0.9
+ 1936010p -0.3
+ 1938000p -0.3
+ 1938010p 0.9
+ 1940000p 0.9
+ 1940010p -0.3
+ 1942000p -0.3
+ 1942010p 0.9
+ 1944000p 0.9
+ 1944010p -0.3
+ 1946000p -0.3
+ 1946010p 0.9
+ 1948000p 0.9
+ 1948010p -0.3
+ 1950000p -0.3
+ 1950010p 0.9
+ 1952000p 0.9
+ 1952010p -0.3
+ 1954000p -0.3
+ 1954010p 0.9
+ 1956000p 0.9
+ 1956010p -0.3
+ 1958000p -0.3
+ 1958010p 0.9
+ 1960000p 0.9
+ 1960010p -0.3
+ 1962000p -0.3
+ 1962010p 0.9
+ 1964000p 0.9
+ 1964010p -0.3
+ 1966000p -0.3
+ 1966010p 0.9
+ 1968000p 0.9
+ 1968010p -0.3
+ 1970000p -0.3
+ 1970010p 0.9
+ 1972000p 0.9
+ 1972010p -0.3
+ 1974000p -0.3
+ 1974010p 0.9
+ 1976000p 0.9
+ 1976010p -0.3
+ 1978000p -0.3
+ 1978010p 0.9
+ 1980000p 0.9
+ 1980010p -0.3
+ 1982000p -0.3
+ 1982010p 0.9
+ 1984000p 0.9
+ 1984010p -0.3
+ 1986000p -0.3
+ 1986010p 0.9
+ 1988000p 0.9
+ 1988010p -0.3
+ 1990000p -0.3
+ 1990010p 0.9
+ 1992000p 0.9
+ 1992010p -0.3
+ 1994000p -0.3
+ 1994010p 0.9
+ 1996000p 0.9
+ 1996010p -0.3
+ 1998000p -0.3
+ 1998010p 0.9
+ 2000000p 0.9
+ 2000010p -0.3
+ 2002000p -0.3
+ 2002010p 0.9
+ 2004000p 0.9
+ 2004010p -0.3
+ 2006000p -0.3
+ 2006010p 0.9
+ 2008000p 0.9
+ 2008010p -0.3
+ 2010000p -0.3
+ 2010010p 0.9
+ 2012000p 0.9
+ 2012010p -0.3
+ 2014000p -0.3
+ 2014010p 0.9
+ 2016000p 0.9
+ 2016010p -0.3
+ 2018000p -0.3
+ 2018010p 0.9
+ 2020000p 0.9
+ 2020010p -0.3
+ 2022000p -0.3
+ 2022010p 0.9
+ 2024000p 0.9
+ 2024010p -0.3
+ 2026000p -0.3
+ 2026010p 0.9
+ 2028000p 0.9
+ 2028010p -0.3
+ 2030000p -0.3
+ 2030010p 0.9
+ 2032000p 0.9
+ 2032010p -0.3
+ 2034000p -0.3
+ 2034010p 0.9
+ 2036000p 0.9
+ 2036010p -0.3
+ 2038000p -0.3
+ 2038010p 0.9
+ 2040000p 0.9
+ 2040010p -0.3
+ 2042000p -0.3
+ 2042010p 0.9
+ 2044000p 0.9
+ 2044010p -0.3
+ 2046000p -0.3
+ 2046010p 0.9
+ 2048000p 0.9
+ 2048010p -0.3
+ \]
V_data_3 (Data\\<3\\> gnd!) vsource type=pwl wave=\[
+ 0    0.9
+ 2000p 0.9
+ 2010p -0.3
+ 4000p -0.3
+ 4010p 0.9
+ 6000p 0.9
+ 6010p -0.3
+ 8000p -0.3
+ 8010p 0.9
+ 10000p 0.9
+ 10010p -0.3
+ 12000p -0.3
+ 12010p 0.9
+ 14000p 0.9
+ 14010p -0.3
+ 16000p -0.3
+ 16010p 0.9
+ 18000p 0.9
+ 18010p -0.3
+ 20000p -0.3
+ 20010p 0.9
+ 22000p 0.9
+ 22010p -0.3
+ 24000p -0.3
+ 24010p 0.9
+ 26000p 0.9
+ 26010p -0.3
+ 28000p -0.3
+ 28010p 0.9
+ 30000p 0.9
+ 30010p -0.3
+ 32000p -0.3
+ 32010p 0.9
+ 34000p 0.9
+ 34010p -0.3
+ 36000p -0.3
+ 36010p 0.9
+ 38000p 0.9
+ 38010p -0.3
+ 40000p -0.3
+ 40010p 0.9
+ 42000p 0.9
+ 42010p -0.3
+ 44000p -0.3
+ 44010p 0.9
+ 46000p 0.9
+ 46010p -0.3
+ 48000p -0.3
+ 48010p 0.9
+ 50000p 0.9
+ 50010p -0.3
+ 52000p -0.3
+ 52010p 0.9
+ 54000p 0.9
+ 54010p -0.3
+ 56000p -0.3
+ 56010p 0.9
+ 58000p 0.9
+ 58010p -0.3
+ 60000p -0.3
+ 60010p 0.9
+ 62000p 0.9
+ 62010p -0.3
+ 64000p -0.3
+ 64010p 0.9
+ 66000p 0.9
+ 66010p -0.3
+ 68000p -0.3
+ 68010p 0.9
+ 70000p 0.9
+ 70010p -0.3
+ 72000p -0.3
+ 72010p 0.9
+ 74000p 0.9
+ 74010p -0.3
+ 76000p -0.3
+ 76010p 0.9
+ 78000p 0.9
+ 78010p -0.3
+ 80000p -0.3
+ 80010p 0.9
+ 82000p 0.9
+ 82010p -0.3
+ 84000p -0.3
+ 84010p 0.9
+ 86000p 0.9
+ 86010p -0.3
+ 88000p -0.3
+ 88010p 0.9
+ 90000p 0.9
+ 90010p -0.3
+ 92000p -0.3
+ 92010p 0.9
+ 94000p 0.9
+ 94010p -0.3
+ 96000p -0.3
+ 96010p 0.9
+ 98000p 0.9
+ 98010p -0.3
+ 100000p -0.3
+ 100010p 0.9
+ 102000p 0.9
+ 102010p -0.3
+ 104000p -0.3
+ 104010p 0.9
+ 106000p 0.9
+ 106010p -0.3
+ 108000p -0.3
+ 108010p 0.9
+ 110000p 0.9
+ 110010p -0.3
+ 112000p -0.3
+ 112010p 0.9
+ 114000p 0.9
+ 114010p -0.3
+ 116000p -0.3
+ 116010p 0.9
+ 118000p 0.9
+ 118010p -0.3
+ 120000p -0.3
+ 120010p 0.9
+ 122000p 0.9
+ 122010p -0.3
+ 124000p -0.3
+ 124010p 0.9
+ 126000p 0.9
+ 126010p -0.3
+ 128000p -0.3
+ 128010p 0.9
+ 130000p 0.9
+ 130010p -0.3
+ 132000p -0.3
+ 132010p 0.9
+ 134000p 0.9
+ 134010p -0.3
+ 136000p -0.3
+ 136010p 0.9
+ 138000p 0.9
+ 138010p -0.3
+ 140000p -0.3
+ 140010p 0.9
+ 142000p 0.9
+ 142010p -0.3
+ 144000p -0.3
+ 144010p 0.9
+ 146000p 0.9
+ 146010p -0.3
+ 148000p -0.3
+ 148010p 0.9
+ 150000p 0.9
+ 150010p -0.3
+ 152000p -0.3
+ 152010p 0.9
+ 154000p 0.9
+ 154010p -0.3
+ 156000p -0.3
+ 156010p 0.9
+ 158000p 0.9
+ 158010p -0.3
+ 160000p -0.3
+ 160010p 0.9
+ 162000p 0.9
+ 162010p -0.3
+ 164000p -0.3
+ 164010p 0.9
+ 166000p 0.9
+ 166010p -0.3
+ 168000p -0.3
+ 168010p 0.9
+ 170000p 0.9
+ 170010p -0.3
+ 172000p -0.3
+ 172010p 0.9
+ 174000p 0.9
+ 174010p -0.3
+ 176000p -0.3
+ 176010p 0.9
+ 178000p 0.9
+ 178010p -0.3
+ 180000p -0.3
+ 180010p 0.9
+ 182000p 0.9
+ 182010p -0.3
+ 184000p -0.3
+ 184010p 0.9
+ 186000p 0.9
+ 186010p -0.3
+ 188000p -0.3
+ 188010p 0.9
+ 190000p 0.9
+ 190010p -0.3
+ 192000p -0.3
+ 192010p 0.9
+ 194000p 0.9
+ 194010p -0.3
+ 196000p -0.3
+ 196010p 0.9
+ 198000p 0.9
+ 198010p -0.3
+ 200000p -0.3
+ 200010p 0.9
+ 202000p 0.9
+ 202010p -0.3
+ 204000p -0.3
+ 204010p 0.9
+ 206000p 0.9
+ 206010p -0.3
+ 208000p -0.3
+ 208010p 0.9
+ 210000p 0.9
+ 210010p -0.3
+ 212000p -0.3
+ 212010p 0.9
+ 214000p 0.9
+ 214010p -0.3
+ 216000p -0.3
+ 216010p 0.9
+ 218000p 0.9
+ 218010p -0.3
+ 220000p -0.3
+ 220010p 0.9
+ 222000p 0.9
+ 222010p -0.3
+ 224000p -0.3
+ 224010p 0.9
+ 226000p 0.9
+ 226010p -0.3
+ 228000p -0.3
+ 228010p 0.9
+ 230000p 0.9
+ 230010p -0.3
+ 232000p -0.3
+ 232010p 0.9
+ 234000p 0.9
+ 234010p -0.3
+ 236000p -0.3
+ 236010p 0.9
+ 238000p 0.9
+ 238010p -0.3
+ 240000p -0.3
+ 240010p 0.9
+ 242000p 0.9
+ 242010p -0.3
+ 244000p -0.3
+ 244010p 0.9
+ 246000p 0.9
+ 246010p -0.3
+ 248000p -0.3
+ 248010p 0.9
+ 250000p 0.9
+ 250010p -0.3
+ 252000p -0.3
+ 252010p 0.9
+ 254000p 0.9
+ 254010p -0.3
+ 256000p -0.3
+ 256010p 0.9
+ 258000p 0.9
+ 258010p -0.3
+ 260000p -0.3
+ 260010p 0.9
+ 262000p 0.9
+ 262010p -0.3
+ 264000p -0.3
+ 264010p 0.9
+ 266000p 0.9
+ 266010p -0.3
+ 268000p -0.3
+ 268010p 0.9
+ 270000p 0.9
+ 270010p -0.3
+ 272000p -0.3
+ 272010p 0.9
+ 274000p 0.9
+ 274010p -0.3
+ 276000p -0.3
+ 276010p 0.9
+ 278000p 0.9
+ 278010p -0.3
+ 280000p -0.3
+ 280010p 0.9
+ 282000p 0.9
+ 282010p -0.3
+ 284000p -0.3
+ 284010p 0.9
+ 286000p 0.9
+ 286010p -0.3
+ 288000p -0.3
+ 288010p 0.9
+ 290000p 0.9
+ 290010p -0.3
+ 292000p -0.3
+ 292010p 0.9
+ 294000p 0.9
+ 294010p -0.3
+ 296000p -0.3
+ 296010p 0.9
+ 298000p 0.9
+ 298010p -0.3
+ 300000p -0.3
+ 300010p 0.9
+ 302000p 0.9
+ 302010p -0.3
+ 304000p -0.3
+ 304010p 0.9
+ 306000p 0.9
+ 306010p -0.3
+ 308000p -0.3
+ 308010p 0.9
+ 310000p 0.9
+ 310010p -0.3
+ 312000p -0.3
+ 312010p 0.9
+ 314000p 0.9
+ 314010p -0.3
+ 316000p -0.3
+ 316010p 0.9
+ 318000p 0.9
+ 318010p -0.3
+ 320000p -0.3
+ 320010p 0.9
+ 322000p 0.9
+ 322010p -0.3
+ 324000p -0.3
+ 324010p 0.9
+ 326000p 0.9
+ 326010p -0.3
+ 328000p -0.3
+ 328010p 0.9
+ 330000p 0.9
+ 330010p -0.3
+ 332000p -0.3
+ 332010p 0.9
+ 334000p 0.9
+ 334010p -0.3
+ 336000p -0.3
+ 336010p 0.9
+ 338000p 0.9
+ 338010p -0.3
+ 340000p -0.3
+ 340010p 0.9
+ 342000p 0.9
+ 342010p -0.3
+ 344000p -0.3
+ 344010p 0.9
+ 346000p 0.9
+ 346010p -0.3
+ 348000p -0.3
+ 348010p 0.9
+ 350000p 0.9
+ 350010p -0.3
+ 352000p -0.3
+ 352010p 0.9
+ 354000p 0.9
+ 354010p -0.3
+ 356000p -0.3
+ 356010p 0.9
+ 358000p 0.9
+ 358010p -0.3
+ 360000p -0.3
+ 360010p 0.9
+ 362000p 0.9
+ 362010p -0.3
+ 364000p -0.3
+ 364010p 0.9
+ 366000p 0.9
+ 366010p -0.3
+ 368000p -0.3
+ 368010p 0.9
+ 370000p 0.9
+ 370010p -0.3
+ 372000p -0.3
+ 372010p 0.9
+ 374000p 0.9
+ 374010p -0.3
+ 376000p -0.3
+ 376010p 0.9
+ 378000p 0.9
+ 378010p -0.3
+ 380000p -0.3
+ 380010p 0.9
+ 382000p 0.9
+ 382010p -0.3
+ 384000p -0.3
+ 384010p 0.9
+ 386000p 0.9
+ 386010p -0.3
+ 388000p -0.3
+ 388010p 0.9
+ 390000p 0.9
+ 390010p -0.3
+ 392000p -0.3
+ 392010p 0.9
+ 394000p 0.9
+ 394010p -0.3
+ 396000p -0.3
+ 396010p 0.9
+ 398000p 0.9
+ 398010p -0.3
+ 400000p -0.3
+ 400010p 0.9
+ 402000p 0.9
+ 402010p -0.3
+ 404000p -0.3
+ 404010p 0.9
+ 406000p 0.9
+ 406010p -0.3
+ 408000p -0.3
+ 408010p 0.9
+ 410000p 0.9
+ 410010p -0.3
+ 412000p -0.3
+ 412010p 0.9
+ 414000p 0.9
+ 414010p -0.3
+ 416000p -0.3
+ 416010p 0.9
+ 418000p 0.9
+ 418010p -0.3
+ 420000p -0.3
+ 420010p 0.9
+ 422000p 0.9
+ 422010p -0.3
+ 424000p -0.3
+ 424010p 0.9
+ 426000p 0.9
+ 426010p -0.3
+ 428000p -0.3
+ 428010p 0.9
+ 430000p 0.9
+ 430010p -0.3
+ 432000p -0.3
+ 432010p 0.9
+ 434000p 0.9
+ 434010p -0.3
+ 436000p -0.3
+ 436010p 0.9
+ 438000p 0.9
+ 438010p -0.3
+ 440000p -0.3
+ 440010p 0.9
+ 442000p 0.9
+ 442010p -0.3
+ 444000p -0.3
+ 444010p 0.9
+ 446000p 0.9
+ 446010p -0.3
+ 448000p -0.3
+ 448010p 0.9
+ 450000p 0.9
+ 450010p -0.3
+ 452000p -0.3
+ 452010p 0.9
+ 454000p 0.9
+ 454010p -0.3
+ 456000p -0.3
+ 456010p 0.9
+ 458000p 0.9
+ 458010p -0.3
+ 460000p -0.3
+ 460010p 0.9
+ 462000p 0.9
+ 462010p -0.3
+ 464000p -0.3
+ 464010p 0.9
+ 466000p 0.9
+ 466010p -0.3
+ 468000p -0.3
+ 468010p 0.9
+ 470000p 0.9
+ 470010p -0.3
+ 472000p -0.3
+ 472010p 0.9
+ 474000p 0.9
+ 474010p -0.3
+ 476000p -0.3
+ 476010p 0.9
+ 478000p 0.9
+ 478010p -0.3
+ 480000p -0.3
+ 480010p 0.9
+ 482000p 0.9
+ 482010p -0.3
+ 484000p -0.3
+ 484010p 0.9
+ 486000p 0.9
+ 486010p -0.3
+ 488000p -0.3
+ 488010p 0.9
+ 490000p 0.9
+ 490010p -0.3
+ 492000p -0.3
+ 492010p 0.9
+ 494000p 0.9
+ 494010p -0.3
+ 496000p -0.3
+ 496010p 0.9
+ 498000p 0.9
+ 498010p -0.3
+ 500000p -0.3
+ 500010p 0.9
+ 502000p 0.9
+ 502010p -0.3
+ 504000p -0.3
+ 504010p 0.9
+ 506000p 0.9
+ 506010p -0.3
+ 508000p -0.3
+ 508010p 0.9
+ 510000p 0.9
+ 510010p -0.3
+ 512000p -0.3
+ 512010p 0.9
+ 514000p 0.9
+ 514010p -0.3
+ 516000p -0.3
+ 516010p 0.9
+ 518000p 0.9
+ 518010p -0.3
+ 520000p -0.3
+ 520010p 0.9
+ 522000p 0.9
+ 522010p -0.3
+ 524000p -0.3
+ 524010p 0.9
+ 526000p 0.9
+ 526010p -0.3
+ 528000p -0.3
+ 528010p 0.9
+ 530000p 0.9
+ 530010p -0.3
+ 532000p -0.3
+ 532010p 0.9
+ 534000p 0.9
+ 534010p -0.3
+ 536000p -0.3
+ 536010p 0.9
+ 538000p 0.9
+ 538010p -0.3
+ 540000p -0.3
+ 540010p 0.9
+ 542000p 0.9
+ 542010p -0.3
+ 544000p -0.3
+ 544010p 0.9
+ 546000p 0.9
+ 546010p -0.3
+ 548000p -0.3
+ 548010p 0.9
+ 550000p 0.9
+ 550010p -0.3
+ 552000p -0.3
+ 552010p 0.9
+ 554000p 0.9
+ 554010p -0.3
+ 556000p -0.3
+ 556010p 0.9
+ 558000p 0.9
+ 558010p -0.3
+ 560000p -0.3
+ 560010p 0.9
+ 562000p 0.9
+ 562010p -0.3
+ 564000p -0.3
+ 564010p 0.9
+ 566000p 0.9
+ 566010p -0.3
+ 568000p -0.3
+ 568010p 0.9
+ 570000p 0.9
+ 570010p -0.3
+ 572000p -0.3
+ 572010p 0.9
+ 574000p 0.9
+ 574010p -0.3
+ 576000p -0.3
+ 576010p 0.9
+ 578000p 0.9
+ 578010p -0.3
+ 580000p -0.3
+ 580010p 0.9
+ 582000p 0.9
+ 582010p -0.3
+ 584000p -0.3
+ 584010p 0.9
+ 586000p 0.9
+ 586010p -0.3
+ 588000p -0.3
+ 588010p 0.9
+ 590000p 0.9
+ 590010p -0.3
+ 592000p -0.3
+ 592010p 0.9
+ 594000p 0.9
+ 594010p -0.3
+ 596000p -0.3
+ 596010p 0.9
+ 598000p 0.9
+ 598010p -0.3
+ 600000p -0.3
+ 600010p 0.9
+ 602000p 0.9
+ 602010p -0.3
+ 604000p -0.3
+ 604010p 0.9
+ 606000p 0.9
+ 606010p -0.3
+ 608000p -0.3
+ 608010p 0.9
+ 610000p 0.9
+ 610010p -0.3
+ 612000p -0.3
+ 612010p 0.9
+ 614000p 0.9
+ 614010p -0.3
+ 616000p -0.3
+ 616010p 0.9
+ 618000p 0.9
+ 618010p -0.3
+ 620000p -0.3
+ 620010p 0.9
+ 622000p 0.9
+ 622010p -0.3
+ 624000p -0.3
+ 624010p 0.9
+ 626000p 0.9
+ 626010p -0.3
+ 628000p -0.3
+ 628010p 0.9
+ 630000p 0.9
+ 630010p -0.3
+ 632000p -0.3
+ 632010p 0.9
+ 634000p 0.9
+ 634010p -0.3
+ 636000p -0.3
+ 636010p 0.9
+ 638000p 0.9
+ 638010p -0.3
+ 640000p -0.3
+ 640010p 0.9
+ 642000p 0.9
+ 642010p -0.3
+ 644000p -0.3
+ 644010p 0.9
+ 646000p 0.9
+ 646010p -0.3
+ 648000p -0.3
+ 648010p 0.9
+ 650000p 0.9
+ 650010p -0.3
+ 652000p -0.3
+ 652010p 0.9
+ 654000p 0.9
+ 654010p -0.3
+ 656000p -0.3
+ 656010p 0.9
+ 658000p 0.9
+ 658010p -0.3
+ 660000p -0.3
+ 660010p 0.9
+ 662000p 0.9
+ 662010p -0.3
+ 664000p -0.3
+ 664010p 0.9
+ 666000p 0.9
+ 666010p -0.3
+ 668000p -0.3
+ 668010p 0.9
+ 670000p 0.9
+ 670010p -0.3
+ 672000p -0.3
+ 672010p 0.9
+ 674000p 0.9
+ 674010p -0.3
+ 676000p -0.3
+ 676010p 0.9
+ 678000p 0.9
+ 678010p -0.3
+ 680000p -0.3
+ 680010p 0.9
+ 682000p 0.9
+ 682010p -0.3
+ 684000p -0.3
+ 684010p 0.9
+ 686000p 0.9
+ 686010p -0.3
+ 688000p -0.3
+ 688010p 0.9
+ 690000p 0.9
+ 690010p -0.3
+ 692000p -0.3
+ 692010p 0.9
+ 694000p 0.9
+ 694010p -0.3
+ 696000p -0.3
+ 696010p 0.9
+ 698000p 0.9
+ 698010p -0.3
+ 700000p -0.3
+ 700010p 0.9
+ 702000p 0.9
+ 702010p -0.3
+ 704000p -0.3
+ 704010p 0.9
+ 706000p 0.9
+ 706010p -0.3
+ 708000p -0.3
+ 708010p 0.9
+ 710000p 0.9
+ 710010p -0.3
+ 712000p -0.3
+ 712010p 0.9
+ 714000p 0.9
+ 714010p -0.3
+ 716000p -0.3
+ 716010p 0.9
+ 718000p 0.9
+ 718010p -0.3
+ 720000p -0.3
+ 720010p 0.9
+ 722000p 0.9
+ 722010p -0.3
+ 724000p -0.3
+ 724010p 0.9
+ 726000p 0.9
+ 726010p -0.3
+ 728000p -0.3
+ 728010p 0.9
+ 730000p 0.9
+ 730010p -0.3
+ 732000p -0.3
+ 732010p 0.9
+ 734000p 0.9
+ 734010p -0.3
+ 736000p -0.3
+ 736010p 0.9
+ 738000p 0.9
+ 738010p -0.3
+ 740000p -0.3
+ 740010p 0.9
+ 742000p 0.9
+ 742010p -0.3
+ 744000p -0.3
+ 744010p 0.9
+ 746000p 0.9
+ 746010p -0.3
+ 748000p -0.3
+ 748010p 0.9
+ 750000p 0.9
+ 750010p -0.3
+ 752000p -0.3
+ 752010p 0.9
+ 754000p 0.9
+ 754010p -0.3
+ 756000p -0.3
+ 756010p 0.9
+ 758000p 0.9
+ 758010p -0.3
+ 760000p -0.3
+ 760010p 0.9
+ 762000p 0.9
+ 762010p -0.3
+ 764000p -0.3
+ 764010p 0.9
+ 766000p 0.9
+ 766010p -0.3
+ 768000p -0.3
+ 768010p 0.9
+ 770000p 0.9
+ 770010p -0.3
+ 772000p -0.3
+ 772010p 0.9
+ 774000p 0.9
+ 774010p -0.3
+ 776000p -0.3
+ 776010p 0.9
+ 778000p 0.9
+ 778010p -0.3
+ 780000p -0.3
+ 780010p 0.9
+ 782000p 0.9
+ 782010p -0.3
+ 784000p -0.3
+ 784010p 0.9
+ 786000p 0.9
+ 786010p -0.3
+ 788000p -0.3
+ 788010p 0.9
+ 790000p 0.9
+ 790010p -0.3
+ 792000p -0.3
+ 792010p 0.9
+ 794000p 0.9
+ 794010p -0.3
+ 796000p -0.3
+ 796010p 0.9
+ 798000p 0.9
+ 798010p -0.3
+ 800000p -0.3
+ 800010p 0.9
+ 802000p 0.9
+ 802010p -0.3
+ 804000p -0.3
+ 804010p 0.9
+ 806000p 0.9
+ 806010p -0.3
+ 808000p -0.3
+ 808010p 0.9
+ 810000p 0.9
+ 810010p -0.3
+ 812000p -0.3
+ 812010p 0.9
+ 814000p 0.9
+ 814010p -0.3
+ 816000p -0.3
+ 816010p 0.9
+ 818000p 0.9
+ 818010p -0.3
+ 820000p -0.3
+ 820010p 0.9
+ 822000p 0.9
+ 822010p -0.3
+ 824000p -0.3
+ 824010p 0.9
+ 826000p 0.9
+ 826010p -0.3
+ 828000p -0.3
+ 828010p 0.9
+ 830000p 0.9
+ 830010p -0.3
+ 832000p -0.3
+ 832010p 0.9
+ 834000p 0.9
+ 834010p -0.3
+ 836000p -0.3
+ 836010p 0.9
+ 838000p 0.9
+ 838010p -0.3
+ 840000p -0.3
+ 840010p 0.9
+ 842000p 0.9
+ 842010p -0.3
+ 844000p -0.3
+ 844010p 0.9
+ 846000p 0.9
+ 846010p -0.3
+ 848000p -0.3
+ 848010p 0.9
+ 850000p 0.9
+ 850010p -0.3
+ 852000p -0.3
+ 852010p 0.9
+ 854000p 0.9
+ 854010p -0.3
+ 856000p -0.3
+ 856010p 0.9
+ 858000p 0.9
+ 858010p -0.3
+ 860000p -0.3
+ 860010p 0.9
+ 862000p 0.9
+ 862010p -0.3
+ 864000p -0.3
+ 864010p 0.9
+ 866000p 0.9
+ 866010p -0.3
+ 868000p -0.3
+ 868010p 0.9
+ 870000p 0.9
+ 870010p -0.3
+ 872000p -0.3
+ 872010p 0.9
+ 874000p 0.9
+ 874010p -0.3
+ 876000p -0.3
+ 876010p 0.9
+ 878000p 0.9
+ 878010p -0.3
+ 880000p -0.3
+ 880010p 0.9
+ 882000p 0.9
+ 882010p -0.3
+ 884000p -0.3
+ 884010p 0.9
+ 886000p 0.9
+ 886010p -0.3
+ 888000p -0.3
+ 888010p 0.9
+ 890000p 0.9
+ 890010p -0.3
+ 892000p -0.3
+ 892010p 0.9
+ 894000p 0.9
+ 894010p -0.3
+ 896000p -0.3
+ 896010p 0.9
+ 898000p 0.9
+ 898010p -0.3
+ 900000p -0.3
+ 900010p 0.9
+ 902000p 0.9
+ 902010p -0.3
+ 904000p -0.3
+ 904010p 0.9
+ 906000p 0.9
+ 906010p -0.3
+ 908000p -0.3
+ 908010p 0.9
+ 910000p 0.9
+ 910010p -0.3
+ 912000p -0.3
+ 912010p 0.9
+ 914000p 0.9
+ 914010p -0.3
+ 916000p -0.3
+ 916010p 0.9
+ 918000p 0.9
+ 918010p -0.3
+ 920000p -0.3
+ 920010p 0.9
+ 922000p 0.9
+ 922010p -0.3
+ 924000p -0.3
+ 924010p 0.9
+ 926000p 0.9
+ 926010p -0.3
+ 928000p -0.3
+ 928010p 0.9
+ 930000p 0.9
+ 930010p -0.3
+ 932000p -0.3
+ 932010p 0.9
+ 934000p 0.9
+ 934010p -0.3
+ 936000p -0.3
+ 936010p 0.9
+ 938000p 0.9
+ 938010p -0.3
+ 940000p -0.3
+ 940010p 0.9
+ 942000p 0.9
+ 942010p -0.3
+ 944000p -0.3
+ 944010p 0.9
+ 946000p 0.9
+ 946010p -0.3
+ 948000p -0.3
+ 948010p 0.9
+ 950000p 0.9
+ 950010p -0.3
+ 952000p -0.3
+ 952010p 0.9
+ 954000p 0.9
+ 954010p -0.3
+ 956000p -0.3
+ 956010p 0.9
+ 958000p 0.9
+ 958010p -0.3
+ 960000p -0.3
+ 960010p 0.9
+ 962000p 0.9
+ 962010p -0.3
+ 964000p -0.3
+ 964010p 0.9
+ 966000p 0.9
+ 966010p -0.3
+ 968000p -0.3
+ 968010p 0.9
+ 970000p 0.9
+ 970010p -0.3
+ 972000p -0.3
+ 972010p 0.9
+ 974000p 0.9
+ 974010p -0.3
+ 976000p -0.3
+ 976010p 0.9
+ 978000p 0.9
+ 978010p -0.3
+ 980000p -0.3
+ 980010p 0.9
+ 982000p 0.9
+ 982010p -0.3
+ 984000p -0.3
+ 984010p 0.9
+ 986000p 0.9
+ 986010p -0.3
+ 988000p -0.3
+ 988010p 0.9
+ 990000p 0.9
+ 990010p -0.3
+ 992000p -0.3
+ 992010p 0.9
+ 994000p 0.9
+ 994010p -0.3
+ 996000p -0.3
+ 996010p 0.9
+ 998000p 0.9
+ 998010p -0.3
+ 1000000p -0.3
+ 1000010p 0.9
+ 1002000p 0.9
+ 1002010p -0.3
+ 1004000p -0.3
+ 1004010p 0.9
+ 1006000p 0.9
+ 1006010p -0.3
+ 1008000p -0.3
+ 1008010p 0.9
+ 1010000p 0.9
+ 1010010p -0.3
+ 1012000p -0.3
+ 1012010p 0.9
+ 1014000p 0.9
+ 1014010p -0.3
+ 1016000p -0.3
+ 1016010p 0.9
+ 1018000p 0.9
+ 1018010p -0.3
+ 1020000p -0.3
+ 1020010p 0.9
+ 1022000p 0.9
+ 1022010p -0.3
+ 1024000p -0.3
+ 1024010p 0.9
+ 1026000p 0.9
+ 1026010p -0.3
+ 1028000p -0.3
+ 1028010p 0.9
+ 1030000p 0.9
+ 1030010p -0.3
+ 1032000p -0.3
+ 1032010p 0.9
+ 1034000p 0.9
+ 1034010p -0.3
+ 1036000p -0.3
+ 1036010p 0.9
+ 1038000p 0.9
+ 1038010p -0.3
+ 1040000p -0.3
+ 1040010p 0.9
+ 1042000p 0.9
+ 1042010p -0.3
+ 1044000p -0.3
+ 1044010p 0.9
+ 1046000p 0.9
+ 1046010p -0.3
+ 1048000p -0.3
+ 1048010p 0.9
+ 1050000p 0.9
+ 1050010p -0.3
+ 1052000p -0.3
+ 1052010p 0.9
+ 1054000p 0.9
+ 1054010p -0.3
+ 1056000p -0.3
+ 1056010p 0.9
+ 1058000p 0.9
+ 1058010p -0.3
+ 1060000p -0.3
+ 1060010p 0.9
+ 1062000p 0.9
+ 1062010p -0.3
+ 1064000p -0.3
+ 1064010p 0.9
+ 1066000p 0.9
+ 1066010p -0.3
+ 1068000p -0.3
+ 1068010p 0.9
+ 1070000p 0.9
+ 1070010p -0.3
+ 1072000p -0.3
+ 1072010p 0.9
+ 1074000p 0.9
+ 1074010p -0.3
+ 1076000p -0.3
+ 1076010p 0.9
+ 1078000p 0.9
+ 1078010p -0.3
+ 1080000p -0.3
+ 1080010p 0.9
+ 1082000p 0.9
+ 1082010p -0.3
+ 1084000p -0.3
+ 1084010p 0.9
+ 1086000p 0.9
+ 1086010p -0.3
+ 1088000p -0.3
+ 1088010p 0.9
+ 1090000p 0.9
+ 1090010p -0.3
+ 1092000p -0.3
+ 1092010p 0.9
+ 1094000p 0.9
+ 1094010p -0.3
+ 1096000p -0.3
+ 1096010p 0.9
+ 1098000p 0.9
+ 1098010p -0.3
+ 1100000p -0.3
+ 1100010p 0.9
+ 1102000p 0.9
+ 1102010p -0.3
+ 1104000p -0.3
+ 1104010p 0.9
+ 1106000p 0.9
+ 1106010p -0.3
+ 1108000p -0.3
+ 1108010p 0.9
+ 1110000p 0.9
+ 1110010p -0.3
+ 1112000p -0.3
+ 1112010p 0.9
+ 1114000p 0.9
+ 1114010p -0.3
+ 1116000p -0.3
+ 1116010p 0.9
+ 1118000p 0.9
+ 1118010p -0.3
+ 1120000p -0.3
+ 1120010p 0.9
+ 1122000p 0.9
+ 1122010p -0.3
+ 1124000p -0.3
+ 1124010p 0.9
+ 1126000p 0.9
+ 1126010p -0.3
+ 1128000p -0.3
+ 1128010p 0.9
+ 1130000p 0.9
+ 1130010p -0.3
+ 1132000p -0.3
+ 1132010p 0.9
+ 1134000p 0.9
+ 1134010p -0.3
+ 1136000p -0.3
+ 1136010p 0.9
+ 1138000p 0.9
+ 1138010p -0.3
+ 1140000p -0.3
+ 1140010p 0.9
+ 1142000p 0.9
+ 1142010p -0.3
+ 1144000p -0.3
+ 1144010p 0.9
+ 1146000p 0.9
+ 1146010p -0.3
+ 1148000p -0.3
+ 1148010p 0.9
+ 1150000p 0.9
+ 1150010p -0.3
+ 1152000p -0.3
+ 1152010p 0.9
+ 1154000p 0.9
+ 1154010p -0.3
+ 1156000p -0.3
+ 1156010p 0.9
+ 1158000p 0.9
+ 1158010p -0.3
+ 1160000p -0.3
+ 1160010p 0.9
+ 1162000p 0.9
+ 1162010p -0.3
+ 1164000p -0.3
+ 1164010p 0.9
+ 1166000p 0.9
+ 1166010p -0.3
+ 1168000p -0.3
+ 1168010p 0.9
+ 1170000p 0.9
+ 1170010p -0.3
+ 1172000p -0.3
+ 1172010p 0.9
+ 1174000p 0.9
+ 1174010p -0.3
+ 1176000p -0.3
+ 1176010p 0.9
+ 1178000p 0.9
+ 1178010p -0.3
+ 1180000p -0.3
+ 1180010p 0.9
+ 1182000p 0.9
+ 1182010p -0.3
+ 1184000p -0.3
+ 1184010p 0.9
+ 1186000p 0.9
+ 1186010p -0.3
+ 1188000p -0.3
+ 1188010p 0.9
+ 1190000p 0.9
+ 1190010p -0.3
+ 1192000p -0.3
+ 1192010p 0.9
+ 1194000p 0.9
+ 1194010p -0.3
+ 1196000p -0.3
+ 1196010p 0.9
+ 1198000p 0.9
+ 1198010p -0.3
+ 1200000p -0.3
+ 1200010p 0.9
+ 1202000p 0.9
+ 1202010p -0.3
+ 1204000p -0.3
+ 1204010p 0.9
+ 1206000p 0.9
+ 1206010p -0.3
+ 1208000p -0.3
+ 1208010p 0.9
+ 1210000p 0.9
+ 1210010p -0.3
+ 1212000p -0.3
+ 1212010p 0.9
+ 1214000p 0.9
+ 1214010p -0.3
+ 1216000p -0.3
+ 1216010p 0.9
+ 1218000p 0.9
+ 1218010p -0.3
+ 1220000p -0.3
+ 1220010p 0.9
+ 1222000p 0.9
+ 1222010p -0.3
+ 1224000p -0.3
+ 1224010p 0.9
+ 1226000p 0.9
+ 1226010p -0.3
+ 1228000p -0.3
+ 1228010p 0.9
+ 1230000p 0.9
+ 1230010p -0.3
+ 1232000p -0.3
+ 1232010p 0.9
+ 1234000p 0.9
+ 1234010p -0.3
+ 1236000p -0.3
+ 1236010p 0.9
+ 1238000p 0.9
+ 1238010p -0.3
+ 1240000p -0.3
+ 1240010p 0.9
+ 1242000p 0.9
+ 1242010p -0.3
+ 1244000p -0.3
+ 1244010p 0.9
+ 1246000p 0.9
+ 1246010p -0.3
+ 1248000p -0.3
+ 1248010p 0.9
+ 1250000p 0.9
+ 1250010p -0.3
+ 1252000p -0.3
+ 1252010p 0.9
+ 1254000p 0.9
+ 1254010p -0.3
+ 1256000p -0.3
+ 1256010p 0.9
+ 1258000p 0.9
+ 1258010p -0.3
+ 1260000p -0.3
+ 1260010p 0.9
+ 1262000p 0.9
+ 1262010p -0.3
+ 1264000p -0.3
+ 1264010p 0.9
+ 1266000p 0.9
+ 1266010p -0.3
+ 1268000p -0.3
+ 1268010p 0.9
+ 1270000p 0.9
+ 1270010p -0.3
+ 1272000p -0.3
+ 1272010p 0.9
+ 1274000p 0.9
+ 1274010p -0.3
+ 1276000p -0.3
+ 1276010p 0.9
+ 1278000p 0.9
+ 1278010p -0.3
+ 1280000p -0.3
+ 1280010p 0.9
+ 1282000p 0.9
+ 1282010p -0.3
+ 1284000p -0.3
+ 1284010p 0.9
+ 1286000p 0.9
+ 1286010p -0.3
+ 1288000p -0.3
+ 1288010p 0.9
+ 1290000p 0.9
+ 1290010p -0.3
+ 1292000p -0.3
+ 1292010p 0.9
+ 1294000p 0.9
+ 1294010p -0.3
+ 1296000p -0.3
+ 1296010p 0.9
+ 1298000p 0.9
+ 1298010p -0.3
+ 1300000p -0.3
+ 1300010p 0.9
+ 1302000p 0.9
+ 1302010p -0.3
+ 1304000p -0.3
+ 1304010p 0.9
+ 1306000p 0.9
+ 1306010p -0.3
+ 1308000p -0.3
+ 1308010p 0.9
+ 1310000p 0.9
+ 1310010p -0.3
+ 1312000p -0.3
+ 1312010p 0.9
+ 1314000p 0.9
+ 1314010p -0.3
+ 1316000p -0.3
+ 1316010p 0.9
+ 1318000p 0.9
+ 1318010p -0.3
+ 1320000p -0.3
+ 1320010p 0.9
+ 1322000p 0.9
+ 1322010p -0.3
+ 1324000p -0.3
+ 1324010p 0.9
+ 1326000p 0.9
+ 1326010p -0.3
+ 1328000p -0.3
+ 1328010p 0.9
+ 1330000p 0.9
+ 1330010p -0.3
+ 1332000p -0.3
+ 1332010p 0.9
+ 1334000p 0.9
+ 1334010p -0.3
+ 1336000p -0.3
+ 1336010p 0.9
+ 1338000p 0.9
+ 1338010p -0.3
+ 1340000p -0.3
+ 1340010p 0.9
+ 1342000p 0.9
+ 1342010p -0.3
+ 1344000p -0.3
+ 1344010p 0.9
+ 1346000p 0.9
+ 1346010p -0.3
+ 1348000p -0.3
+ 1348010p 0.9
+ 1350000p 0.9
+ 1350010p -0.3
+ 1352000p -0.3
+ 1352010p 0.9
+ 1354000p 0.9
+ 1354010p -0.3
+ 1356000p -0.3
+ 1356010p 0.9
+ 1358000p 0.9
+ 1358010p -0.3
+ 1360000p -0.3
+ 1360010p 0.9
+ 1362000p 0.9
+ 1362010p -0.3
+ 1364000p -0.3
+ 1364010p 0.9
+ 1366000p 0.9
+ 1366010p -0.3
+ 1368000p -0.3
+ 1368010p 0.9
+ 1370000p 0.9
+ 1370010p -0.3
+ 1372000p -0.3
+ 1372010p 0.9
+ 1374000p 0.9
+ 1374010p -0.3
+ 1376000p -0.3
+ 1376010p 0.9
+ 1378000p 0.9
+ 1378010p -0.3
+ 1380000p -0.3
+ 1380010p 0.9
+ 1382000p 0.9
+ 1382010p -0.3
+ 1384000p -0.3
+ 1384010p 0.9
+ 1386000p 0.9
+ 1386010p -0.3
+ 1388000p -0.3
+ 1388010p 0.9
+ 1390000p 0.9
+ 1390010p -0.3
+ 1392000p -0.3
+ 1392010p 0.9
+ 1394000p 0.9
+ 1394010p -0.3
+ 1396000p -0.3
+ 1396010p 0.9
+ 1398000p 0.9
+ 1398010p -0.3
+ 1400000p -0.3
+ 1400010p 0.9
+ 1402000p 0.9
+ 1402010p -0.3
+ 1404000p -0.3
+ 1404010p 0.9
+ 1406000p 0.9
+ 1406010p -0.3
+ 1408000p -0.3
+ 1408010p 0.9
+ 1410000p 0.9
+ 1410010p -0.3
+ 1412000p -0.3
+ 1412010p 0.9
+ 1414000p 0.9
+ 1414010p -0.3
+ 1416000p -0.3
+ 1416010p 0.9
+ 1418000p 0.9
+ 1418010p -0.3
+ 1420000p -0.3
+ 1420010p 0.9
+ 1422000p 0.9
+ 1422010p -0.3
+ 1424000p -0.3
+ 1424010p 0.9
+ 1426000p 0.9
+ 1426010p -0.3
+ 1428000p -0.3
+ 1428010p 0.9
+ 1430000p 0.9
+ 1430010p -0.3
+ 1432000p -0.3
+ 1432010p 0.9
+ 1434000p 0.9
+ 1434010p -0.3
+ 1436000p -0.3
+ 1436010p 0.9
+ 1438000p 0.9
+ 1438010p -0.3
+ 1440000p -0.3
+ 1440010p 0.9
+ 1442000p 0.9
+ 1442010p -0.3
+ 1444000p -0.3
+ 1444010p 0.9
+ 1446000p 0.9
+ 1446010p -0.3
+ 1448000p -0.3
+ 1448010p 0.9
+ 1450000p 0.9
+ 1450010p -0.3
+ 1452000p -0.3
+ 1452010p 0.9
+ 1454000p 0.9
+ 1454010p -0.3
+ 1456000p -0.3
+ 1456010p 0.9
+ 1458000p 0.9
+ 1458010p -0.3
+ 1460000p -0.3
+ 1460010p 0.9
+ 1462000p 0.9
+ 1462010p -0.3
+ 1464000p -0.3
+ 1464010p 0.9
+ 1466000p 0.9
+ 1466010p -0.3
+ 1468000p -0.3
+ 1468010p 0.9
+ 1470000p 0.9
+ 1470010p -0.3
+ 1472000p -0.3
+ 1472010p 0.9
+ 1474000p 0.9
+ 1474010p -0.3
+ 1476000p -0.3
+ 1476010p 0.9
+ 1478000p 0.9
+ 1478010p -0.3
+ 1480000p -0.3
+ 1480010p 0.9
+ 1482000p 0.9
+ 1482010p -0.3
+ 1484000p -0.3
+ 1484010p 0.9
+ 1486000p 0.9
+ 1486010p -0.3
+ 1488000p -0.3
+ 1488010p 0.9
+ 1490000p 0.9
+ 1490010p -0.3
+ 1492000p -0.3
+ 1492010p 0.9
+ 1494000p 0.9
+ 1494010p -0.3
+ 1496000p -0.3
+ 1496010p 0.9
+ 1498000p 0.9
+ 1498010p -0.3
+ 1500000p -0.3
+ 1500010p 0.9
+ 1502000p 0.9
+ 1502010p -0.3
+ 1504000p -0.3
+ 1504010p 0.9
+ 1506000p 0.9
+ 1506010p -0.3
+ 1508000p -0.3
+ 1508010p 0.9
+ 1510000p 0.9
+ 1510010p -0.3
+ 1512000p -0.3
+ 1512010p 0.9
+ 1514000p 0.9
+ 1514010p -0.3
+ 1516000p -0.3
+ 1516010p 0.9
+ 1518000p 0.9
+ 1518010p -0.3
+ 1520000p -0.3
+ 1520010p 0.9
+ 1522000p 0.9
+ 1522010p -0.3
+ 1524000p -0.3
+ 1524010p 0.9
+ 1526000p 0.9
+ 1526010p -0.3
+ 1528000p -0.3
+ 1528010p 0.9
+ 1530000p 0.9
+ 1530010p -0.3
+ 1532000p -0.3
+ 1532010p 0.9
+ 1534000p 0.9
+ 1534010p -0.3
+ 1536000p -0.3
+ 1536010p 0.9
+ 1538000p 0.9
+ 1538010p -0.3
+ 1540000p -0.3
+ 1540010p 0.9
+ 1542000p 0.9
+ 1542010p -0.3
+ 1544000p -0.3
+ 1544010p 0.9
+ 1546000p 0.9
+ 1546010p -0.3
+ 1548000p -0.3
+ 1548010p 0.9
+ 1550000p 0.9
+ 1550010p -0.3
+ 1552000p -0.3
+ 1552010p 0.9
+ 1554000p 0.9
+ 1554010p -0.3
+ 1556000p -0.3
+ 1556010p 0.9
+ 1558000p 0.9
+ 1558010p -0.3
+ 1560000p -0.3
+ 1560010p 0.9
+ 1562000p 0.9
+ 1562010p -0.3
+ 1564000p -0.3
+ 1564010p 0.9
+ 1566000p 0.9
+ 1566010p -0.3
+ 1568000p -0.3
+ 1568010p 0.9
+ 1570000p 0.9
+ 1570010p -0.3
+ 1572000p -0.3
+ 1572010p 0.9
+ 1574000p 0.9
+ 1574010p -0.3
+ 1576000p -0.3
+ 1576010p 0.9
+ 1578000p 0.9
+ 1578010p -0.3
+ 1580000p -0.3
+ 1580010p 0.9
+ 1582000p 0.9
+ 1582010p -0.3
+ 1584000p -0.3
+ 1584010p 0.9
+ 1586000p 0.9
+ 1586010p -0.3
+ 1588000p -0.3
+ 1588010p 0.9
+ 1590000p 0.9
+ 1590010p -0.3
+ 1592000p -0.3
+ 1592010p 0.9
+ 1594000p 0.9
+ 1594010p -0.3
+ 1596000p -0.3
+ 1596010p 0.9
+ 1598000p 0.9
+ 1598010p -0.3
+ 1600000p -0.3
+ 1600010p 0.9
+ 1602000p 0.9
+ 1602010p -0.3
+ 1604000p -0.3
+ 1604010p 0.9
+ 1606000p 0.9
+ 1606010p -0.3
+ 1608000p -0.3
+ 1608010p 0.9
+ 1610000p 0.9
+ 1610010p -0.3
+ 1612000p -0.3
+ 1612010p 0.9
+ 1614000p 0.9
+ 1614010p -0.3
+ 1616000p -0.3
+ 1616010p 0.9
+ 1618000p 0.9
+ 1618010p -0.3
+ 1620000p -0.3
+ 1620010p 0.9
+ 1622000p 0.9
+ 1622010p -0.3
+ 1624000p -0.3
+ 1624010p 0.9
+ 1626000p 0.9
+ 1626010p -0.3
+ 1628000p -0.3
+ 1628010p 0.9
+ 1630000p 0.9
+ 1630010p -0.3
+ 1632000p -0.3
+ 1632010p 0.9
+ 1634000p 0.9
+ 1634010p -0.3
+ 1636000p -0.3
+ 1636010p 0.9
+ 1638000p 0.9
+ 1638010p -0.3
+ 1640000p -0.3
+ 1640010p 0.9
+ 1642000p 0.9
+ 1642010p -0.3
+ 1644000p -0.3
+ 1644010p 0.9
+ 1646000p 0.9
+ 1646010p -0.3
+ 1648000p -0.3
+ 1648010p 0.9
+ 1650000p 0.9
+ 1650010p -0.3
+ 1652000p -0.3
+ 1652010p 0.9
+ 1654000p 0.9
+ 1654010p -0.3
+ 1656000p -0.3
+ 1656010p 0.9
+ 1658000p 0.9
+ 1658010p -0.3
+ 1660000p -0.3
+ 1660010p 0.9
+ 1662000p 0.9
+ 1662010p -0.3
+ 1664000p -0.3
+ 1664010p 0.9
+ 1666000p 0.9
+ 1666010p -0.3
+ 1668000p -0.3
+ 1668010p 0.9
+ 1670000p 0.9
+ 1670010p -0.3
+ 1672000p -0.3
+ 1672010p 0.9
+ 1674000p 0.9
+ 1674010p -0.3
+ 1676000p -0.3
+ 1676010p 0.9
+ 1678000p 0.9
+ 1678010p -0.3
+ 1680000p -0.3
+ 1680010p 0.9
+ 1682000p 0.9
+ 1682010p -0.3
+ 1684000p -0.3
+ 1684010p 0.9
+ 1686000p 0.9
+ 1686010p -0.3
+ 1688000p -0.3
+ 1688010p 0.9
+ 1690000p 0.9
+ 1690010p -0.3
+ 1692000p -0.3
+ 1692010p 0.9
+ 1694000p 0.9
+ 1694010p -0.3
+ 1696000p -0.3
+ 1696010p 0.9
+ 1698000p 0.9
+ 1698010p -0.3
+ 1700000p -0.3
+ 1700010p 0.9
+ 1702000p 0.9
+ 1702010p -0.3
+ 1704000p -0.3
+ 1704010p 0.9
+ 1706000p 0.9
+ 1706010p -0.3
+ 1708000p -0.3
+ 1708010p 0.9
+ 1710000p 0.9
+ 1710010p -0.3
+ 1712000p -0.3
+ 1712010p 0.9
+ 1714000p 0.9
+ 1714010p -0.3
+ 1716000p -0.3
+ 1716010p 0.9
+ 1718000p 0.9
+ 1718010p -0.3
+ 1720000p -0.3
+ 1720010p 0.9
+ 1722000p 0.9
+ 1722010p -0.3
+ 1724000p -0.3
+ 1724010p 0.9
+ 1726000p 0.9
+ 1726010p -0.3
+ 1728000p -0.3
+ 1728010p 0.9
+ 1730000p 0.9
+ 1730010p -0.3
+ 1732000p -0.3
+ 1732010p 0.9
+ 1734000p 0.9
+ 1734010p -0.3
+ 1736000p -0.3
+ 1736010p 0.9
+ 1738000p 0.9
+ 1738010p -0.3
+ 1740000p -0.3
+ 1740010p 0.9
+ 1742000p 0.9
+ 1742010p -0.3
+ 1744000p -0.3
+ 1744010p 0.9
+ 1746000p 0.9
+ 1746010p -0.3
+ 1748000p -0.3
+ 1748010p 0.9
+ 1750000p 0.9
+ 1750010p -0.3
+ 1752000p -0.3
+ 1752010p 0.9
+ 1754000p 0.9
+ 1754010p -0.3
+ 1756000p -0.3
+ 1756010p 0.9
+ 1758000p 0.9
+ 1758010p -0.3
+ 1760000p -0.3
+ 1760010p 0.9
+ 1762000p 0.9
+ 1762010p -0.3
+ 1764000p -0.3
+ 1764010p 0.9
+ 1766000p 0.9
+ 1766010p -0.3
+ 1768000p -0.3
+ 1768010p 0.9
+ 1770000p 0.9
+ 1770010p -0.3
+ 1772000p -0.3
+ 1772010p 0.9
+ 1774000p 0.9
+ 1774010p -0.3
+ 1776000p -0.3
+ 1776010p 0.9
+ 1778000p 0.9
+ 1778010p -0.3
+ 1780000p -0.3
+ 1780010p 0.9
+ 1782000p 0.9
+ 1782010p -0.3
+ 1784000p -0.3
+ 1784010p 0.9
+ 1786000p 0.9
+ 1786010p -0.3
+ 1788000p -0.3
+ 1788010p 0.9
+ 1790000p 0.9
+ 1790010p -0.3
+ 1792000p -0.3
+ 1792010p 0.9
+ 1794000p 0.9
+ 1794010p -0.3
+ 1796000p -0.3
+ 1796010p 0.9
+ 1798000p 0.9
+ 1798010p -0.3
+ 1800000p -0.3
+ 1800010p 0.9
+ 1802000p 0.9
+ 1802010p -0.3
+ 1804000p -0.3
+ 1804010p 0.9
+ 1806000p 0.9
+ 1806010p -0.3
+ 1808000p -0.3
+ 1808010p 0.9
+ 1810000p 0.9
+ 1810010p -0.3
+ 1812000p -0.3
+ 1812010p 0.9
+ 1814000p 0.9
+ 1814010p -0.3
+ 1816000p -0.3
+ 1816010p 0.9
+ 1818000p 0.9
+ 1818010p -0.3
+ 1820000p -0.3
+ 1820010p 0.9
+ 1822000p 0.9
+ 1822010p -0.3
+ 1824000p -0.3
+ 1824010p 0.9
+ 1826000p 0.9
+ 1826010p -0.3
+ 1828000p -0.3
+ 1828010p 0.9
+ 1830000p 0.9
+ 1830010p -0.3
+ 1832000p -0.3
+ 1832010p 0.9
+ 1834000p 0.9
+ 1834010p -0.3
+ 1836000p -0.3
+ 1836010p 0.9
+ 1838000p 0.9
+ 1838010p -0.3
+ 1840000p -0.3
+ 1840010p 0.9
+ 1842000p 0.9
+ 1842010p -0.3
+ 1844000p -0.3
+ 1844010p 0.9
+ 1846000p 0.9
+ 1846010p -0.3
+ 1848000p -0.3
+ 1848010p 0.9
+ 1850000p 0.9
+ 1850010p -0.3
+ 1852000p -0.3
+ 1852010p 0.9
+ 1854000p 0.9
+ 1854010p -0.3
+ 1856000p -0.3
+ 1856010p 0.9
+ 1858000p 0.9
+ 1858010p -0.3
+ 1860000p -0.3
+ 1860010p 0.9
+ 1862000p 0.9
+ 1862010p -0.3
+ 1864000p -0.3
+ 1864010p 0.9
+ 1866000p 0.9
+ 1866010p -0.3
+ 1868000p -0.3
+ 1868010p 0.9
+ 1870000p 0.9
+ 1870010p -0.3
+ 1872000p -0.3
+ 1872010p 0.9
+ 1874000p 0.9
+ 1874010p -0.3
+ 1876000p -0.3
+ 1876010p 0.9
+ 1878000p 0.9
+ 1878010p -0.3
+ 1880000p -0.3
+ 1880010p 0.9
+ 1882000p 0.9
+ 1882010p -0.3
+ 1884000p -0.3
+ 1884010p 0.9
+ 1886000p 0.9
+ 1886010p -0.3
+ 1888000p -0.3
+ 1888010p 0.9
+ 1890000p 0.9
+ 1890010p -0.3
+ 1892000p -0.3
+ 1892010p 0.9
+ 1894000p 0.9
+ 1894010p -0.3
+ 1896000p -0.3
+ 1896010p 0.9
+ 1898000p 0.9
+ 1898010p -0.3
+ 1900000p -0.3
+ 1900010p 0.9
+ 1902000p 0.9
+ 1902010p -0.3
+ 1904000p -0.3
+ 1904010p 0.9
+ 1906000p 0.9
+ 1906010p -0.3
+ 1908000p -0.3
+ 1908010p 0.9
+ 1910000p 0.9
+ 1910010p -0.3
+ 1912000p -0.3
+ 1912010p 0.9
+ 1914000p 0.9
+ 1914010p -0.3
+ 1916000p -0.3
+ 1916010p 0.9
+ 1918000p 0.9
+ 1918010p -0.3
+ 1920000p -0.3
+ 1920010p 0.9
+ 1922000p 0.9
+ 1922010p -0.3
+ 1924000p -0.3
+ 1924010p 0.9
+ 1926000p 0.9
+ 1926010p -0.3
+ 1928000p -0.3
+ 1928010p 0.9
+ 1930000p 0.9
+ 1930010p -0.3
+ 1932000p -0.3
+ 1932010p 0.9
+ 1934000p 0.9
+ 1934010p -0.3
+ 1936000p -0.3
+ 1936010p 0.9
+ 1938000p 0.9
+ 1938010p -0.3
+ 1940000p -0.3
+ 1940010p 0.9
+ 1942000p 0.9
+ 1942010p -0.3
+ 1944000p -0.3
+ 1944010p 0.9
+ 1946000p 0.9
+ 1946010p -0.3
+ 1948000p -0.3
+ 1948010p 0.9
+ 1950000p 0.9
+ 1950010p -0.3
+ 1952000p -0.3
+ 1952010p 0.9
+ 1954000p 0.9
+ 1954010p -0.3
+ 1956000p -0.3
+ 1956010p 0.9
+ 1958000p 0.9
+ 1958010p -0.3
+ 1960000p -0.3
+ 1960010p 0.9
+ 1962000p 0.9
+ 1962010p -0.3
+ 1964000p -0.3
+ 1964010p 0.9
+ 1966000p 0.9
+ 1966010p -0.3
+ 1968000p -0.3
+ 1968010p 0.9
+ 1970000p 0.9
+ 1970010p -0.3
+ 1972000p -0.3
+ 1972010p 0.9
+ 1974000p 0.9
+ 1974010p -0.3
+ 1976000p -0.3
+ 1976010p 0.9
+ 1978000p 0.9
+ 1978010p -0.3
+ 1980000p -0.3
+ 1980010p 0.9
+ 1982000p 0.9
+ 1982010p -0.3
+ 1984000p -0.3
+ 1984010p 0.9
+ 1986000p 0.9
+ 1986010p -0.3
+ 1988000p -0.3
+ 1988010p 0.9
+ 1990000p 0.9
+ 1990010p -0.3
+ 1992000p -0.3
+ 1992010p 0.9
+ 1994000p 0.9
+ 1994010p -0.3
+ 1996000p -0.3
+ 1996010p 0.9
+ 1998000p 0.9
+ 1998010p -0.3
+ 2000000p -0.3
+ 2000010p 0.9
+ 2002000p 0.9
+ 2002010p -0.3
+ 2004000p -0.3
+ 2004010p 0.9
+ 2006000p 0.9
+ 2006010p -0.3
+ 2008000p -0.3
+ 2008010p 0.9
+ 2010000p 0.9
+ 2010010p -0.3
+ 2012000p -0.3
+ 2012010p 0.9
+ 2014000p 0.9
+ 2014010p -0.3
+ 2016000p -0.3
+ 2016010p 0.9
+ 2018000p 0.9
+ 2018010p -0.3
+ 2020000p -0.3
+ 2020010p 0.9
+ 2022000p 0.9
+ 2022010p -0.3
+ 2024000p -0.3
+ 2024010p 0.9
+ 2026000p 0.9
+ 2026010p -0.3
+ 2028000p -0.3
+ 2028010p 0.9
+ 2030000p 0.9
+ 2030010p -0.3
+ 2032000p -0.3
+ 2032010p 0.9
+ 2034000p 0.9
+ 2034010p -0.3
+ 2036000p -0.3
+ 2036010p 0.9
+ 2038000p 0.9
+ 2038010p -0.3
+ 2040000p -0.3
+ 2040010p 0.9
+ 2042000p 0.9
+ 2042010p -0.3
+ 2044000p -0.3
+ 2044010p 0.9
+ 2046000p 0.9
+ 2046010p -0.3
+ 2048000p -0.3
+ 2048010p 0.9
+ \]
V_data_bar_3 (Data_bar\\<3\\> gnd!) vsource type=pwl wave=\[
+ 0    -0.3
+ 2000p -0.3
+ 2010p 0.9
+ 4000p 0.9
+ 4010p -0.3
+ 6000p -0.3
+ 6010p 0.9
+ 8000p 0.9
+ 8010p -0.3
+ 10000p -0.3
+ 10010p 0.9
+ 12000p 0.9
+ 12010p -0.3
+ 14000p -0.3
+ 14010p 0.9
+ 16000p 0.9
+ 16010p -0.3
+ 18000p -0.3
+ 18010p 0.9
+ 20000p 0.9
+ 20010p -0.3
+ 22000p -0.3
+ 22010p 0.9
+ 24000p 0.9
+ 24010p -0.3
+ 26000p -0.3
+ 26010p 0.9
+ 28000p 0.9
+ 28010p -0.3
+ 30000p -0.3
+ 30010p 0.9
+ 32000p 0.9
+ 32010p -0.3
+ 34000p -0.3
+ 34010p 0.9
+ 36000p 0.9
+ 36010p -0.3
+ 38000p -0.3
+ 38010p 0.9
+ 40000p 0.9
+ 40010p -0.3
+ 42000p -0.3
+ 42010p 0.9
+ 44000p 0.9
+ 44010p -0.3
+ 46000p -0.3
+ 46010p 0.9
+ 48000p 0.9
+ 48010p -0.3
+ 50000p -0.3
+ 50010p 0.9
+ 52000p 0.9
+ 52010p -0.3
+ 54000p -0.3
+ 54010p 0.9
+ 56000p 0.9
+ 56010p -0.3
+ 58000p -0.3
+ 58010p 0.9
+ 60000p 0.9
+ 60010p -0.3
+ 62000p -0.3
+ 62010p 0.9
+ 64000p 0.9
+ 64010p -0.3
+ 66000p -0.3
+ 66010p 0.9
+ 68000p 0.9
+ 68010p -0.3
+ 70000p -0.3
+ 70010p 0.9
+ 72000p 0.9
+ 72010p -0.3
+ 74000p -0.3
+ 74010p 0.9
+ 76000p 0.9
+ 76010p -0.3
+ 78000p -0.3
+ 78010p 0.9
+ 80000p 0.9
+ 80010p -0.3
+ 82000p -0.3
+ 82010p 0.9
+ 84000p 0.9
+ 84010p -0.3
+ 86000p -0.3
+ 86010p 0.9
+ 88000p 0.9
+ 88010p -0.3
+ 90000p -0.3
+ 90010p 0.9
+ 92000p 0.9
+ 92010p -0.3
+ 94000p -0.3
+ 94010p 0.9
+ 96000p 0.9
+ 96010p -0.3
+ 98000p -0.3
+ 98010p 0.9
+ 100000p 0.9
+ 100010p -0.3
+ 102000p -0.3
+ 102010p 0.9
+ 104000p 0.9
+ 104010p -0.3
+ 106000p -0.3
+ 106010p 0.9
+ 108000p 0.9
+ 108010p -0.3
+ 110000p -0.3
+ 110010p 0.9
+ 112000p 0.9
+ 112010p -0.3
+ 114000p -0.3
+ 114010p 0.9
+ 116000p 0.9
+ 116010p -0.3
+ 118000p -0.3
+ 118010p 0.9
+ 120000p 0.9
+ 120010p -0.3
+ 122000p -0.3
+ 122010p 0.9
+ 124000p 0.9
+ 124010p -0.3
+ 126000p -0.3
+ 126010p 0.9
+ 128000p 0.9
+ 128010p -0.3
+ 130000p -0.3
+ 130010p 0.9
+ 132000p 0.9
+ 132010p -0.3
+ 134000p -0.3
+ 134010p 0.9
+ 136000p 0.9
+ 136010p -0.3
+ 138000p -0.3
+ 138010p 0.9
+ 140000p 0.9
+ 140010p -0.3
+ 142000p -0.3
+ 142010p 0.9
+ 144000p 0.9
+ 144010p -0.3
+ 146000p -0.3
+ 146010p 0.9
+ 148000p 0.9
+ 148010p -0.3
+ 150000p -0.3
+ 150010p 0.9
+ 152000p 0.9
+ 152010p -0.3
+ 154000p -0.3
+ 154010p 0.9
+ 156000p 0.9
+ 156010p -0.3
+ 158000p -0.3
+ 158010p 0.9
+ 160000p 0.9
+ 160010p -0.3
+ 162000p -0.3
+ 162010p 0.9
+ 164000p 0.9
+ 164010p -0.3
+ 166000p -0.3
+ 166010p 0.9
+ 168000p 0.9
+ 168010p -0.3
+ 170000p -0.3
+ 170010p 0.9
+ 172000p 0.9
+ 172010p -0.3
+ 174000p -0.3
+ 174010p 0.9
+ 176000p 0.9
+ 176010p -0.3
+ 178000p -0.3
+ 178010p 0.9
+ 180000p 0.9
+ 180010p -0.3
+ 182000p -0.3
+ 182010p 0.9
+ 184000p 0.9
+ 184010p -0.3
+ 186000p -0.3
+ 186010p 0.9
+ 188000p 0.9
+ 188010p -0.3
+ 190000p -0.3
+ 190010p 0.9
+ 192000p 0.9
+ 192010p -0.3
+ 194000p -0.3
+ 194010p 0.9
+ 196000p 0.9
+ 196010p -0.3
+ 198000p -0.3
+ 198010p 0.9
+ 200000p 0.9
+ 200010p -0.3
+ 202000p -0.3
+ 202010p 0.9
+ 204000p 0.9
+ 204010p -0.3
+ 206000p -0.3
+ 206010p 0.9
+ 208000p 0.9
+ 208010p -0.3
+ 210000p -0.3
+ 210010p 0.9
+ 212000p 0.9
+ 212010p -0.3
+ 214000p -0.3
+ 214010p 0.9
+ 216000p 0.9
+ 216010p -0.3
+ 218000p -0.3
+ 218010p 0.9
+ 220000p 0.9
+ 220010p -0.3
+ 222000p -0.3
+ 222010p 0.9
+ 224000p 0.9
+ 224010p -0.3
+ 226000p -0.3
+ 226010p 0.9
+ 228000p 0.9
+ 228010p -0.3
+ 230000p -0.3
+ 230010p 0.9
+ 232000p 0.9
+ 232010p -0.3
+ 234000p -0.3
+ 234010p 0.9
+ 236000p 0.9
+ 236010p -0.3
+ 238000p -0.3
+ 238010p 0.9
+ 240000p 0.9
+ 240010p -0.3
+ 242000p -0.3
+ 242010p 0.9
+ 244000p 0.9
+ 244010p -0.3
+ 246000p -0.3
+ 246010p 0.9
+ 248000p 0.9
+ 248010p -0.3
+ 250000p -0.3
+ 250010p 0.9
+ 252000p 0.9
+ 252010p -0.3
+ 254000p -0.3
+ 254010p 0.9
+ 256000p 0.9
+ 256010p -0.3
+ 258000p -0.3
+ 258010p 0.9
+ 260000p 0.9
+ 260010p -0.3
+ 262000p -0.3
+ 262010p 0.9
+ 264000p 0.9
+ 264010p -0.3
+ 266000p -0.3
+ 266010p 0.9
+ 268000p 0.9
+ 268010p -0.3
+ 270000p -0.3
+ 270010p 0.9
+ 272000p 0.9
+ 272010p -0.3
+ 274000p -0.3
+ 274010p 0.9
+ 276000p 0.9
+ 276010p -0.3
+ 278000p -0.3
+ 278010p 0.9
+ 280000p 0.9
+ 280010p -0.3
+ 282000p -0.3
+ 282010p 0.9
+ 284000p 0.9
+ 284010p -0.3
+ 286000p -0.3
+ 286010p 0.9
+ 288000p 0.9
+ 288010p -0.3
+ 290000p -0.3
+ 290010p 0.9
+ 292000p 0.9
+ 292010p -0.3
+ 294000p -0.3
+ 294010p 0.9
+ 296000p 0.9
+ 296010p -0.3
+ 298000p -0.3
+ 298010p 0.9
+ 300000p 0.9
+ 300010p -0.3
+ 302000p -0.3
+ 302010p 0.9
+ 304000p 0.9
+ 304010p -0.3
+ 306000p -0.3
+ 306010p 0.9
+ 308000p 0.9
+ 308010p -0.3
+ 310000p -0.3
+ 310010p 0.9
+ 312000p 0.9
+ 312010p -0.3
+ 314000p -0.3
+ 314010p 0.9
+ 316000p 0.9
+ 316010p -0.3
+ 318000p -0.3
+ 318010p 0.9
+ 320000p 0.9
+ 320010p -0.3
+ 322000p -0.3
+ 322010p 0.9
+ 324000p 0.9
+ 324010p -0.3
+ 326000p -0.3
+ 326010p 0.9
+ 328000p 0.9
+ 328010p -0.3
+ 330000p -0.3
+ 330010p 0.9
+ 332000p 0.9
+ 332010p -0.3
+ 334000p -0.3
+ 334010p 0.9
+ 336000p 0.9
+ 336010p -0.3
+ 338000p -0.3
+ 338010p 0.9
+ 340000p 0.9
+ 340010p -0.3
+ 342000p -0.3
+ 342010p 0.9
+ 344000p 0.9
+ 344010p -0.3
+ 346000p -0.3
+ 346010p 0.9
+ 348000p 0.9
+ 348010p -0.3
+ 350000p -0.3
+ 350010p 0.9
+ 352000p 0.9
+ 352010p -0.3
+ 354000p -0.3
+ 354010p 0.9
+ 356000p 0.9
+ 356010p -0.3
+ 358000p -0.3
+ 358010p 0.9
+ 360000p 0.9
+ 360010p -0.3
+ 362000p -0.3
+ 362010p 0.9
+ 364000p 0.9
+ 364010p -0.3
+ 366000p -0.3
+ 366010p 0.9
+ 368000p 0.9
+ 368010p -0.3
+ 370000p -0.3
+ 370010p 0.9
+ 372000p 0.9
+ 372010p -0.3
+ 374000p -0.3
+ 374010p 0.9
+ 376000p 0.9
+ 376010p -0.3
+ 378000p -0.3
+ 378010p 0.9
+ 380000p 0.9
+ 380010p -0.3
+ 382000p -0.3
+ 382010p 0.9
+ 384000p 0.9
+ 384010p -0.3
+ 386000p -0.3
+ 386010p 0.9
+ 388000p 0.9
+ 388010p -0.3
+ 390000p -0.3
+ 390010p 0.9
+ 392000p 0.9
+ 392010p -0.3
+ 394000p -0.3
+ 394010p 0.9
+ 396000p 0.9
+ 396010p -0.3
+ 398000p -0.3
+ 398010p 0.9
+ 400000p 0.9
+ 400010p -0.3
+ 402000p -0.3
+ 402010p 0.9
+ 404000p 0.9
+ 404010p -0.3
+ 406000p -0.3
+ 406010p 0.9
+ 408000p 0.9
+ 408010p -0.3
+ 410000p -0.3
+ 410010p 0.9
+ 412000p 0.9
+ 412010p -0.3
+ 414000p -0.3
+ 414010p 0.9
+ 416000p 0.9
+ 416010p -0.3
+ 418000p -0.3
+ 418010p 0.9
+ 420000p 0.9
+ 420010p -0.3
+ 422000p -0.3
+ 422010p 0.9
+ 424000p 0.9
+ 424010p -0.3
+ 426000p -0.3
+ 426010p 0.9
+ 428000p 0.9
+ 428010p -0.3
+ 430000p -0.3
+ 430010p 0.9
+ 432000p 0.9
+ 432010p -0.3
+ 434000p -0.3
+ 434010p 0.9
+ 436000p 0.9
+ 436010p -0.3
+ 438000p -0.3
+ 438010p 0.9
+ 440000p 0.9
+ 440010p -0.3
+ 442000p -0.3
+ 442010p 0.9
+ 444000p 0.9
+ 444010p -0.3
+ 446000p -0.3
+ 446010p 0.9
+ 448000p 0.9
+ 448010p -0.3
+ 450000p -0.3
+ 450010p 0.9
+ 452000p 0.9
+ 452010p -0.3
+ 454000p -0.3
+ 454010p 0.9
+ 456000p 0.9
+ 456010p -0.3
+ 458000p -0.3
+ 458010p 0.9
+ 460000p 0.9
+ 460010p -0.3
+ 462000p -0.3
+ 462010p 0.9
+ 464000p 0.9
+ 464010p -0.3
+ 466000p -0.3
+ 466010p 0.9
+ 468000p 0.9
+ 468010p -0.3
+ 470000p -0.3
+ 470010p 0.9
+ 472000p 0.9
+ 472010p -0.3
+ 474000p -0.3
+ 474010p 0.9
+ 476000p 0.9
+ 476010p -0.3
+ 478000p -0.3
+ 478010p 0.9
+ 480000p 0.9
+ 480010p -0.3
+ 482000p -0.3
+ 482010p 0.9
+ 484000p 0.9
+ 484010p -0.3
+ 486000p -0.3
+ 486010p 0.9
+ 488000p 0.9
+ 488010p -0.3
+ 490000p -0.3
+ 490010p 0.9
+ 492000p 0.9
+ 492010p -0.3
+ 494000p -0.3
+ 494010p 0.9
+ 496000p 0.9
+ 496010p -0.3
+ 498000p -0.3
+ 498010p 0.9
+ 500000p 0.9
+ 500010p -0.3
+ 502000p -0.3
+ 502010p 0.9
+ 504000p 0.9
+ 504010p -0.3
+ 506000p -0.3
+ 506010p 0.9
+ 508000p 0.9
+ 508010p -0.3
+ 510000p -0.3
+ 510010p 0.9
+ 512000p 0.9
+ 512010p -0.3
+ 514000p -0.3
+ 514010p 0.9
+ 516000p 0.9
+ 516010p -0.3
+ 518000p -0.3
+ 518010p 0.9
+ 520000p 0.9
+ 520010p -0.3
+ 522000p -0.3
+ 522010p 0.9
+ 524000p 0.9
+ 524010p -0.3
+ 526000p -0.3
+ 526010p 0.9
+ 528000p 0.9
+ 528010p -0.3
+ 530000p -0.3
+ 530010p 0.9
+ 532000p 0.9
+ 532010p -0.3
+ 534000p -0.3
+ 534010p 0.9
+ 536000p 0.9
+ 536010p -0.3
+ 538000p -0.3
+ 538010p 0.9
+ 540000p 0.9
+ 540010p -0.3
+ 542000p -0.3
+ 542010p 0.9
+ 544000p 0.9
+ 544010p -0.3
+ 546000p -0.3
+ 546010p 0.9
+ 548000p 0.9
+ 548010p -0.3
+ 550000p -0.3
+ 550010p 0.9
+ 552000p 0.9
+ 552010p -0.3
+ 554000p -0.3
+ 554010p 0.9
+ 556000p 0.9
+ 556010p -0.3
+ 558000p -0.3
+ 558010p 0.9
+ 560000p 0.9
+ 560010p -0.3
+ 562000p -0.3
+ 562010p 0.9
+ 564000p 0.9
+ 564010p -0.3
+ 566000p -0.3
+ 566010p 0.9
+ 568000p 0.9
+ 568010p -0.3
+ 570000p -0.3
+ 570010p 0.9
+ 572000p 0.9
+ 572010p -0.3
+ 574000p -0.3
+ 574010p 0.9
+ 576000p 0.9
+ 576010p -0.3
+ 578000p -0.3
+ 578010p 0.9
+ 580000p 0.9
+ 580010p -0.3
+ 582000p -0.3
+ 582010p 0.9
+ 584000p 0.9
+ 584010p -0.3
+ 586000p -0.3
+ 586010p 0.9
+ 588000p 0.9
+ 588010p -0.3
+ 590000p -0.3
+ 590010p 0.9
+ 592000p 0.9
+ 592010p -0.3
+ 594000p -0.3
+ 594010p 0.9
+ 596000p 0.9
+ 596010p -0.3
+ 598000p -0.3
+ 598010p 0.9
+ 600000p 0.9
+ 600010p -0.3
+ 602000p -0.3
+ 602010p 0.9
+ 604000p 0.9
+ 604010p -0.3
+ 606000p -0.3
+ 606010p 0.9
+ 608000p 0.9
+ 608010p -0.3
+ 610000p -0.3
+ 610010p 0.9
+ 612000p 0.9
+ 612010p -0.3
+ 614000p -0.3
+ 614010p 0.9
+ 616000p 0.9
+ 616010p -0.3
+ 618000p -0.3
+ 618010p 0.9
+ 620000p 0.9
+ 620010p -0.3
+ 622000p -0.3
+ 622010p 0.9
+ 624000p 0.9
+ 624010p -0.3
+ 626000p -0.3
+ 626010p 0.9
+ 628000p 0.9
+ 628010p -0.3
+ 630000p -0.3
+ 630010p 0.9
+ 632000p 0.9
+ 632010p -0.3
+ 634000p -0.3
+ 634010p 0.9
+ 636000p 0.9
+ 636010p -0.3
+ 638000p -0.3
+ 638010p 0.9
+ 640000p 0.9
+ 640010p -0.3
+ 642000p -0.3
+ 642010p 0.9
+ 644000p 0.9
+ 644010p -0.3
+ 646000p -0.3
+ 646010p 0.9
+ 648000p 0.9
+ 648010p -0.3
+ 650000p -0.3
+ 650010p 0.9
+ 652000p 0.9
+ 652010p -0.3
+ 654000p -0.3
+ 654010p 0.9
+ 656000p 0.9
+ 656010p -0.3
+ 658000p -0.3
+ 658010p 0.9
+ 660000p 0.9
+ 660010p -0.3
+ 662000p -0.3
+ 662010p 0.9
+ 664000p 0.9
+ 664010p -0.3
+ 666000p -0.3
+ 666010p 0.9
+ 668000p 0.9
+ 668010p -0.3
+ 670000p -0.3
+ 670010p 0.9
+ 672000p 0.9
+ 672010p -0.3
+ 674000p -0.3
+ 674010p 0.9
+ 676000p 0.9
+ 676010p -0.3
+ 678000p -0.3
+ 678010p 0.9
+ 680000p 0.9
+ 680010p -0.3
+ 682000p -0.3
+ 682010p 0.9
+ 684000p 0.9
+ 684010p -0.3
+ 686000p -0.3
+ 686010p 0.9
+ 688000p 0.9
+ 688010p -0.3
+ 690000p -0.3
+ 690010p 0.9
+ 692000p 0.9
+ 692010p -0.3
+ 694000p -0.3
+ 694010p 0.9
+ 696000p 0.9
+ 696010p -0.3
+ 698000p -0.3
+ 698010p 0.9
+ 700000p 0.9
+ 700010p -0.3
+ 702000p -0.3
+ 702010p 0.9
+ 704000p 0.9
+ 704010p -0.3
+ 706000p -0.3
+ 706010p 0.9
+ 708000p 0.9
+ 708010p -0.3
+ 710000p -0.3
+ 710010p 0.9
+ 712000p 0.9
+ 712010p -0.3
+ 714000p -0.3
+ 714010p 0.9
+ 716000p 0.9
+ 716010p -0.3
+ 718000p -0.3
+ 718010p 0.9
+ 720000p 0.9
+ 720010p -0.3
+ 722000p -0.3
+ 722010p 0.9
+ 724000p 0.9
+ 724010p -0.3
+ 726000p -0.3
+ 726010p 0.9
+ 728000p 0.9
+ 728010p -0.3
+ 730000p -0.3
+ 730010p 0.9
+ 732000p 0.9
+ 732010p -0.3
+ 734000p -0.3
+ 734010p 0.9
+ 736000p 0.9
+ 736010p -0.3
+ 738000p -0.3
+ 738010p 0.9
+ 740000p 0.9
+ 740010p -0.3
+ 742000p -0.3
+ 742010p 0.9
+ 744000p 0.9
+ 744010p -0.3
+ 746000p -0.3
+ 746010p 0.9
+ 748000p 0.9
+ 748010p -0.3
+ 750000p -0.3
+ 750010p 0.9
+ 752000p 0.9
+ 752010p -0.3
+ 754000p -0.3
+ 754010p 0.9
+ 756000p 0.9
+ 756010p -0.3
+ 758000p -0.3
+ 758010p 0.9
+ 760000p 0.9
+ 760010p -0.3
+ 762000p -0.3
+ 762010p 0.9
+ 764000p 0.9
+ 764010p -0.3
+ 766000p -0.3
+ 766010p 0.9
+ 768000p 0.9
+ 768010p -0.3
+ 770000p -0.3
+ 770010p 0.9
+ 772000p 0.9
+ 772010p -0.3
+ 774000p -0.3
+ 774010p 0.9
+ 776000p 0.9
+ 776010p -0.3
+ 778000p -0.3
+ 778010p 0.9
+ 780000p 0.9
+ 780010p -0.3
+ 782000p -0.3
+ 782010p 0.9
+ 784000p 0.9
+ 784010p -0.3
+ 786000p -0.3
+ 786010p 0.9
+ 788000p 0.9
+ 788010p -0.3
+ 790000p -0.3
+ 790010p 0.9
+ 792000p 0.9
+ 792010p -0.3
+ 794000p -0.3
+ 794010p 0.9
+ 796000p 0.9
+ 796010p -0.3
+ 798000p -0.3
+ 798010p 0.9
+ 800000p 0.9
+ 800010p -0.3
+ 802000p -0.3
+ 802010p 0.9
+ 804000p 0.9
+ 804010p -0.3
+ 806000p -0.3
+ 806010p 0.9
+ 808000p 0.9
+ 808010p -0.3
+ 810000p -0.3
+ 810010p 0.9
+ 812000p 0.9
+ 812010p -0.3
+ 814000p -0.3
+ 814010p 0.9
+ 816000p 0.9
+ 816010p -0.3
+ 818000p -0.3
+ 818010p 0.9
+ 820000p 0.9
+ 820010p -0.3
+ 822000p -0.3
+ 822010p 0.9
+ 824000p 0.9
+ 824010p -0.3
+ 826000p -0.3
+ 826010p 0.9
+ 828000p 0.9
+ 828010p -0.3
+ 830000p -0.3
+ 830010p 0.9
+ 832000p 0.9
+ 832010p -0.3
+ 834000p -0.3
+ 834010p 0.9
+ 836000p 0.9
+ 836010p -0.3
+ 838000p -0.3
+ 838010p 0.9
+ 840000p 0.9
+ 840010p -0.3
+ 842000p -0.3
+ 842010p 0.9
+ 844000p 0.9
+ 844010p -0.3
+ 846000p -0.3
+ 846010p 0.9
+ 848000p 0.9
+ 848010p -0.3
+ 850000p -0.3
+ 850010p 0.9
+ 852000p 0.9
+ 852010p -0.3
+ 854000p -0.3
+ 854010p 0.9
+ 856000p 0.9
+ 856010p -0.3
+ 858000p -0.3
+ 858010p 0.9
+ 860000p 0.9
+ 860010p -0.3
+ 862000p -0.3
+ 862010p 0.9
+ 864000p 0.9
+ 864010p -0.3
+ 866000p -0.3
+ 866010p 0.9
+ 868000p 0.9
+ 868010p -0.3
+ 870000p -0.3
+ 870010p 0.9
+ 872000p 0.9
+ 872010p -0.3
+ 874000p -0.3
+ 874010p 0.9
+ 876000p 0.9
+ 876010p -0.3
+ 878000p -0.3
+ 878010p 0.9
+ 880000p 0.9
+ 880010p -0.3
+ 882000p -0.3
+ 882010p 0.9
+ 884000p 0.9
+ 884010p -0.3
+ 886000p -0.3
+ 886010p 0.9
+ 888000p 0.9
+ 888010p -0.3
+ 890000p -0.3
+ 890010p 0.9
+ 892000p 0.9
+ 892010p -0.3
+ 894000p -0.3
+ 894010p 0.9
+ 896000p 0.9
+ 896010p -0.3
+ 898000p -0.3
+ 898010p 0.9
+ 900000p 0.9
+ 900010p -0.3
+ 902000p -0.3
+ 902010p 0.9
+ 904000p 0.9
+ 904010p -0.3
+ 906000p -0.3
+ 906010p 0.9
+ 908000p 0.9
+ 908010p -0.3
+ 910000p -0.3
+ 910010p 0.9
+ 912000p 0.9
+ 912010p -0.3
+ 914000p -0.3
+ 914010p 0.9
+ 916000p 0.9
+ 916010p -0.3
+ 918000p -0.3
+ 918010p 0.9
+ 920000p 0.9
+ 920010p -0.3
+ 922000p -0.3
+ 922010p 0.9
+ 924000p 0.9
+ 924010p -0.3
+ 926000p -0.3
+ 926010p 0.9
+ 928000p 0.9
+ 928010p -0.3
+ 930000p -0.3
+ 930010p 0.9
+ 932000p 0.9
+ 932010p -0.3
+ 934000p -0.3
+ 934010p 0.9
+ 936000p 0.9
+ 936010p -0.3
+ 938000p -0.3
+ 938010p 0.9
+ 940000p 0.9
+ 940010p -0.3
+ 942000p -0.3
+ 942010p 0.9
+ 944000p 0.9
+ 944010p -0.3
+ 946000p -0.3
+ 946010p 0.9
+ 948000p 0.9
+ 948010p -0.3
+ 950000p -0.3
+ 950010p 0.9
+ 952000p 0.9
+ 952010p -0.3
+ 954000p -0.3
+ 954010p 0.9
+ 956000p 0.9
+ 956010p -0.3
+ 958000p -0.3
+ 958010p 0.9
+ 960000p 0.9
+ 960010p -0.3
+ 962000p -0.3
+ 962010p 0.9
+ 964000p 0.9
+ 964010p -0.3
+ 966000p -0.3
+ 966010p 0.9
+ 968000p 0.9
+ 968010p -0.3
+ 970000p -0.3
+ 970010p 0.9
+ 972000p 0.9
+ 972010p -0.3
+ 974000p -0.3
+ 974010p 0.9
+ 976000p 0.9
+ 976010p -0.3
+ 978000p -0.3
+ 978010p 0.9
+ 980000p 0.9
+ 980010p -0.3
+ 982000p -0.3
+ 982010p 0.9
+ 984000p 0.9
+ 984010p -0.3
+ 986000p -0.3
+ 986010p 0.9
+ 988000p 0.9
+ 988010p -0.3
+ 990000p -0.3
+ 990010p 0.9
+ 992000p 0.9
+ 992010p -0.3
+ 994000p -0.3
+ 994010p 0.9
+ 996000p 0.9
+ 996010p -0.3
+ 998000p -0.3
+ 998010p 0.9
+ 1000000p 0.9
+ 1000010p -0.3
+ 1002000p -0.3
+ 1002010p 0.9
+ 1004000p 0.9
+ 1004010p -0.3
+ 1006000p -0.3
+ 1006010p 0.9
+ 1008000p 0.9
+ 1008010p -0.3
+ 1010000p -0.3
+ 1010010p 0.9
+ 1012000p 0.9
+ 1012010p -0.3
+ 1014000p -0.3
+ 1014010p 0.9
+ 1016000p 0.9
+ 1016010p -0.3
+ 1018000p -0.3
+ 1018010p 0.9
+ 1020000p 0.9
+ 1020010p -0.3
+ 1022000p -0.3
+ 1022010p 0.9
+ 1024000p 0.9
+ 1024010p -0.3
+ 1026000p -0.3
+ 1026010p 0.9
+ 1028000p 0.9
+ 1028010p -0.3
+ 1030000p -0.3
+ 1030010p 0.9
+ 1032000p 0.9
+ 1032010p -0.3
+ 1034000p -0.3
+ 1034010p 0.9
+ 1036000p 0.9
+ 1036010p -0.3
+ 1038000p -0.3
+ 1038010p 0.9
+ 1040000p 0.9
+ 1040010p -0.3
+ 1042000p -0.3
+ 1042010p 0.9
+ 1044000p 0.9
+ 1044010p -0.3
+ 1046000p -0.3
+ 1046010p 0.9
+ 1048000p 0.9
+ 1048010p -0.3
+ 1050000p -0.3
+ 1050010p 0.9
+ 1052000p 0.9
+ 1052010p -0.3
+ 1054000p -0.3
+ 1054010p 0.9
+ 1056000p 0.9
+ 1056010p -0.3
+ 1058000p -0.3
+ 1058010p 0.9
+ 1060000p 0.9
+ 1060010p -0.3
+ 1062000p -0.3
+ 1062010p 0.9
+ 1064000p 0.9
+ 1064010p -0.3
+ 1066000p -0.3
+ 1066010p 0.9
+ 1068000p 0.9
+ 1068010p -0.3
+ 1070000p -0.3
+ 1070010p 0.9
+ 1072000p 0.9
+ 1072010p -0.3
+ 1074000p -0.3
+ 1074010p 0.9
+ 1076000p 0.9
+ 1076010p -0.3
+ 1078000p -0.3
+ 1078010p 0.9
+ 1080000p 0.9
+ 1080010p -0.3
+ 1082000p -0.3
+ 1082010p 0.9
+ 1084000p 0.9
+ 1084010p -0.3
+ 1086000p -0.3
+ 1086010p 0.9
+ 1088000p 0.9
+ 1088010p -0.3
+ 1090000p -0.3
+ 1090010p 0.9
+ 1092000p 0.9
+ 1092010p -0.3
+ 1094000p -0.3
+ 1094010p 0.9
+ 1096000p 0.9
+ 1096010p -0.3
+ 1098000p -0.3
+ 1098010p 0.9
+ 1100000p 0.9
+ 1100010p -0.3
+ 1102000p -0.3
+ 1102010p 0.9
+ 1104000p 0.9
+ 1104010p -0.3
+ 1106000p -0.3
+ 1106010p 0.9
+ 1108000p 0.9
+ 1108010p -0.3
+ 1110000p -0.3
+ 1110010p 0.9
+ 1112000p 0.9
+ 1112010p -0.3
+ 1114000p -0.3
+ 1114010p 0.9
+ 1116000p 0.9
+ 1116010p -0.3
+ 1118000p -0.3
+ 1118010p 0.9
+ 1120000p 0.9
+ 1120010p -0.3
+ 1122000p -0.3
+ 1122010p 0.9
+ 1124000p 0.9
+ 1124010p -0.3
+ 1126000p -0.3
+ 1126010p 0.9
+ 1128000p 0.9
+ 1128010p -0.3
+ 1130000p -0.3
+ 1130010p 0.9
+ 1132000p 0.9
+ 1132010p -0.3
+ 1134000p -0.3
+ 1134010p 0.9
+ 1136000p 0.9
+ 1136010p -0.3
+ 1138000p -0.3
+ 1138010p 0.9
+ 1140000p 0.9
+ 1140010p -0.3
+ 1142000p -0.3
+ 1142010p 0.9
+ 1144000p 0.9
+ 1144010p -0.3
+ 1146000p -0.3
+ 1146010p 0.9
+ 1148000p 0.9
+ 1148010p -0.3
+ 1150000p -0.3
+ 1150010p 0.9
+ 1152000p 0.9
+ 1152010p -0.3
+ 1154000p -0.3
+ 1154010p 0.9
+ 1156000p 0.9
+ 1156010p -0.3
+ 1158000p -0.3
+ 1158010p 0.9
+ 1160000p 0.9
+ 1160010p -0.3
+ 1162000p -0.3
+ 1162010p 0.9
+ 1164000p 0.9
+ 1164010p -0.3
+ 1166000p -0.3
+ 1166010p 0.9
+ 1168000p 0.9
+ 1168010p -0.3
+ 1170000p -0.3
+ 1170010p 0.9
+ 1172000p 0.9
+ 1172010p -0.3
+ 1174000p -0.3
+ 1174010p 0.9
+ 1176000p 0.9
+ 1176010p -0.3
+ 1178000p -0.3
+ 1178010p 0.9
+ 1180000p 0.9
+ 1180010p -0.3
+ 1182000p -0.3
+ 1182010p 0.9
+ 1184000p 0.9
+ 1184010p -0.3
+ 1186000p -0.3
+ 1186010p 0.9
+ 1188000p 0.9
+ 1188010p -0.3
+ 1190000p -0.3
+ 1190010p 0.9
+ 1192000p 0.9
+ 1192010p -0.3
+ 1194000p -0.3
+ 1194010p 0.9
+ 1196000p 0.9
+ 1196010p -0.3
+ 1198000p -0.3
+ 1198010p 0.9
+ 1200000p 0.9
+ 1200010p -0.3
+ 1202000p -0.3
+ 1202010p 0.9
+ 1204000p 0.9
+ 1204010p -0.3
+ 1206000p -0.3
+ 1206010p 0.9
+ 1208000p 0.9
+ 1208010p -0.3
+ 1210000p -0.3
+ 1210010p 0.9
+ 1212000p 0.9
+ 1212010p -0.3
+ 1214000p -0.3
+ 1214010p 0.9
+ 1216000p 0.9
+ 1216010p -0.3
+ 1218000p -0.3
+ 1218010p 0.9
+ 1220000p 0.9
+ 1220010p -0.3
+ 1222000p -0.3
+ 1222010p 0.9
+ 1224000p 0.9
+ 1224010p -0.3
+ 1226000p -0.3
+ 1226010p 0.9
+ 1228000p 0.9
+ 1228010p -0.3
+ 1230000p -0.3
+ 1230010p 0.9
+ 1232000p 0.9
+ 1232010p -0.3
+ 1234000p -0.3
+ 1234010p 0.9
+ 1236000p 0.9
+ 1236010p -0.3
+ 1238000p -0.3
+ 1238010p 0.9
+ 1240000p 0.9
+ 1240010p -0.3
+ 1242000p -0.3
+ 1242010p 0.9
+ 1244000p 0.9
+ 1244010p -0.3
+ 1246000p -0.3
+ 1246010p 0.9
+ 1248000p 0.9
+ 1248010p -0.3
+ 1250000p -0.3
+ 1250010p 0.9
+ 1252000p 0.9
+ 1252010p -0.3
+ 1254000p -0.3
+ 1254010p 0.9
+ 1256000p 0.9
+ 1256010p -0.3
+ 1258000p -0.3
+ 1258010p 0.9
+ 1260000p 0.9
+ 1260010p -0.3
+ 1262000p -0.3
+ 1262010p 0.9
+ 1264000p 0.9
+ 1264010p -0.3
+ 1266000p -0.3
+ 1266010p 0.9
+ 1268000p 0.9
+ 1268010p -0.3
+ 1270000p -0.3
+ 1270010p 0.9
+ 1272000p 0.9
+ 1272010p -0.3
+ 1274000p -0.3
+ 1274010p 0.9
+ 1276000p 0.9
+ 1276010p -0.3
+ 1278000p -0.3
+ 1278010p 0.9
+ 1280000p 0.9
+ 1280010p -0.3
+ 1282000p -0.3
+ 1282010p 0.9
+ 1284000p 0.9
+ 1284010p -0.3
+ 1286000p -0.3
+ 1286010p 0.9
+ 1288000p 0.9
+ 1288010p -0.3
+ 1290000p -0.3
+ 1290010p 0.9
+ 1292000p 0.9
+ 1292010p -0.3
+ 1294000p -0.3
+ 1294010p 0.9
+ 1296000p 0.9
+ 1296010p -0.3
+ 1298000p -0.3
+ 1298010p 0.9
+ 1300000p 0.9
+ 1300010p -0.3
+ 1302000p -0.3
+ 1302010p 0.9
+ 1304000p 0.9
+ 1304010p -0.3
+ 1306000p -0.3
+ 1306010p 0.9
+ 1308000p 0.9
+ 1308010p -0.3
+ 1310000p -0.3
+ 1310010p 0.9
+ 1312000p 0.9
+ 1312010p -0.3
+ 1314000p -0.3
+ 1314010p 0.9
+ 1316000p 0.9
+ 1316010p -0.3
+ 1318000p -0.3
+ 1318010p 0.9
+ 1320000p 0.9
+ 1320010p -0.3
+ 1322000p -0.3
+ 1322010p 0.9
+ 1324000p 0.9
+ 1324010p -0.3
+ 1326000p -0.3
+ 1326010p 0.9
+ 1328000p 0.9
+ 1328010p -0.3
+ 1330000p -0.3
+ 1330010p 0.9
+ 1332000p 0.9
+ 1332010p -0.3
+ 1334000p -0.3
+ 1334010p 0.9
+ 1336000p 0.9
+ 1336010p -0.3
+ 1338000p -0.3
+ 1338010p 0.9
+ 1340000p 0.9
+ 1340010p -0.3
+ 1342000p -0.3
+ 1342010p 0.9
+ 1344000p 0.9
+ 1344010p -0.3
+ 1346000p -0.3
+ 1346010p 0.9
+ 1348000p 0.9
+ 1348010p -0.3
+ 1350000p -0.3
+ 1350010p 0.9
+ 1352000p 0.9
+ 1352010p -0.3
+ 1354000p -0.3
+ 1354010p 0.9
+ 1356000p 0.9
+ 1356010p -0.3
+ 1358000p -0.3
+ 1358010p 0.9
+ 1360000p 0.9
+ 1360010p -0.3
+ 1362000p -0.3
+ 1362010p 0.9
+ 1364000p 0.9
+ 1364010p -0.3
+ 1366000p -0.3
+ 1366010p 0.9
+ 1368000p 0.9
+ 1368010p -0.3
+ 1370000p -0.3
+ 1370010p 0.9
+ 1372000p 0.9
+ 1372010p -0.3
+ 1374000p -0.3
+ 1374010p 0.9
+ 1376000p 0.9
+ 1376010p -0.3
+ 1378000p -0.3
+ 1378010p 0.9
+ 1380000p 0.9
+ 1380010p -0.3
+ 1382000p -0.3
+ 1382010p 0.9
+ 1384000p 0.9
+ 1384010p -0.3
+ 1386000p -0.3
+ 1386010p 0.9
+ 1388000p 0.9
+ 1388010p -0.3
+ 1390000p -0.3
+ 1390010p 0.9
+ 1392000p 0.9
+ 1392010p -0.3
+ 1394000p -0.3
+ 1394010p 0.9
+ 1396000p 0.9
+ 1396010p -0.3
+ 1398000p -0.3
+ 1398010p 0.9
+ 1400000p 0.9
+ 1400010p -0.3
+ 1402000p -0.3
+ 1402010p 0.9
+ 1404000p 0.9
+ 1404010p -0.3
+ 1406000p -0.3
+ 1406010p 0.9
+ 1408000p 0.9
+ 1408010p -0.3
+ 1410000p -0.3
+ 1410010p 0.9
+ 1412000p 0.9
+ 1412010p -0.3
+ 1414000p -0.3
+ 1414010p 0.9
+ 1416000p 0.9
+ 1416010p -0.3
+ 1418000p -0.3
+ 1418010p 0.9
+ 1420000p 0.9
+ 1420010p -0.3
+ 1422000p -0.3
+ 1422010p 0.9
+ 1424000p 0.9
+ 1424010p -0.3
+ 1426000p -0.3
+ 1426010p 0.9
+ 1428000p 0.9
+ 1428010p -0.3
+ 1430000p -0.3
+ 1430010p 0.9
+ 1432000p 0.9
+ 1432010p -0.3
+ 1434000p -0.3
+ 1434010p 0.9
+ 1436000p 0.9
+ 1436010p -0.3
+ 1438000p -0.3
+ 1438010p 0.9
+ 1440000p 0.9
+ 1440010p -0.3
+ 1442000p -0.3
+ 1442010p 0.9
+ 1444000p 0.9
+ 1444010p -0.3
+ 1446000p -0.3
+ 1446010p 0.9
+ 1448000p 0.9
+ 1448010p -0.3
+ 1450000p -0.3
+ 1450010p 0.9
+ 1452000p 0.9
+ 1452010p -0.3
+ 1454000p -0.3
+ 1454010p 0.9
+ 1456000p 0.9
+ 1456010p -0.3
+ 1458000p -0.3
+ 1458010p 0.9
+ 1460000p 0.9
+ 1460010p -0.3
+ 1462000p -0.3
+ 1462010p 0.9
+ 1464000p 0.9
+ 1464010p -0.3
+ 1466000p -0.3
+ 1466010p 0.9
+ 1468000p 0.9
+ 1468010p -0.3
+ 1470000p -0.3
+ 1470010p 0.9
+ 1472000p 0.9
+ 1472010p -0.3
+ 1474000p -0.3
+ 1474010p 0.9
+ 1476000p 0.9
+ 1476010p -0.3
+ 1478000p -0.3
+ 1478010p 0.9
+ 1480000p 0.9
+ 1480010p -0.3
+ 1482000p -0.3
+ 1482010p 0.9
+ 1484000p 0.9
+ 1484010p -0.3
+ 1486000p -0.3
+ 1486010p 0.9
+ 1488000p 0.9
+ 1488010p -0.3
+ 1490000p -0.3
+ 1490010p 0.9
+ 1492000p 0.9
+ 1492010p -0.3
+ 1494000p -0.3
+ 1494010p 0.9
+ 1496000p 0.9
+ 1496010p -0.3
+ 1498000p -0.3
+ 1498010p 0.9
+ 1500000p 0.9
+ 1500010p -0.3
+ 1502000p -0.3
+ 1502010p 0.9
+ 1504000p 0.9
+ 1504010p -0.3
+ 1506000p -0.3
+ 1506010p 0.9
+ 1508000p 0.9
+ 1508010p -0.3
+ 1510000p -0.3
+ 1510010p 0.9
+ 1512000p 0.9
+ 1512010p -0.3
+ 1514000p -0.3
+ 1514010p 0.9
+ 1516000p 0.9
+ 1516010p -0.3
+ 1518000p -0.3
+ 1518010p 0.9
+ 1520000p 0.9
+ 1520010p -0.3
+ 1522000p -0.3
+ 1522010p 0.9
+ 1524000p 0.9
+ 1524010p -0.3
+ 1526000p -0.3
+ 1526010p 0.9
+ 1528000p 0.9
+ 1528010p -0.3
+ 1530000p -0.3
+ 1530010p 0.9
+ 1532000p 0.9
+ 1532010p -0.3
+ 1534000p -0.3
+ 1534010p 0.9
+ 1536000p 0.9
+ 1536010p -0.3
+ 1538000p -0.3
+ 1538010p 0.9
+ 1540000p 0.9
+ 1540010p -0.3
+ 1542000p -0.3
+ 1542010p 0.9
+ 1544000p 0.9
+ 1544010p -0.3
+ 1546000p -0.3
+ 1546010p 0.9
+ 1548000p 0.9
+ 1548010p -0.3
+ 1550000p -0.3
+ 1550010p 0.9
+ 1552000p 0.9
+ 1552010p -0.3
+ 1554000p -0.3
+ 1554010p 0.9
+ 1556000p 0.9
+ 1556010p -0.3
+ 1558000p -0.3
+ 1558010p 0.9
+ 1560000p 0.9
+ 1560010p -0.3
+ 1562000p -0.3
+ 1562010p 0.9
+ 1564000p 0.9
+ 1564010p -0.3
+ 1566000p -0.3
+ 1566010p 0.9
+ 1568000p 0.9
+ 1568010p -0.3
+ 1570000p -0.3
+ 1570010p 0.9
+ 1572000p 0.9
+ 1572010p -0.3
+ 1574000p -0.3
+ 1574010p 0.9
+ 1576000p 0.9
+ 1576010p -0.3
+ 1578000p -0.3
+ 1578010p 0.9
+ 1580000p 0.9
+ 1580010p -0.3
+ 1582000p -0.3
+ 1582010p 0.9
+ 1584000p 0.9
+ 1584010p -0.3
+ 1586000p -0.3
+ 1586010p 0.9
+ 1588000p 0.9
+ 1588010p -0.3
+ 1590000p -0.3
+ 1590010p 0.9
+ 1592000p 0.9
+ 1592010p -0.3
+ 1594000p -0.3
+ 1594010p 0.9
+ 1596000p 0.9
+ 1596010p -0.3
+ 1598000p -0.3
+ 1598010p 0.9
+ 1600000p 0.9
+ 1600010p -0.3
+ 1602000p -0.3
+ 1602010p 0.9
+ 1604000p 0.9
+ 1604010p -0.3
+ 1606000p -0.3
+ 1606010p 0.9
+ 1608000p 0.9
+ 1608010p -0.3
+ 1610000p -0.3
+ 1610010p 0.9
+ 1612000p 0.9
+ 1612010p -0.3
+ 1614000p -0.3
+ 1614010p 0.9
+ 1616000p 0.9
+ 1616010p -0.3
+ 1618000p -0.3
+ 1618010p 0.9
+ 1620000p 0.9
+ 1620010p -0.3
+ 1622000p -0.3
+ 1622010p 0.9
+ 1624000p 0.9
+ 1624010p -0.3
+ 1626000p -0.3
+ 1626010p 0.9
+ 1628000p 0.9
+ 1628010p -0.3
+ 1630000p -0.3
+ 1630010p 0.9
+ 1632000p 0.9
+ 1632010p -0.3
+ 1634000p -0.3
+ 1634010p 0.9
+ 1636000p 0.9
+ 1636010p -0.3
+ 1638000p -0.3
+ 1638010p 0.9
+ 1640000p 0.9
+ 1640010p -0.3
+ 1642000p -0.3
+ 1642010p 0.9
+ 1644000p 0.9
+ 1644010p -0.3
+ 1646000p -0.3
+ 1646010p 0.9
+ 1648000p 0.9
+ 1648010p -0.3
+ 1650000p -0.3
+ 1650010p 0.9
+ 1652000p 0.9
+ 1652010p -0.3
+ 1654000p -0.3
+ 1654010p 0.9
+ 1656000p 0.9
+ 1656010p -0.3
+ 1658000p -0.3
+ 1658010p 0.9
+ 1660000p 0.9
+ 1660010p -0.3
+ 1662000p -0.3
+ 1662010p 0.9
+ 1664000p 0.9
+ 1664010p -0.3
+ 1666000p -0.3
+ 1666010p 0.9
+ 1668000p 0.9
+ 1668010p -0.3
+ 1670000p -0.3
+ 1670010p 0.9
+ 1672000p 0.9
+ 1672010p -0.3
+ 1674000p -0.3
+ 1674010p 0.9
+ 1676000p 0.9
+ 1676010p -0.3
+ 1678000p -0.3
+ 1678010p 0.9
+ 1680000p 0.9
+ 1680010p -0.3
+ 1682000p -0.3
+ 1682010p 0.9
+ 1684000p 0.9
+ 1684010p -0.3
+ 1686000p -0.3
+ 1686010p 0.9
+ 1688000p 0.9
+ 1688010p -0.3
+ 1690000p -0.3
+ 1690010p 0.9
+ 1692000p 0.9
+ 1692010p -0.3
+ 1694000p -0.3
+ 1694010p 0.9
+ 1696000p 0.9
+ 1696010p -0.3
+ 1698000p -0.3
+ 1698010p 0.9
+ 1700000p 0.9
+ 1700010p -0.3
+ 1702000p -0.3
+ 1702010p 0.9
+ 1704000p 0.9
+ 1704010p -0.3
+ 1706000p -0.3
+ 1706010p 0.9
+ 1708000p 0.9
+ 1708010p -0.3
+ 1710000p -0.3
+ 1710010p 0.9
+ 1712000p 0.9
+ 1712010p -0.3
+ 1714000p -0.3
+ 1714010p 0.9
+ 1716000p 0.9
+ 1716010p -0.3
+ 1718000p -0.3
+ 1718010p 0.9
+ 1720000p 0.9
+ 1720010p -0.3
+ 1722000p -0.3
+ 1722010p 0.9
+ 1724000p 0.9
+ 1724010p -0.3
+ 1726000p -0.3
+ 1726010p 0.9
+ 1728000p 0.9
+ 1728010p -0.3
+ 1730000p -0.3
+ 1730010p 0.9
+ 1732000p 0.9
+ 1732010p -0.3
+ 1734000p -0.3
+ 1734010p 0.9
+ 1736000p 0.9
+ 1736010p -0.3
+ 1738000p -0.3
+ 1738010p 0.9
+ 1740000p 0.9
+ 1740010p -0.3
+ 1742000p -0.3
+ 1742010p 0.9
+ 1744000p 0.9
+ 1744010p -0.3
+ 1746000p -0.3
+ 1746010p 0.9
+ 1748000p 0.9
+ 1748010p -0.3
+ 1750000p -0.3
+ 1750010p 0.9
+ 1752000p 0.9
+ 1752010p -0.3
+ 1754000p -0.3
+ 1754010p 0.9
+ 1756000p 0.9
+ 1756010p -0.3
+ 1758000p -0.3
+ 1758010p 0.9
+ 1760000p 0.9
+ 1760010p -0.3
+ 1762000p -0.3
+ 1762010p 0.9
+ 1764000p 0.9
+ 1764010p -0.3
+ 1766000p -0.3
+ 1766010p 0.9
+ 1768000p 0.9
+ 1768010p -0.3
+ 1770000p -0.3
+ 1770010p 0.9
+ 1772000p 0.9
+ 1772010p -0.3
+ 1774000p -0.3
+ 1774010p 0.9
+ 1776000p 0.9
+ 1776010p -0.3
+ 1778000p -0.3
+ 1778010p 0.9
+ 1780000p 0.9
+ 1780010p -0.3
+ 1782000p -0.3
+ 1782010p 0.9
+ 1784000p 0.9
+ 1784010p -0.3
+ 1786000p -0.3
+ 1786010p 0.9
+ 1788000p 0.9
+ 1788010p -0.3
+ 1790000p -0.3
+ 1790010p 0.9
+ 1792000p 0.9
+ 1792010p -0.3
+ 1794000p -0.3
+ 1794010p 0.9
+ 1796000p 0.9
+ 1796010p -0.3
+ 1798000p -0.3
+ 1798010p 0.9
+ 1800000p 0.9
+ 1800010p -0.3
+ 1802000p -0.3
+ 1802010p 0.9
+ 1804000p 0.9
+ 1804010p -0.3
+ 1806000p -0.3
+ 1806010p 0.9
+ 1808000p 0.9
+ 1808010p -0.3
+ 1810000p -0.3
+ 1810010p 0.9
+ 1812000p 0.9
+ 1812010p -0.3
+ 1814000p -0.3
+ 1814010p 0.9
+ 1816000p 0.9
+ 1816010p -0.3
+ 1818000p -0.3
+ 1818010p 0.9
+ 1820000p 0.9
+ 1820010p -0.3
+ 1822000p -0.3
+ 1822010p 0.9
+ 1824000p 0.9
+ 1824010p -0.3
+ 1826000p -0.3
+ 1826010p 0.9
+ 1828000p 0.9
+ 1828010p -0.3
+ 1830000p -0.3
+ 1830010p 0.9
+ 1832000p 0.9
+ 1832010p -0.3
+ 1834000p -0.3
+ 1834010p 0.9
+ 1836000p 0.9
+ 1836010p -0.3
+ 1838000p -0.3
+ 1838010p 0.9
+ 1840000p 0.9
+ 1840010p -0.3
+ 1842000p -0.3
+ 1842010p 0.9
+ 1844000p 0.9
+ 1844010p -0.3
+ 1846000p -0.3
+ 1846010p 0.9
+ 1848000p 0.9
+ 1848010p -0.3
+ 1850000p -0.3
+ 1850010p 0.9
+ 1852000p 0.9
+ 1852010p -0.3
+ 1854000p -0.3
+ 1854010p 0.9
+ 1856000p 0.9
+ 1856010p -0.3
+ 1858000p -0.3
+ 1858010p 0.9
+ 1860000p 0.9
+ 1860010p -0.3
+ 1862000p -0.3
+ 1862010p 0.9
+ 1864000p 0.9
+ 1864010p -0.3
+ 1866000p -0.3
+ 1866010p 0.9
+ 1868000p 0.9
+ 1868010p -0.3
+ 1870000p -0.3
+ 1870010p 0.9
+ 1872000p 0.9
+ 1872010p -0.3
+ 1874000p -0.3
+ 1874010p 0.9
+ 1876000p 0.9
+ 1876010p -0.3
+ 1878000p -0.3
+ 1878010p 0.9
+ 1880000p 0.9
+ 1880010p -0.3
+ 1882000p -0.3
+ 1882010p 0.9
+ 1884000p 0.9
+ 1884010p -0.3
+ 1886000p -0.3
+ 1886010p 0.9
+ 1888000p 0.9
+ 1888010p -0.3
+ 1890000p -0.3
+ 1890010p 0.9
+ 1892000p 0.9
+ 1892010p -0.3
+ 1894000p -0.3
+ 1894010p 0.9
+ 1896000p 0.9
+ 1896010p -0.3
+ 1898000p -0.3
+ 1898010p 0.9
+ 1900000p 0.9
+ 1900010p -0.3
+ 1902000p -0.3
+ 1902010p 0.9
+ 1904000p 0.9
+ 1904010p -0.3
+ 1906000p -0.3
+ 1906010p 0.9
+ 1908000p 0.9
+ 1908010p -0.3
+ 1910000p -0.3
+ 1910010p 0.9
+ 1912000p 0.9
+ 1912010p -0.3
+ 1914000p -0.3
+ 1914010p 0.9
+ 1916000p 0.9
+ 1916010p -0.3
+ 1918000p -0.3
+ 1918010p 0.9
+ 1920000p 0.9
+ 1920010p -0.3
+ 1922000p -0.3
+ 1922010p 0.9
+ 1924000p 0.9
+ 1924010p -0.3
+ 1926000p -0.3
+ 1926010p 0.9
+ 1928000p 0.9
+ 1928010p -0.3
+ 1930000p -0.3
+ 1930010p 0.9
+ 1932000p 0.9
+ 1932010p -0.3
+ 1934000p -0.3
+ 1934010p 0.9
+ 1936000p 0.9
+ 1936010p -0.3
+ 1938000p -0.3
+ 1938010p 0.9
+ 1940000p 0.9
+ 1940010p -0.3
+ 1942000p -0.3
+ 1942010p 0.9
+ 1944000p 0.9
+ 1944010p -0.3
+ 1946000p -0.3
+ 1946010p 0.9
+ 1948000p 0.9
+ 1948010p -0.3
+ 1950000p -0.3
+ 1950010p 0.9
+ 1952000p 0.9
+ 1952010p -0.3
+ 1954000p -0.3
+ 1954010p 0.9
+ 1956000p 0.9
+ 1956010p -0.3
+ 1958000p -0.3
+ 1958010p 0.9
+ 1960000p 0.9
+ 1960010p -0.3
+ 1962000p -0.3
+ 1962010p 0.9
+ 1964000p 0.9
+ 1964010p -0.3
+ 1966000p -0.3
+ 1966010p 0.9
+ 1968000p 0.9
+ 1968010p -0.3
+ 1970000p -0.3
+ 1970010p 0.9
+ 1972000p 0.9
+ 1972010p -0.3
+ 1974000p -0.3
+ 1974010p 0.9
+ 1976000p 0.9
+ 1976010p -0.3
+ 1978000p -0.3
+ 1978010p 0.9
+ 1980000p 0.9
+ 1980010p -0.3
+ 1982000p -0.3
+ 1982010p 0.9
+ 1984000p 0.9
+ 1984010p -0.3
+ 1986000p -0.3
+ 1986010p 0.9
+ 1988000p 0.9
+ 1988010p -0.3
+ 1990000p -0.3
+ 1990010p 0.9
+ 1992000p 0.9
+ 1992010p -0.3
+ 1994000p -0.3
+ 1994010p 0.9
+ 1996000p 0.9
+ 1996010p -0.3
+ 1998000p -0.3
+ 1998010p 0.9
+ 2000000p 0.9
+ 2000010p -0.3
+ 2002000p -0.3
+ 2002010p 0.9
+ 2004000p 0.9
+ 2004010p -0.3
+ 2006000p -0.3
+ 2006010p 0.9
+ 2008000p 0.9
+ 2008010p -0.3
+ 2010000p -0.3
+ 2010010p 0.9
+ 2012000p 0.9
+ 2012010p -0.3
+ 2014000p -0.3
+ 2014010p 0.9
+ 2016000p 0.9
+ 2016010p -0.3
+ 2018000p -0.3
+ 2018010p 0.9
+ 2020000p 0.9
+ 2020010p -0.3
+ 2022000p -0.3
+ 2022010p 0.9
+ 2024000p 0.9
+ 2024010p -0.3
+ 2026000p -0.3
+ 2026010p 0.9
+ 2028000p 0.9
+ 2028010p -0.3
+ 2030000p -0.3
+ 2030010p 0.9
+ 2032000p 0.9
+ 2032010p -0.3
+ 2034000p -0.3
+ 2034010p 0.9
+ 2036000p 0.9
+ 2036010p -0.3
+ 2038000p -0.3
+ 2038010p 0.9
+ 2040000p 0.9
+ 2040010p -0.3
+ 2042000p -0.3
+ 2042010p 0.9
+ 2044000p 0.9
+ 2044010p -0.3
+ 2046000p -0.3
+ 2046010p 0.9
+ 2048000p 0.9
+ 2048010p -0.3
+ \]
V_data_4 (Data\\<4\\> gnd!) vsource type=pwl wave=\[
+ 0    0.9
+ 2000p 0.9
+ 2010p -0.3
+ 4000p -0.3
+ 4010p 0.9
+ 6000p 0.9
+ 6010p -0.3
+ 8000p -0.3
+ 8010p 0.9
+ 10000p 0.9
+ 10010p -0.3
+ 12000p -0.3
+ 12010p 0.9
+ 14000p 0.9
+ 14010p -0.3
+ 16000p -0.3
+ 16010p 0.9
+ 18000p 0.9
+ 18010p -0.3
+ 20000p -0.3
+ 20010p 0.9
+ 22000p 0.9
+ 22010p -0.3
+ 24000p -0.3
+ 24010p 0.9
+ 26000p 0.9
+ 26010p -0.3
+ 28000p -0.3
+ 28010p 0.9
+ 30000p 0.9
+ 30010p -0.3
+ 32000p -0.3
+ 32010p 0.9
+ 34000p 0.9
+ 34010p -0.3
+ 36000p -0.3
+ 36010p 0.9
+ 38000p 0.9
+ 38010p -0.3
+ 40000p -0.3
+ 40010p 0.9
+ 42000p 0.9
+ 42010p -0.3
+ 44000p -0.3
+ 44010p 0.9
+ 46000p 0.9
+ 46010p -0.3
+ 48000p -0.3
+ 48010p 0.9
+ 50000p 0.9
+ 50010p -0.3
+ 52000p -0.3
+ 52010p 0.9
+ 54000p 0.9
+ 54010p -0.3
+ 56000p -0.3
+ 56010p 0.9
+ 58000p 0.9
+ 58010p -0.3
+ 60000p -0.3
+ 60010p 0.9
+ 62000p 0.9
+ 62010p -0.3
+ 64000p -0.3
+ 64010p 0.9
+ 66000p 0.9
+ 66010p -0.3
+ 68000p -0.3
+ 68010p 0.9
+ 70000p 0.9
+ 70010p -0.3
+ 72000p -0.3
+ 72010p 0.9
+ 74000p 0.9
+ 74010p -0.3
+ 76000p -0.3
+ 76010p 0.9
+ 78000p 0.9
+ 78010p -0.3
+ 80000p -0.3
+ 80010p 0.9
+ 82000p 0.9
+ 82010p -0.3
+ 84000p -0.3
+ 84010p 0.9
+ 86000p 0.9
+ 86010p -0.3
+ 88000p -0.3
+ 88010p 0.9
+ 90000p 0.9
+ 90010p -0.3
+ 92000p -0.3
+ 92010p 0.9
+ 94000p 0.9
+ 94010p -0.3
+ 96000p -0.3
+ 96010p 0.9
+ 98000p 0.9
+ 98010p -0.3
+ 100000p -0.3
+ 100010p 0.9
+ 102000p 0.9
+ 102010p -0.3
+ 104000p -0.3
+ 104010p 0.9
+ 106000p 0.9
+ 106010p -0.3
+ 108000p -0.3
+ 108010p 0.9
+ 110000p 0.9
+ 110010p -0.3
+ 112000p -0.3
+ 112010p 0.9
+ 114000p 0.9
+ 114010p -0.3
+ 116000p -0.3
+ 116010p 0.9
+ 118000p 0.9
+ 118010p -0.3
+ 120000p -0.3
+ 120010p 0.9
+ 122000p 0.9
+ 122010p -0.3
+ 124000p -0.3
+ 124010p 0.9
+ 126000p 0.9
+ 126010p -0.3
+ 128000p -0.3
+ 128010p 0.9
+ 130000p 0.9
+ 130010p -0.3
+ 132000p -0.3
+ 132010p 0.9
+ 134000p 0.9
+ 134010p -0.3
+ 136000p -0.3
+ 136010p 0.9
+ 138000p 0.9
+ 138010p -0.3
+ 140000p -0.3
+ 140010p 0.9
+ 142000p 0.9
+ 142010p -0.3
+ 144000p -0.3
+ 144010p 0.9
+ 146000p 0.9
+ 146010p -0.3
+ 148000p -0.3
+ 148010p 0.9
+ 150000p 0.9
+ 150010p -0.3
+ 152000p -0.3
+ 152010p 0.9
+ 154000p 0.9
+ 154010p -0.3
+ 156000p -0.3
+ 156010p 0.9
+ 158000p 0.9
+ 158010p -0.3
+ 160000p -0.3
+ 160010p 0.9
+ 162000p 0.9
+ 162010p -0.3
+ 164000p -0.3
+ 164010p 0.9
+ 166000p 0.9
+ 166010p -0.3
+ 168000p -0.3
+ 168010p 0.9
+ 170000p 0.9
+ 170010p -0.3
+ 172000p -0.3
+ 172010p 0.9
+ 174000p 0.9
+ 174010p -0.3
+ 176000p -0.3
+ 176010p 0.9
+ 178000p 0.9
+ 178010p -0.3
+ 180000p -0.3
+ 180010p 0.9
+ 182000p 0.9
+ 182010p -0.3
+ 184000p -0.3
+ 184010p 0.9
+ 186000p 0.9
+ 186010p -0.3
+ 188000p -0.3
+ 188010p 0.9
+ 190000p 0.9
+ 190010p -0.3
+ 192000p -0.3
+ 192010p 0.9
+ 194000p 0.9
+ 194010p -0.3
+ 196000p -0.3
+ 196010p 0.9
+ 198000p 0.9
+ 198010p -0.3
+ 200000p -0.3
+ 200010p 0.9
+ 202000p 0.9
+ 202010p -0.3
+ 204000p -0.3
+ 204010p 0.9
+ 206000p 0.9
+ 206010p -0.3
+ 208000p -0.3
+ 208010p 0.9
+ 210000p 0.9
+ 210010p -0.3
+ 212000p -0.3
+ 212010p 0.9
+ 214000p 0.9
+ 214010p -0.3
+ 216000p -0.3
+ 216010p 0.9
+ 218000p 0.9
+ 218010p -0.3
+ 220000p -0.3
+ 220010p 0.9
+ 222000p 0.9
+ 222010p -0.3
+ 224000p -0.3
+ 224010p 0.9
+ 226000p 0.9
+ 226010p -0.3
+ 228000p -0.3
+ 228010p 0.9
+ 230000p 0.9
+ 230010p -0.3
+ 232000p -0.3
+ 232010p 0.9
+ 234000p 0.9
+ 234010p -0.3
+ 236000p -0.3
+ 236010p 0.9
+ 238000p 0.9
+ 238010p -0.3
+ 240000p -0.3
+ 240010p 0.9
+ 242000p 0.9
+ 242010p -0.3
+ 244000p -0.3
+ 244010p 0.9
+ 246000p 0.9
+ 246010p -0.3
+ 248000p -0.3
+ 248010p 0.9
+ 250000p 0.9
+ 250010p -0.3
+ 252000p -0.3
+ 252010p 0.9
+ 254000p 0.9
+ 254010p -0.3
+ 256000p -0.3
+ 256010p 0.9
+ 258000p 0.9
+ 258010p -0.3
+ 260000p -0.3
+ 260010p 0.9
+ 262000p 0.9
+ 262010p -0.3
+ 264000p -0.3
+ 264010p 0.9
+ 266000p 0.9
+ 266010p -0.3
+ 268000p -0.3
+ 268010p 0.9
+ 270000p 0.9
+ 270010p -0.3
+ 272000p -0.3
+ 272010p 0.9
+ 274000p 0.9
+ 274010p -0.3
+ 276000p -0.3
+ 276010p 0.9
+ 278000p 0.9
+ 278010p -0.3
+ 280000p -0.3
+ 280010p 0.9
+ 282000p 0.9
+ 282010p -0.3
+ 284000p -0.3
+ 284010p 0.9
+ 286000p 0.9
+ 286010p -0.3
+ 288000p -0.3
+ 288010p 0.9
+ 290000p 0.9
+ 290010p -0.3
+ 292000p -0.3
+ 292010p 0.9
+ 294000p 0.9
+ 294010p -0.3
+ 296000p -0.3
+ 296010p 0.9
+ 298000p 0.9
+ 298010p -0.3
+ 300000p -0.3
+ 300010p 0.9
+ 302000p 0.9
+ 302010p -0.3
+ 304000p -0.3
+ 304010p 0.9
+ 306000p 0.9
+ 306010p -0.3
+ 308000p -0.3
+ 308010p 0.9
+ 310000p 0.9
+ 310010p -0.3
+ 312000p -0.3
+ 312010p 0.9
+ 314000p 0.9
+ 314010p -0.3
+ 316000p -0.3
+ 316010p 0.9
+ 318000p 0.9
+ 318010p -0.3
+ 320000p -0.3
+ 320010p 0.9
+ 322000p 0.9
+ 322010p -0.3
+ 324000p -0.3
+ 324010p 0.9
+ 326000p 0.9
+ 326010p -0.3
+ 328000p -0.3
+ 328010p 0.9
+ 330000p 0.9
+ 330010p -0.3
+ 332000p -0.3
+ 332010p 0.9
+ 334000p 0.9
+ 334010p -0.3
+ 336000p -0.3
+ 336010p 0.9
+ 338000p 0.9
+ 338010p -0.3
+ 340000p -0.3
+ 340010p 0.9
+ 342000p 0.9
+ 342010p -0.3
+ 344000p -0.3
+ 344010p 0.9
+ 346000p 0.9
+ 346010p -0.3
+ 348000p -0.3
+ 348010p 0.9
+ 350000p 0.9
+ 350010p -0.3
+ 352000p -0.3
+ 352010p 0.9
+ 354000p 0.9
+ 354010p -0.3
+ 356000p -0.3
+ 356010p 0.9
+ 358000p 0.9
+ 358010p -0.3
+ 360000p -0.3
+ 360010p 0.9
+ 362000p 0.9
+ 362010p -0.3
+ 364000p -0.3
+ 364010p 0.9
+ 366000p 0.9
+ 366010p -0.3
+ 368000p -0.3
+ 368010p 0.9
+ 370000p 0.9
+ 370010p -0.3
+ 372000p -0.3
+ 372010p 0.9
+ 374000p 0.9
+ 374010p -0.3
+ 376000p -0.3
+ 376010p 0.9
+ 378000p 0.9
+ 378010p -0.3
+ 380000p -0.3
+ 380010p 0.9
+ 382000p 0.9
+ 382010p -0.3
+ 384000p -0.3
+ 384010p 0.9
+ 386000p 0.9
+ 386010p -0.3
+ 388000p -0.3
+ 388010p 0.9
+ 390000p 0.9
+ 390010p -0.3
+ 392000p -0.3
+ 392010p 0.9
+ 394000p 0.9
+ 394010p -0.3
+ 396000p -0.3
+ 396010p 0.9
+ 398000p 0.9
+ 398010p -0.3
+ 400000p -0.3
+ 400010p 0.9
+ 402000p 0.9
+ 402010p -0.3
+ 404000p -0.3
+ 404010p 0.9
+ 406000p 0.9
+ 406010p -0.3
+ 408000p -0.3
+ 408010p 0.9
+ 410000p 0.9
+ 410010p -0.3
+ 412000p -0.3
+ 412010p 0.9
+ 414000p 0.9
+ 414010p -0.3
+ 416000p -0.3
+ 416010p 0.9
+ 418000p 0.9
+ 418010p -0.3
+ 420000p -0.3
+ 420010p 0.9
+ 422000p 0.9
+ 422010p -0.3
+ 424000p -0.3
+ 424010p 0.9
+ 426000p 0.9
+ 426010p -0.3
+ 428000p -0.3
+ 428010p 0.9
+ 430000p 0.9
+ 430010p -0.3
+ 432000p -0.3
+ 432010p 0.9
+ 434000p 0.9
+ 434010p -0.3
+ 436000p -0.3
+ 436010p 0.9
+ 438000p 0.9
+ 438010p -0.3
+ 440000p -0.3
+ 440010p 0.9
+ 442000p 0.9
+ 442010p -0.3
+ 444000p -0.3
+ 444010p 0.9
+ 446000p 0.9
+ 446010p -0.3
+ 448000p -0.3
+ 448010p 0.9
+ 450000p 0.9
+ 450010p -0.3
+ 452000p -0.3
+ 452010p 0.9
+ 454000p 0.9
+ 454010p -0.3
+ 456000p -0.3
+ 456010p 0.9
+ 458000p 0.9
+ 458010p -0.3
+ 460000p -0.3
+ 460010p 0.9
+ 462000p 0.9
+ 462010p -0.3
+ 464000p -0.3
+ 464010p 0.9
+ 466000p 0.9
+ 466010p -0.3
+ 468000p -0.3
+ 468010p 0.9
+ 470000p 0.9
+ 470010p -0.3
+ 472000p -0.3
+ 472010p 0.9
+ 474000p 0.9
+ 474010p -0.3
+ 476000p -0.3
+ 476010p 0.9
+ 478000p 0.9
+ 478010p -0.3
+ 480000p -0.3
+ 480010p 0.9
+ 482000p 0.9
+ 482010p -0.3
+ 484000p -0.3
+ 484010p 0.9
+ 486000p 0.9
+ 486010p -0.3
+ 488000p -0.3
+ 488010p 0.9
+ 490000p 0.9
+ 490010p -0.3
+ 492000p -0.3
+ 492010p 0.9
+ 494000p 0.9
+ 494010p -0.3
+ 496000p -0.3
+ 496010p 0.9
+ 498000p 0.9
+ 498010p -0.3
+ 500000p -0.3
+ 500010p 0.9
+ 502000p 0.9
+ 502010p -0.3
+ 504000p -0.3
+ 504010p 0.9
+ 506000p 0.9
+ 506010p -0.3
+ 508000p -0.3
+ 508010p 0.9
+ 510000p 0.9
+ 510010p -0.3
+ 512000p -0.3
+ 512010p 0.9
+ 514000p 0.9
+ 514010p -0.3
+ 516000p -0.3
+ 516010p 0.9
+ 518000p 0.9
+ 518010p -0.3
+ 520000p -0.3
+ 520010p 0.9
+ 522000p 0.9
+ 522010p -0.3
+ 524000p -0.3
+ 524010p 0.9
+ 526000p 0.9
+ 526010p -0.3
+ 528000p -0.3
+ 528010p 0.9
+ 530000p 0.9
+ 530010p -0.3
+ 532000p -0.3
+ 532010p 0.9
+ 534000p 0.9
+ 534010p -0.3
+ 536000p -0.3
+ 536010p 0.9
+ 538000p 0.9
+ 538010p -0.3
+ 540000p -0.3
+ 540010p 0.9
+ 542000p 0.9
+ 542010p -0.3
+ 544000p -0.3
+ 544010p 0.9
+ 546000p 0.9
+ 546010p -0.3
+ 548000p -0.3
+ 548010p 0.9
+ 550000p 0.9
+ 550010p -0.3
+ 552000p -0.3
+ 552010p 0.9
+ 554000p 0.9
+ 554010p -0.3
+ 556000p -0.3
+ 556010p 0.9
+ 558000p 0.9
+ 558010p -0.3
+ 560000p -0.3
+ 560010p 0.9
+ 562000p 0.9
+ 562010p -0.3
+ 564000p -0.3
+ 564010p 0.9
+ 566000p 0.9
+ 566010p -0.3
+ 568000p -0.3
+ 568010p 0.9
+ 570000p 0.9
+ 570010p -0.3
+ 572000p -0.3
+ 572010p 0.9
+ 574000p 0.9
+ 574010p -0.3
+ 576000p -0.3
+ 576010p 0.9
+ 578000p 0.9
+ 578010p -0.3
+ 580000p -0.3
+ 580010p 0.9
+ 582000p 0.9
+ 582010p -0.3
+ 584000p -0.3
+ 584010p 0.9
+ 586000p 0.9
+ 586010p -0.3
+ 588000p -0.3
+ 588010p 0.9
+ 590000p 0.9
+ 590010p -0.3
+ 592000p -0.3
+ 592010p 0.9
+ 594000p 0.9
+ 594010p -0.3
+ 596000p -0.3
+ 596010p 0.9
+ 598000p 0.9
+ 598010p -0.3
+ 600000p -0.3
+ 600010p 0.9
+ 602000p 0.9
+ 602010p -0.3
+ 604000p -0.3
+ 604010p 0.9
+ 606000p 0.9
+ 606010p -0.3
+ 608000p -0.3
+ 608010p 0.9
+ 610000p 0.9
+ 610010p -0.3
+ 612000p -0.3
+ 612010p 0.9
+ 614000p 0.9
+ 614010p -0.3
+ 616000p -0.3
+ 616010p 0.9
+ 618000p 0.9
+ 618010p -0.3
+ 620000p -0.3
+ 620010p 0.9
+ 622000p 0.9
+ 622010p -0.3
+ 624000p -0.3
+ 624010p 0.9
+ 626000p 0.9
+ 626010p -0.3
+ 628000p -0.3
+ 628010p 0.9
+ 630000p 0.9
+ 630010p -0.3
+ 632000p -0.3
+ 632010p 0.9
+ 634000p 0.9
+ 634010p -0.3
+ 636000p -0.3
+ 636010p 0.9
+ 638000p 0.9
+ 638010p -0.3
+ 640000p -0.3
+ 640010p 0.9
+ 642000p 0.9
+ 642010p -0.3
+ 644000p -0.3
+ 644010p 0.9
+ 646000p 0.9
+ 646010p -0.3
+ 648000p -0.3
+ 648010p 0.9
+ 650000p 0.9
+ 650010p -0.3
+ 652000p -0.3
+ 652010p 0.9
+ 654000p 0.9
+ 654010p -0.3
+ 656000p -0.3
+ 656010p 0.9
+ 658000p 0.9
+ 658010p -0.3
+ 660000p -0.3
+ 660010p 0.9
+ 662000p 0.9
+ 662010p -0.3
+ 664000p -0.3
+ 664010p 0.9
+ 666000p 0.9
+ 666010p -0.3
+ 668000p -0.3
+ 668010p 0.9
+ 670000p 0.9
+ 670010p -0.3
+ 672000p -0.3
+ 672010p 0.9
+ 674000p 0.9
+ 674010p -0.3
+ 676000p -0.3
+ 676010p 0.9
+ 678000p 0.9
+ 678010p -0.3
+ 680000p -0.3
+ 680010p 0.9
+ 682000p 0.9
+ 682010p -0.3
+ 684000p -0.3
+ 684010p 0.9
+ 686000p 0.9
+ 686010p -0.3
+ 688000p -0.3
+ 688010p 0.9
+ 690000p 0.9
+ 690010p -0.3
+ 692000p -0.3
+ 692010p 0.9
+ 694000p 0.9
+ 694010p -0.3
+ 696000p -0.3
+ 696010p 0.9
+ 698000p 0.9
+ 698010p -0.3
+ 700000p -0.3
+ 700010p 0.9
+ 702000p 0.9
+ 702010p -0.3
+ 704000p -0.3
+ 704010p 0.9
+ 706000p 0.9
+ 706010p -0.3
+ 708000p -0.3
+ 708010p 0.9
+ 710000p 0.9
+ 710010p -0.3
+ 712000p -0.3
+ 712010p 0.9
+ 714000p 0.9
+ 714010p -0.3
+ 716000p -0.3
+ 716010p 0.9
+ 718000p 0.9
+ 718010p -0.3
+ 720000p -0.3
+ 720010p 0.9
+ 722000p 0.9
+ 722010p -0.3
+ 724000p -0.3
+ 724010p 0.9
+ 726000p 0.9
+ 726010p -0.3
+ 728000p -0.3
+ 728010p 0.9
+ 730000p 0.9
+ 730010p -0.3
+ 732000p -0.3
+ 732010p 0.9
+ 734000p 0.9
+ 734010p -0.3
+ 736000p -0.3
+ 736010p 0.9
+ 738000p 0.9
+ 738010p -0.3
+ 740000p -0.3
+ 740010p 0.9
+ 742000p 0.9
+ 742010p -0.3
+ 744000p -0.3
+ 744010p 0.9
+ 746000p 0.9
+ 746010p -0.3
+ 748000p -0.3
+ 748010p 0.9
+ 750000p 0.9
+ 750010p -0.3
+ 752000p -0.3
+ 752010p 0.9
+ 754000p 0.9
+ 754010p -0.3
+ 756000p -0.3
+ 756010p 0.9
+ 758000p 0.9
+ 758010p -0.3
+ 760000p -0.3
+ 760010p 0.9
+ 762000p 0.9
+ 762010p -0.3
+ 764000p -0.3
+ 764010p 0.9
+ 766000p 0.9
+ 766010p -0.3
+ 768000p -0.3
+ 768010p 0.9
+ 770000p 0.9
+ 770010p -0.3
+ 772000p -0.3
+ 772010p 0.9
+ 774000p 0.9
+ 774010p -0.3
+ 776000p -0.3
+ 776010p 0.9
+ 778000p 0.9
+ 778010p -0.3
+ 780000p -0.3
+ 780010p 0.9
+ 782000p 0.9
+ 782010p -0.3
+ 784000p -0.3
+ 784010p 0.9
+ 786000p 0.9
+ 786010p -0.3
+ 788000p -0.3
+ 788010p 0.9
+ 790000p 0.9
+ 790010p -0.3
+ 792000p -0.3
+ 792010p 0.9
+ 794000p 0.9
+ 794010p -0.3
+ 796000p -0.3
+ 796010p 0.9
+ 798000p 0.9
+ 798010p -0.3
+ 800000p -0.3
+ 800010p 0.9
+ 802000p 0.9
+ 802010p -0.3
+ 804000p -0.3
+ 804010p 0.9
+ 806000p 0.9
+ 806010p -0.3
+ 808000p -0.3
+ 808010p 0.9
+ 810000p 0.9
+ 810010p -0.3
+ 812000p -0.3
+ 812010p 0.9
+ 814000p 0.9
+ 814010p -0.3
+ 816000p -0.3
+ 816010p 0.9
+ 818000p 0.9
+ 818010p -0.3
+ 820000p -0.3
+ 820010p 0.9
+ 822000p 0.9
+ 822010p -0.3
+ 824000p -0.3
+ 824010p 0.9
+ 826000p 0.9
+ 826010p -0.3
+ 828000p -0.3
+ 828010p 0.9
+ 830000p 0.9
+ 830010p -0.3
+ 832000p -0.3
+ 832010p 0.9
+ 834000p 0.9
+ 834010p -0.3
+ 836000p -0.3
+ 836010p 0.9
+ 838000p 0.9
+ 838010p -0.3
+ 840000p -0.3
+ 840010p 0.9
+ 842000p 0.9
+ 842010p -0.3
+ 844000p -0.3
+ 844010p 0.9
+ 846000p 0.9
+ 846010p -0.3
+ 848000p -0.3
+ 848010p 0.9
+ 850000p 0.9
+ 850010p -0.3
+ 852000p -0.3
+ 852010p 0.9
+ 854000p 0.9
+ 854010p -0.3
+ 856000p -0.3
+ 856010p 0.9
+ 858000p 0.9
+ 858010p -0.3
+ 860000p -0.3
+ 860010p 0.9
+ 862000p 0.9
+ 862010p -0.3
+ 864000p -0.3
+ 864010p 0.9
+ 866000p 0.9
+ 866010p -0.3
+ 868000p -0.3
+ 868010p 0.9
+ 870000p 0.9
+ 870010p -0.3
+ 872000p -0.3
+ 872010p 0.9
+ 874000p 0.9
+ 874010p -0.3
+ 876000p -0.3
+ 876010p 0.9
+ 878000p 0.9
+ 878010p -0.3
+ 880000p -0.3
+ 880010p 0.9
+ 882000p 0.9
+ 882010p -0.3
+ 884000p -0.3
+ 884010p 0.9
+ 886000p 0.9
+ 886010p -0.3
+ 888000p -0.3
+ 888010p 0.9
+ 890000p 0.9
+ 890010p -0.3
+ 892000p -0.3
+ 892010p 0.9
+ 894000p 0.9
+ 894010p -0.3
+ 896000p -0.3
+ 896010p 0.9
+ 898000p 0.9
+ 898010p -0.3
+ 900000p -0.3
+ 900010p 0.9
+ 902000p 0.9
+ 902010p -0.3
+ 904000p -0.3
+ 904010p 0.9
+ 906000p 0.9
+ 906010p -0.3
+ 908000p -0.3
+ 908010p 0.9
+ 910000p 0.9
+ 910010p -0.3
+ 912000p -0.3
+ 912010p 0.9
+ 914000p 0.9
+ 914010p -0.3
+ 916000p -0.3
+ 916010p 0.9
+ 918000p 0.9
+ 918010p -0.3
+ 920000p -0.3
+ 920010p 0.9
+ 922000p 0.9
+ 922010p -0.3
+ 924000p -0.3
+ 924010p 0.9
+ 926000p 0.9
+ 926010p -0.3
+ 928000p -0.3
+ 928010p 0.9
+ 930000p 0.9
+ 930010p -0.3
+ 932000p -0.3
+ 932010p 0.9
+ 934000p 0.9
+ 934010p -0.3
+ 936000p -0.3
+ 936010p 0.9
+ 938000p 0.9
+ 938010p -0.3
+ 940000p -0.3
+ 940010p 0.9
+ 942000p 0.9
+ 942010p -0.3
+ 944000p -0.3
+ 944010p 0.9
+ 946000p 0.9
+ 946010p -0.3
+ 948000p -0.3
+ 948010p 0.9
+ 950000p 0.9
+ 950010p -0.3
+ 952000p -0.3
+ 952010p 0.9
+ 954000p 0.9
+ 954010p -0.3
+ 956000p -0.3
+ 956010p 0.9
+ 958000p 0.9
+ 958010p -0.3
+ 960000p -0.3
+ 960010p 0.9
+ 962000p 0.9
+ 962010p -0.3
+ 964000p -0.3
+ 964010p 0.9
+ 966000p 0.9
+ 966010p -0.3
+ 968000p -0.3
+ 968010p 0.9
+ 970000p 0.9
+ 970010p -0.3
+ 972000p -0.3
+ 972010p 0.9
+ 974000p 0.9
+ 974010p -0.3
+ 976000p -0.3
+ 976010p 0.9
+ 978000p 0.9
+ 978010p -0.3
+ 980000p -0.3
+ 980010p 0.9
+ 982000p 0.9
+ 982010p -0.3
+ 984000p -0.3
+ 984010p 0.9
+ 986000p 0.9
+ 986010p -0.3
+ 988000p -0.3
+ 988010p 0.9
+ 990000p 0.9
+ 990010p -0.3
+ 992000p -0.3
+ 992010p 0.9
+ 994000p 0.9
+ 994010p -0.3
+ 996000p -0.3
+ 996010p 0.9
+ 998000p 0.9
+ 998010p -0.3
+ 1000000p -0.3
+ 1000010p 0.9
+ 1002000p 0.9
+ 1002010p -0.3
+ 1004000p -0.3
+ 1004010p 0.9
+ 1006000p 0.9
+ 1006010p -0.3
+ 1008000p -0.3
+ 1008010p 0.9
+ 1010000p 0.9
+ 1010010p -0.3
+ 1012000p -0.3
+ 1012010p 0.9
+ 1014000p 0.9
+ 1014010p -0.3
+ 1016000p -0.3
+ 1016010p 0.9
+ 1018000p 0.9
+ 1018010p -0.3
+ 1020000p -0.3
+ 1020010p 0.9
+ 1022000p 0.9
+ 1022010p -0.3
+ 1024000p -0.3
+ 1024010p 0.9
+ 1026000p 0.9
+ 1026010p -0.3
+ 1028000p -0.3
+ 1028010p 0.9
+ 1030000p 0.9
+ 1030010p -0.3
+ 1032000p -0.3
+ 1032010p 0.9
+ 1034000p 0.9
+ 1034010p -0.3
+ 1036000p -0.3
+ 1036010p 0.9
+ 1038000p 0.9
+ 1038010p -0.3
+ 1040000p -0.3
+ 1040010p 0.9
+ 1042000p 0.9
+ 1042010p -0.3
+ 1044000p -0.3
+ 1044010p 0.9
+ 1046000p 0.9
+ 1046010p -0.3
+ 1048000p -0.3
+ 1048010p 0.9
+ 1050000p 0.9
+ 1050010p -0.3
+ 1052000p -0.3
+ 1052010p 0.9
+ 1054000p 0.9
+ 1054010p -0.3
+ 1056000p -0.3
+ 1056010p 0.9
+ 1058000p 0.9
+ 1058010p -0.3
+ 1060000p -0.3
+ 1060010p 0.9
+ 1062000p 0.9
+ 1062010p -0.3
+ 1064000p -0.3
+ 1064010p 0.9
+ 1066000p 0.9
+ 1066010p -0.3
+ 1068000p -0.3
+ 1068010p 0.9
+ 1070000p 0.9
+ 1070010p -0.3
+ 1072000p -0.3
+ 1072010p 0.9
+ 1074000p 0.9
+ 1074010p -0.3
+ 1076000p -0.3
+ 1076010p 0.9
+ 1078000p 0.9
+ 1078010p -0.3
+ 1080000p -0.3
+ 1080010p 0.9
+ 1082000p 0.9
+ 1082010p -0.3
+ 1084000p -0.3
+ 1084010p 0.9
+ 1086000p 0.9
+ 1086010p -0.3
+ 1088000p -0.3
+ 1088010p 0.9
+ 1090000p 0.9
+ 1090010p -0.3
+ 1092000p -0.3
+ 1092010p 0.9
+ 1094000p 0.9
+ 1094010p -0.3
+ 1096000p -0.3
+ 1096010p 0.9
+ 1098000p 0.9
+ 1098010p -0.3
+ 1100000p -0.3
+ 1100010p 0.9
+ 1102000p 0.9
+ 1102010p -0.3
+ 1104000p -0.3
+ 1104010p 0.9
+ 1106000p 0.9
+ 1106010p -0.3
+ 1108000p -0.3
+ 1108010p 0.9
+ 1110000p 0.9
+ 1110010p -0.3
+ 1112000p -0.3
+ 1112010p 0.9
+ 1114000p 0.9
+ 1114010p -0.3
+ 1116000p -0.3
+ 1116010p 0.9
+ 1118000p 0.9
+ 1118010p -0.3
+ 1120000p -0.3
+ 1120010p 0.9
+ 1122000p 0.9
+ 1122010p -0.3
+ 1124000p -0.3
+ 1124010p 0.9
+ 1126000p 0.9
+ 1126010p -0.3
+ 1128000p -0.3
+ 1128010p 0.9
+ 1130000p 0.9
+ 1130010p -0.3
+ 1132000p -0.3
+ 1132010p 0.9
+ 1134000p 0.9
+ 1134010p -0.3
+ 1136000p -0.3
+ 1136010p 0.9
+ 1138000p 0.9
+ 1138010p -0.3
+ 1140000p -0.3
+ 1140010p 0.9
+ 1142000p 0.9
+ 1142010p -0.3
+ 1144000p -0.3
+ 1144010p 0.9
+ 1146000p 0.9
+ 1146010p -0.3
+ 1148000p -0.3
+ 1148010p 0.9
+ 1150000p 0.9
+ 1150010p -0.3
+ 1152000p -0.3
+ 1152010p 0.9
+ 1154000p 0.9
+ 1154010p -0.3
+ 1156000p -0.3
+ 1156010p 0.9
+ 1158000p 0.9
+ 1158010p -0.3
+ 1160000p -0.3
+ 1160010p 0.9
+ 1162000p 0.9
+ 1162010p -0.3
+ 1164000p -0.3
+ 1164010p 0.9
+ 1166000p 0.9
+ 1166010p -0.3
+ 1168000p -0.3
+ 1168010p 0.9
+ 1170000p 0.9
+ 1170010p -0.3
+ 1172000p -0.3
+ 1172010p 0.9
+ 1174000p 0.9
+ 1174010p -0.3
+ 1176000p -0.3
+ 1176010p 0.9
+ 1178000p 0.9
+ 1178010p -0.3
+ 1180000p -0.3
+ 1180010p 0.9
+ 1182000p 0.9
+ 1182010p -0.3
+ 1184000p -0.3
+ 1184010p 0.9
+ 1186000p 0.9
+ 1186010p -0.3
+ 1188000p -0.3
+ 1188010p 0.9
+ 1190000p 0.9
+ 1190010p -0.3
+ 1192000p -0.3
+ 1192010p 0.9
+ 1194000p 0.9
+ 1194010p -0.3
+ 1196000p -0.3
+ 1196010p 0.9
+ 1198000p 0.9
+ 1198010p -0.3
+ 1200000p -0.3
+ 1200010p 0.9
+ 1202000p 0.9
+ 1202010p -0.3
+ 1204000p -0.3
+ 1204010p 0.9
+ 1206000p 0.9
+ 1206010p -0.3
+ 1208000p -0.3
+ 1208010p 0.9
+ 1210000p 0.9
+ 1210010p -0.3
+ 1212000p -0.3
+ 1212010p 0.9
+ 1214000p 0.9
+ 1214010p -0.3
+ 1216000p -0.3
+ 1216010p 0.9
+ 1218000p 0.9
+ 1218010p -0.3
+ 1220000p -0.3
+ 1220010p 0.9
+ 1222000p 0.9
+ 1222010p -0.3
+ 1224000p -0.3
+ 1224010p 0.9
+ 1226000p 0.9
+ 1226010p -0.3
+ 1228000p -0.3
+ 1228010p 0.9
+ 1230000p 0.9
+ 1230010p -0.3
+ 1232000p -0.3
+ 1232010p 0.9
+ 1234000p 0.9
+ 1234010p -0.3
+ 1236000p -0.3
+ 1236010p 0.9
+ 1238000p 0.9
+ 1238010p -0.3
+ 1240000p -0.3
+ 1240010p 0.9
+ 1242000p 0.9
+ 1242010p -0.3
+ 1244000p -0.3
+ 1244010p 0.9
+ 1246000p 0.9
+ 1246010p -0.3
+ 1248000p -0.3
+ 1248010p 0.9
+ 1250000p 0.9
+ 1250010p -0.3
+ 1252000p -0.3
+ 1252010p 0.9
+ 1254000p 0.9
+ 1254010p -0.3
+ 1256000p -0.3
+ 1256010p 0.9
+ 1258000p 0.9
+ 1258010p -0.3
+ 1260000p -0.3
+ 1260010p 0.9
+ 1262000p 0.9
+ 1262010p -0.3
+ 1264000p -0.3
+ 1264010p 0.9
+ 1266000p 0.9
+ 1266010p -0.3
+ 1268000p -0.3
+ 1268010p 0.9
+ 1270000p 0.9
+ 1270010p -0.3
+ 1272000p -0.3
+ 1272010p 0.9
+ 1274000p 0.9
+ 1274010p -0.3
+ 1276000p -0.3
+ 1276010p 0.9
+ 1278000p 0.9
+ 1278010p -0.3
+ 1280000p -0.3
+ 1280010p 0.9
+ 1282000p 0.9
+ 1282010p -0.3
+ 1284000p -0.3
+ 1284010p 0.9
+ 1286000p 0.9
+ 1286010p -0.3
+ 1288000p -0.3
+ 1288010p 0.9
+ 1290000p 0.9
+ 1290010p -0.3
+ 1292000p -0.3
+ 1292010p 0.9
+ 1294000p 0.9
+ 1294010p -0.3
+ 1296000p -0.3
+ 1296010p 0.9
+ 1298000p 0.9
+ 1298010p -0.3
+ 1300000p -0.3
+ 1300010p 0.9
+ 1302000p 0.9
+ 1302010p -0.3
+ 1304000p -0.3
+ 1304010p 0.9
+ 1306000p 0.9
+ 1306010p -0.3
+ 1308000p -0.3
+ 1308010p 0.9
+ 1310000p 0.9
+ 1310010p -0.3
+ 1312000p -0.3
+ 1312010p 0.9
+ 1314000p 0.9
+ 1314010p -0.3
+ 1316000p -0.3
+ 1316010p 0.9
+ 1318000p 0.9
+ 1318010p -0.3
+ 1320000p -0.3
+ 1320010p 0.9
+ 1322000p 0.9
+ 1322010p -0.3
+ 1324000p -0.3
+ 1324010p 0.9
+ 1326000p 0.9
+ 1326010p -0.3
+ 1328000p -0.3
+ 1328010p 0.9
+ 1330000p 0.9
+ 1330010p -0.3
+ 1332000p -0.3
+ 1332010p 0.9
+ 1334000p 0.9
+ 1334010p -0.3
+ 1336000p -0.3
+ 1336010p 0.9
+ 1338000p 0.9
+ 1338010p -0.3
+ 1340000p -0.3
+ 1340010p 0.9
+ 1342000p 0.9
+ 1342010p -0.3
+ 1344000p -0.3
+ 1344010p 0.9
+ 1346000p 0.9
+ 1346010p -0.3
+ 1348000p -0.3
+ 1348010p 0.9
+ 1350000p 0.9
+ 1350010p -0.3
+ 1352000p -0.3
+ 1352010p 0.9
+ 1354000p 0.9
+ 1354010p -0.3
+ 1356000p -0.3
+ 1356010p 0.9
+ 1358000p 0.9
+ 1358010p -0.3
+ 1360000p -0.3
+ 1360010p 0.9
+ 1362000p 0.9
+ 1362010p -0.3
+ 1364000p -0.3
+ 1364010p 0.9
+ 1366000p 0.9
+ 1366010p -0.3
+ 1368000p -0.3
+ 1368010p 0.9
+ 1370000p 0.9
+ 1370010p -0.3
+ 1372000p -0.3
+ 1372010p 0.9
+ 1374000p 0.9
+ 1374010p -0.3
+ 1376000p -0.3
+ 1376010p 0.9
+ 1378000p 0.9
+ 1378010p -0.3
+ 1380000p -0.3
+ 1380010p 0.9
+ 1382000p 0.9
+ 1382010p -0.3
+ 1384000p -0.3
+ 1384010p 0.9
+ 1386000p 0.9
+ 1386010p -0.3
+ 1388000p -0.3
+ 1388010p 0.9
+ 1390000p 0.9
+ 1390010p -0.3
+ 1392000p -0.3
+ 1392010p 0.9
+ 1394000p 0.9
+ 1394010p -0.3
+ 1396000p -0.3
+ 1396010p 0.9
+ 1398000p 0.9
+ 1398010p -0.3
+ 1400000p -0.3
+ 1400010p 0.9
+ 1402000p 0.9
+ 1402010p -0.3
+ 1404000p -0.3
+ 1404010p 0.9
+ 1406000p 0.9
+ 1406010p -0.3
+ 1408000p -0.3
+ 1408010p 0.9
+ 1410000p 0.9
+ 1410010p -0.3
+ 1412000p -0.3
+ 1412010p 0.9
+ 1414000p 0.9
+ 1414010p -0.3
+ 1416000p -0.3
+ 1416010p 0.9
+ 1418000p 0.9
+ 1418010p -0.3
+ 1420000p -0.3
+ 1420010p 0.9
+ 1422000p 0.9
+ 1422010p -0.3
+ 1424000p -0.3
+ 1424010p 0.9
+ 1426000p 0.9
+ 1426010p -0.3
+ 1428000p -0.3
+ 1428010p 0.9
+ 1430000p 0.9
+ 1430010p -0.3
+ 1432000p -0.3
+ 1432010p 0.9
+ 1434000p 0.9
+ 1434010p -0.3
+ 1436000p -0.3
+ 1436010p 0.9
+ 1438000p 0.9
+ 1438010p -0.3
+ 1440000p -0.3
+ 1440010p 0.9
+ 1442000p 0.9
+ 1442010p -0.3
+ 1444000p -0.3
+ 1444010p 0.9
+ 1446000p 0.9
+ 1446010p -0.3
+ 1448000p -0.3
+ 1448010p 0.9
+ 1450000p 0.9
+ 1450010p -0.3
+ 1452000p -0.3
+ 1452010p 0.9
+ 1454000p 0.9
+ 1454010p -0.3
+ 1456000p -0.3
+ 1456010p 0.9
+ 1458000p 0.9
+ 1458010p -0.3
+ 1460000p -0.3
+ 1460010p 0.9
+ 1462000p 0.9
+ 1462010p -0.3
+ 1464000p -0.3
+ 1464010p 0.9
+ 1466000p 0.9
+ 1466010p -0.3
+ 1468000p -0.3
+ 1468010p 0.9
+ 1470000p 0.9
+ 1470010p -0.3
+ 1472000p -0.3
+ 1472010p 0.9
+ 1474000p 0.9
+ 1474010p -0.3
+ 1476000p -0.3
+ 1476010p 0.9
+ 1478000p 0.9
+ 1478010p -0.3
+ 1480000p -0.3
+ 1480010p 0.9
+ 1482000p 0.9
+ 1482010p -0.3
+ 1484000p -0.3
+ 1484010p 0.9
+ 1486000p 0.9
+ 1486010p -0.3
+ 1488000p -0.3
+ 1488010p 0.9
+ 1490000p 0.9
+ 1490010p -0.3
+ 1492000p -0.3
+ 1492010p 0.9
+ 1494000p 0.9
+ 1494010p -0.3
+ 1496000p -0.3
+ 1496010p 0.9
+ 1498000p 0.9
+ 1498010p -0.3
+ 1500000p -0.3
+ 1500010p 0.9
+ 1502000p 0.9
+ 1502010p -0.3
+ 1504000p -0.3
+ 1504010p 0.9
+ 1506000p 0.9
+ 1506010p -0.3
+ 1508000p -0.3
+ 1508010p 0.9
+ 1510000p 0.9
+ 1510010p -0.3
+ 1512000p -0.3
+ 1512010p 0.9
+ 1514000p 0.9
+ 1514010p -0.3
+ 1516000p -0.3
+ 1516010p 0.9
+ 1518000p 0.9
+ 1518010p -0.3
+ 1520000p -0.3
+ 1520010p 0.9
+ 1522000p 0.9
+ 1522010p -0.3
+ 1524000p -0.3
+ 1524010p 0.9
+ 1526000p 0.9
+ 1526010p -0.3
+ 1528000p -0.3
+ 1528010p 0.9
+ 1530000p 0.9
+ 1530010p -0.3
+ 1532000p -0.3
+ 1532010p 0.9
+ 1534000p 0.9
+ 1534010p -0.3
+ 1536000p -0.3
+ 1536010p 0.9
+ 1538000p 0.9
+ 1538010p -0.3
+ 1540000p -0.3
+ 1540010p 0.9
+ 1542000p 0.9
+ 1542010p -0.3
+ 1544000p -0.3
+ 1544010p 0.9
+ 1546000p 0.9
+ 1546010p -0.3
+ 1548000p -0.3
+ 1548010p 0.9
+ 1550000p 0.9
+ 1550010p -0.3
+ 1552000p -0.3
+ 1552010p 0.9
+ 1554000p 0.9
+ 1554010p -0.3
+ 1556000p -0.3
+ 1556010p 0.9
+ 1558000p 0.9
+ 1558010p -0.3
+ 1560000p -0.3
+ 1560010p 0.9
+ 1562000p 0.9
+ 1562010p -0.3
+ 1564000p -0.3
+ 1564010p 0.9
+ 1566000p 0.9
+ 1566010p -0.3
+ 1568000p -0.3
+ 1568010p 0.9
+ 1570000p 0.9
+ 1570010p -0.3
+ 1572000p -0.3
+ 1572010p 0.9
+ 1574000p 0.9
+ 1574010p -0.3
+ 1576000p -0.3
+ 1576010p 0.9
+ 1578000p 0.9
+ 1578010p -0.3
+ 1580000p -0.3
+ 1580010p 0.9
+ 1582000p 0.9
+ 1582010p -0.3
+ 1584000p -0.3
+ 1584010p 0.9
+ 1586000p 0.9
+ 1586010p -0.3
+ 1588000p -0.3
+ 1588010p 0.9
+ 1590000p 0.9
+ 1590010p -0.3
+ 1592000p -0.3
+ 1592010p 0.9
+ 1594000p 0.9
+ 1594010p -0.3
+ 1596000p -0.3
+ 1596010p 0.9
+ 1598000p 0.9
+ 1598010p -0.3
+ 1600000p -0.3
+ 1600010p 0.9
+ 1602000p 0.9
+ 1602010p -0.3
+ 1604000p -0.3
+ 1604010p 0.9
+ 1606000p 0.9
+ 1606010p -0.3
+ 1608000p -0.3
+ 1608010p 0.9
+ 1610000p 0.9
+ 1610010p -0.3
+ 1612000p -0.3
+ 1612010p 0.9
+ 1614000p 0.9
+ 1614010p -0.3
+ 1616000p -0.3
+ 1616010p 0.9
+ 1618000p 0.9
+ 1618010p -0.3
+ 1620000p -0.3
+ 1620010p 0.9
+ 1622000p 0.9
+ 1622010p -0.3
+ 1624000p -0.3
+ 1624010p 0.9
+ 1626000p 0.9
+ 1626010p -0.3
+ 1628000p -0.3
+ 1628010p 0.9
+ 1630000p 0.9
+ 1630010p -0.3
+ 1632000p -0.3
+ 1632010p 0.9
+ 1634000p 0.9
+ 1634010p -0.3
+ 1636000p -0.3
+ 1636010p 0.9
+ 1638000p 0.9
+ 1638010p -0.3
+ 1640000p -0.3
+ 1640010p 0.9
+ 1642000p 0.9
+ 1642010p -0.3
+ 1644000p -0.3
+ 1644010p 0.9
+ 1646000p 0.9
+ 1646010p -0.3
+ 1648000p -0.3
+ 1648010p 0.9
+ 1650000p 0.9
+ 1650010p -0.3
+ 1652000p -0.3
+ 1652010p 0.9
+ 1654000p 0.9
+ 1654010p -0.3
+ 1656000p -0.3
+ 1656010p 0.9
+ 1658000p 0.9
+ 1658010p -0.3
+ 1660000p -0.3
+ 1660010p 0.9
+ 1662000p 0.9
+ 1662010p -0.3
+ 1664000p -0.3
+ 1664010p 0.9
+ 1666000p 0.9
+ 1666010p -0.3
+ 1668000p -0.3
+ 1668010p 0.9
+ 1670000p 0.9
+ 1670010p -0.3
+ 1672000p -0.3
+ 1672010p 0.9
+ 1674000p 0.9
+ 1674010p -0.3
+ 1676000p -0.3
+ 1676010p 0.9
+ 1678000p 0.9
+ 1678010p -0.3
+ 1680000p -0.3
+ 1680010p 0.9
+ 1682000p 0.9
+ 1682010p -0.3
+ 1684000p -0.3
+ 1684010p 0.9
+ 1686000p 0.9
+ 1686010p -0.3
+ 1688000p -0.3
+ 1688010p 0.9
+ 1690000p 0.9
+ 1690010p -0.3
+ 1692000p -0.3
+ 1692010p 0.9
+ 1694000p 0.9
+ 1694010p -0.3
+ 1696000p -0.3
+ 1696010p 0.9
+ 1698000p 0.9
+ 1698010p -0.3
+ 1700000p -0.3
+ 1700010p 0.9
+ 1702000p 0.9
+ 1702010p -0.3
+ 1704000p -0.3
+ 1704010p 0.9
+ 1706000p 0.9
+ 1706010p -0.3
+ 1708000p -0.3
+ 1708010p 0.9
+ 1710000p 0.9
+ 1710010p -0.3
+ 1712000p -0.3
+ 1712010p 0.9
+ 1714000p 0.9
+ 1714010p -0.3
+ 1716000p -0.3
+ 1716010p 0.9
+ 1718000p 0.9
+ 1718010p -0.3
+ 1720000p -0.3
+ 1720010p 0.9
+ 1722000p 0.9
+ 1722010p -0.3
+ 1724000p -0.3
+ 1724010p 0.9
+ 1726000p 0.9
+ 1726010p -0.3
+ 1728000p -0.3
+ 1728010p 0.9
+ 1730000p 0.9
+ 1730010p -0.3
+ 1732000p -0.3
+ 1732010p 0.9
+ 1734000p 0.9
+ 1734010p -0.3
+ 1736000p -0.3
+ 1736010p 0.9
+ 1738000p 0.9
+ 1738010p -0.3
+ 1740000p -0.3
+ 1740010p 0.9
+ 1742000p 0.9
+ 1742010p -0.3
+ 1744000p -0.3
+ 1744010p 0.9
+ 1746000p 0.9
+ 1746010p -0.3
+ 1748000p -0.3
+ 1748010p 0.9
+ 1750000p 0.9
+ 1750010p -0.3
+ 1752000p -0.3
+ 1752010p 0.9
+ 1754000p 0.9
+ 1754010p -0.3
+ 1756000p -0.3
+ 1756010p 0.9
+ 1758000p 0.9
+ 1758010p -0.3
+ 1760000p -0.3
+ 1760010p 0.9
+ 1762000p 0.9
+ 1762010p -0.3
+ 1764000p -0.3
+ 1764010p 0.9
+ 1766000p 0.9
+ 1766010p -0.3
+ 1768000p -0.3
+ 1768010p 0.9
+ 1770000p 0.9
+ 1770010p -0.3
+ 1772000p -0.3
+ 1772010p 0.9
+ 1774000p 0.9
+ 1774010p -0.3
+ 1776000p -0.3
+ 1776010p 0.9
+ 1778000p 0.9
+ 1778010p -0.3
+ 1780000p -0.3
+ 1780010p 0.9
+ 1782000p 0.9
+ 1782010p -0.3
+ 1784000p -0.3
+ 1784010p 0.9
+ 1786000p 0.9
+ 1786010p -0.3
+ 1788000p -0.3
+ 1788010p 0.9
+ 1790000p 0.9
+ 1790010p -0.3
+ 1792000p -0.3
+ 1792010p 0.9
+ 1794000p 0.9
+ 1794010p -0.3
+ 1796000p -0.3
+ 1796010p 0.9
+ 1798000p 0.9
+ 1798010p -0.3
+ 1800000p -0.3
+ 1800010p 0.9
+ 1802000p 0.9
+ 1802010p -0.3
+ 1804000p -0.3
+ 1804010p 0.9
+ 1806000p 0.9
+ 1806010p -0.3
+ 1808000p -0.3
+ 1808010p 0.9
+ 1810000p 0.9
+ 1810010p -0.3
+ 1812000p -0.3
+ 1812010p 0.9
+ 1814000p 0.9
+ 1814010p -0.3
+ 1816000p -0.3
+ 1816010p 0.9
+ 1818000p 0.9
+ 1818010p -0.3
+ 1820000p -0.3
+ 1820010p 0.9
+ 1822000p 0.9
+ 1822010p -0.3
+ 1824000p -0.3
+ 1824010p 0.9
+ 1826000p 0.9
+ 1826010p -0.3
+ 1828000p -0.3
+ 1828010p 0.9
+ 1830000p 0.9
+ 1830010p -0.3
+ 1832000p -0.3
+ 1832010p 0.9
+ 1834000p 0.9
+ 1834010p -0.3
+ 1836000p -0.3
+ 1836010p 0.9
+ 1838000p 0.9
+ 1838010p -0.3
+ 1840000p -0.3
+ 1840010p 0.9
+ 1842000p 0.9
+ 1842010p -0.3
+ 1844000p -0.3
+ 1844010p 0.9
+ 1846000p 0.9
+ 1846010p -0.3
+ 1848000p -0.3
+ 1848010p 0.9
+ 1850000p 0.9
+ 1850010p -0.3
+ 1852000p -0.3
+ 1852010p 0.9
+ 1854000p 0.9
+ 1854010p -0.3
+ 1856000p -0.3
+ 1856010p 0.9
+ 1858000p 0.9
+ 1858010p -0.3
+ 1860000p -0.3
+ 1860010p 0.9
+ 1862000p 0.9
+ 1862010p -0.3
+ 1864000p -0.3
+ 1864010p 0.9
+ 1866000p 0.9
+ 1866010p -0.3
+ 1868000p -0.3
+ 1868010p 0.9
+ 1870000p 0.9
+ 1870010p -0.3
+ 1872000p -0.3
+ 1872010p 0.9
+ 1874000p 0.9
+ 1874010p -0.3
+ 1876000p -0.3
+ 1876010p 0.9
+ 1878000p 0.9
+ 1878010p -0.3
+ 1880000p -0.3
+ 1880010p 0.9
+ 1882000p 0.9
+ 1882010p -0.3
+ 1884000p -0.3
+ 1884010p 0.9
+ 1886000p 0.9
+ 1886010p -0.3
+ 1888000p -0.3
+ 1888010p 0.9
+ 1890000p 0.9
+ 1890010p -0.3
+ 1892000p -0.3
+ 1892010p 0.9
+ 1894000p 0.9
+ 1894010p -0.3
+ 1896000p -0.3
+ 1896010p 0.9
+ 1898000p 0.9
+ 1898010p -0.3
+ 1900000p -0.3
+ 1900010p 0.9
+ 1902000p 0.9
+ 1902010p -0.3
+ 1904000p -0.3
+ 1904010p 0.9
+ 1906000p 0.9
+ 1906010p -0.3
+ 1908000p -0.3
+ 1908010p 0.9
+ 1910000p 0.9
+ 1910010p -0.3
+ 1912000p -0.3
+ 1912010p 0.9
+ 1914000p 0.9
+ 1914010p -0.3
+ 1916000p -0.3
+ 1916010p 0.9
+ 1918000p 0.9
+ 1918010p -0.3
+ 1920000p -0.3
+ 1920010p 0.9
+ 1922000p 0.9
+ 1922010p -0.3
+ 1924000p -0.3
+ 1924010p 0.9
+ 1926000p 0.9
+ 1926010p -0.3
+ 1928000p -0.3
+ 1928010p 0.9
+ 1930000p 0.9
+ 1930010p -0.3
+ 1932000p -0.3
+ 1932010p 0.9
+ 1934000p 0.9
+ 1934010p -0.3
+ 1936000p -0.3
+ 1936010p 0.9
+ 1938000p 0.9
+ 1938010p -0.3
+ 1940000p -0.3
+ 1940010p 0.9
+ 1942000p 0.9
+ 1942010p -0.3
+ 1944000p -0.3
+ 1944010p 0.9
+ 1946000p 0.9
+ 1946010p -0.3
+ 1948000p -0.3
+ 1948010p 0.9
+ 1950000p 0.9
+ 1950010p -0.3
+ 1952000p -0.3
+ 1952010p 0.9
+ 1954000p 0.9
+ 1954010p -0.3
+ 1956000p -0.3
+ 1956010p 0.9
+ 1958000p 0.9
+ 1958010p -0.3
+ 1960000p -0.3
+ 1960010p 0.9
+ 1962000p 0.9
+ 1962010p -0.3
+ 1964000p -0.3
+ 1964010p 0.9
+ 1966000p 0.9
+ 1966010p -0.3
+ 1968000p -0.3
+ 1968010p 0.9
+ 1970000p 0.9
+ 1970010p -0.3
+ 1972000p -0.3
+ 1972010p 0.9
+ 1974000p 0.9
+ 1974010p -0.3
+ 1976000p -0.3
+ 1976010p 0.9
+ 1978000p 0.9
+ 1978010p -0.3
+ 1980000p -0.3
+ 1980010p 0.9
+ 1982000p 0.9
+ 1982010p -0.3
+ 1984000p -0.3
+ 1984010p 0.9
+ 1986000p 0.9
+ 1986010p -0.3
+ 1988000p -0.3
+ 1988010p 0.9
+ 1990000p 0.9
+ 1990010p -0.3
+ 1992000p -0.3
+ 1992010p 0.9
+ 1994000p 0.9
+ 1994010p -0.3
+ 1996000p -0.3
+ 1996010p 0.9
+ 1998000p 0.9
+ 1998010p -0.3
+ 2000000p -0.3
+ 2000010p 0.9
+ 2002000p 0.9
+ 2002010p -0.3
+ 2004000p -0.3
+ 2004010p 0.9
+ 2006000p 0.9
+ 2006010p -0.3
+ 2008000p -0.3
+ 2008010p 0.9
+ 2010000p 0.9
+ 2010010p -0.3
+ 2012000p -0.3
+ 2012010p 0.9
+ 2014000p 0.9
+ 2014010p -0.3
+ 2016000p -0.3
+ 2016010p 0.9
+ 2018000p 0.9
+ 2018010p -0.3
+ 2020000p -0.3
+ 2020010p 0.9
+ 2022000p 0.9
+ 2022010p -0.3
+ 2024000p -0.3
+ 2024010p 0.9
+ 2026000p 0.9
+ 2026010p -0.3
+ 2028000p -0.3
+ 2028010p 0.9
+ 2030000p 0.9
+ 2030010p -0.3
+ 2032000p -0.3
+ 2032010p 0.9
+ 2034000p 0.9
+ 2034010p -0.3
+ 2036000p -0.3
+ 2036010p 0.9
+ 2038000p 0.9
+ 2038010p -0.3
+ 2040000p -0.3
+ 2040010p 0.9
+ 2042000p 0.9
+ 2042010p -0.3
+ 2044000p -0.3
+ 2044010p 0.9
+ 2046000p 0.9
+ 2046010p -0.3
+ 2048000p -0.3
+ 2048010p 0.9
+ \]
V_data_bar_4 (Data_bar\\<4\\> gnd!) vsource type=pwl wave=\[
+ 0    -0.3
+ 2000p -0.3
+ 2010p 0.9
+ 4000p 0.9
+ 4010p -0.3
+ 6000p -0.3
+ 6010p 0.9
+ 8000p 0.9
+ 8010p -0.3
+ 10000p -0.3
+ 10010p 0.9
+ 12000p 0.9
+ 12010p -0.3
+ 14000p -0.3
+ 14010p 0.9
+ 16000p 0.9
+ 16010p -0.3
+ 18000p -0.3
+ 18010p 0.9
+ 20000p 0.9
+ 20010p -0.3
+ 22000p -0.3
+ 22010p 0.9
+ 24000p 0.9
+ 24010p -0.3
+ 26000p -0.3
+ 26010p 0.9
+ 28000p 0.9
+ 28010p -0.3
+ 30000p -0.3
+ 30010p 0.9
+ 32000p 0.9
+ 32010p -0.3
+ 34000p -0.3
+ 34010p 0.9
+ 36000p 0.9
+ 36010p -0.3
+ 38000p -0.3
+ 38010p 0.9
+ 40000p 0.9
+ 40010p -0.3
+ 42000p -0.3
+ 42010p 0.9
+ 44000p 0.9
+ 44010p -0.3
+ 46000p -0.3
+ 46010p 0.9
+ 48000p 0.9
+ 48010p -0.3
+ 50000p -0.3
+ 50010p 0.9
+ 52000p 0.9
+ 52010p -0.3
+ 54000p -0.3
+ 54010p 0.9
+ 56000p 0.9
+ 56010p -0.3
+ 58000p -0.3
+ 58010p 0.9
+ 60000p 0.9
+ 60010p -0.3
+ 62000p -0.3
+ 62010p 0.9
+ 64000p 0.9
+ 64010p -0.3
+ 66000p -0.3
+ 66010p 0.9
+ 68000p 0.9
+ 68010p -0.3
+ 70000p -0.3
+ 70010p 0.9
+ 72000p 0.9
+ 72010p -0.3
+ 74000p -0.3
+ 74010p 0.9
+ 76000p 0.9
+ 76010p -0.3
+ 78000p -0.3
+ 78010p 0.9
+ 80000p 0.9
+ 80010p -0.3
+ 82000p -0.3
+ 82010p 0.9
+ 84000p 0.9
+ 84010p -0.3
+ 86000p -0.3
+ 86010p 0.9
+ 88000p 0.9
+ 88010p -0.3
+ 90000p -0.3
+ 90010p 0.9
+ 92000p 0.9
+ 92010p -0.3
+ 94000p -0.3
+ 94010p 0.9
+ 96000p 0.9
+ 96010p -0.3
+ 98000p -0.3
+ 98010p 0.9
+ 100000p 0.9
+ 100010p -0.3
+ 102000p -0.3
+ 102010p 0.9
+ 104000p 0.9
+ 104010p -0.3
+ 106000p -0.3
+ 106010p 0.9
+ 108000p 0.9
+ 108010p -0.3
+ 110000p -0.3
+ 110010p 0.9
+ 112000p 0.9
+ 112010p -0.3
+ 114000p -0.3
+ 114010p 0.9
+ 116000p 0.9
+ 116010p -0.3
+ 118000p -0.3
+ 118010p 0.9
+ 120000p 0.9
+ 120010p -0.3
+ 122000p -0.3
+ 122010p 0.9
+ 124000p 0.9
+ 124010p -0.3
+ 126000p -0.3
+ 126010p 0.9
+ 128000p 0.9
+ 128010p -0.3
+ 130000p -0.3
+ 130010p 0.9
+ 132000p 0.9
+ 132010p -0.3
+ 134000p -0.3
+ 134010p 0.9
+ 136000p 0.9
+ 136010p -0.3
+ 138000p -0.3
+ 138010p 0.9
+ 140000p 0.9
+ 140010p -0.3
+ 142000p -0.3
+ 142010p 0.9
+ 144000p 0.9
+ 144010p -0.3
+ 146000p -0.3
+ 146010p 0.9
+ 148000p 0.9
+ 148010p -0.3
+ 150000p -0.3
+ 150010p 0.9
+ 152000p 0.9
+ 152010p -0.3
+ 154000p -0.3
+ 154010p 0.9
+ 156000p 0.9
+ 156010p -0.3
+ 158000p -0.3
+ 158010p 0.9
+ 160000p 0.9
+ 160010p -0.3
+ 162000p -0.3
+ 162010p 0.9
+ 164000p 0.9
+ 164010p -0.3
+ 166000p -0.3
+ 166010p 0.9
+ 168000p 0.9
+ 168010p -0.3
+ 170000p -0.3
+ 170010p 0.9
+ 172000p 0.9
+ 172010p -0.3
+ 174000p -0.3
+ 174010p 0.9
+ 176000p 0.9
+ 176010p -0.3
+ 178000p -0.3
+ 178010p 0.9
+ 180000p 0.9
+ 180010p -0.3
+ 182000p -0.3
+ 182010p 0.9
+ 184000p 0.9
+ 184010p -0.3
+ 186000p -0.3
+ 186010p 0.9
+ 188000p 0.9
+ 188010p -0.3
+ 190000p -0.3
+ 190010p 0.9
+ 192000p 0.9
+ 192010p -0.3
+ 194000p -0.3
+ 194010p 0.9
+ 196000p 0.9
+ 196010p -0.3
+ 198000p -0.3
+ 198010p 0.9
+ 200000p 0.9
+ 200010p -0.3
+ 202000p -0.3
+ 202010p 0.9
+ 204000p 0.9
+ 204010p -0.3
+ 206000p -0.3
+ 206010p 0.9
+ 208000p 0.9
+ 208010p -0.3
+ 210000p -0.3
+ 210010p 0.9
+ 212000p 0.9
+ 212010p -0.3
+ 214000p -0.3
+ 214010p 0.9
+ 216000p 0.9
+ 216010p -0.3
+ 218000p -0.3
+ 218010p 0.9
+ 220000p 0.9
+ 220010p -0.3
+ 222000p -0.3
+ 222010p 0.9
+ 224000p 0.9
+ 224010p -0.3
+ 226000p -0.3
+ 226010p 0.9
+ 228000p 0.9
+ 228010p -0.3
+ 230000p -0.3
+ 230010p 0.9
+ 232000p 0.9
+ 232010p -0.3
+ 234000p -0.3
+ 234010p 0.9
+ 236000p 0.9
+ 236010p -0.3
+ 238000p -0.3
+ 238010p 0.9
+ 240000p 0.9
+ 240010p -0.3
+ 242000p -0.3
+ 242010p 0.9
+ 244000p 0.9
+ 244010p -0.3
+ 246000p -0.3
+ 246010p 0.9
+ 248000p 0.9
+ 248010p -0.3
+ 250000p -0.3
+ 250010p 0.9
+ 252000p 0.9
+ 252010p -0.3
+ 254000p -0.3
+ 254010p 0.9
+ 256000p 0.9
+ 256010p -0.3
+ 258000p -0.3
+ 258010p 0.9
+ 260000p 0.9
+ 260010p -0.3
+ 262000p -0.3
+ 262010p 0.9
+ 264000p 0.9
+ 264010p -0.3
+ 266000p -0.3
+ 266010p 0.9
+ 268000p 0.9
+ 268010p -0.3
+ 270000p -0.3
+ 270010p 0.9
+ 272000p 0.9
+ 272010p -0.3
+ 274000p -0.3
+ 274010p 0.9
+ 276000p 0.9
+ 276010p -0.3
+ 278000p -0.3
+ 278010p 0.9
+ 280000p 0.9
+ 280010p -0.3
+ 282000p -0.3
+ 282010p 0.9
+ 284000p 0.9
+ 284010p -0.3
+ 286000p -0.3
+ 286010p 0.9
+ 288000p 0.9
+ 288010p -0.3
+ 290000p -0.3
+ 290010p 0.9
+ 292000p 0.9
+ 292010p -0.3
+ 294000p -0.3
+ 294010p 0.9
+ 296000p 0.9
+ 296010p -0.3
+ 298000p -0.3
+ 298010p 0.9
+ 300000p 0.9
+ 300010p -0.3
+ 302000p -0.3
+ 302010p 0.9
+ 304000p 0.9
+ 304010p -0.3
+ 306000p -0.3
+ 306010p 0.9
+ 308000p 0.9
+ 308010p -0.3
+ 310000p -0.3
+ 310010p 0.9
+ 312000p 0.9
+ 312010p -0.3
+ 314000p -0.3
+ 314010p 0.9
+ 316000p 0.9
+ 316010p -0.3
+ 318000p -0.3
+ 318010p 0.9
+ 320000p 0.9
+ 320010p -0.3
+ 322000p -0.3
+ 322010p 0.9
+ 324000p 0.9
+ 324010p -0.3
+ 326000p -0.3
+ 326010p 0.9
+ 328000p 0.9
+ 328010p -0.3
+ 330000p -0.3
+ 330010p 0.9
+ 332000p 0.9
+ 332010p -0.3
+ 334000p -0.3
+ 334010p 0.9
+ 336000p 0.9
+ 336010p -0.3
+ 338000p -0.3
+ 338010p 0.9
+ 340000p 0.9
+ 340010p -0.3
+ 342000p -0.3
+ 342010p 0.9
+ 344000p 0.9
+ 344010p -0.3
+ 346000p -0.3
+ 346010p 0.9
+ 348000p 0.9
+ 348010p -0.3
+ 350000p -0.3
+ 350010p 0.9
+ 352000p 0.9
+ 352010p -0.3
+ 354000p -0.3
+ 354010p 0.9
+ 356000p 0.9
+ 356010p -0.3
+ 358000p -0.3
+ 358010p 0.9
+ 360000p 0.9
+ 360010p -0.3
+ 362000p -0.3
+ 362010p 0.9
+ 364000p 0.9
+ 364010p -0.3
+ 366000p -0.3
+ 366010p 0.9
+ 368000p 0.9
+ 368010p -0.3
+ 370000p -0.3
+ 370010p 0.9
+ 372000p 0.9
+ 372010p -0.3
+ 374000p -0.3
+ 374010p 0.9
+ 376000p 0.9
+ 376010p -0.3
+ 378000p -0.3
+ 378010p 0.9
+ 380000p 0.9
+ 380010p -0.3
+ 382000p -0.3
+ 382010p 0.9
+ 384000p 0.9
+ 384010p -0.3
+ 386000p -0.3
+ 386010p 0.9
+ 388000p 0.9
+ 388010p -0.3
+ 390000p -0.3
+ 390010p 0.9
+ 392000p 0.9
+ 392010p -0.3
+ 394000p -0.3
+ 394010p 0.9
+ 396000p 0.9
+ 396010p -0.3
+ 398000p -0.3
+ 398010p 0.9
+ 400000p 0.9
+ 400010p -0.3
+ 402000p -0.3
+ 402010p 0.9
+ 404000p 0.9
+ 404010p -0.3
+ 406000p -0.3
+ 406010p 0.9
+ 408000p 0.9
+ 408010p -0.3
+ 410000p -0.3
+ 410010p 0.9
+ 412000p 0.9
+ 412010p -0.3
+ 414000p -0.3
+ 414010p 0.9
+ 416000p 0.9
+ 416010p -0.3
+ 418000p -0.3
+ 418010p 0.9
+ 420000p 0.9
+ 420010p -0.3
+ 422000p -0.3
+ 422010p 0.9
+ 424000p 0.9
+ 424010p -0.3
+ 426000p -0.3
+ 426010p 0.9
+ 428000p 0.9
+ 428010p -0.3
+ 430000p -0.3
+ 430010p 0.9
+ 432000p 0.9
+ 432010p -0.3
+ 434000p -0.3
+ 434010p 0.9
+ 436000p 0.9
+ 436010p -0.3
+ 438000p -0.3
+ 438010p 0.9
+ 440000p 0.9
+ 440010p -0.3
+ 442000p -0.3
+ 442010p 0.9
+ 444000p 0.9
+ 444010p -0.3
+ 446000p -0.3
+ 446010p 0.9
+ 448000p 0.9
+ 448010p -0.3
+ 450000p -0.3
+ 450010p 0.9
+ 452000p 0.9
+ 452010p -0.3
+ 454000p -0.3
+ 454010p 0.9
+ 456000p 0.9
+ 456010p -0.3
+ 458000p -0.3
+ 458010p 0.9
+ 460000p 0.9
+ 460010p -0.3
+ 462000p -0.3
+ 462010p 0.9
+ 464000p 0.9
+ 464010p -0.3
+ 466000p -0.3
+ 466010p 0.9
+ 468000p 0.9
+ 468010p -0.3
+ 470000p -0.3
+ 470010p 0.9
+ 472000p 0.9
+ 472010p -0.3
+ 474000p -0.3
+ 474010p 0.9
+ 476000p 0.9
+ 476010p -0.3
+ 478000p -0.3
+ 478010p 0.9
+ 480000p 0.9
+ 480010p -0.3
+ 482000p -0.3
+ 482010p 0.9
+ 484000p 0.9
+ 484010p -0.3
+ 486000p -0.3
+ 486010p 0.9
+ 488000p 0.9
+ 488010p -0.3
+ 490000p -0.3
+ 490010p 0.9
+ 492000p 0.9
+ 492010p -0.3
+ 494000p -0.3
+ 494010p 0.9
+ 496000p 0.9
+ 496010p -0.3
+ 498000p -0.3
+ 498010p 0.9
+ 500000p 0.9
+ 500010p -0.3
+ 502000p -0.3
+ 502010p 0.9
+ 504000p 0.9
+ 504010p -0.3
+ 506000p -0.3
+ 506010p 0.9
+ 508000p 0.9
+ 508010p -0.3
+ 510000p -0.3
+ 510010p 0.9
+ 512000p 0.9
+ 512010p -0.3
+ 514000p -0.3
+ 514010p 0.9
+ 516000p 0.9
+ 516010p -0.3
+ 518000p -0.3
+ 518010p 0.9
+ 520000p 0.9
+ 520010p -0.3
+ 522000p -0.3
+ 522010p 0.9
+ 524000p 0.9
+ 524010p -0.3
+ 526000p -0.3
+ 526010p 0.9
+ 528000p 0.9
+ 528010p -0.3
+ 530000p -0.3
+ 530010p 0.9
+ 532000p 0.9
+ 532010p -0.3
+ 534000p -0.3
+ 534010p 0.9
+ 536000p 0.9
+ 536010p -0.3
+ 538000p -0.3
+ 538010p 0.9
+ 540000p 0.9
+ 540010p -0.3
+ 542000p -0.3
+ 542010p 0.9
+ 544000p 0.9
+ 544010p -0.3
+ 546000p -0.3
+ 546010p 0.9
+ 548000p 0.9
+ 548010p -0.3
+ 550000p -0.3
+ 550010p 0.9
+ 552000p 0.9
+ 552010p -0.3
+ 554000p -0.3
+ 554010p 0.9
+ 556000p 0.9
+ 556010p -0.3
+ 558000p -0.3
+ 558010p 0.9
+ 560000p 0.9
+ 560010p -0.3
+ 562000p -0.3
+ 562010p 0.9
+ 564000p 0.9
+ 564010p -0.3
+ 566000p -0.3
+ 566010p 0.9
+ 568000p 0.9
+ 568010p -0.3
+ 570000p -0.3
+ 570010p 0.9
+ 572000p 0.9
+ 572010p -0.3
+ 574000p -0.3
+ 574010p 0.9
+ 576000p 0.9
+ 576010p -0.3
+ 578000p -0.3
+ 578010p 0.9
+ 580000p 0.9
+ 580010p -0.3
+ 582000p -0.3
+ 582010p 0.9
+ 584000p 0.9
+ 584010p -0.3
+ 586000p -0.3
+ 586010p 0.9
+ 588000p 0.9
+ 588010p -0.3
+ 590000p -0.3
+ 590010p 0.9
+ 592000p 0.9
+ 592010p -0.3
+ 594000p -0.3
+ 594010p 0.9
+ 596000p 0.9
+ 596010p -0.3
+ 598000p -0.3
+ 598010p 0.9
+ 600000p 0.9
+ 600010p -0.3
+ 602000p -0.3
+ 602010p 0.9
+ 604000p 0.9
+ 604010p -0.3
+ 606000p -0.3
+ 606010p 0.9
+ 608000p 0.9
+ 608010p -0.3
+ 610000p -0.3
+ 610010p 0.9
+ 612000p 0.9
+ 612010p -0.3
+ 614000p -0.3
+ 614010p 0.9
+ 616000p 0.9
+ 616010p -0.3
+ 618000p -0.3
+ 618010p 0.9
+ 620000p 0.9
+ 620010p -0.3
+ 622000p -0.3
+ 622010p 0.9
+ 624000p 0.9
+ 624010p -0.3
+ 626000p -0.3
+ 626010p 0.9
+ 628000p 0.9
+ 628010p -0.3
+ 630000p -0.3
+ 630010p 0.9
+ 632000p 0.9
+ 632010p -0.3
+ 634000p -0.3
+ 634010p 0.9
+ 636000p 0.9
+ 636010p -0.3
+ 638000p -0.3
+ 638010p 0.9
+ 640000p 0.9
+ 640010p -0.3
+ 642000p -0.3
+ 642010p 0.9
+ 644000p 0.9
+ 644010p -0.3
+ 646000p -0.3
+ 646010p 0.9
+ 648000p 0.9
+ 648010p -0.3
+ 650000p -0.3
+ 650010p 0.9
+ 652000p 0.9
+ 652010p -0.3
+ 654000p -0.3
+ 654010p 0.9
+ 656000p 0.9
+ 656010p -0.3
+ 658000p -0.3
+ 658010p 0.9
+ 660000p 0.9
+ 660010p -0.3
+ 662000p -0.3
+ 662010p 0.9
+ 664000p 0.9
+ 664010p -0.3
+ 666000p -0.3
+ 666010p 0.9
+ 668000p 0.9
+ 668010p -0.3
+ 670000p -0.3
+ 670010p 0.9
+ 672000p 0.9
+ 672010p -0.3
+ 674000p -0.3
+ 674010p 0.9
+ 676000p 0.9
+ 676010p -0.3
+ 678000p -0.3
+ 678010p 0.9
+ 680000p 0.9
+ 680010p -0.3
+ 682000p -0.3
+ 682010p 0.9
+ 684000p 0.9
+ 684010p -0.3
+ 686000p -0.3
+ 686010p 0.9
+ 688000p 0.9
+ 688010p -0.3
+ 690000p -0.3
+ 690010p 0.9
+ 692000p 0.9
+ 692010p -0.3
+ 694000p -0.3
+ 694010p 0.9
+ 696000p 0.9
+ 696010p -0.3
+ 698000p -0.3
+ 698010p 0.9
+ 700000p 0.9
+ 700010p -0.3
+ 702000p -0.3
+ 702010p 0.9
+ 704000p 0.9
+ 704010p -0.3
+ 706000p -0.3
+ 706010p 0.9
+ 708000p 0.9
+ 708010p -0.3
+ 710000p -0.3
+ 710010p 0.9
+ 712000p 0.9
+ 712010p -0.3
+ 714000p -0.3
+ 714010p 0.9
+ 716000p 0.9
+ 716010p -0.3
+ 718000p -0.3
+ 718010p 0.9
+ 720000p 0.9
+ 720010p -0.3
+ 722000p -0.3
+ 722010p 0.9
+ 724000p 0.9
+ 724010p -0.3
+ 726000p -0.3
+ 726010p 0.9
+ 728000p 0.9
+ 728010p -0.3
+ 730000p -0.3
+ 730010p 0.9
+ 732000p 0.9
+ 732010p -0.3
+ 734000p -0.3
+ 734010p 0.9
+ 736000p 0.9
+ 736010p -0.3
+ 738000p -0.3
+ 738010p 0.9
+ 740000p 0.9
+ 740010p -0.3
+ 742000p -0.3
+ 742010p 0.9
+ 744000p 0.9
+ 744010p -0.3
+ 746000p -0.3
+ 746010p 0.9
+ 748000p 0.9
+ 748010p -0.3
+ 750000p -0.3
+ 750010p 0.9
+ 752000p 0.9
+ 752010p -0.3
+ 754000p -0.3
+ 754010p 0.9
+ 756000p 0.9
+ 756010p -0.3
+ 758000p -0.3
+ 758010p 0.9
+ 760000p 0.9
+ 760010p -0.3
+ 762000p -0.3
+ 762010p 0.9
+ 764000p 0.9
+ 764010p -0.3
+ 766000p -0.3
+ 766010p 0.9
+ 768000p 0.9
+ 768010p -0.3
+ 770000p -0.3
+ 770010p 0.9
+ 772000p 0.9
+ 772010p -0.3
+ 774000p -0.3
+ 774010p 0.9
+ 776000p 0.9
+ 776010p -0.3
+ 778000p -0.3
+ 778010p 0.9
+ 780000p 0.9
+ 780010p -0.3
+ 782000p -0.3
+ 782010p 0.9
+ 784000p 0.9
+ 784010p -0.3
+ 786000p -0.3
+ 786010p 0.9
+ 788000p 0.9
+ 788010p -0.3
+ 790000p -0.3
+ 790010p 0.9
+ 792000p 0.9
+ 792010p -0.3
+ 794000p -0.3
+ 794010p 0.9
+ 796000p 0.9
+ 796010p -0.3
+ 798000p -0.3
+ 798010p 0.9
+ 800000p 0.9
+ 800010p -0.3
+ 802000p -0.3
+ 802010p 0.9
+ 804000p 0.9
+ 804010p -0.3
+ 806000p -0.3
+ 806010p 0.9
+ 808000p 0.9
+ 808010p -0.3
+ 810000p -0.3
+ 810010p 0.9
+ 812000p 0.9
+ 812010p -0.3
+ 814000p -0.3
+ 814010p 0.9
+ 816000p 0.9
+ 816010p -0.3
+ 818000p -0.3
+ 818010p 0.9
+ 820000p 0.9
+ 820010p -0.3
+ 822000p -0.3
+ 822010p 0.9
+ 824000p 0.9
+ 824010p -0.3
+ 826000p -0.3
+ 826010p 0.9
+ 828000p 0.9
+ 828010p -0.3
+ 830000p -0.3
+ 830010p 0.9
+ 832000p 0.9
+ 832010p -0.3
+ 834000p -0.3
+ 834010p 0.9
+ 836000p 0.9
+ 836010p -0.3
+ 838000p -0.3
+ 838010p 0.9
+ 840000p 0.9
+ 840010p -0.3
+ 842000p -0.3
+ 842010p 0.9
+ 844000p 0.9
+ 844010p -0.3
+ 846000p -0.3
+ 846010p 0.9
+ 848000p 0.9
+ 848010p -0.3
+ 850000p -0.3
+ 850010p 0.9
+ 852000p 0.9
+ 852010p -0.3
+ 854000p -0.3
+ 854010p 0.9
+ 856000p 0.9
+ 856010p -0.3
+ 858000p -0.3
+ 858010p 0.9
+ 860000p 0.9
+ 860010p -0.3
+ 862000p -0.3
+ 862010p 0.9
+ 864000p 0.9
+ 864010p -0.3
+ 866000p -0.3
+ 866010p 0.9
+ 868000p 0.9
+ 868010p -0.3
+ 870000p -0.3
+ 870010p 0.9
+ 872000p 0.9
+ 872010p -0.3
+ 874000p -0.3
+ 874010p 0.9
+ 876000p 0.9
+ 876010p -0.3
+ 878000p -0.3
+ 878010p 0.9
+ 880000p 0.9
+ 880010p -0.3
+ 882000p -0.3
+ 882010p 0.9
+ 884000p 0.9
+ 884010p -0.3
+ 886000p -0.3
+ 886010p 0.9
+ 888000p 0.9
+ 888010p -0.3
+ 890000p -0.3
+ 890010p 0.9
+ 892000p 0.9
+ 892010p -0.3
+ 894000p -0.3
+ 894010p 0.9
+ 896000p 0.9
+ 896010p -0.3
+ 898000p -0.3
+ 898010p 0.9
+ 900000p 0.9
+ 900010p -0.3
+ 902000p -0.3
+ 902010p 0.9
+ 904000p 0.9
+ 904010p -0.3
+ 906000p -0.3
+ 906010p 0.9
+ 908000p 0.9
+ 908010p -0.3
+ 910000p -0.3
+ 910010p 0.9
+ 912000p 0.9
+ 912010p -0.3
+ 914000p -0.3
+ 914010p 0.9
+ 916000p 0.9
+ 916010p -0.3
+ 918000p -0.3
+ 918010p 0.9
+ 920000p 0.9
+ 920010p -0.3
+ 922000p -0.3
+ 922010p 0.9
+ 924000p 0.9
+ 924010p -0.3
+ 926000p -0.3
+ 926010p 0.9
+ 928000p 0.9
+ 928010p -0.3
+ 930000p -0.3
+ 930010p 0.9
+ 932000p 0.9
+ 932010p -0.3
+ 934000p -0.3
+ 934010p 0.9
+ 936000p 0.9
+ 936010p -0.3
+ 938000p -0.3
+ 938010p 0.9
+ 940000p 0.9
+ 940010p -0.3
+ 942000p -0.3
+ 942010p 0.9
+ 944000p 0.9
+ 944010p -0.3
+ 946000p -0.3
+ 946010p 0.9
+ 948000p 0.9
+ 948010p -0.3
+ 950000p -0.3
+ 950010p 0.9
+ 952000p 0.9
+ 952010p -0.3
+ 954000p -0.3
+ 954010p 0.9
+ 956000p 0.9
+ 956010p -0.3
+ 958000p -0.3
+ 958010p 0.9
+ 960000p 0.9
+ 960010p -0.3
+ 962000p -0.3
+ 962010p 0.9
+ 964000p 0.9
+ 964010p -0.3
+ 966000p -0.3
+ 966010p 0.9
+ 968000p 0.9
+ 968010p -0.3
+ 970000p -0.3
+ 970010p 0.9
+ 972000p 0.9
+ 972010p -0.3
+ 974000p -0.3
+ 974010p 0.9
+ 976000p 0.9
+ 976010p -0.3
+ 978000p -0.3
+ 978010p 0.9
+ 980000p 0.9
+ 980010p -0.3
+ 982000p -0.3
+ 982010p 0.9
+ 984000p 0.9
+ 984010p -0.3
+ 986000p -0.3
+ 986010p 0.9
+ 988000p 0.9
+ 988010p -0.3
+ 990000p -0.3
+ 990010p 0.9
+ 992000p 0.9
+ 992010p -0.3
+ 994000p -0.3
+ 994010p 0.9
+ 996000p 0.9
+ 996010p -0.3
+ 998000p -0.3
+ 998010p 0.9
+ 1000000p 0.9
+ 1000010p -0.3
+ 1002000p -0.3
+ 1002010p 0.9
+ 1004000p 0.9
+ 1004010p -0.3
+ 1006000p -0.3
+ 1006010p 0.9
+ 1008000p 0.9
+ 1008010p -0.3
+ 1010000p -0.3
+ 1010010p 0.9
+ 1012000p 0.9
+ 1012010p -0.3
+ 1014000p -0.3
+ 1014010p 0.9
+ 1016000p 0.9
+ 1016010p -0.3
+ 1018000p -0.3
+ 1018010p 0.9
+ 1020000p 0.9
+ 1020010p -0.3
+ 1022000p -0.3
+ 1022010p 0.9
+ 1024000p 0.9
+ 1024010p -0.3
+ 1026000p -0.3
+ 1026010p 0.9
+ 1028000p 0.9
+ 1028010p -0.3
+ 1030000p -0.3
+ 1030010p 0.9
+ 1032000p 0.9
+ 1032010p -0.3
+ 1034000p -0.3
+ 1034010p 0.9
+ 1036000p 0.9
+ 1036010p -0.3
+ 1038000p -0.3
+ 1038010p 0.9
+ 1040000p 0.9
+ 1040010p -0.3
+ 1042000p -0.3
+ 1042010p 0.9
+ 1044000p 0.9
+ 1044010p -0.3
+ 1046000p -0.3
+ 1046010p 0.9
+ 1048000p 0.9
+ 1048010p -0.3
+ 1050000p -0.3
+ 1050010p 0.9
+ 1052000p 0.9
+ 1052010p -0.3
+ 1054000p -0.3
+ 1054010p 0.9
+ 1056000p 0.9
+ 1056010p -0.3
+ 1058000p -0.3
+ 1058010p 0.9
+ 1060000p 0.9
+ 1060010p -0.3
+ 1062000p -0.3
+ 1062010p 0.9
+ 1064000p 0.9
+ 1064010p -0.3
+ 1066000p -0.3
+ 1066010p 0.9
+ 1068000p 0.9
+ 1068010p -0.3
+ 1070000p -0.3
+ 1070010p 0.9
+ 1072000p 0.9
+ 1072010p -0.3
+ 1074000p -0.3
+ 1074010p 0.9
+ 1076000p 0.9
+ 1076010p -0.3
+ 1078000p -0.3
+ 1078010p 0.9
+ 1080000p 0.9
+ 1080010p -0.3
+ 1082000p -0.3
+ 1082010p 0.9
+ 1084000p 0.9
+ 1084010p -0.3
+ 1086000p -0.3
+ 1086010p 0.9
+ 1088000p 0.9
+ 1088010p -0.3
+ 1090000p -0.3
+ 1090010p 0.9
+ 1092000p 0.9
+ 1092010p -0.3
+ 1094000p -0.3
+ 1094010p 0.9
+ 1096000p 0.9
+ 1096010p -0.3
+ 1098000p -0.3
+ 1098010p 0.9
+ 1100000p 0.9
+ 1100010p -0.3
+ 1102000p -0.3
+ 1102010p 0.9
+ 1104000p 0.9
+ 1104010p -0.3
+ 1106000p -0.3
+ 1106010p 0.9
+ 1108000p 0.9
+ 1108010p -0.3
+ 1110000p -0.3
+ 1110010p 0.9
+ 1112000p 0.9
+ 1112010p -0.3
+ 1114000p -0.3
+ 1114010p 0.9
+ 1116000p 0.9
+ 1116010p -0.3
+ 1118000p -0.3
+ 1118010p 0.9
+ 1120000p 0.9
+ 1120010p -0.3
+ 1122000p -0.3
+ 1122010p 0.9
+ 1124000p 0.9
+ 1124010p -0.3
+ 1126000p -0.3
+ 1126010p 0.9
+ 1128000p 0.9
+ 1128010p -0.3
+ 1130000p -0.3
+ 1130010p 0.9
+ 1132000p 0.9
+ 1132010p -0.3
+ 1134000p -0.3
+ 1134010p 0.9
+ 1136000p 0.9
+ 1136010p -0.3
+ 1138000p -0.3
+ 1138010p 0.9
+ 1140000p 0.9
+ 1140010p -0.3
+ 1142000p -0.3
+ 1142010p 0.9
+ 1144000p 0.9
+ 1144010p -0.3
+ 1146000p -0.3
+ 1146010p 0.9
+ 1148000p 0.9
+ 1148010p -0.3
+ 1150000p -0.3
+ 1150010p 0.9
+ 1152000p 0.9
+ 1152010p -0.3
+ 1154000p -0.3
+ 1154010p 0.9
+ 1156000p 0.9
+ 1156010p -0.3
+ 1158000p -0.3
+ 1158010p 0.9
+ 1160000p 0.9
+ 1160010p -0.3
+ 1162000p -0.3
+ 1162010p 0.9
+ 1164000p 0.9
+ 1164010p -0.3
+ 1166000p -0.3
+ 1166010p 0.9
+ 1168000p 0.9
+ 1168010p -0.3
+ 1170000p -0.3
+ 1170010p 0.9
+ 1172000p 0.9
+ 1172010p -0.3
+ 1174000p -0.3
+ 1174010p 0.9
+ 1176000p 0.9
+ 1176010p -0.3
+ 1178000p -0.3
+ 1178010p 0.9
+ 1180000p 0.9
+ 1180010p -0.3
+ 1182000p -0.3
+ 1182010p 0.9
+ 1184000p 0.9
+ 1184010p -0.3
+ 1186000p -0.3
+ 1186010p 0.9
+ 1188000p 0.9
+ 1188010p -0.3
+ 1190000p -0.3
+ 1190010p 0.9
+ 1192000p 0.9
+ 1192010p -0.3
+ 1194000p -0.3
+ 1194010p 0.9
+ 1196000p 0.9
+ 1196010p -0.3
+ 1198000p -0.3
+ 1198010p 0.9
+ 1200000p 0.9
+ 1200010p -0.3
+ 1202000p -0.3
+ 1202010p 0.9
+ 1204000p 0.9
+ 1204010p -0.3
+ 1206000p -0.3
+ 1206010p 0.9
+ 1208000p 0.9
+ 1208010p -0.3
+ 1210000p -0.3
+ 1210010p 0.9
+ 1212000p 0.9
+ 1212010p -0.3
+ 1214000p -0.3
+ 1214010p 0.9
+ 1216000p 0.9
+ 1216010p -0.3
+ 1218000p -0.3
+ 1218010p 0.9
+ 1220000p 0.9
+ 1220010p -0.3
+ 1222000p -0.3
+ 1222010p 0.9
+ 1224000p 0.9
+ 1224010p -0.3
+ 1226000p -0.3
+ 1226010p 0.9
+ 1228000p 0.9
+ 1228010p -0.3
+ 1230000p -0.3
+ 1230010p 0.9
+ 1232000p 0.9
+ 1232010p -0.3
+ 1234000p -0.3
+ 1234010p 0.9
+ 1236000p 0.9
+ 1236010p -0.3
+ 1238000p -0.3
+ 1238010p 0.9
+ 1240000p 0.9
+ 1240010p -0.3
+ 1242000p -0.3
+ 1242010p 0.9
+ 1244000p 0.9
+ 1244010p -0.3
+ 1246000p -0.3
+ 1246010p 0.9
+ 1248000p 0.9
+ 1248010p -0.3
+ 1250000p -0.3
+ 1250010p 0.9
+ 1252000p 0.9
+ 1252010p -0.3
+ 1254000p -0.3
+ 1254010p 0.9
+ 1256000p 0.9
+ 1256010p -0.3
+ 1258000p -0.3
+ 1258010p 0.9
+ 1260000p 0.9
+ 1260010p -0.3
+ 1262000p -0.3
+ 1262010p 0.9
+ 1264000p 0.9
+ 1264010p -0.3
+ 1266000p -0.3
+ 1266010p 0.9
+ 1268000p 0.9
+ 1268010p -0.3
+ 1270000p -0.3
+ 1270010p 0.9
+ 1272000p 0.9
+ 1272010p -0.3
+ 1274000p -0.3
+ 1274010p 0.9
+ 1276000p 0.9
+ 1276010p -0.3
+ 1278000p -0.3
+ 1278010p 0.9
+ 1280000p 0.9
+ 1280010p -0.3
+ 1282000p -0.3
+ 1282010p 0.9
+ 1284000p 0.9
+ 1284010p -0.3
+ 1286000p -0.3
+ 1286010p 0.9
+ 1288000p 0.9
+ 1288010p -0.3
+ 1290000p -0.3
+ 1290010p 0.9
+ 1292000p 0.9
+ 1292010p -0.3
+ 1294000p -0.3
+ 1294010p 0.9
+ 1296000p 0.9
+ 1296010p -0.3
+ 1298000p -0.3
+ 1298010p 0.9
+ 1300000p 0.9
+ 1300010p -0.3
+ 1302000p -0.3
+ 1302010p 0.9
+ 1304000p 0.9
+ 1304010p -0.3
+ 1306000p -0.3
+ 1306010p 0.9
+ 1308000p 0.9
+ 1308010p -0.3
+ 1310000p -0.3
+ 1310010p 0.9
+ 1312000p 0.9
+ 1312010p -0.3
+ 1314000p -0.3
+ 1314010p 0.9
+ 1316000p 0.9
+ 1316010p -0.3
+ 1318000p -0.3
+ 1318010p 0.9
+ 1320000p 0.9
+ 1320010p -0.3
+ 1322000p -0.3
+ 1322010p 0.9
+ 1324000p 0.9
+ 1324010p -0.3
+ 1326000p -0.3
+ 1326010p 0.9
+ 1328000p 0.9
+ 1328010p -0.3
+ 1330000p -0.3
+ 1330010p 0.9
+ 1332000p 0.9
+ 1332010p -0.3
+ 1334000p -0.3
+ 1334010p 0.9
+ 1336000p 0.9
+ 1336010p -0.3
+ 1338000p -0.3
+ 1338010p 0.9
+ 1340000p 0.9
+ 1340010p -0.3
+ 1342000p -0.3
+ 1342010p 0.9
+ 1344000p 0.9
+ 1344010p -0.3
+ 1346000p -0.3
+ 1346010p 0.9
+ 1348000p 0.9
+ 1348010p -0.3
+ 1350000p -0.3
+ 1350010p 0.9
+ 1352000p 0.9
+ 1352010p -0.3
+ 1354000p -0.3
+ 1354010p 0.9
+ 1356000p 0.9
+ 1356010p -0.3
+ 1358000p -0.3
+ 1358010p 0.9
+ 1360000p 0.9
+ 1360010p -0.3
+ 1362000p -0.3
+ 1362010p 0.9
+ 1364000p 0.9
+ 1364010p -0.3
+ 1366000p -0.3
+ 1366010p 0.9
+ 1368000p 0.9
+ 1368010p -0.3
+ 1370000p -0.3
+ 1370010p 0.9
+ 1372000p 0.9
+ 1372010p -0.3
+ 1374000p -0.3
+ 1374010p 0.9
+ 1376000p 0.9
+ 1376010p -0.3
+ 1378000p -0.3
+ 1378010p 0.9
+ 1380000p 0.9
+ 1380010p -0.3
+ 1382000p -0.3
+ 1382010p 0.9
+ 1384000p 0.9
+ 1384010p -0.3
+ 1386000p -0.3
+ 1386010p 0.9
+ 1388000p 0.9
+ 1388010p -0.3
+ 1390000p -0.3
+ 1390010p 0.9
+ 1392000p 0.9
+ 1392010p -0.3
+ 1394000p -0.3
+ 1394010p 0.9
+ 1396000p 0.9
+ 1396010p -0.3
+ 1398000p -0.3
+ 1398010p 0.9
+ 1400000p 0.9
+ 1400010p -0.3
+ 1402000p -0.3
+ 1402010p 0.9
+ 1404000p 0.9
+ 1404010p -0.3
+ 1406000p -0.3
+ 1406010p 0.9
+ 1408000p 0.9
+ 1408010p -0.3
+ 1410000p -0.3
+ 1410010p 0.9
+ 1412000p 0.9
+ 1412010p -0.3
+ 1414000p -0.3
+ 1414010p 0.9
+ 1416000p 0.9
+ 1416010p -0.3
+ 1418000p -0.3
+ 1418010p 0.9
+ 1420000p 0.9
+ 1420010p -0.3
+ 1422000p -0.3
+ 1422010p 0.9
+ 1424000p 0.9
+ 1424010p -0.3
+ 1426000p -0.3
+ 1426010p 0.9
+ 1428000p 0.9
+ 1428010p -0.3
+ 1430000p -0.3
+ 1430010p 0.9
+ 1432000p 0.9
+ 1432010p -0.3
+ 1434000p -0.3
+ 1434010p 0.9
+ 1436000p 0.9
+ 1436010p -0.3
+ 1438000p -0.3
+ 1438010p 0.9
+ 1440000p 0.9
+ 1440010p -0.3
+ 1442000p -0.3
+ 1442010p 0.9
+ 1444000p 0.9
+ 1444010p -0.3
+ 1446000p -0.3
+ 1446010p 0.9
+ 1448000p 0.9
+ 1448010p -0.3
+ 1450000p -0.3
+ 1450010p 0.9
+ 1452000p 0.9
+ 1452010p -0.3
+ 1454000p -0.3
+ 1454010p 0.9
+ 1456000p 0.9
+ 1456010p -0.3
+ 1458000p -0.3
+ 1458010p 0.9
+ 1460000p 0.9
+ 1460010p -0.3
+ 1462000p -0.3
+ 1462010p 0.9
+ 1464000p 0.9
+ 1464010p -0.3
+ 1466000p -0.3
+ 1466010p 0.9
+ 1468000p 0.9
+ 1468010p -0.3
+ 1470000p -0.3
+ 1470010p 0.9
+ 1472000p 0.9
+ 1472010p -0.3
+ 1474000p -0.3
+ 1474010p 0.9
+ 1476000p 0.9
+ 1476010p -0.3
+ 1478000p -0.3
+ 1478010p 0.9
+ 1480000p 0.9
+ 1480010p -0.3
+ 1482000p -0.3
+ 1482010p 0.9
+ 1484000p 0.9
+ 1484010p -0.3
+ 1486000p -0.3
+ 1486010p 0.9
+ 1488000p 0.9
+ 1488010p -0.3
+ 1490000p -0.3
+ 1490010p 0.9
+ 1492000p 0.9
+ 1492010p -0.3
+ 1494000p -0.3
+ 1494010p 0.9
+ 1496000p 0.9
+ 1496010p -0.3
+ 1498000p -0.3
+ 1498010p 0.9
+ 1500000p 0.9
+ 1500010p -0.3
+ 1502000p -0.3
+ 1502010p 0.9
+ 1504000p 0.9
+ 1504010p -0.3
+ 1506000p -0.3
+ 1506010p 0.9
+ 1508000p 0.9
+ 1508010p -0.3
+ 1510000p -0.3
+ 1510010p 0.9
+ 1512000p 0.9
+ 1512010p -0.3
+ 1514000p -0.3
+ 1514010p 0.9
+ 1516000p 0.9
+ 1516010p -0.3
+ 1518000p -0.3
+ 1518010p 0.9
+ 1520000p 0.9
+ 1520010p -0.3
+ 1522000p -0.3
+ 1522010p 0.9
+ 1524000p 0.9
+ 1524010p -0.3
+ 1526000p -0.3
+ 1526010p 0.9
+ 1528000p 0.9
+ 1528010p -0.3
+ 1530000p -0.3
+ 1530010p 0.9
+ 1532000p 0.9
+ 1532010p -0.3
+ 1534000p -0.3
+ 1534010p 0.9
+ 1536000p 0.9
+ 1536010p -0.3
+ 1538000p -0.3
+ 1538010p 0.9
+ 1540000p 0.9
+ 1540010p -0.3
+ 1542000p -0.3
+ 1542010p 0.9
+ 1544000p 0.9
+ 1544010p -0.3
+ 1546000p -0.3
+ 1546010p 0.9
+ 1548000p 0.9
+ 1548010p -0.3
+ 1550000p -0.3
+ 1550010p 0.9
+ 1552000p 0.9
+ 1552010p -0.3
+ 1554000p -0.3
+ 1554010p 0.9
+ 1556000p 0.9
+ 1556010p -0.3
+ 1558000p -0.3
+ 1558010p 0.9
+ 1560000p 0.9
+ 1560010p -0.3
+ 1562000p -0.3
+ 1562010p 0.9
+ 1564000p 0.9
+ 1564010p -0.3
+ 1566000p -0.3
+ 1566010p 0.9
+ 1568000p 0.9
+ 1568010p -0.3
+ 1570000p -0.3
+ 1570010p 0.9
+ 1572000p 0.9
+ 1572010p -0.3
+ 1574000p -0.3
+ 1574010p 0.9
+ 1576000p 0.9
+ 1576010p -0.3
+ 1578000p -0.3
+ 1578010p 0.9
+ 1580000p 0.9
+ 1580010p -0.3
+ 1582000p -0.3
+ 1582010p 0.9
+ 1584000p 0.9
+ 1584010p -0.3
+ 1586000p -0.3
+ 1586010p 0.9
+ 1588000p 0.9
+ 1588010p -0.3
+ 1590000p -0.3
+ 1590010p 0.9
+ 1592000p 0.9
+ 1592010p -0.3
+ 1594000p -0.3
+ 1594010p 0.9
+ 1596000p 0.9
+ 1596010p -0.3
+ 1598000p -0.3
+ 1598010p 0.9
+ 1600000p 0.9
+ 1600010p -0.3
+ 1602000p -0.3
+ 1602010p 0.9
+ 1604000p 0.9
+ 1604010p -0.3
+ 1606000p -0.3
+ 1606010p 0.9
+ 1608000p 0.9
+ 1608010p -0.3
+ 1610000p -0.3
+ 1610010p 0.9
+ 1612000p 0.9
+ 1612010p -0.3
+ 1614000p -0.3
+ 1614010p 0.9
+ 1616000p 0.9
+ 1616010p -0.3
+ 1618000p -0.3
+ 1618010p 0.9
+ 1620000p 0.9
+ 1620010p -0.3
+ 1622000p -0.3
+ 1622010p 0.9
+ 1624000p 0.9
+ 1624010p -0.3
+ 1626000p -0.3
+ 1626010p 0.9
+ 1628000p 0.9
+ 1628010p -0.3
+ 1630000p -0.3
+ 1630010p 0.9
+ 1632000p 0.9
+ 1632010p -0.3
+ 1634000p -0.3
+ 1634010p 0.9
+ 1636000p 0.9
+ 1636010p -0.3
+ 1638000p -0.3
+ 1638010p 0.9
+ 1640000p 0.9
+ 1640010p -0.3
+ 1642000p -0.3
+ 1642010p 0.9
+ 1644000p 0.9
+ 1644010p -0.3
+ 1646000p -0.3
+ 1646010p 0.9
+ 1648000p 0.9
+ 1648010p -0.3
+ 1650000p -0.3
+ 1650010p 0.9
+ 1652000p 0.9
+ 1652010p -0.3
+ 1654000p -0.3
+ 1654010p 0.9
+ 1656000p 0.9
+ 1656010p -0.3
+ 1658000p -0.3
+ 1658010p 0.9
+ 1660000p 0.9
+ 1660010p -0.3
+ 1662000p -0.3
+ 1662010p 0.9
+ 1664000p 0.9
+ 1664010p -0.3
+ 1666000p -0.3
+ 1666010p 0.9
+ 1668000p 0.9
+ 1668010p -0.3
+ 1670000p -0.3
+ 1670010p 0.9
+ 1672000p 0.9
+ 1672010p -0.3
+ 1674000p -0.3
+ 1674010p 0.9
+ 1676000p 0.9
+ 1676010p -0.3
+ 1678000p -0.3
+ 1678010p 0.9
+ 1680000p 0.9
+ 1680010p -0.3
+ 1682000p -0.3
+ 1682010p 0.9
+ 1684000p 0.9
+ 1684010p -0.3
+ 1686000p -0.3
+ 1686010p 0.9
+ 1688000p 0.9
+ 1688010p -0.3
+ 1690000p -0.3
+ 1690010p 0.9
+ 1692000p 0.9
+ 1692010p -0.3
+ 1694000p -0.3
+ 1694010p 0.9
+ 1696000p 0.9
+ 1696010p -0.3
+ 1698000p -0.3
+ 1698010p 0.9
+ 1700000p 0.9
+ 1700010p -0.3
+ 1702000p -0.3
+ 1702010p 0.9
+ 1704000p 0.9
+ 1704010p -0.3
+ 1706000p -0.3
+ 1706010p 0.9
+ 1708000p 0.9
+ 1708010p -0.3
+ 1710000p -0.3
+ 1710010p 0.9
+ 1712000p 0.9
+ 1712010p -0.3
+ 1714000p -0.3
+ 1714010p 0.9
+ 1716000p 0.9
+ 1716010p -0.3
+ 1718000p -0.3
+ 1718010p 0.9
+ 1720000p 0.9
+ 1720010p -0.3
+ 1722000p -0.3
+ 1722010p 0.9
+ 1724000p 0.9
+ 1724010p -0.3
+ 1726000p -0.3
+ 1726010p 0.9
+ 1728000p 0.9
+ 1728010p -0.3
+ 1730000p -0.3
+ 1730010p 0.9
+ 1732000p 0.9
+ 1732010p -0.3
+ 1734000p -0.3
+ 1734010p 0.9
+ 1736000p 0.9
+ 1736010p -0.3
+ 1738000p -0.3
+ 1738010p 0.9
+ 1740000p 0.9
+ 1740010p -0.3
+ 1742000p -0.3
+ 1742010p 0.9
+ 1744000p 0.9
+ 1744010p -0.3
+ 1746000p -0.3
+ 1746010p 0.9
+ 1748000p 0.9
+ 1748010p -0.3
+ 1750000p -0.3
+ 1750010p 0.9
+ 1752000p 0.9
+ 1752010p -0.3
+ 1754000p -0.3
+ 1754010p 0.9
+ 1756000p 0.9
+ 1756010p -0.3
+ 1758000p -0.3
+ 1758010p 0.9
+ 1760000p 0.9
+ 1760010p -0.3
+ 1762000p -0.3
+ 1762010p 0.9
+ 1764000p 0.9
+ 1764010p -0.3
+ 1766000p -0.3
+ 1766010p 0.9
+ 1768000p 0.9
+ 1768010p -0.3
+ 1770000p -0.3
+ 1770010p 0.9
+ 1772000p 0.9
+ 1772010p -0.3
+ 1774000p -0.3
+ 1774010p 0.9
+ 1776000p 0.9
+ 1776010p -0.3
+ 1778000p -0.3
+ 1778010p 0.9
+ 1780000p 0.9
+ 1780010p -0.3
+ 1782000p -0.3
+ 1782010p 0.9
+ 1784000p 0.9
+ 1784010p -0.3
+ 1786000p -0.3
+ 1786010p 0.9
+ 1788000p 0.9
+ 1788010p -0.3
+ 1790000p -0.3
+ 1790010p 0.9
+ 1792000p 0.9
+ 1792010p -0.3
+ 1794000p -0.3
+ 1794010p 0.9
+ 1796000p 0.9
+ 1796010p -0.3
+ 1798000p -0.3
+ 1798010p 0.9
+ 1800000p 0.9
+ 1800010p -0.3
+ 1802000p -0.3
+ 1802010p 0.9
+ 1804000p 0.9
+ 1804010p -0.3
+ 1806000p -0.3
+ 1806010p 0.9
+ 1808000p 0.9
+ 1808010p -0.3
+ 1810000p -0.3
+ 1810010p 0.9
+ 1812000p 0.9
+ 1812010p -0.3
+ 1814000p -0.3
+ 1814010p 0.9
+ 1816000p 0.9
+ 1816010p -0.3
+ 1818000p -0.3
+ 1818010p 0.9
+ 1820000p 0.9
+ 1820010p -0.3
+ 1822000p -0.3
+ 1822010p 0.9
+ 1824000p 0.9
+ 1824010p -0.3
+ 1826000p -0.3
+ 1826010p 0.9
+ 1828000p 0.9
+ 1828010p -0.3
+ 1830000p -0.3
+ 1830010p 0.9
+ 1832000p 0.9
+ 1832010p -0.3
+ 1834000p -0.3
+ 1834010p 0.9
+ 1836000p 0.9
+ 1836010p -0.3
+ 1838000p -0.3
+ 1838010p 0.9
+ 1840000p 0.9
+ 1840010p -0.3
+ 1842000p -0.3
+ 1842010p 0.9
+ 1844000p 0.9
+ 1844010p -0.3
+ 1846000p -0.3
+ 1846010p 0.9
+ 1848000p 0.9
+ 1848010p -0.3
+ 1850000p -0.3
+ 1850010p 0.9
+ 1852000p 0.9
+ 1852010p -0.3
+ 1854000p -0.3
+ 1854010p 0.9
+ 1856000p 0.9
+ 1856010p -0.3
+ 1858000p -0.3
+ 1858010p 0.9
+ 1860000p 0.9
+ 1860010p -0.3
+ 1862000p -0.3
+ 1862010p 0.9
+ 1864000p 0.9
+ 1864010p -0.3
+ 1866000p -0.3
+ 1866010p 0.9
+ 1868000p 0.9
+ 1868010p -0.3
+ 1870000p -0.3
+ 1870010p 0.9
+ 1872000p 0.9
+ 1872010p -0.3
+ 1874000p -0.3
+ 1874010p 0.9
+ 1876000p 0.9
+ 1876010p -0.3
+ 1878000p -0.3
+ 1878010p 0.9
+ 1880000p 0.9
+ 1880010p -0.3
+ 1882000p -0.3
+ 1882010p 0.9
+ 1884000p 0.9
+ 1884010p -0.3
+ 1886000p -0.3
+ 1886010p 0.9
+ 1888000p 0.9
+ 1888010p -0.3
+ 1890000p -0.3
+ 1890010p 0.9
+ 1892000p 0.9
+ 1892010p -0.3
+ 1894000p -0.3
+ 1894010p 0.9
+ 1896000p 0.9
+ 1896010p -0.3
+ 1898000p -0.3
+ 1898010p 0.9
+ 1900000p 0.9
+ 1900010p -0.3
+ 1902000p -0.3
+ 1902010p 0.9
+ 1904000p 0.9
+ 1904010p -0.3
+ 1906000p -0.3
+ 1906010p 0.9
+ 1908000p 0.9
+ 1908010p -0.3
+ 1910000p -0.3
+ 1910010p 0.9
+ 1912000p 0.9
+ 1912010p -0.3
+ 1914000p -0.3
+ 1914010p 0.9
+ 1916000p 0.9
+ 1916010p -0.3
+ 1918000p -0.3
+ 1918010p 0.9
+ 1920000p 0.9
+ 1920010p -0.3
+ 1922000p -0.3
+ 1922010p 0.9
+ 1924000p 0.9
+ 1924010p -0.3
+ 1926000p -0.3
+ 1926010p 0.9
+ 1928000p 0.9
+ 1928010p -0.3
+ 1930000p -0.3
+ 1930010p 0.9
+ 1932000p 0.9
+ 1932010p -0.3
+ 1934000p -0.3
+ 1934010p 0.9
+ 1936000p 0.9
+ 1936010p -0.3
+ 1938000p -0.3
+ 1938010p 0.9
+ 1940000p 0.9
+ 1940010p -0.3
+ 1942000p -0.3
+ 1942010p 0.9
+ 1944000p 0.9
+ 1944010p -0.3
+ 1946000p -0.3
+ 1946010p 0.9
+ 1948000p 0.9
+ 1948010p -0.3
+ 1950000p -0.3
+ 1950010p 0.9
+ 1952000p 0.9
+ 1952010p -0.3
+ 1954000p -0.3
+ 1954010p 0.9
+ 1956000p 0.9
+ 1956010p -0.3
+ 1958000p -0.3
+ 1958010p 0.9
+ 1960000p 0.9
+ 1960010p -0.3
+ 1962000p -0.3
+ 1962010p 0.9
+ 1964000p 0.9
+ 1964010p -0.3
+ 1966000p -0.3
+ 1966010p 0.9
+ 1968000p 0.9
+ 1968010p -0.3
+ 1970000p -0.3
+ 1970010p 0.9
+ 1972000p 0.9
+ 1972010p -0.3
+ 1974000p -0.3
+ 1974010p 0.9
+ 1976000p 0.9
+ 1976010p -0.3
+ 1978000p -0.3
+ 1978010p 0.9
+ 1980000p 0.9
+ 1980010p -0.3
+ 1982000p -0.3
+ 1982010p 0.9
+ 1984000p 0.9
+ 1984010p -0.3
+ 1986000p -0.3
+ 1986010p 0.9
+ 1988000p 0.9
+ 1988010p -0.3
+ 1990000p -0.3
+ 1990010p 0.9
+ 1992000p 0.9
+ 1992010p -0.3
+ 1994000p -0.3
+ 1994010p 0.9
+ 1996000p 0.9
+ 1996010p -0.3
+ 1998000p -0.3
+ 1998010p 0.9
+ 2000000p 0.9
+ 2000010p -0.3
+ 2002000p -0.3
+ 2002010p 0.9
+ 2004000p 0.9
+ 2004010p -0.3
+ 2006000p -0.3
+ 2006010p 0.9
+ 2008000p 0.9
+ 2008010p -0.3
+ 2010000p -0.3
+ 2010010p 0.9
+ 2012000p 0.9
+ 2012010p -0.3
+ 2014000p -0.3
+ 2014010p 0.9
+ 2016000p 0.9
+ 2016010p -0.3
+ 2018000p -0.3
+ 2018010p 0.9
+ 2020000p 0.9
+ 2020010p -0.3
+ 2022000p -0.3
+ 2022010p 0.9
+ 2024000p 0.9
+ 2024010p -0.3
+ 2026000p -0.3
+ 2026010p 0.9
+ 2028000p 0.9
+ 2028010p -0.3
+ 2030000p -0.3
+ 2030010p 0.9
+ 2032000p 0.9
+ 2032010p -0.3
+ 2034000p -0.3
+ 2034010p 0.9
+ 2036000p 0.9
+ 2036010p -0.3
+ 2038000p -0.3
+ 2038010p 0.9
+ 2040000p 0.9
+ 2040010p -0.3
+ 2042000p -0.3
+ 2042010p 0.9
+ 2044000p 0.9
+ 2044010p -0.3
+ 2046000p -0.3
+ 2046010p 0.9
+ 2048000p 0.9
+ 2048010p -0.3
+ \]
V_data_5 (Data\\<5\\> gnd!) vsource type=pwl wave=\[
+ 0    0.9
+ 2000p 0.9
+ 2010p -0.3
+ 4000p -0.3
+ 4010p 0.9
+ 6000p 0.9
+ 6010p -0.3
+ 8000p -0.3
+ 8010p 0.9
+ 10000p 0.9
+ 10010p -0.3
+ 12000p -0.3
+ 12010p 0.9
+ 14000p 0.9
+ 14010p -0.3
+ 16000p -0.3
+ 16010p 0.9
+ 18000p 0.9
+ 18010p -0.3
+ 20000p -0.3
+ 20010p 0.9
+ 22000p 0.9
+ 22010p -0.3
+ 24000p -0.3
+ 24010p 0.9
+ 26000p 0.9
+ 26010p -0.3
+ 28000p -0.3
+ 28010p 0.9
+ 30000p 0.9
+ 30010p -0.3
+ 32000p -0.3
+ 32010p 0.9
+ 34000p 0.9
+ 34010p -0.3
+ 36000p -0.3
+ 36010p 0.9
+ 38000p 0.9
+ 38010p -0.3
+ 40000p -0.3
+ 40010p 0.9
+ 42000p 0.9
+ 42010p -0.3
+ 44000p -0.3
+ 44010p 0.9
+ 46000p 0.9
+ 46010p -0.3
+ 48000p -0.3
+ 48010p 0.9
+ 50000p 0.9
+ 50010p -0.3
+ 52000p -0.3
+ 52010p 0.9
+ 54000p 0.9
+ 54010p -0.3
+ 56000p -0.3
+ 56010p 0.9
+ 58000p 0.9
+ 58010p -0.3
+ 60000p -0.3
+ 60010p 0.9
+ 62000p 0.9
+ 62010p -0.3
+ 64000p -0.3
+ 64010p 0.9
+ 66000p 0.9
+ 66010p -0.3
+ 68000p -0.3
+ 68010p 0.9
+ 70000p 0.9
+ 70010p -0.3
+ 72000p -0.3
+ 72010p 0.9
+ 74000p 0.9
+ 74010p -0.3
+ 76000p -0.3
+ 76010p 0.9
+ 78000p 0.9
+ 78010p -0.3
+ 80000p -0.3
+ 80010p 0.9
+ 82000p 0.9
+ 82010p -0.3
+ 84000p -0.3
+ 84010p 0.9
+ 86000p 0.9
+ 86010p -0.3
+ 88000p -0.3
+ 88010p 0.9
+ 90000p 0.9
+ 90010p -0.3
+ 92000p -0.3
+ 92010p 0.9
+ 94000p 0.9
+ 94010p -0.3
+ 96000p -0.3
+ 96010p 0.9
+ 98000p 0.9
+ 98010p -0.3
+ 100000p -0.3
+ 100010p 0.9
+ 102000p 0.9
+ 102010p -0.3
+ 104000p -0.3
+ 104010p 0.9
+ 106000p 0.9
+ 106010p -0.3
+ 108000p -0.3
+ 108010p 0.9
+ 110000p 0.9
+ 110010p -0.3
+ 112000p -0.3
+ 112010p 0.9
+ 114000p 0.9
+ 114010p -0.3
+ 116000p -0.3
+ 116010p 0.9
+ 118000p 0.9
+ 118010p -0.3
+ 120000p -0.3
+ 120010p 0.9
+ 122000p 0.9
+ 122010p -0.3
+ 124000p -0.3
+ 124010p 0.9
+ 126000p 0.9
+ 126010p -0.3
+ 128000p -0.3
+ 128010p 0.9
+ 130000p 0.9
+ 130010p -0.3
+ 132000p -0.3
+ 132010p 0.9
+ 134000p 0.9
+ 134010p -0.3
+ 136000p -0.3
+ 136010p 0.9
+ 138000p 0.9
+ 138010p -0.3
+ 140000p -0.3
+ 140010p 0.9
+ 142000p 0.9
+ 142010p -0.3
+ 144000p -0.3
+ 144010p 0.9
+ 146000p 0.9
+ 146010p -0.3
+ 148000p -0.3
+ 148010p 0.9
+ 150000p 0.9
+ 150010p -0.3
+ 152000p -0.3
+ 152010p 0.9
+ 154000p 0.9
+ 154010p -0.3
+ 156000p -0.3
+ 156010p 0.9
+ 158000p 0.9
+ 158010p -0.3
+ 160000p -0.3
+ 160010p 0.9
+ 162000p 0.9
+ 162010p -0.3
+ 164000p -0.3
+ 164010p 0.9
+ 166000p 0.9
+ 166010p -0.3
+ 168000p -0.3
+ 168010p 0.9
+ 170000p 0.9
+ 170010p -0.3
+ 172000p -0.3
+ 172010p 0.9
+ 174000p 0.9
+ 174010p -0.3
+ 176000p -0.3
+ 176010p 0.9
+ 178000p 0.9
+ 178010p -0.3
+ 180000p -0.3
+ 180010p 0.9
+ 182000p 0.9
+ 182010p -0.3
+ 184000p -0.3
+ 184010p 0.9
+ 186000p 0.9
+ 186010p -0.3
+ 188000p -0.3
+ 188010p 0.9
+ 190000p 0.9
+ 190010p -0.3
+ 192000p -0.3
+ 192010p 0.9
+ 194000p 0.9
+ 194010p -0.3
+ 196000p -0.3
+ 196010p 0.9
+ 198000p 0.9
+ 198010p -0.3
+ 200000p -0.3
+ 200010p 0.9
+ 202000p 0.9
+ 202010p -0.3
+ 204000p -0.3
+ 204010p 0.9
+ 206000p 0.9
+ 206010p -0.3
+ 208000p -0.3
+ 208010p 0.9
+ 210000p 0.9
+ 210010p -0.3
+ 212000p -0.3
+ 212010p 0.9
+ 214000p 0.9
+ 214010p -0.3
+ 216000p -0.3
+ 216010p 0.9
+ 218000p 0.9
+ 218010p -0.3
+ 220000p -0.3
+ 220010p 0.9
+ 222000p 0.9
+ 222010p -0.3
+ 224000p -0.3
+ 224010p 0.9
+ 226000p 0.9
+ 226010p -0.3
+ 228000p -0.3
+ 228010p 0.9
+ 230000p 0.9
+ 230010p -0.3
+ 232000p -0.3
+ 232010p 0.9
+ 234000p 0.9
+ 234010p -0.3
+ 236000p -0.3
+ 236010p 0.9
+ 238000p 0.9
+ 238010p -0.3
+ 240000p -0.3
+ 240010p 0.9
+ 242000p 0.9
+ 242010p -0.3
+ 244000p -0.3
+ 244010p 0.9
+ 246000p 0.9
+ 246010p -0.3
+ 248000p -0.3
+ 248010p 0.9
+ 250000p 0.9
+ 250010p -0.3
+ 252000p -0.3
+ 252010p 0.9
+ 254000p 0.9
+ 254010p -0.3
+ 256000p -0.3
+ 256010p 0.9
+ 258000p 0.9
+ 258010p -0.3
+ 260000p -0.3
+ 260010p 0.9
+ 262000p 0.9
+ 262010p -0.3
+ 264000p -0.3
+ 264010p 0.9
+ 266000p 0.9
+ 266010p -0.3
+ 268000p -0.3
+ 268010p 0.9
+ 270000p 0.9
+ 270010p -0.3
+ 272000p -0.3
+ 272010p 0.9
+ 274000p 0.9
+ 274010p -0.3
+ 276000p -0.3
+ 276010p 0.9
+ 278000p 0.9
+ 278010p -0.3
+ 280000p -0.3
+ 280010p 0.9
+ 282000p 0.9
+ 282010p -0.3
+ 284000p -0.3
+ 284010p 0.9
+ 286000p 0.9
+ 286010p -0.3
+ 288000p -0.3
+ 288010p 0.9
+ 290000p 0.9
+ 290010p -0.3
+ 292000p -0.3
+ 292010p 0.9
+ 294000p 0.9
+ 294010p -0.3
+ 296000p -0.3
+ 296010p 0.9
+ 298000p 0.9
+ 298010p -0.3
+ 300000p -0.3
+ 300010p 0.9
+ 302000p 0.9
+ 302010p -0.3
+ 304000p -0.3
+ 304010p 0.9
+ 306000p 0.9
+ 306010p -0.3
+ 308000p -0.3
+ 308010p 0.9
+ 310000p 0.9
+ 310010p -0.3
+ 312000p -0.3
+ 312010p 0.9
+ 314000p 0.9
+ 314010p -0.3
+ 316000p -0.3
+ 316010p 0.9
+ 318000p 0.9
+ 318010p -0.3
+ 320000p -0.3
+ 320010p 0.9
+ 322000p 0.9
+ 322010p -0.3
+ 324000p -0.3
+ 324010p 0.9
+ 326000p 0.9
+ 326010p -0.3
+ 328000p -0.3
+ 328010p 0.9
+ 330000p 0.9
+ 330010p -0.3
+ 332000p -0.3
+ 332010p 0.9
+ 334000p 0.9
+ 334010p -0.3
+ 336000p -0.3
+ 336010p 0.9
+ 338000p 0.9
+ 338010p -0.3
+ 340000p -0.3
+ 340010p 0.9
+ 342000p 0.9
+ 342010p -0.3
+ 344000p -0.3
+ 344010p 0.9
+ 346000p 0.9
+ 346010p -0.3
+ 348000p -0.3
+ 348010p 0.9
+ 350000p 0.9
+ 350010p -0.3
+ 352000p -0.3
+ 352010p 0.9
+ 354000p 0.9
+ 354010p -0.3
+ 356000p -0.3
+ 356010p 0.9
+ 358000p 0.9
+ 358010p -0.3
+ 360000p -0.3
+ 360010p 0.9
+ 362000p 0.9
+ 362010p -0.3
+ 364000p -0.3
+ 364010p 0.9
+ 366000p 0.9
+ 366010p -0.3
+ 368000p -0.3
+ 368010p 0.9
+ 370000p 0.9
+ 370010p -0.3
+ 372000p -0.3
+ 372010p 0.9
+ 374000p 0.9
+ 374010p -0.3
+ 376000p -0.3
+ 376010p 0.9
+ 378000p 0.9
+ 378010p -0.3
+ 380000p -0.3
+ 380010p 0.9
+ 382000p 0.9
+ 382010p -0.3
+ 384000p -0.3
+ 384010p 0.9
+ 386000p 0.9
+ 386010p -0.3
+ 388000p -0.3
+ 388010p 0.9
+ 390000p 0.9
+ 390010p -0.3
+ 392000p -0.3
+ 392010p 0.9
+ 394000p 0.9
+ 394010p -0.3
+ 396000p -0.3
+ 396010p 0.9
+ 398000p 0.9
+ 398010p -0.3
+ 400000p -0.3
+ 400010p 0.9
+ 402000p 0.9
+ 402010p -0.3
+ 404000p -0.3
+ 404010p 0.9
+ 406000p 0.9
+ 406010p -0.3
+ 408000p -0.3
+ 408010p 0.9
+ 410000p 0.9
+ 410010p -0.3
+ 412000p -0.3
+ 412010p 0.9
+ 414000p 0.9
+ 414010p -0.3
+ 416000p -0.3
+ 416010p 0.9
+ 418000p 0.9
+ 418010p -0.3
+ 420000p -0.3
+ 420010p 0.9
+ 422000p 0.9
+ 422010p -0.3
+ 424000p -0.3
+ 424010p 0.9
+ 426000p 0.9
+ 426010p -0.3
+ 428000p -0.3
+ 428010p 0.9
+ 430000p 0.9
+ 430010p -0.3
+ 432000p -0.3
+ 432010p 0.9
+ 434000p 0.9
+ 434010p -0.3
+ 436000p -0.3
+ 436010p 0.9
+ 438000p 0.9
+ 438010p -0.3
+ 440000p -0.3
+ 440010p 0.9
+ 442000p 0.9
+ 442010p -0.3
+ 444000p -0.3
+ 444010p 0.9
+ 446000p 0.9
+ 446010p -0.3
+ 448000p -0.3
+ 448010p 0.9
+ 450000p 0.9
+ 450010p -0.3
+ 452000p -0.3
+ 452010p 0.9
+ 454000p 0.9
+ 454010p -0.3
+ 456000p -0.3
+ 456010p 0.9
+ 458000p 0.9
+ 458010p -0.3
+ 460000p -0.3
+ 460010p 0.9
+ 462000p 0.9
+ 462010p -0.3
+ 464000p -0.3
+ 464010p 0.9
+ 466000p 0.9
+ 466010p -0.3
+ 468000p -0.3
+ 468010p 0.9
+ 470000p 0.9
+ 470010p -0.3
+ 472000p -0.3
+ 472010p 0.9
+ 474000p 0.9
+ 474010p -0.3
+ 476000p -0.3
+ 476010p 0.9
+ 478000p 0.9
+ 478010p -0.3
+ 480000p -0.3
+ 480010p 0.9
+ 482000p 0.9
+ 482010p -0.3
+ 484000p -0.3
+ 484010p 0.9
+ 486000p 0.9
+ 486010p -0.3
+ 488000p -0.3
+ 488010p 0.9
+ 490000p 0.9
+ 490010p -0.3
+ 492000p -0.3
+ 492010p 0.9
+ 494000p 0.9
+ 494010p -0.3
+ 496000p -0.3
+ 496010p 0.9
+ 498000p 0.9
+ 498010p -0.3
+ 500000p -0.3
+ 500010p 0.9
+ 502000p 0.9
+ 502010p -0.3
+ 504000p -0.3
+ 504010p 0.9
+ 506000p 0.9
+ 506010p -0.3
+ 508000p -0.3
+ 508010p 0.9
+ 510000p 0.9
+ 510010p -0.3
+ 512000p -0.3
+ 512010p 0.9
+ 514000p 0.9
+ 514010p -0.3
+ 516000p -0.3
+ 516010p 0.9
+ 518000p 0.9
+ 518010p -0.3
+ 520000p -0.3
+ 520010p 0.9
+ 522000p 0.9
+ 522010p -0.3
+ 524000p -0.3
+ 524010p 0.9
+ 526000p 0.9
+ 526010p -0.3
+ 528000p -0.3
+ 528010p 0.9
+ 530000p 0.9
+ 530010p -0.3
+ 532000p -0.3
+ 532010p 0.9
+ 534000p 0.9
+ 534010p -0.3
+ 536000p -0.3
+ 536010p 0.9
+ 538000p 0.9
+ 538010p -0.3
+ 540000p -0.3
+ 540010p 0.9
+ 542000p 0.9
+ 542010p -0.3
+ 544000p -0.3
+ 544010p 0.9
+ 546000p 0.9
+ 546010p -0.3
+ 548000p -0.3
+ 548010p 0.9
+ 550000p 0.9
+ 550010p -0.3
+ 552000p -0.3
+ 552010p 0.9
+ 554000p 0.9
+ 554010p -0.3
+ 556000p -0.3
+ 556010p 0.9
+ 558000p 0.9
+ 558010p -0.3
+ 560000p -0.3
+ 560010p 0.9
+ 562000p 0.9
+ 562010p -0.3
+ 564000p -0.3
+ 564010p 0.9
+ 566000p 0.9
+ 566010p -0.3
+ 568000p -0.3
+ 568010p 0.9
+ 570000p 0.9
+ 570010p -0.3
+ 572000p -0.3
+ 572010p 0.9
+ 574000p 0.9
+ 574010p -0.3
+ 576000p -0.3
+ 576010p 0.9
+ 578000p 0.9
+ 578010p -0.3
+ 580000p -0.3
+ 580010p 0.9
+ 582000p 0.9
+ 582010p -0.3
+ 584000p -0.3
+ 584010p 0.9
+ 586000p 0.9
+ 586010p -0.3
+ 588000p -0.3
+ 588010p 0.9
+ 590000p 0.9
+ 590010p -0.3
+ 592000p -0.3
+ 592010p 0.9
+ 594000p 0.9
+ 594010p -0.3
+ 596000p -0.3
+ 596010p 0.9
+ 598000p 0.9
+ 598010p -0.3
+ 600000p -0.3
+ 600010p 0.9
+ 602000p 0.9
+ 602010p -0.3
+ 604000p -0.3
+ 604010p 0.9
+ 606000p 0.9
+ 606010p -0.3
+ 608000p -0.3
+ 608010p 0.9
+ 610000p 0.9
+ 610010p -0.3
+ 612000p -0.3
+ 612010p 0.9
+ 614000p 0.9
+ 614010p -0.3
+ 616000p -0.3
+ 616010p 0.9
+ 618000p 0.9
+ 618010p -0.3
+ 620000p -0.3
+ 620010p 0.9
+ 622000p 0.9
+ 622010p -0.3
+ 624000p -0.3
+ 624010p 0.9
+ 626000p 0.9
+ 626010p -0.3
+ 628000p -0.3
+ 628010p 0.9
+ 630000p 0.9
+ 630010p -0.3
+ 632000p -0.3
+ 632010p 0.9
+ 634000p 0.9
+ 634010p -0.3
+ 636000p -0.3
+ 636010p 0.9
+ 638000p 0.9
+ 638010p -0.3
+ 640000p -0.3
+ 640010p 0.9
+ 642000p 0.9
+ 642010p -0.3
+ 644000p -0.3
+ 644010p 0.9
+ 646000p 0.9
+ 646010p -0.3
+ 648000p -0.3
+ 648010p 0.9
+ 650000p 0.9
+ 650010p -0.3
+ 652000p -0.3
+ 652010p 0.9
+ 654000p 0.9
+ 654010p -0.3
+ 656000p -0.3
+ 656010p 0.9
+ 658000p 0.9
+ 658010p -0.3
+ 660000p -0.3
+ 660010p 0.9
+ 662000p 0.9
+ 662010p -0.3
+ 664000p -0.3
+ 664010p 0.9
+ 666000p 0.9
+ 666010p -0.3
+ 668000p -0.3
+ 668010p 0.9
+ 670000p 0.9
+ 670010p -0.3
+ 672000p -0.3
+ 672010p 0.9
+ 674000p 0.9
+ 674010p -0.3
+ 676000p -0.3
+ 676010p 0.9
+ 678000p 0.9
+ 678010p -0.3
+ 680000p -0.3
+ 680010p 0.9
+ 682000p 0.9
+ 682010p -0.3
+ 684000p -0.3
+ 684010p 0.9
+ 686000p 0.9
+ 686010p -0.3
+ 688000p -0.3
+ 688010p 0.9
+ 690000p 0.9
+ 690010p -0.3
+ 692000p -0.3
+ 692010p 0.9
+ 694000p 0.9
+ 694010p -0.3
+ 696000p -0.3
+ 696010p 0.9
+ 698000p 0.9
+ 698010p -0.3
+ 700000p -0.3
+ 700010p 0.9
+ 702000p 0.9
+ 702010p -0.3
+ 704000p -0.3
+ 704010p 0.9
+ 706000p 0.9
+ 706010p -0.3
+ 708000p -0.3
+ 708010p 0.9
+ 710000p 0.9
+ 710010p -0.3
+ 712000p -0.3
+ 712010p 0.9
+ 714000p 0.9
+ 714010p -0.3
+ 716000p -0.3
+ 716010p 0.9
+ 718000p 0.9
+ 718010p -0.3
+ 720000p -0.3
+ 720010p 0.9
+ 722000p 0.9
+ 722010p -0.3
+ 724000p -0.3
+ 724010p 0.9
+ 726000p 0.9
+ 726010p -0.3
+ 728000p -0.3
+ 728010p 0.9
+ 730000p 0.9
+ 730010p -0.3
+ 732000p -0.3
+ 732010p 0.9
+ 734000p 0.9
+ 734010p -0.3
+ 736000p -0.3
+ 736010p 0.9
+ 738000p 0.9
+ 738010p -0.3
+ 740000p -0.3
+ 740010p 0.9
+ 742000p 0.9
+ 742010p -0.3
+ 744000p -0.3
+ 744010p 0.9
+ 746000p 0.9
+ 746010p -0.3
+ 748000p -0.3
+ 748010p 0.9
+ 750000p 0.9
+ 750010p -0.3
+ 752000p -0.3
+ 752010p 0.9
+ 754000p 0.9
+ 754010p -0.3
+ 756000p -0.3
+ 756010p 0.9
+ 758000p 0.9
+ 758010p -0.3
+ 760000p -0.3
+ 760010p 0.9
+ 762000p 0.9
+ 762010p -0.3
+ 764000p -0.3
+ 764010p 0.9
+ 766000p 0.9
+ 766010p -0.3
+ 768000p -0.3
+ 768010p 0.9
+ 770000p 0.9
+ 770010p -0.3
+ 772000p -0.3
+ 772010p 0.9
+ 774000p 0.9
+ 774010p -0.3
+ 776000p -0.3
+ 776010p 0.9
+ 778000p 0.9
+ 778010p -0.3
+ 780000p -0.3
+ 780010p 0.9
+ 782000p 0.9
+ 782010p -0.3
+ 784000p -0.3
+ 784010p 0.9
+ 786000p 0.9
+ 786010p -0.3
+ 788000p -0.3
+ 788010p 0.9
+ 790000p 0.9
+ 790010p -0.3
+ 792000p -0.3
+ 792010p 0.9
+ 794000p 0.9
+ 794010p -0.3
+ 796000p -0.3
+ 796010p 0.9
+ 798000p 0.9
+ 798010p -0.3
+ 800000p -0.3
+ 800010p 0.9
+ 802000p 0.9
+ 802010p -0.3
+ 804000p -0.3
+ 804010p 0.9
+ 806000p 0.9
+ 806010p -0.3
+ 808000p -0.3
+ 808010p 0.9
+ 810000p 0.9
+ 810010p -0.3
+ 812000p -0.3
+ 812010p 0.9
+ 814000p 0.9
+ 814010p -0.3
+ 816000p -0.3
+ 816010p 0.9
+ 818000p 0.9
+ 818010p -0.3
+ 820000p -0.3
+ 820010p 0.9
+ 822000p 0.9
+ 822010p -0.3
+ 824000p -0.3
+ 824010p 0.9
+ 826000p 0.9
+ 826010p -0.3
+ 828000p -0.3
+ 828010p 0.9
+ 830000p 0.9
+ 830010p -0.3
+ 832000p -0.3
+ 832010p 0.9
+ 834000p 0.9
+ 834010p -0.3
+ 836000p -0.3
+ 836010p 0.9
+ 838000p 0.9
+ 838010p -0.3
+ 840000p -0.3
+ 840010p 0.9
+ 842000p 0.9
+ 842010p -0.3
+ 844000p -0.3
+ 844010p 0.9
+ 846000p 0.9
+ 846010p -0.3
+ 848000p -0.3
+ 848010p 0.9
+ 850000p 0.9
+ 850010p -0.3
+ 852000p -0.3
+ 852010p 0.9
+ 854000p 0.9
+ 854010p -0.3
+ 856000p -0.3
+ 856010p 0.9
+ 858000p 0.9
+ 858010p -0.3
+ 860000p -0.3
+ 860010p 0.9
+ 862000p 0.9
+ 862010p -0.3
+ 864000p -0.3
+ 864010p 0.9
+ 866000p 0.9
+ 866010p -0.3
+ 868000p -0.3
+ 868010p 0.9
+ 870000p 0.9
+ 870010p -0.3
+ 872000p -0.3
+ 872010p 0.9
+ 874000p 0.9
+ 874010p -0.3
+ 876000p -0.3
+ 876010p 0.9
+ 878000p 0.9
+ 878010p -0.3
+ 880000p -0.3
+ 880010p 0.9
+ 882000p 0.9
+ 882010p -0.3
+ 884000p -0.3
+ 884010p 0.9
+ 886000p 0.9
+ 886010p -0.3
+ 888000p -0.3
+ 888010p 0.9
+ 890000p 0.9
+ 890010p -0.3
+ 892000p -0.3
+ 892010p 0.9
+ 894000p 0.9
+ 894010p -0.3
+ 896000p -0.3
+ 896010p 0.9
+ 898000p 0.9
+ 898010p -0.3
+ 900000p -0.3
+ 900010p 0.9
+ 902000p 0.9
+ 902010p -0.3
+ 904000p -0.3
+ 904010p 0.9
+ 906000p 0.9
+ 906010p -0.3
+ 908000p -0.3
+ 908010p 0.9
+ 910000p 0.9
+ 910010p -0.3
+ 912000p -0.3
+ 912010p 0.9
+ 914000p 0.9
+ 914010p -0.3
+ 916000p -0.3
+ 916010p 0.9
+ 918000p 0.9
+ 918010p -0.3
+ 920000p -0.3
+ 920010p 0.9
+ 922000p 0.9
+ 922010p -0.3
+ 924000p -0.3
+ 924010p 0.9
+ 926000p 0.9
+ 926010p -0.3
+ 928000p -0.3
+ 928010p 0.9
+ 930000p 0.9
+ 930010p -0.3
+ 932000p -0.3
+ 932010p 0.9
+ 934000p 0.9
+ 934010p -0.3
+ 936000p -0.3
+ 936010p 0.9
+ 938000p 0.9
+ 938010p -0.3
+ 940000p -0.3
+ 940010p 0.9
+ 942000p 0.9
+ 942010p -0.3
+ 944000p -0.3
+ 944010p 0.9
+ 946000p 0.9
+ 946010p -0.3
+ 948000p -0.3
+ 948010p 0.9
+ 950000p 0.9
+ 950010p -0.3
+ 952000p -0.3
+ 952010p 0.9
+ 954000p 0.9
+ 954010p -0.3
+ 956000p -0.3
+ 956010p 0.9
+ 958000p 0.9
+ 958010p -0.3
+ 960000p -0.3
+ 960010p 0.9
+ 962000p 0.9
+ 962010p -0.3
+ 964000p -0.3
+ 964010p 0.9
+ 966000p 0.9
+ 966010p -0.3
+ 968000p -0.3
+ 968010p 0.9
+ 970000p 0.9
+ 970010p -0.3
+ 972000p -0.3
+ 972010p 0.9
+ 974000p 0.9
+ 974010p -0.3
+ 976000p -0.3
+ 976010p 0.9
+ 978000p 0.9
+ 978010p -0.3
+ 980000p -0.3
+ 980010p 0.9
+ 982000p 0.9
+ 982010p -0.3
+ 984000p -0.3
+ 984010p 0.9
+ 986000p 0.9
+ 986010p -0.3
+ 988000p -0.3
+ 988010p 0.9
+ 990000p 0.9
+ 990010p -0.3
+ 992000p -0.3
+ 992010p 0.9
+ 994000p 0.9
+ 994010p -0.3
+ 996000p -0.3
+ 996010p 0.9
+ 998000p 0.9
+ 998010p -0.3
+ 1000000p -0.3
+ 1000010p 0.9
+ 1002000p 0.9
+ 1002010p -0.3
+ 1004000p -0.3
+ 1004010p 0.9
+ 1006000p 0.9
+ 1006010p -0.3
+ 1008000p -0.3
+ 1008010p 0.9
+ 1010000p 0.9
+ 1010010p -0.3
+ 1012000p -0.3
+ 1012010p 0.9
+ 1014000p 0.9
+ 1014010p -0.3
+ 1016000p -0.3
+ 1016010p 0.9
+ 1018000p 0.9
+ 1018010p -0.3
+ 1020000p -0.3
+ 1020010p 0.9
+ 1022000p 0.9
+ 1022010p -0.3
+ 1024000p -0.3
+ 1024010p 0.9
+ 1026000p 0.9
+ 1026010p -0.3
+ 1028000p -0.3
+ 1028010p 0.9
+ 1030000p 0.9
+ 1030010p -0.3
+ 1032000p -0.3
+ 1032010p 0.9
+ 1034000p 0.9
+ 1034010p -0.3
+ 1036000p -0.3
+ 1036010p 0.9
+ 1038000p 0.9
+ 1038010p -0.3
+ 1040000p -0.3
+ 1040010p 0.9
+ 1042000p 0.9
+ 1042010p -0.3
+ 1044000p -0.3
+ 1044010p 0.9
+ 1046000p 0.9
+ 1046010p -0.3
+ 1048000p -0.3
+ 1048010p 0.9
+ 1050000p 0.9
+ 1050010p -0.3
+ 1052000p -0.3
+ 1052010p 0.9
+ 1054000p 0.9
+ 1054010p -0.3
+ 1056000p -0.3
+ 1056010p 0.9
+ 1058000p 0.9
+ 1058010p -0.3
+ 1060000p -0.3
+ 1060010p 0.9
+ 1062000p 0.9
+ 1062010p -0.3
+ 1064000p -0.3
+ 1064010p 0.9
+ 1066000p 0.9
+ 1066010p -0.3
+ 1068000p -0.3
+ 1068010p 0.9
+ 1070000p 0.9
+ 1070010p -0.3
+ 1072000p -0.3
+ 1072010p 0.9
+ 1074000p 0.9
+ 1074010p -0.3
+ 1076000p -0.3
+ 1076010p 0.9
+ 1078000p 0.9
+ 1078010p -0.3
+ 1080000p -0.3
+ 1080010p 0.9
+ 1082000p 0.9
+ 1082010p -0.3
+ 1084000p -0.3
+ 1084010p 0.9
+ 1086000p 0.9
+ 1086010p -0.3
+ 1088000p -0.3
+ 1088010p 0.9
+ 1090000p 0.9
+ 1090010p -0.3
+ 1092000p -0.3
+ 1092010p 0.9
+ 1094000p 0.9
+ 1094010p -0.3
+ 1096000p -0.3
+ 1096010p 0.9
+ 1098000p 0.9
+ 1098010p -0.3
+ 1100000p -0.3
+ 1100010p 0.9
+ 1102000p 0.9
+ 1102010p -0.3
+ 1104000p -0.3
+ 1104010p 0.9
+ 1106000p 0.9
+ 1106010p -0.3
+ 1108000p -0.3
+ 1108010p 0.9
+ 1110000p 0.9
+ 1110010p -0.3
+ 1112000p -0.3
+ 1112010p 0.9
+ 1114000p 0.9
+ 1114010p -0.3
+ 1116000p -0.3
+ 1116010p 0.9
+ 1118000p 0.9
+ 1118010p -0.3
+ 1120000p -0.3
+ 1120010p 0.9
+ 1122000p 0.9
+ 1122010p -0.3
+ 1124000p -0.3
+ 1124010p 0.9
+ 1126000p 0.9
+ 1126010p -0.3
+ 1128000p -0.3
+ 1128010p 0.9
+ 1130000p 0.9
+ 1130010p -0.3
+ 1132000p -0.3
+ 1132010p 0.9
+ 1134000p 0.9
+ 1134010p -0.3
+ 1136000p -0.3
+ 1136010p 0.9
+ 1138000p 0.9
+ 1138010p -0.3
+ 1140000p -0.3
+ 1140010p 0.9
+ 1142000p 0.9
+ 1142010p -0.3
+ 1144000p -0.3
+ 1144010p 0.9
+ 1146000p 0.9
+ 1146010p -0.3
+ 1148000p -0.3
+ 1148010p 0.9
+ 1150000p 0.9
+ 1150010p -0.3
+ 1152000p -0.3
+ 1152010p 0.9
+ 1154000p 0.9
+ 1154010p -0.3
+ 1156000p -0.3
+ 1156010p 0.9
+ 1158000p 0.9
+ 1158010p -0.3
+ 1160000p -0.3
+ 1160010p 0.9
+ 1162000p 0.9
+ 1162010p -0.3
+ 1164000p -0.3
+ 1164010p 0.9
+ 1166000p 0.9
+ 1166010p -0.3
+ 1168000p -0.3
+ 1168010p 0.9
+ 1170000p 0.9
+ 1170010p -0.3
+ 1172000p -0.3
+ 1172010p 0.9
+ 1174000p 0.9
+ 1174010p -0.3
+ 1176000p -0.3
+ 1176010p 0.9
+ 1178000p 0.9
+ 1178010p -0.3
+ 1180000p -0.3
+ 1180010p 0.9
+ 1182000p 0.9
+ 1182010p -0.3
+ 1184000p -0.3
+ 1184010p 0.9
+ 1186000p 0.9
+ 1186010p -0.3
+ 1188000p -0.3
+ 1188010p 0.9
+ 1190000p 0.9
+ 1190010p -0.3
+ 1192000p -0.3
+ 1192010p 0.9
+ 1194000p 0.9
+ 1194010p -0.3
+ 1196000p -0.3
+ 1196010p 0.9
+ 1198000p 0.9
+ 1198010p -0.3
+ 1200000p -0.3
+ 1200010p 0.9
+ 1202000p 0.9
+ 1202010p -0.3
+ 1204000p -0.3
+ 1204010p 0.9
+ 1206000p 0.9
+ 1206010p -0.3
+ 1208000p -0.3
+ 1208010p 0.9
+ 1210000p 0.9
+ 1210010p -0.3
+ 1212000p -0.3
+ 1212010p 0.9
+ 1214000p 0.9
+ 1214010p -0.3
+ 1216000p -0.3
+ 1216010p 0.9
+ 1218000p 0.9
+ 1218010p -0.3
+ 1220000p -0.3
+ 1220010p 0.9
+ 1222000p 0.9
+ 1222010p -0.3
+ 1224000p -0.3
+ 1224010p 0.9
+ 1226000p 0.9
+ 1226010p -0.3
+ 1228000p -0.3
+ 1228010p 0.9
+ 1230000p 0.9
+ 1230010p -0.3
+ 1232000p -0.3
+ 1232010p 0.9
+ 1234000p 0.9
+ 1234010p -0.3
+ 1236000p -0.3
+ 1236010p 0.9
+ 1238000p 0.9
+ 1238010p -0.3
+ 1240000p -0.3
+ 1240010p 0.9
+ 1242000p 0.9
+ 1242010p -0.3
+ 1244000p -0.3
+ 1244010p 0.9
+ 1246000p 0.9
+ 1246010p -0.3
+ 1248000p -0.3
+ 1248010p 0.9
+ 1250000p 0.9
+ 1250010p -0.3
+ 1252000p -0.3
+ 1252010p 0.9
+ 1254000p 0.9
+ 1254010p -0.3
+ 1256000p -0.3
+ 1256010p 0.9
+ 1258000p 0.9
+ 1258010p -0.3
+ 1260000p -0.3
+ 1260010p 0.9
+ 1262000p 0.9
+ 1262010p -0.3
+ 1264000p -0.3
+ 1264010p 0.9
+ 1266000p 0.9
+ 1266010p -0.3
+ 1268000p -0.3
+ 1268010p 0.9
+ 1270000p 0.9
+ 1270010p -0.3
+ 1272000p -0.3
+ 1272010p 0.9
+ 1274000p 0.9
+ 1274010p -0.3
+ 1276000p -0.3
+ 1276010p 0.9
+ 1278000p 0.9
+ 1278010p -0.3
+ 1280000p -0.3
+ 1280010p 0.9
+ 1282000p 0.9
+ 1282010p -0.3
+ 1284000p -0.3
+ 1284010p 0.9
+ 1286000p 0.9
+ 1286010p -0.3
+ 1288000p -0.3
+ 1288010p 0.9
+ 1290000p 0.9
+ 1290010p -0.3
+ 1292000p -0.3
+ 1292010p 0.9
+ 1294000p 0.9
+ 1294010p -0.3
+ 1296000p -0.3
+ 1296010p 0.9
+ 1298000p 0.9
+ 1298010p -0.3
+ 1300000p -0.3
+ 1300010p 0.9
+ 1302000p 0.9
+ 1302010p -0.3
+ 1304000p -0.3
+ 1304010p 0.9
+ 1306000p 0.9
+ 1306010p -0.3
+ 1308000p -0.3
+ 1308010p 0.9
+ 1310000p 0.9
+ 1310010p -0.3
+ 1312000p -0.3
+ 1312010p 0.9
+ 1314000p 0.9
+ 1314010p -0.3
+ 1316000p -0.3
+ 1316010p 0.9
+ 1318000p 0.9
+ 1318010p -0.3
+ 1320000p -0.3
+ 1320010p 0.9
+ 1322000p 0.9
+ 1322010p -0.3
+ 1324000p -0.3
+ 1324010p 0.9
+ 1326000p 0.9
+ 1326010p -0.3
+ 1328000p -0.3
+ 1328010p 0.9
+ 1330000p 0.9
+ 1330010p -0.3
+ 1332000p -0.3
+ 1332010p 0.9
+ 1334000p 0.9
+ 1334010p -0.3
+ 1336000p -0.3
+ 1336010p 0.9
+ 1338000p 0.9
+ 1338010p -0.3
+ 1340000p -0.3
+ 1340010p 0.9
+ 1342000p 0.9
+ 1342010p -0.3
+ 1344000p -0.3
+ 1344010p 0.9
+ 1346000p 0.9
+ 1346010p -0.3
+ 1348000p -0.3
+ 1348010p 0.9
+ 1350000p 0.9
+ 1350010p -0.3
+ 1352000p -0.3
+ 1352010p 0.9
+ 1354000p 0.9
+ 1354010p -0.3
+ 1356000p -0.3
+ 1356010p 0.9
+ 1358000p 0.9
+ 1358010p -0.3
+ 1360000p -0.3
+ 1360010p 0.9
+ 1362000p 0.9
+ 1362010p -0.3
+ 1364000p -0.3
+ 1364010p 0.9
+ 1366000p 0.9
+ 1366010p -0.3
+ 1368000p -0.3
+ 1368010p 0.9
+ 1370000p 0.9
+ 1370010p -0.3
+ 1372000p -0.3
+ 1372010p 0.9
+ 1374000p 0.9
+ 1374010p -0.3
+ 1376000p -0.3
+ 1376010p 0.9
+ 1378000p 0.9
+ 1378010p -0.3
+ 1380000p -0.3
+ 1380010p 0.9
+ 1382000p 0.9
+ 1382010p -0.3
+ 1384000p -0.3
+ 1384010p 0.9
+ 1386000p 0.9
+ 1386010p -0.3
+ 1388000p -0.3
+ 1388010p 0.9
+ 1390000p 0.9
+ 1390010p -0.3
+ 1392000p -0.3
+ 1392010p 0.9
+ 1394000p 0.9
+ 1394010p -0.3
+ 1396000p -0.3
+ 1396010p 0.9
+ 1398000p 0.9
+ 1398010p -0.3
+ 1400000p -0.3
+ 1400010p 0.9
+ 1402000p 0.9
+ 1402010p -0.3
+ 1404000p -0.3
+ 1404010p 0.9
+ 1406000p 0.9
+ 1406010p -0.3
+ 1408000p -0.3
+ 1408010p 0.9
+ 1410000p 0.9
+ 1410010p -0.3
+ 1412000p -0.3
+ 1412010p 0.9
+ 1414000p 0.9
+ 1414010p -0.3
+ 1416000p -0.3
+ 1416010p 0.9
+ 1418000p 0.9
+ 1418010p -0.3
+ 1420000p -0.3
+ 1420010p 0.9
+ 1422000p 0.9
+ 1422010p -0.3
+ 1424000p -0.3
+ 1424010p 0.9
+ 1426000p 0.9
+ 1426010p -0.3
+ 1428000p -0.3
+ 1428010p 0.9
+ 1430000p 0.9
+ 1430010p -0.3
+ 1432000p -0.3
+ 1432010p 0.9
+ 1434000p 0.9
+ 1434010p -0.3
+ 1436000p -0.3
+ 1436010p 0.9
+ 1438000p 0.9
+ 1438010p -0.3
+ 1440000p -0.3
+ 1440010p 0.9
+ 1442000p 0.9
+ 1442010p -0.3
+ 1444000p -0.3
+ 1444010p 0.9
+ 1446000p 0.9
+ 1446010p -0.3
+ 1448000p -0.3
+ 1448010p 0.9
+ 1450000p 0.9
+ 1450010p -0.3
+ 1452000p -0.3
+ 1452010p 0.9
+ 1454000p 0.9
+ 1454010p -0.3
+ 1456000p -0.3
+ 1456010p 0.9
+ 1458000p 0.9
+ 1458010p -0.3
+ 1460000p -0.3
+ 1460010p 0.9
+ 1462000p 0.9
+ 1462010p -0.3
+ 1464000p -0.3
+ 1464010p 0.9
+ 1466000p 0.9
+ 1466010p -0.3
+ 1468000p -0.3
+ 1468010p 0.9
+ 1470000p 0.9
+ 1470010p -0.3
+ 1472000p -0.3
+ 1472010p 0.9
+ 1474000p 0.9
+ 1474010p -0.3
+ 1476000p -0.3
+ 1476010p 0.9
+ 1478000p 0.9
+ 1478010p -0.3
+ 1480000p -0.3
+ 1480010p 0.9
+ 1482000p 0.9
+ 1482010p -0.3
+ 1484000p -0.3
+ 1484010p 0.9
+ 1486000p 0.9
+ 1486010p -0.3
+ 1488000p -0.3
+ 1488010p 0.9
+ 1490000p 0.9
+ 1490010p -0.3
+ 1492000p -0.3
+ 1492010p 0.9
+ 1494000p 0.9
+ 1494010p -0.3
+ 1496000p -0.3
+ 1496010p 0.9
+ 1498000p 0.9
+ 1498010p -0.3
+ 1500000p -0.3
+ 1500010p 0.9
+ 1502000p 0.9
+ 1502010p -0.3
+ 1504000p -0.3
+ 1504010p 0.9
+ 1506000p 0.9
+ 1506010p -0.3
+ 1508000p -0.3
+ 1508010p 0.9
+ 1510000p 0.9
+ 1510010p -0.3
+ 1512000p -0.3
+ 1512010p 0.9
+ 1514000p 0.9
+ 1514010p -0.3
+ 1516000p -0.3
+ 1516010p 0.9
+ 1518000p 0.9
+ 1518010p -0.3
+ 1520000p -0.3
+ 1520010p 0.9
+ 1522000p 0.9
+ 1522010p -0.3
+ 1524000p -0.3
+ 1524010p 0.9
+ 1526000p 0.9
+ 1526010p -0.3
+ 1528000p -0.3
+ 1528010p 0.9
+ 1530000p 0.9
+ 1530010p -0.3
+ 1532000p -0.3
+ 1532010p 0.9
+ 1534000p 0.9
+ 1534010p -0.3
+ 1536000p -0.3
+ 1536010p 0.9
+ 1538000p 0.9
+ 1538010p -0.3
+ 1540000p -0.3
+ 1540010p 0.9
+ 1542000p 0.9
+ 1542010p -0.3
+ 1544000p -0.3
+ 1544010p 0.9
+ 1546000p 0.9
+ 1546010p -0.3
+ 1548000p -0.3
+ 1548010p 0.9
+ 1550000p 0.9
+ 1550010p -0.3
+ 1552000p -0.3
+ 1552010p 0.9
+ 1554000p 0.9
+ 1554010p -0.3
+ 1556000p -0.3
+ 1556010p 0.9
+ 1558000p 0.9
+ 1558010p -0.3
+ 1560000p -0.3
+ 1560010p 0.9
+ 1562000p 0.9
+ 1562010p -0.3
+ 1564000p -0.3
+ 1564010p 0.9
+ 1566000p 0.9
+ 1566010p -0.3
+ 1568000p -0.3
+ 1568010p 0.9
+ 1570000p 0.9
+ 1570010p -0.3
+ 1572000p -0.3
+ 1572010p 0.9
+ 1574000p 0.9
+ 1574010p -0.3
+ 1576000p -0.3
+ 1576010p 0.9
+ 1578000p 0.9
+ 1578010p -0.3
+ 1580000p -0.3
+ 1580010p 0.9
+ 1582000p 0.9
+ 1582010p -0.3
+ 1584000p -0.3
+ 1584010p 0.9
+ 1586000p 0.9
+ 1586010p -0.3
+ 1588000p -0.3
+ 1588010p 0.9
+ 1590000p 0.9
+ 1590010p -0.3
+ 1592000p -0.3
+ 1592010p 0.9
+ 1594000p 0.9
+ 1594010p -0.3
+ 1596000p -0.3
+ 1596010p 0.9
+ 1598000p 0.9
+ 1598010p -0.3
+ 1600000p -0.3
+ 1600010p 0.9
+ 1602000p 0.9
+ 1602010p -0.3
+ 1604000p -0.3
+ 1604010p 0.9
+ 1606000p 0.9
+ 1606010p -0.3
+ 1608000p -0.3
+ 1608010p 0.9
+ 1610000p 0.9
+ 1610010p -0.3
+ 1612000p -0.3
+ 1612010p 0.9
+ 1614000p 0.9
+ 1614010p -0.3
+ 1616000p -0.3
+ 1616010p 0.9
+ 1618000p 0.9
+ 1618010p -0.3
+ 1620000p -0.3
+ 1620010p 0.9
+ 1622000p 0.9
+ 1622010p -0.3
+ 1624000p -0.3
+ 1624010p 0.9
+ 1626000p 0.9
+ 1626010p -0.3
+ 1628000p -0.3
+ 1628010p 0.9
+ 1630000p 0.9
+ 1630010p -0.3
+ 1632000p -0.3
+ 1632010p 0.9
+ 1634000p 0.9
+ 1634010p -0.3
+ 1636000p -0.3
+ 1636010p 0.9
+ 1638000p 0.9
+ 1638010p -0.3
+ 1640000p -0.3
+ 1640010p 0.9
+ 1642000p 0.9
+ 1642010p -0.3
+ 1644000p -0.3
+ 1644010p 0.9
+ 1646000p 0.9
+ 1646010p -0.3
+ 1648000p -0.3
+ 1648010p 0.9
+ 1650000p 0.9
+ 1650010p -0.3
+ 1652000p -0.3
+ 1652010p 0.9
+ 1654000p 0.9
+ 1654010p -0.3
+ 1656000p -0.3
+ 1656010p 0.9
+ 1658000p 0.9
+ 1658010p -0.3
+ 1660000p -0.3
+ 1660010p 0.9
+ 1662000p 0.9
+ 1662010p -0.3
+ 1664000p -0.3
+ 1664010p 0.9
+ 1666000p 0.9
+ 1666010p -0.3
+ 1668000p -0.3
+ 1668010p 0.9
+ 1670000p 0.9
+ 1670010p -0.3
+ 1672000p -0.3
+ 1672010p 0.9
+ 1674000p 0.9
+ 1674010p -0.3
+ 1676000p -0.3
+ 1676010p 0.9
+ 1678000p 0.9
+ 1678010p -0.3
+ 1680000p -0.3
+ 1680010p 0.9
+ 1682000p 0.9
+ 1682010p -0.3
+ 1684000p -0.3
+ 1684010p 0.9
+ 1686000p 0.9
+ 1686010p -0.3
+ 1688000p -0.3
+ 1688010p 0.9
+ 1690000p 0.9
+ 1690010p -0.3
+ 1692000p -0.3
+ 1692010p 0.9
+ 1694000p 0.9
+ 1694010p -0.3
+ 1696000p -0.3
+ 1696010p 0.9
+ 1698000p 0.9
+ 1698010p -0.3
+ 1700000p -0.3
+ 1700010p 0.9
+ 1702000p 0.9
+ 1702010p -0.3
+ 1704000p -0.3
+ 1704010p 0.9
+ 1706000p 0.9
+ 1706010p -0.3
+ 1708000p -0.3
+ 1708010p 0.9
+ 1710000p 0.9
+ 1710010p -0.3
+ 1712000p -0.3
+ 1712010p 0.9
+ 1714000p 0.9
+ 1714010p -0.3
+ 1716000p -0.3
+ 1716010p 0.9
+ 1718000p 0.9
+ 1718010p -0.3
+ 1720000p -0.3
+ 1720010p 0.9
+ 1722000p 0.9
+ 1722010p -0.3
+ 1724000p -0.3
+ 1724010p 0.9
+ 1726000p 0.9
+ 1726010p -0.3
+ 1728000p -0.3
+ 1728010p 0.9
+ 1730000p 0.9
+ 1730010p -0.3
+ 1732000p -0.3
+ 1732010p 0.9
+ 1734000p 0.9
+ 1734010p -0.3
+ 1736000p -0.3
+ 1736010p 0.9
+ 1738000p 0.9
+ 1738010p -0.3
+ 1740000p -0.3
+ 1740010p 0.9
+ 1742000p 0.9
+ 1742010p -0.3
+ 1744000p -0.3
+ 1744010p 0.9
+ 1746000p 0.9
+ 1746010p -0.3
+ 1748000p -0.3
+ 1748010p 0.9
+ 1750000p 0.9
+ 1750010p -0.3
+ 1752000p -0.3
+ 1752010p 0.9
+ 1754000p 0.9
+ 1754010p -0.3
+ 1756000p -0.3
+ 1756010p 0.9
+ 1758000p 0.9
+ 1758010p -0.3
+ 1760000p -0.3
+ 1760010p 0.9
+ 1762000p 0.9
+ 1762010p -0.3
+ 1764000p -0.3
+ 1764010p 0.9
+ 1766000p 0.9
+ 1766010p -0.3
+ 1768000p -0.3
+ 1768010p 0.9
+ 1770000p 0.9
+ 1770010p -0.3
+ 1772000p -0.3
+ 1772010p 0.9
+ 1774000p 0.9
+ 1774010p -0.3
+ 1776000p -0.3
+ 1776010p 0.9
+ 1778000p 0.9
+ 1778010p -0.3
+ 1780000p -0.3
+ 1780010p 0.9
+ 1782000p 0.9
+ 1782010p -0.3
+ 1784000p -0.3
+ 1784010p 0.9
+ 1786000p 0.9
+ 1786010p -0.3
+ 1788000p -0.3
+ 1788010p 0.9
+ 1790000p 0.9
+ 1790010p -0.3
+ 1792000p -0.3
+ 1792010p 0.9
+ 1794000p 0.9
+ 1794010p -0.3
+ 1796000p -0.3
+ 1796010p 0.9
+ 1798000p 0.9
+ 1798010p -0.3
+ 1800000p -0.3
+ 1800010p 0.9
+ 1802000p 0.9
+ 1802010p -0.3
+ 1804000p -0.3
+ 1804010p 0.9
+ 1806000p 0.9
+ 1806010p -0.3
+ 1808000p -0.3
+ 1808010p 0.9
+ 1810000p 0.9
+ 1810010p -0.3
+ 1812000p -0.3
+ 1812010p 0.9
+ 1814000p 0.9
+ 1814010p -0.3
+ 1816000p -0.3
+ 1816010p 0.9
+ 1818000p 0.9
+ 1818010p -0.3
+ 1820000p -0.3
+ 1820010p 0.9
+ 1822000p 0.9
+ 1822010p -0.3
+ 1824000p -0.3
+ 1824010p 0.9
+ 1826000p 0.9
+ 1826010p -0.3
+ 1828000p -0.3
+ 1828010p 0.9
+ 1830000p 0.9
+ 1830010p -0.3
+ 1832000p -0.3
+ 1832010p 0.9
+ 1834000p 0.9
+ 1834010p -0.3
+ 1836000p -0.3
+ 1836010p 0.9
+ 1838000p 0.9
+ 1838010p -0.3
+ 1840000p -0.3
+ 1840010p 0.9
+ 1842000p 0.9
+ 1842010p -0.3
+ 1844000p -0.3
+ 1844010p 0.9
+ 1846000p 0.9
+ 1846010p -0.3
+ 1848000p -0.3
+ 1848010p 0.9
+ 1850000p 0.9
+ 1850010p -0.3
+ 1852000p -0.3
+ 1852010p 0.9
+ 1854000p 0.9
+ 1854010p -0.3
+ 1856000p -0.3
+ 1856010p 0.9
+ 1858000p 0.9
+ 1858010p -0.3
+ 1860000p -0.3
+ 1860010p 0.9
+ 1862000p 0.9
+ 1862010p -0.3
+ 1864000p -0.3
+ 1864010p 0.9
+ 1866000p 0.9
+ 1866010p -0.3
+ 1868000p -0.3
+ 1868010p 0.9
+ 1870000p 0.9
+ 1870010p -0.3
+ 1872000p -0.3
+ 1872010p 0.9
+ 1874000p 0.9
+ 1874010p -0.3
+ 1876000p -0.3
+ 1876010p 0.9
+ 1878000p 0.9
+ 1878010p -0.3
+ 1880000p -0.3
+ 1880010p 0.9
+ 1882000p 0.9
+ 1882010p -0.3
+ 1884000p -0.3
+ 1884010p 0.9
+ 1886000p 0.9
+ 1886010p -0.3
+ 1888000p -0.3
+ 1888010p 0.9
+ 1890000p 0.9
+ 1890010p -0.3
+ 1892000p -0.3
+ 1892010p 0.9
+ 1894000p 0.9
+ 1894010p -0.3
+ 1896000p -0.3
+ 1896010p 0.9
+ 1898000p 0.9
+ 1898010p -0.3
+ 1900000p -0.3
+ 1900010p 0.9
+ 1902000p 0.9
+ 1902010p -0.3
+ 1904000p -0.3
+ 1904010p 0.9
+ 1906000p 0.9
+ 1906010p -0.3
+ 1908000p -0.3
+ 1908010p 0.9
+ 1910000p 0.9
+ 1910010p -0.3
+ 1912000p -0.3
+ 1912010p 0.9
+ 1914000p 0.9
+ 1914010p -0.3
+ 1916000p -0.3
+ 1916010p 0.9
+ 1918000p 0.9
+ 1918010p -0.3
+ 1920000p -0.3
+ 1920010p 0.9
+ 1922000p 0.9
+ 1922010p -0.3
+ 1924000p -0.3
+ 1924010p 0.9
+ 1926000p 0.9
+ 1926010p -0.3
+ 1928000p -0.3
+ 1928010p 0.9
+ 1930000p 0.9
+ 1930010p -0.3
+ 1932000p -0.3
+ 1932010p 0.9
+ 1934000p 0.9
+ 1934010p -0.3
+ 1936000p -0.3
+ 1936010p 0.9
+ 1938000p 0.9
+ 1938010p -0.3
+ 1940000p -0.3
+ 1940010p 0.9
+ 1942000p 0.9
+ 1942010p -0.3
+ 1944000p -0.3
+ 1944010p 0.9
+ 1946000p 0.9
+ 1946010p -0.3
+ 1948000p -0.3
+ 1948010p 0.9
+ 1950000p 0.9
+ 1950010p -0.3
+ 1952000p -0.3
+ 1952010p 0.9
+ 1954000p 0.9
+ 1954010p -0.3
+ 1956000p -0.3
+ 1956010p 0.9
+ 1958000p 0.9
+ 1958010p -0.3
+ 1960000p -0.3
+ 1960010p 0.9
+ 1962000p 0.9
+ 1962010p -0.3
+ 1964000p -0.3
+ 1964010p 0.9
+ 1966000p 0.9
+ 1966010p -0.3
+ 1968000p -0.3
+ 1968010p 0.9
+ 1970000p 0.9
+ 1970010p -0.3
+ 1972000p -0.3
+ 1972010p 0.9
+ 1974000p 0.9
+ 1974010p -0.3
+ 1976000p -0.3
+ 1976010p 0.9
+ 1978000p 0.9
+ 1978010p -0.3
+ 1980000p -0.3
+ 1980010p 0.9
+ 1982000p 0.9
+ 1982010p -0.3
+ 1984000p -0.3
+ 1984010p 0.9
+ 1986000p 0.9
+ 1986010p -0.3
+ 1988000p -0.3
+ 1988010p 0.9
+ 1990000p 0.9
+ 1990010p -0.3
+ 1992000p -0.3
+ 1992010p 0.9
+ 1994000p 0.9
+ 1994010p -0.3
+ 1996000p -0.3
+ 1996010p 0.9
+ 1998000p 0.9
+ 1998010p -0.3
+ 2000000p -0.3
+ 2000010p 0.9
+ 2002000p 0.9
+ 2002010p -0.3
+ 2004000p -0.3
+ 2004010p 0.9
+ 2006000p 0.9
+ 2006010p -0.3
+ 2008000p -0.3
+ 2008010p 0.9
+ 2010000p 0.9
+ 2010010p -0.3
+ 2012000p -0.3
+ 2012010p 0.9
+ 2014000p 0.9
+ 2014010p -0.3
+ 2016000p -0.3
+ 2016010p 0.9
+ 2018000p 0.9
+ 2018010p -0.3
+ 2020000p -0.3
+ 2020010p 0.9
+ 2022000p 0.9
+ 2022010p -0.3
+ 2024000p -0.3
+ 2024010p 0.9
+ 2026000p 0.9
+ 2026010p -0.3
+ 2028000p -0.3
+ 2028010p 0.9
+ 2030000p 0.9
+ 2030010p -0.3
+ 2032000p -0.3
+ 2032010p 0.9
+ 2034000p 0.9
+ 2034010p -0.3
+ 2036000p -0.3
+ 2036010p 0.9
+ 2038000p 0.9
+ 2038010p -0.3
+ 2040000p -0.3
+ 2040010p 0.9
+ 2042000p 0.9
+ 2042010p -0.3
+ 2044000p -0.3
+ 2044010p 0.9
+ 2046000p 0.9
+ 2046010p -0.3
+ 2048000p -0.3
+ 2048010p 0.9
+ \]
V_data_bar_5 (Data_bar\\<5\\> gnd!) vsource type=pwl wave=\[
+ 0    -0.3
+ 2000p -0.3
+ 2010p 0.9
+ 4000p 0.9
+ 4010p -0.3
+ 6000p -0.3
+ 6010p 0.9
+ 8000p 0.9
+ 8010p -0.3
+ 10000p -0.3
+ 10010p 0.9
+ 12000p 0.9
+ 12010p -0.3
+ 14000p -0.3
+ 14010p 0.9
+ 16000p 0.9
+ 16010p -0.3
+ 18000p -0.3
+ 18010p 0.9
+ 20000p 0.9
+ 20010p -0.3
+ 22000p -0.3
+ 22010p 0.9
+ 24000p 0.9
+ 24010p -0.3
+ 26000p -0.3
+ 26010p 0.9
+ 28000p 0.9
+ 28010p -0.3
+ 30000p -0.3
+ 30010p 0.9
+ 32000p 0.9
+ 32010p -0.3
+ 34000p -0.3
+ 34010p 0.9
+ 36000p 0.9
+ 36010p -0.3
+ 38000p -0.3
+ 38010p 0.9
+ 40000p 0.9
+ 40010p -0.3
+ 42000p -0.3
+ 42010p 0.9
+ 44000p 0.9
+ 44010p -0.3
+ 46000p -0.3
+ 46010p 0.9
+ 48000p 0.9
+ 48010p -0.3
+ 50000p -0.3
+ 50010p 0.9
+ 52000p 0.9
+ 52010p -0.3
+ 54000p -0.3
+ 54010p 0.9
+ 56000p 0.9
+ 56010p -0.3
+ 58000p -0.3
+ 58010p 0.9
+ 60000p 0.9
+ 60010p -0.3
+ 62000p -0.3
+ 62010p 0.9
+ 64000p 0.9
+ 64010p -0.3
+ 66000p -0.3
+ 66010p 0.9
+ 68000p 0.9
+ 68010p -0.3
+ 70000p -0.3
+ 70010p 0.9
+ 72000p 0.9
+ 72010p -0.3
+ 74000p -0.3
+ 74010p 0.9
+ 76000p 0.9
+ 76010p -0.3
+ 78000p -0.3
+ 78010p 0.9
+ 80000p 0.9
+ 80010p -0.3
+ 82000p -0.3
+ 82010p 0.9
+ 84000p 0.9
+ 84010p -0.3
+ 86000p -0.3
+ 86010p 0.9
+ 88000p 0.9
+ 88010p -0.3
+ 90000p -0.3
+ 90010p 0.9
+ 92000p 0.9
+ 92010p -0.3
+ 94000p -0.3
+ 94010p 0.9
+ 96000p 0.9
+ 96010p -0.3
+ 98000p -0.3
+ 98010p 0.9
+ 100000p 0.9
+ 100010p -0.3
+ 102000p -0.3
+ 102010p 0.9
+ 104000p 0.9
+ 104010p -0.3
+ 106000p -0.3
+ 106010p 0.9
+ 108000p 0.9
+ 108010p -0.3
+ 110000p -0.3
+ 110010p 0.9
+ 112000p 0.9
+ 112010p -0.3
+ 114000p -0.3
+ 114010p 0.9
+ 116000p 0.9
+ 116010p -0.3
+ 118000p -0.3
+ 118010p 0.9
+ 120000p 0.9
+ 120010p -0.3
+ 122000p -0.3
+ 122010p 0.9
+ 124000p 0.9
+ 124010p -0.3
+ 126000p -0.3
+ 126010p 0.9
+ 128000p 0.9
+ 128010p -0.3
+ 130000p -0.3
+ 130010p 0.9
+ 132000p 0.9
+ 132010p -0.3
+ 134000p -0.3
+ 134010p 0.9
+ 136000p 0.9
+ 136010p -0.3
+ 138000p -0.3
+ 138010p 0.9
+ 140000p 0.9
+ 140010p -0.3
+ 142000p -0.3
+ 142010p 0.9
+ 144000p 0.9
+ 144010p -0.3
+ 146000p -0.3
+ 146010p 0.9
+ 148000p 0.9
+ 148010p -0.3
+ 150000p -0.3
+ 150010p 0.9
+ 152000p 0.9
+ 152010p -0.3
+ 154000p -0.3
+ 154010p 0.9
+ 156000p 0.9
+ 156010p -0.3
+ 158000p -0.3
+ 158010p 0.9
+ 160000p 0.9
+ 160010p -0.3
+ 162000p -0.3
+ 162010p 0.9
+ 164000p 0.9
+ 164010p -0.3
+ 166000p -0.3
+ 166010p 0.9
+ 168000p 0.9
+ 168010p -0.3
+ 170000p -0.3
+ 170010p 0.9
+ 172000p 0.9
+ 172010p -0.3
+ 174000p -0.3
+ 174010p 0.9
+ 176000p 0.9
+ 176010p -0.3
+ 178000p -0.3
+ 178010p 0.9
+ 180000p 0.9
+ 180010p -0.3
+ 182000p -0.3
+ 182010p 0.9
+ 184000p 0.9
+ 184010p -0.3
+ 186000p -0.3
+ 186010p 0.9
+ 188000p 0.9
+ 188010p -0.3
+ 190000p -0.3
+ 190010p 0.9
+ 192000p 0.9
+ 192010p -0.3
+ 194000p -0.3
+ 194010p 0.9
+ 196000p 0.9
+ 196010p -0.3
+ 198000p -0.3
+ 198010p 0.9
+ 200000p 0.9
+ 200010p -0.3
+ 202000p -0.3
+ 202010p 0.9
+ 204000p 0.9
+ 204010p -0.3
+ 206000p -0.3
+ 206010p 0.9
+ 208000p 0.9
+ 208010p -0.3
+ 210000p -0.3
+ 210010p 0.9
+ 212000p 0.9
+ 212010p -0.3
+ 214000p -0.3
+ 214010p 0.9
+ 216000p 0.9
+ 216010p -0.3
+ 218000p -0.3
+ 218010p 0.9
+ 220000p 0.9
+ 220010p -0.3
+ 222000p -0.3
+ 222010p 0.9
+ 224000p 0.9
+ 224010p -0.3
+ 226000p -0.3
+ 226010p 0.9
+ 228000p 0.9
+ 228010p -0.3
+ 230000p -0.3
+ 230010p 0.9
+ 232000p 0.9
+ 232010p -0.3
+ 234000p -0.3
+ 234010p 0.9
+ 236000p 0.9
+ 236010p -0.3
+ 238000p -0.3
+ 238010p 0.9
+ 240000p 0.9
+ 240010p -0.3
+ 242000p -0.3
+ 242010p 0.9
+ 244000p 0.9
+ 244010p -0.3
+ 246000p -0.3
+ 246010p 0.9
+ 248000p 0.9
+ 248010p -0.3
+ 250000p -0.3
+ 250010p 0.9
+ 252000p 0.9
+ 252010p -0.3
+ 254000p -0.3
+ 254010p 0.9
+ 256000p 0.9
+ 256010p -0.3
+ 258000p -0.3
+ 258010p 0.9
+ 260000p 0.9
+ 260010p -0.3
+ 262000p -0.3
+ 262010p 0.9
+ 264000p 0.9
+ 264010p -0.3
+ 266000p -0.3
+ 266010p 0.9
+ 268000p 0.9
+ 268010p -0.3
+ 270000p -0.3
+ 270010p 0.9
+ 272000p 0.9
+ 272010p -0.3
+ 274000p -0.3
+ 274010p 0.9
+ 276000p 0.9
+ 276010p -0.3
+ 278000p -0.3
+ 278010p 0.9
+ 280000p 0.9
+ 280010p -0.3
+ 282000p -0.3
+ 282010p 0.9
+ 284000p 0.9
+ 284010p -0.3
+ 286000p -0.3
+ 286010p 0.9
+ 288000p 0.9
+ 288010p -0.3
+ 290000p -0.3
+ 290010p 0.9
+ 292000p 0.9
+ 292010p -0.3
+ 294000p -0.3
+ 294010p 0.9
+ 296000p 0.9
+ 296010p -0.3
+ 298000p -0.3
+ 298010p 0.9
+ 300000p 0.9
+ 300010p -0.3
+ 302000p -0.3
+ 302010p 0.9
+ 304000p 0.9
+ 304010p -0.3
+ 306000p -0.3
+ 306010p 0.9
+ 308000p 0.9
+ 308010p -0.3
+ 310000p -0.3
+ 310010p 0.9
+ 312000p 0.9
+ 312010p -0.3
+ 314000p -0.3
+ 314010p 0.9
+ 316000p 0.9
+ 316010p -0.3
+ 318000p -0.3
+ 318010p 0.9
+ 320000p 0.9
+ 320010p -0.3
+ 322000p -0.3
+ 322010p 0.9
+ 324000p 0.9
+ 324010p -0.3
+ 326000p -0.3
+ 326010p 0.9
+ 328000p 0.9
+ 328010p -0.3
+ 330000p -0.3
+ 330010p 0.9
+ 332000p 0.9
+ 332010p -0.3
+ 334000p -0.3
+ 334010p 0.9
+ 336000p 0.9
+ 336010p -0.3
+ 338000p -0.3
+ 338010p 0.9
+ 340000p 0.9
+ 340010p -0.3
+ 342000p -0.3
+ 342010p 0.9
+ 344000p 0.9
+ 344010p -0.3
+ 346000p -0.3
+ 346010p 0.9
+ 348000p 0.9
+ 348010p -0.3
+ 350000p -0.3
+ 350010p 0.9
+ 352000p 0.9
+ 352010p -0.3
+ 354000p -0.3
+ 354010p 0.9
+ 356000p 0.9
+ 356010p -0.3
+ 358000p -0.3
+ 358010p 0.9
+ 360000p 0.9
+ 360010p -0.3
+ 362000p -0.3
+ 362010p 0.9
+ 364000p 0.9
+ 364010p -0.3
+ 366000p -0.3
+ 366010p 0.9
+ 368000p 0.9
+ 368010p -0.3
+ 370000p -0.3
+ 370010p 0.9
+ 372000p 0.9
+ 372010p -0.3
+ 374000p -0.3
+ 374010p 0.9
+ 376000p 0.9
+ 376010p -0.3
+ 378000p -0.3
+ 378010p 0.9
+ 380000p 0.9
+ 380010p -0.3
+ 382000p -0.3
+ 382010p 0.9
+ 384000p 0.9
+ 384010p -0.3
+ 386000p -0.3
+ 386010p 0.9
+ 388000p 0.9
+ 388010p -0.3
+ 390000p -0.3
+ 390010p 0.9
+ 392000p 0.9
+ 392010p -0.3
+ 394000p -0.3
+ 394010p 0.9
+ 396000p 0.9
+ 396010p -0.3
+ 398000p -0.3
+ 398010p 0.9
+ 400000p 0.9
+ 400010p -0.3
+ 402000p -0.3
+ 402010p 0.9
+ 404000p 0.9
+ 404010p -0.3
+ 406000p -0.3
+ 406010p 0.9
+ 408000p 0.9
+ 408010p -0.3
+ 410000p -0.3
+ 410010p 0.9
+ 412000p 0.9
+ 412010p -0.3
+ 414000p -0.3
+ 414010p 0.9
+ 416000p 0.9
+ 416010p -0.3
+ 418000p -0.3
+ 418010p 0.9
+ 420000p 0.9
+ 420010p -0.3
+ 422000p -0.3
+ 422010p 0.9
+ 424000p 0.9
+ 424010p -0.3
+ 426000p -0.3
+ 426010p 0.9
+ 428000p 0.9
+ 428010p -0.3
+ 430000p -0.3
+ 430010p 0.9
+ 432000p 0.9
+ 432010p -0.3
+ 434000p -0.3
+ 434010p 0.9
+ 436000p 0.9
+ 436010p -0.3
+ 438000p -0.3
+ 438010p 0.9
+ 440000p 0.9
+ 440010p -0.3
+ 442000p -0.3
+ 442010p 0.9
+ 444000p 0.9
+ 444010p -0.3
+ 446000p -0.3
+ 446010p 0.9
+ 448000p 0.9
+ 448010p -0.3
+ 450000p -0.3
+ 450010p 0.9
+ 452000p 0.9
+ 452010p -0.3
+ 454000p -0.3
+ 454010p 0.9
+ 456000p 0.9
+ 456010p -0.3
+ 458000p -0.3
+ 458010p 0.9
+ 460000p 0.9
+ 460010p -0.3
+ 462000p -0.3
+ 462010p 0.9
+ 464000p 0.9
+ 464010p -0.3
+ 466000p -0.3
+ 466010p 0.9
+ 468000p 0.9
+ 468010p -0.3
+ 470000p -0.3
+ 470010p 0.9
+ 472000p 0.9
+ 472010p -0.3
+ 474000p -0.3
+ 474010p 0.9
+ 476000p 0.9
+ 476010p -0.3
+ 478000p -0.3
+ 478010p 0.9
+ 480000p 0.9
+ 480010p -0.3
+ 482000p -0.3
+ 482010p 0.9
+ 484000p 0.9
+ 484010p -0.3
+ 486000p -0.3
+ 486010p 0.9
+ 488000p 0.9
+ 488010p -0.3
+ 490000p -0.3
+ 490010p 0.9
+ 492000p 0.9
+ 492010p -0.3
+ 494000p -0.3
+ 494010p 0.9
+ 496000p 0.9
+ 496010p -0.3
+ 498000p -0.3
+ 498010p 0.9
+ 500000p 0.9
+ 500010p -0.3
+ 502000p -0.3
+ 502010p 0.9
+ 504000p 0.9
+ 504010p -0.3
+ 506000p -0.3
+ 506010p 0.9
+ 508000p 0.9
+ 508010p -0.3
+ 510000p -0.3
+ 510010p 0.9
+ 512000p 0.9
+ 512010p -0.3
+ 514000p -0.3
+ 514010p 0.9
+ 516000p 0.9
+ 516010p -0.3
+ 518000p -0.3
+ 518010p 0.9
+ 520000p 0.9
+ 520010p -0.3
+ 522000p -0.3
+ 522010p 0.9
+ 524000p 0.9
+ 524010p -0.3
+ 526000p -0.3
+ 526010p 0.9
+ 528000p 0.9
+ 528010p -0.3
+ 530000p -0.3
+ 530010p 0.9
+ 532000p 0.9
+ 532010p -0.3
+ 534000p -0.3
+ 534010p 0.9
+ 536000p 0.9
+ 536010p -0.3
+ 538000p -0.3
+ 538010p 0.9
+ 540000p 0.9
+ 540010p -0.3
+ 542000p -0.3
+ 542010p 0.9
+ 544000p 0.9
+ 544010p -0.3
+ 546000p -0.3
+ 546010p 0.9
+ 548000p 0.9
+ 548010p -0.3
+ 550000p -0.3
+ 550010p 0.9
+ 552000p 0.9
+ 552010p -0.3
+ 554000p -0.3
+ 554010p 0.9
+ 556000p 0.9
+ 556010p -0.3
+ 558000p -0.3
+ 558010p 0.9
+ 560000p 0.9
+ 560010p -0.3
+ 562000p -0.3
+ 562010p 0.9
+ 564000p 0.9
+ 564010p -0.3
+ 566000p -0.3
+ 566010p 0.9
+ 568000p 0.9
+ 568010p -0.3
+ 570000p -0.3
+ 570010p 0.9
+ 572000p 0.9
+ 572010p -0.3
+ 574000p -0.3
+ 574010p 0.9
+ 576000p 0.9
+ 576010p -0.3
+ 578000p -0.3
+ 578010p 0.9
+ 580000p 0.9
+ 580010p -0.3
+ 582000p -0.3
+ 582010p 0.9
+ 584000p 0.9
+ 584010p -0.3
+ 586000p -0.3
+ 586010p 0.9
+ 588000p 0.9
+ 588010p -0.3
+ 590000p -0.3
+ 590010p 0.9
+ 592000p 0.9
+ 592010p -0.3
+ 594000p -0.3
+ 594010p 0.9
+ 596000p 0.9
+ 596010p -0.3
+ 598000p -0.3
+ 598010p 0.9
+ 600000p 0.9
+ 600010p -0.3
+ 602000p -0.3
+ 602010p 0.9
+ 604000p 0.9
+ 604010p -0.3
+ 606000p -0.3
+ 606010p 0.9
+ 608000p 0.9
+ 608010p -0.3
+ 610000p -0.3
+ 610010p 0.9
+ 612000p 0.9
+ 612010p -0.3
+ 614000p -0.3
+ 614010p 0.9
+ 616000p 0.9
+ 616010p -0.3
+ 618000p -0.3
+ 618010p 0.9
+ 620000p 0.9
+ 620010p -0.3
+ 622000p -0.3
+ 622010p 0.9
+ 624000p 0.9
+ 624010p -0.3
+ 626000p -0.3
+ 626010p 0.9
+ 628000p 0.9
+ 628010p -0.3
+ 630000p -0.3
+ 630010p 0.9
+ 632000p 0.9
+ 632010p -0.3
+ 634000p -0.3
+ 634010p 0.9
+ 636000p 0.9
+ 636010p -0.3
+ 638000p -0.3
+ 638010p 0.9
+ 640000p 0.9
+ 640010p -0.3
+ 642000p -0.3
+ 642010p 0.9
+ 644000p 0.9
+ 644010p -0.3
+ 646000p -0.3
+ 646010p 0.9
+ 648000p 0.9
+ 648010p -0.3
+ 650000p -0.3
+ 650010p 0.9
+ 652000p 0.9
+ 652010p -0.3
+ 654000p -0.3
+ 654010p 0.9
+ 656000p 0.9
+ 656010p -0.3
+ 658000p -0.3
+ 658010p 0.9
+ 660000p 0.9
+ 660010p -0.3
+ 662000p -0.3
+ 662010p 0.9
+ 664000p 0.9
+ 664010p -0.3
+ 666000p -0.3
+ 666010p 0.9
+ 668000p 0.9
+ 668010p -0.3
+ 670000p -0.3
+ 670010p 0.9
+ 672000p 0.9
+ 672010p -0.3
+ 674000p -0.3
+ 674010p 0.9
+ 676000p 0.9
+ 676010p -0.3
+ 678000p -0.3
+ 678010p 0.9
+ 680000p 0.9
+ 680010p -0.3
+ 682000p -0.3
+ 682010p 0.9
+ 684000p 0.9
+ 684010p -0.3
+ 686000p -0.3
+ 686010p 0.9
+ 688000p 0.9
+ 688010p -0.3
+ 690000p -0.3
+ 690010p 0.9
+ 692000p 0.9
+ 692010p -0.3
+ 694000p -0.3
+ 694010p 0.9
+ 696000p 0.9
+ 696010p -0.3
+ 698000p -0.3
+ 698010p 0.9
+ 700000p 0.9
+ 700010p -0.3
+ 702000p -0.3
+ 702010p 0.9
+ 704000p 0.9
+ 704010p -0.3
+ 706000p -0.3
+ 706010p 0.9
+ 708000p 0.9
+ 708010p -0.3
+ 710000p -0.3
+ 710010p 0.9
+ 712000p 0.9
+ 712010p -0.3
+ 714000p -0.3
+ 714010p 0.9
+ 716000p 0.9
+ 716010p -0.3
+ 718000p -0.3
+ 718010p 0.9
+ 720000p 0.9
+ 720010p -0.3
+ 722000p -0.3
+ 722010p 0.9
+ 724000p 0.9
+ 724010p -0.3
+ 726000p -0.3
+ 726010p 0.9
+ 728000p 0.9
+ 728010p -0.3
+ 730000p -0.3
+ 730010p 0.9
+ 732000p 0.9
+ 732010p -0.3
+ 734000p -0.3
+ 734010p 0.9
+ 736000p 0.9
+ 736010p -0.3
+ 738000p -0.3
+ 738010p 0.9
+ 740000p 0.9
+ 740010p -0.3
+ 742000p -0.3
+ 742010p 0.9
+ 744000p 0.9
+ 744010p -0.3
+ 746000p -0.3
+ 746010p 0.9
+ 748000p 0.9
+ 748010p -0.3
+ 750000p -0.3
+ 750010p 0.9
+ 752000p 0.9
+ 752010p -0.3
+ 754000p -0.3
+ 754010p 0.9
+ 756000p 0.9
+ 756010p -0.3
+ 758000p -0.3
+ 758010p 0.9
+ 760000p 0.9
+ 760010p -0.3
+ 762000p -0.3
+ 762010p 0.9
+ 764000p 0.9
+ 764010p -0.3
+ 766000p -0.3
+ 766010p 0.9
+ 768000p 0.9
+ 768010p -0.3
+ 770000p -0.3
+ 770010p 0.9
+ 772000p 0.9
+ 772010p -0.3
+ 774000p -0.3
+ 774010p 0.9
+ 776000p 0.9
+ 776010p -0.3
+ 778000p -0.3
+ 778010p 0.9
+ 780000p 0.9
+ 780010p -0.3
+ 782000p -0.3
+ 782010p 0.9
+ 784000p 0.9
+ 784010p -0.3
+ 786000p -0.3
+ 786010p 0.9
+ 788000p 0.9
+ 788010p -0.3
+ 790000p -0.3
+ 790010p 0.9
+ 792000p 0.9
+ 792010p -0.3
+ 794000p -0.3
+ 794010p 0.9
+ 796000p 0.9
+ 796010p -0.3
+ 798000p -0.3
+ 798010p 0.9
+ 800000p 0.9
+ 800010p -0.3
+ 802000p -0.3
+ 802010p 0.9
+ 804000p 0.9
+ 804010p -0.3
+ 806000p -0.3
+ 806010p 0.9
+ 808000p 0.9
+ 808010p -0.3
+ 810000p -0.3
+ 810010p 0.9
+ 812000p 0.9
+ 812010p -0.3
+ 814000p -0.3
+ 814010p 0.9
+ 816000p 0.9
+ 816010p -0.3
+ 818000p -0.3
+ 818010p 0.9
+ 820000p 0.9
+ 820010p -0.3
+ 822000p -0.3
+ 822010p 0.9
+ 824000p 0.9
+ 824010p -0.3
+ 826000p -0.3
+ 826010p 0.9
+ 828000p 0.9
+ 828010p -0.3
+ 830000p -0.3
+ 830010p 0.9
+ 832000p 0.9
+ 832010p -0.3
+ 834000p -0.3
+ 834010p 0.9
+ 836000p 0.9
+ 836010p -0.3
+ 838000p -0.3
+ 838010p 0.9
+ 840000p 0.9
+ 840010p -0.3
+ 842000p -0.3
+ 842010p 0.9
+ 844000p 0.9
+ 844010p -0.3
+ 846000p -0.3
+ 846010p 0.9
+ 848000p 0.9
+ 848010p -0.3
+ 850000p -0.3
+ 850010p 0.9
+ 852000p 0.9
+ 852010p -0.3
+ 854000p -0.3
+ 854010p 0.9
+ 856000p 0.9
+ 856010p -0.3
+ 858000p -0.3
+ 858010p 0.9
+ 860000p 0.9
+ 860010p -0.3
+ 862000p -0.3
+ 862010p 0.9
+ 864000p 0.9
+ 864010p -0.3
+ 866000p -0.3
+ 866010p 0.9
+ 868000p 0.9
+ 868010p -0.3
+ 870000p -0.3
+ 870010p 0.9
+ 872000p 0.9
+ 872010p -0.3
+ 874000p -0.3
+ 874010p 0.9
+ 876000p 0.9
+ 876010p -0.3
+ 878000p -0.3
+ 878010p 0.9
+ 880000p 0.9
+ 880010p -0.3
+ 882000p -0.3
+ 882010p 0.9
+ 884000p 0.9
+ 884010p -0.3
+ 886000p -0.3
+ 886010p 0.9
+ 888000p 0.9
+ 888010p -0.3
+ 890000p -0.3
+ 890010p 0.9
+ 892000p 0.9
+ 892010p -0.3
+ 894000p -0.3
+ 894010p 0.9
+ 896000p 0.9
+ 896010p -0.3
+ 898000p -0.3
+ 898010p 0.9
+ 900000p 0.9
+ 900010p -0.3
+ 902000p -0.3
+ 902010p 0.9
+ 904000p 0.9
+ 904010p -0.3
+ 906000p -0.3
+ 906010p 0.9
+ 908000p 0.9
+ 908010p -0.3
+ 910000p -0.3
+ 910010p 0.9
+ 912000p 0.9
+ 912010p -0.3
+ 914000p -0.3
+ 914010p 0.9
+ 916000p 0.9
+ 916010p -0.3
+ 918000p -0.3
+ 918010p 0.9
+ 920000p 0.9
+ 920010p -0.3
+ 922000p -0.3
+ 922010p 0.9
+ 924000p 0.9
+ 924010p -0.3
+ 926000p -0.3
+ 926010p 0.9
+ 928000p 0.9
+ 928010p -0.3
+ 930000p -0.3
+ 930010p 0.9
+ 932000p 0.9
+ 932010p -0.3
+ 934000p -0.3
+ 934010p 0.9
+ 936000p 0.9
+ 936010p -0.3
+ 938000p -0.3
+ 938010p 0.9
+ 940000p 0.9
+ 940010p -0.3
+ 942000p -0.3
+ 942010p 0.9
+ 944000p 0.9
+ 944010p -0.3
+ 946000p -0.3
+ 946010p 0.9
+ 948000p 0.9
+ 948010p -0.3
+ 950000p -0.3
+ 950010p 0.9
+ 952000p 0.9
+ 952010p -0.3
+ 954000p -0.3
+ 954010p 0.9
+ 956000p 0.9
+ 956010p -0.3
+ 958000p -0.3
+ 958010p 0.9
+ 960000p 0.9
+ 960010p -0.3
+ 962000p -0.3
+ 962010p 0.9
+ 964000p 0.9
+ 964010p -0.3
+ 966000p -0.3
+ 966010p 0.9
+ 968000p 0.9
+ 968010p -0.3
+ 970000p -0.3
+ 970010p 0.9
+ 972000p 0.9
+ 972010p -0.3
+ 974000p -0.3
+ 974010p 0.9
+ 976000p 0.9
+ 976010p -0.3
+ 978000p -0.3
+ 978010p 0.9
+ 980000p 0.9
+ 980010p -0.3
+ 982000p -0.3
+ 982010p 0.9
+ 984000p 0.9
+ 984010p -0.3
+ 986000p -0.3
+ 986010p 0.9
+ 988000p 0.9
+ 988010p -0.3
+ 990000p -0.3
+ 990010p 0.9
+ 992000p 0.9
+ 992010p -0.3
+ 994000p -0.3
+ 994010p 0.9
+ 996000p 0.9
+ 996010p -0.3
+ 998000p -0.3
+ 998010p 0.9
+ 1000000p 0.9
+ 1000010p -0.3
+ 1002000p -0.3
+ 1002010p 0.9
+ 1004000p 0.9
+ 1004010p -0.3
+ 1006000p -0.3
+ 1006010p 0.9
+ 1008000p 0.9
+ 1008010p -0.3
+ 1010000p -0.3
+ 1010010p 0.9
+ 1012000p 0.9
+ 1012010p -0.3
+ 1014000p -0.3
+ 1014010p 0.9
+ 1016000p 0.9
+ 1016010p -0.3
+ 1018000p -0.3
+ 1018010p 0.9
+ 1020000p 0.9
+ 1020010p -0.3
+ 1022000p -0.3
+ 1022010p 0.9
+ 1024000p 0.9
+ 1024010p -0.3
+ 1026000p -0.3
+ 1026010p 0.9
+ 1028000p 0.9
+ 1028010p -0.3
+ 1030000p -0.3
+ 1030010p 0.9
+ 1032000p 0.9
+ 1032010p -0.3
+ 1034000p -0.3
+ 1034010p 0.9
+ 1036000p 0.9
+ 1036010p -0.3
+ 1038000p -0.3
+ 1038010p 0.9
+ 1040000p 0.9
+ 1040010p -0.3
+ 1042000p -0.3
+ 1042010p 0.9
+ 1044000p 0.9
+ 1044010p -0.3
+ 1046000p -0.3
+ 1046010p 0.9
+ 1048000p 0.9
+ 1048010p -0.3
+ 1050000p -0.3
+ 1050010p 0.9
+ 1052000p 0.9
+ 1052010p -0.3
+ 1054000p -0.3
+ 1054010p 0.9
+ 1056000p 0.9
+ 1056010p -0.3
+ 1058000p -0.3
+ 1058010p 0.9
+ 1060000p 0.9
+ 1060010p -0.3
+ 1062000p -0.3
+ 1062010p 0.9
+ 1064000p 0.9
+ 1064010p -0.3
+ 1066000p -0.3
+ 1066010p 0.9
+ 1068000p 0.9
+ 1068010p -0.3
+ 1070000p -0.3
+ 1070010p 0.9
+ 1072000p 0.9
+ 1072010p -0.3
+ 1074000p -0.3
+ 1074010p 0.9
+ 1076000p 0.9
+ 1076010p -0.3
+ 1078000p -0.3
+ 1078010p 0.9
+ 1080000p 0.9
+ 1080010p -0.3
+ 1082000p -0.3
+ 1082010p 0.9
+ 1084000p 0.9
+ 1084010p -0.3
+ 1086000p -0.3
+ 1086010p 0.9
+ 1088000p 0.9
+ 1088010p -0.3
+ 1090000p -0.3
+ 1090010p 0.9
+ 1092000p 0.9
+ 1092010p -0.3
+ 1094000p -0.3
+ 1094010p 0.9
+ 1096000p 0.9
+ 1096010p -0.3
+ 1098000p -0.3
+ 1098010p 0.9
+ 1100000p 0.9
+ 1100010p -0.3
+ 1102000p -0.3
+ 1102010p 0.9
+ 1104000p 0.9
+ 1104010p -0.3
+ 1106000p -0.3
+ 1106010p 0.9
+ 1108000p 0.9
+ 1108010p -0.3
+ 1110000p -0.3
+ 1110010p 0.9
+ 1112000p 0.9
+ 1112010p -0.3
+ 1114000p -0.3
+ 1114010p 0.9
+ 1116000p 0.9
+ 1116010p -0.3
+ 1118000p -0.3
+ 1118010p 0.9
+ 1120000p 0.9
+ 1120010p -0.3
+ 1122000p -0.3
+ 1122010p 0.9
+ 1124000p 0.9
+ 1124010p -0.3
+ 1126000p -0.3
+ 1126010p 0.9
+ 1128000p 0.9
+ 1128010p -0.3
+ 1130000p -0.3
+ 1130010p 0.9
+ 1132000p 0.9
+ 1132010p -0.3
+ 1134000p -0.3
+ 1134010p 0.9
+ 1136000p 0.9
+ 1136010p -0.3
+ 1138000p -0.3
+ 1138010p 0.9
+ 1140000p 0.9
+ 1140010p -0.3
+ 1142000p -0.3
+ 1142010p 0.9
+ 1144000p 0.9
+ 1144010p -0.3
+ 1146000p -0.3
+ 1146010p 0.9
+ 1148000p 0.9
+ 1148010p -0.3
+ 1150000p -0.3
+ 1150010p 0.9
+ 1152000p 0.9
+ 1152010p -0.3
+ 1154000p -0.3
+ 1154010p 0.9
+ 1156000p 0.9
+ 1156010p -0.3
+ 1158000p -0.3
+ 1158010p 0.9
+ 1160000p 0.9
+ 1160010p -0.3
+ 1162000p -0.3
+ 1162010p 0.9
+ 1164000p 0.9
+ 1164010p -0.3
+ 1166000p -0.3
+ 1166010p 0.9
+ 1168000p 0.9
+ 1168010p -0.3
+ 1170000p -0.3
+ 1170010p 0.9
+ 1172000p 0.9
+ 1172010p -0.3
+ 1174000p -0.3
+ 1174010p 0.9
+ 1176000p 0.9
+ 1176010p -0.3
+ 1178000p -0.3
+ 1178010p 0.9
+ 1180000p 0.9
+ 1180010p -0.3
+ 1182000p -0.3
+ 1182010p 0.9
+ 1184000p 0.9
+ 1184010p -0.3
+ 1186000p -0.3
+ 1186010p 0.9
+ 1188000p 0.9
+ 1188010p -0.3
+ 1190000p -0.3
+ 1190010p 0.9
+ 1192000p 0.9
+ 1192010p -0.3
+ 1194000p -0.3
+ 1194010p 0.9
+ 1196000p 0.9
+ 1196010p -0.3
+ 1198000p -0.3
+ 1198010p 0.9
+ 1200000p 0.9
+ 1200010p -0.3
+ 1202000p -0.3
+ 1202010p 0.9
+ 1204000p 0.9
+ 1204010p -0.3
+ 1206000p -0.3
+ 1206010p 0.9
+ 1208000p 0.9
+ 1208010p -0.3
+ 1210000p -0.3
+ 1210010p 0.9
+ 1212000p 0.9
+ 1212010p -0.3
+ 1214000p -0.3
+ 1214010p 0.9
+ 1216000p 0.9
+ 1216010p -0.3
+ 1218000p -0.3
+ 1218010p 0.9
+ 1220000p 0.9
+ 1220010p -0.3
+ 1222000p -0.3
+ 1222010p 0.9
+ 1224000p 0.9
+ 1224010p -0.3
+ 1226000p -0.3
+ 1226010p 0.9
+ 1228000p 0.9
+ 1228010p -0.3
+ 1230000p -0.3
+ 1230010p 0.9
+ 1232000p 0.9
+ 1232010p -0.3
+ 1234000p -0.3
+ 1234010p 0.9
+ 1236000p 0.9
+ 1236010p -0.3
+ 1238000p -0.3
+ 1238010p 0.9
+ 1240000p 0.9
+ 1240010p -0.3
+ 1242000p -0.3
+ 1242010p 0.9
+ 1244000p 0.9
+ 1244010p -0.3
+ 1246000p -0.3
+ 1246010p 0.9
+ 1248000p 0.9
+ 1248010p -0.3
+ 1250000p -0.3
+ 1250010p 0.9
+ 1252000p 0.9
+ 1252010p -0.3
+ 1254000p -0.3
+ 1254010p 0.9
+ 1256000p 0.9
+ 1256010p -0.3
+ 1258000p -0.3
+ 1258010p 0.9
+ 1260000p 0.9
+ 1260010p -0.3
+ 1262000p -0.3
+ 1262010p 0.9
+ 1264000p 0.9
+ 1264010p -0.3
+ 1266000p -0.3
+ 1266010p 0.9
+ 1268000p 0.9
+ 1268010p -0.3
+ 1270000p -0.3
+ 1270010p 0.9
+ 1272000p 0.9
+ 1272010p -0.3
+ 1274000p -0.3
+ 1274010p 0.9
+ 1276000p 0.9
+ 1276010p -0.3
+ 1278000p -0.3
+ 1278010p 0.9
+ 1280000p 0.9
+ 1280010p -0.3
+ 1282000p -0.3
+ 1282010p 0.9
+ 1284000p 0.9
+ 1284010p -0.3
+ 1286000p -0.3
+ 1286010p 0.9
+ 1288000p 0.9
+ 1288010p -0.3
+ 1290000p -0.3
+ 1290010p 0.9
+ 1292000p 0.9
+ 1292010p -0.3
+ 1294000p -0.3
+ 1294010p 0.9
+ 1296000p 0.9
+ 1296010p -0.3
+ 1298000p -0.3
+ 1298010p 0.9
+ 1300000p 0.9
+ 1300010p -0.3
+ 1302000p -0.3
+ 1302010p 0.9
+ 1304000p 0.9
+ 1304010p -0.3
+ 1306000p -0.3
+ 1306010p 0.9
+ 1308000p 0.9
+ 1308010p -0.3
+ 1310000p -0.3
+ 1310010p 0.9
+ 1312000p 0.9
+ 1312010p -0.3
+ 1314000p -0.3
+ 1314010p 0.9
+ 1316000p 0.9
+ 1316010p -0.3
+ 1318000p -0.3
+ 1318010p 0.9
+ 1320000p 0.9
+ 1320010p -0.3
+ 1322000p -0.3
+ 1322010p 0.9
+ 1324000p 0.9
+ 1324010p -0.3
+ 1326000p -0.3
+ 1326010p 0.9
+ 1328000p 0.9
+ 1328010p -0.3
+ 1330000p -0.3
+ 1330010p 0.9
+ 1332000p 0.9
+ 1332010p -0.3
+ 1334000p -0.3
+ 1334010p 0.9
+ 1336000p 0.9
+ 1336010p -0.3
+ 1338000p -0.3
+ 1338010p 0.9
+ 1340000p 0.9
+ 1340010p -0.3
+ 1342000p -0.3
+ 1342010p 0.9
+ 1344000p 0.9
+ 1344010p -0.3
+ 1346000p -0.3
+ 1346010p 0.9
+ 1348000p 0.9
+ 1348010p -0.3
+ 1350000p -0.3
+ 1350010p 0.9
+ 1352000p 0.9
+ 1352010p -0.3
+ 1354000p -0.3
+ 1354010p 0.9
+ 1356000p 0.9
+ 1356010p -0.3
+ 1358000p -0.3
+ 1358010p 0.9
+ 1360000p 0.9
+ 1360010p -0.3
+ 1362000p -0.3
+ 1362010p 0.9
+ 1364000p 0.9
+ 1364010p -0.3
+ 1366000p -0.3
+ 1366010p 0.9
+ 1368000p 0.9
+ 1368010p -0.3
+ 1370000p -0.3
+ 1370010p 0.9
+ 1372000p 0.9
+ 1372010p -0.3
+ 1374000p -0.3
+ 1374010p 0.9
+ 1376000p 0.9
+ 1376010p -0.3
+ 1378000p -0.3
+ 1378010p 0.9
+ 1380000p 0.9
+ 1380010p -0.3
+ 1382000p -0.3
+ 1382010p 0.9
+ 1384000p 0.9
+ 1384010p -0.3
+ 1386000p -0.3
+ 1386010p 0.9
+ 1388000p 0.9
+ 1388010p -0.3
+ 1390000p -0.3
+ 1390010p 0.9
+ 1392000p 0.9
+ 1392010p -0.3
+ 1394000p -0.3
+ 1394010p 0.9
+ 1396000p 0.9
+ 1396010p -0.3
+ 1398000p -0.3
+ 1398010p 0.9
+ 1400000p 0.9
+ 1400010p -0.3
+ 1402000p -0.3
+ 1402010p 0.9
+ 1404000p 0.9
+ 1404010p -0.3
+ 1406000p -0.3
+ 1406010p 0.9
+ 1408000p 0.9
+ 1408010p -0.3
+ 1410000p -0.3
+ 1410010p 0.9
+ 1412000p 0.9
+ 1412010p -0.3
+ 1414000p -0.3
+ 1414010p 0.9
+ 1416000p 0.9
+ 1416010p -0.3
+ 1418000p -0.3
+ 1418010p 0.9
+ 1420000p 0.9
+ 1420010p -0.3
+ 1422000p -0.3
+ 1422010p 0.9
+ 1424000p 0.9
+ 1424010p -0.3
+ 1426000p -0.3
+ 1426010p 0.9
+ 1428000p 0.9
+ 1428010p -0.3
+ 1430000p -0.3
+ 1430010p 0.9
+ 1432000p 0.9
+ 1432010p -0.3
+ 1434000p -0.3
+ 1434010p 0.9
+ 1436000p 0.9
+ 1436010p -0.3
+ 1438000p -0.3
+ 1438010p 0.9
+ 1440000p 0.9
+ 1440010p -0.3
+ 1442000p -0.3
+ 1442010p 0.9
+ 1444000p 0.9
+ 1444010p -0.3
+ 1446000p -0.3
+ 1446010p 0.9
+ 1448000p 0.9
+ 1448010p -0.3
+ 1450000p -0.3
+ 1450010p 0.9
+ 1452000p 0.9
+ 1452010p -0.3
+ 1454000p -0.3
+ 1454010p 0.9
+ 1456000p 0.9
+ 1456010p -0.3
+ 1458000p -0.3
+ 1458010p 0.9
+ 1460000p 0.9
+ 1460010p -0.3
+ 1462000p -0.3
+ 1462010p 0.9
+ 1464000p 0.9
+ 1464010p -0.3
+ 1466000p -0.3
+ 1466010p 0.9
+ 1468000p 0.9
+ 1468010p -0.3
+ 1470000p -0.3
+ 1470010p 0.9
+ 1472000p 0.9
+ 1472010p -0.3
+ 1474000p -0.3
+ 1474010p 0.9
+ 1476000p 0.9
+ 1476010p -0.3
+ 1478000p -0.3
+ 1478010p 0.9
+ 1480000p 0.9
+ 1480010p -0.3
+ 1482000p -0.3
+ 1482010p 0.9
+ 1484000p 0.9
+ 1484010p -0.3
+ 1486000p -0.3
+ 1486010p 0.9
+ 1488000p 0.9
+ 1488010p -0.3
+ 1490000p -0.3
+ 1490010p 0.9
+ 1492000p 0.9
+ 1492010p -0.3
+ 1494000p -0.3
+ 1494010p 0.9
+ 1496000p 0.9
+ 1496010p -0.3
+ 1498000p -0.3
+ 1498010p 0.9
+ 1500000p 0.9
+ 1500010p -0.3
+ 1502000p -0.3
+ 1502010p 0.9
+ 1504000p 0.9
+ 1504010p -0.3
+ 1506000p -0.3
+ 1506010p 0.9
+ 1508000p 0.9
+ 1508010p -0.3
+ 1510000p -0.3
+ 1510010p 0.9
+ 1512000p 0.9
+ 1512010p -0.3
+ 1514000p -0.3
+ 1514010p 0.9
+ 1516000p 0.9
+ 1516010p -0.3
+ 1518000p -0.3
+ 1518010p 0.9
+ 1520000p 0.9
+ 1520010p -0.3
+ 1522000p -0.3
+ 1522010p 0.9
+ 1524000p 0.9
+ 1524010p -0.3
+ 1526000p -0.3
+ 1526010p 0.9
+ 1528000p 0.9
+ 1528010p -0.3
+ 1530000p -0.3
+ 1530010p 0.9
+ 1532000p 0.9
+ 1532010p -0.3
+ 1534000p -0.3
+ 1534010p 0.9
+ 1536000p 0.9
+ 1536010p -0.3
+ 1538000p -0.3
+ 1538010p 0.9
+ 1540000p 0.9
+ 1540010p -0.3
+ 1542000p -0.3
+ 1542010p 0.9
+ 1544000p 0.9
+ 1544010p -0.3
+ 1546000p -0.3
+ 1546010p 0.9
+ 1548000p 0.9
+ 1548010p -0.3
+ 1550000p -0.3
+ 1550010p 0.9
+ 1552000p 0.9
+ 1552010p -0.3
+ 1554000p -0.3
+ 1554010p 0.9
+ 1556000p 0.9
+ 1556010p -0.3
+ 1558000p -0.3
+ 1558010p 0.9
+ 1560000p 0.9
+ 1560010p -0.3
+ 1562000p -0.3
+ 1562010p 0.9
+ 1564000p 0.9
+ 1564010p -0.3
+ 1566000p -0.3
+ 1566010p 0.9
+ 1568000p 0.9
+ 1568010p -0.3
+ 1570000p -0.3
+ 1570010p 0.9
+ 1572000p 0.9
+ 1572010p -0.3
+ 1574000p -0.3
+ 1574010p 0.9
+ 1576000p 0.9
+ 1576010p -0.3
+ 1578000p -0.3
+ 1578010p 0.9
+ 1580000p 0.9
+ 1580010p -0.3
+ 1582000p -0.3
+ 1582010p 0.9
+ 1584000p 0.9
+ 1584010p -0.3
+ 1586000p -0.3
+ 1586010p 0.9
+ 1588000p 0.9
+ 1588010p -0.3
+ 1590000p -0.3
+ 1590010p 0.9
+ 1592000p 0.9
+ 1592010p -0.3
+ 1594000p -0.3
+ 1594010p 0.9
+ 1596000p 0.9
+ 1596010p -0.3
+ 1598000p -0.3
+ 1598010p 0.9
+ 1600000p 0.9
+ 1600010p -0.3
+ 1602000p -0.3
+ 1602010p 0.9
+ 1604000p 0.9
+ 1604010p -0.3
+ 1606000p -0.3
+ 1606010p 0.9
+ 1608000p 0.9
+ 1608010p -0.3
+ 1610000p -0.3
+ 1610010p 0.9
+ 1612000p 0.9
+ 1612010p -0.3
+ 1614000p -0.3
+ 1614010p 0.9
+ 1616000p 0.9
+ 1616010p -0.3
+ 1618000p -0.3
+ 1618010p 0.9
+ 1620000p 0.9
+ 1620010p -0.3
+ 1622000p -0.3
+ 1622010p 0.9
+ 1624000p 0.9
+ 1624010p -0.3
+ 1626000p -0.3
+ 1626010p 0.9
+ 1628000p 0.9
+ 1628010p -0.3
+ 1630000p -0.3
+ 1630010p 0.9
+ 1632000p 0.9
+ 1632010p -0.3
+ 1634000p -0.3
+ 1634010p 0.9
+ 1636000p 0.9
+ 1636010p -0.3
+ 1638000p -0.3
+ 1638010p 0.9
+ 1640000p 0.9
+ 1640010p -0.3
+ 1642000p -0.3
+ 1642010p 0.9
+ 1644000p 0.9
+ 1644010p -0.3
+ 1646000p -0.3
+ 1646010p 0.9
+ 1648000p 0.9
+ 1648010p -0.3
+ 1650000p -0.3
+ 1650010p 0.9
+ 1652000p 0.9
+ 1652010p -0.3
+ 1654000p -0.3
+ 1654010p 0.9
+ 1656000p 0.9
+ 1656010p -0.3
+ 1658000p -0.3
+ 1658010p 0.9
+ 1660000p 0.9
+ 1660010p -0.3
+ 1662000p -0.3
+ 1662010p 0.9
+ 1664000p 0.9
+ 1664010p -0.3
+ 1666000p -0.3
+ 1666010p 0.9
+ 1668000p 0.9
+ 1668010p -0.3
+ 1670000p -0.3
+ 1670010p 0.9
+ 1672000p 0.9
+ 1672010p -0.3
+ 1674000p -0.3
+ 1674010p 0.9
+ 1676000p 0.9
+ 1676010p -0.3
+ 1678000p -0.3
+ 1678010p 0.9
+ 1680000p 0.9
+ 1680010p -0.3
+ 1682000p -0.3
+ 1682010p 0.9
+ 1684000p 0.9
+ 1684010p -0.3
+ 1686000p -0.3
+ 1686010p 0.9
+ 1688000p 0.9
+ 1688010p -0.3
+ 1690000p -0.3
+ 1690010p 0.9
+ 1692000p 0.9
+ 1692010p -0.3
+ 1694000p -0.3
+ 1694010p 0.9
+ 1696000p 0.9
+ 1696010p -0.3
+ 1698000p -0.3
+ 1698010p 0.9
+ 1700000p 0.9
+ 1700010p -0.3
+ 1702000p -0.3
+ 1702010p 0.9
+ 1704000p 0.9
+ 1704010p -0.3
+ 1706000p -0.3
+ 1706010p 0.9
+ 1708000p 0.9
+ 1708010p -0.3
+ 1710000p -0.3
+ 1710010p 0.9
+ 1712000p 0.9
+ 1712010p -0.3
+ 1714000p -0.3
+ 1714010p 0.9
+ 1716000p 0.9
+ 1716010p -0.3
+ 1718000p -0.3
+ 1718010p 0.9
+ 1720000p 0.9
+ 1720010p -0.3
+ 1722000p -0.3
+ 1722010p 0.9
+ 1724000p 0.9
+ 1724010p -0.3
+ 1726000p -0.3
+ 1726010p 0.9
+ 1728000p 0.9
+ 1728010p -0.3
+ 1730000p -0.3
+ 1730010p 0.9
+ 1732000p 0.9
+ 1732010p -0.3
+ 1734000p -0.3
+ 1734010p 0.9
+ 1736000p 0.9
+ 1736010p -0.3
+ 1738000p -0.3
+ 1738010p 0.9
+ 1740000p 0.9
+ 1740010p -0.3
+ 1742000p -0.3
+ 1742010p 0.9
+ 1744000p 0.9
+ 1744010p -0.3
+ 1746000p -0.3
+ 1746010p 0.9
+ 1748000p 0.9
+ 1748010p -0.3
+ 1750000p -0.3
+ 1750010p 0.9
+ 1752000p 0.9
+ 1752010p -0.3
+ 1754000p -0.3
+ 1754010p 0.9
+ 1756000p 0.9
+ 1756010p -0.3
+ 1758000p -0.3
+ 1758010p 0.9
+ 1760000p 0.9
+ 1760010p -0.3
+ 1762000p -0.3
+ 1762010p 0.9
+ 1764000p 0.9
+ 1764010p -0.3
+ 1766000p -0.3
+ 1766010p 0.9
+ 1768000p 0.9
+ 1768010p -0.3
+ 1770000p -0.3
+ 1770010p 0.9
+ 1772000p 0.9
+ 1772010p -0.3
+ 1774000p -0.3
+ 1774010p 0.9
+ 1776000p 0.9
+ 1776010p -0.3
+ 1778000p -0.3
+ 1778010p 0.9
+ 1780000p 0.9
+ 1780010p -0.3
+ 1782000p -0.3
+ 1782010p 0.9
+ 1784000p 0.9
+ 1784010p -0.3
+ 1786000p -0.3
+ 1786010p 0.9
+ 1788000p 0.9
+ 1788010p -0.3
+ 1790000p -0.3
+ 1790010p 0.9
+ 1792000p 0.9
+ 1792010p -0.3
+ 1794000p -0.3
+ 1794010p 0.9
+ 1796000p 0.9
+ 1796010p -0.3
+ 1798000p -0.3
+ 1798010p 0.9
+ 1800000p 0.9
+ 1800010p -0.3
+ 1802000p -0.3
+ 1802010p 0.9
+ 1804000p 0.9
+ 1804010p -0.3
+ 1806000p -0.3
+ 1806010p 0.9
+ 1808000p 0.9
+ 1808010p -0.3
+ 1810000p -0.3
+ 1810010p 0.9
+ 1812000p 0.9
+ 1812010p -0.3
+ 1814000p -0.3
+ 1814010p 0.9
+ 1816000p 0.9
+ 1816010p -0.3
+ 1818000p -0.3
+ 1818010p 0.9
+ 1820000p 0.9
+ 1820010p -0.3
+ 1822000p -0.3
+ 1822010p 0.9
+ 1824000p 0.9
+ 1824010p -0.3
+ 1826000p -0.3
+ 1826010p 0.9
+ 1828000p 0.9
+ 1828010p -0.3
+ 1830000p -0.3
+ 1830010p 0.9
+ 1832000p 0.9
+ 1832010p -0.3
+ 1834000p -0.3
+ 1834010p 0.9
+ 1836000p 0.9
+ 1836010p -0.3
+ 1838000p -0.3
+ 1838010p 0.9
+ 1840000p 0.9
+ 1840010p -0.3
+ 1842000p -0.3
+ 1842010p 0.9
+ 1844000p 0.9
+ 1844010p -0.3
+ 1846000p -0.3
+ 1846010p 0.9
+ 1848000p 0.9
+ 1848010p -0.3
+ 1850000p -0.3
+ 1850010p 0.9
+ 1852000p 0.9
+ 1852010p -0.3
+ 1854000p -0.3
+ 1854010p 0.9
+ 1856000p 0.9
+ 1856010p -0.3
+ 1858000p -0.3
+ 1858010p 0.9
+ 1860000p 0.9
+ 1860010p -0.3
+ 1862000p -0.3
+ 1862010p 0.9
+ 1864000p 0.9
+ 1864010p -0.3
+ 1866000p -0.3
+ 1866010p 0.9
+ 1868000p 0.9
+ 1868010p -0.3
+ 1870000p -0.3
+ 1870010p 0.9
+ 1872000p 0.9
+ 1872010p -0.3
+ 1874000p -0.3
+ 1874010p 0.9
+ 1876000p 0.9
+ 1876010p -0.3
+ 1878000p -0.3
+ 1878010p 0.9
+ 1880000p 0.9
+ 1880010p -0.3
+ 1882000p -0.3
+ 1882010p 0.9
+ 1884000p 0.9
+ 1884010p -0.3
+ 1886000p -0.3
+ 1886010p 0.9
+ 1888000p 0.9
+ 1888010p -0.3
+ 1890000p -0.3
+ 1890010p 0.9
+ 1892000p 0.9
+ 1892010p -0.3
+ 1894000p -0.3
+ 1894010p 0.9
+ 1896000p 0.9
+ 1896010p -0.3
+ 1898000p -0.3
+ 1898010p 0.9
+ 1900000p 0.9
+ 1900010p -0.3
+ 1902000p -0.3
+ 1902010p 0.9
+ 1904000p 0.9
+ 1904010p -0.3
+ 1906000p -0.3
+ 1906010p 0.9
+ 1908000p 0.9
+ 1908010p -0.3
+ 1910000p -0.3
+ 1910010p 0.9
+ 1912000p 0.9
+ 1912010p -0.3
+ 1914000p -0.3
+ 1914010p 0.9
+ 1916000p 0.9
+ 1916010p -0.3
+ 1918000p -0.3
+ 1918010p 0.9
+ 1920000p 0.9
+ 1920010p -0.3
+ 1922000p -0.3
+ 1922010p 0.9
+ 1924000p 0.9
+ 1924010p -0.3
+ 1926000p -0.3
+ 1926010p 0.9
+ 1928000p 0.9
+ 1928010p -0.3
+ 1930000p -0.3
+ 1930010p 0.9
+ 1932000p 0.9
+ 1932010p -0.3
+ 1934000p -0.3
+ 1934010p 0.9
+ 1936000p 0.9
+ 1936010p -0.3
+ 1938000p -0.3
+ 1938010p 0.9
+ 1940000p 0.9
+ 1940010p -0.3
+ 1942000p -0.3
+ 1942010p 0.9
+ 1944000p 0.9
+ 1944010p -0.3
+ 1946000p -0.3
+ 1946010p 0.9
+ 1948000p 0.9
+ 1948010p -0.3
+ 1950000p -0.3
+ 1950010p 0.9
+ 1952000p 0.9
+ 1952010p -0.3
+ 1954000p -0.3
+ 1954010p 0.9
+ 1956000p 0.9
+ 1956010p -0.3
+ 1958000p -0.3
+ 1958010p 0.9
+ 1960000p 0.9
+ 1960010p -0.3
+ 1962000p -0.3
+ 1962010p 0.9
+ 1964000p 0.9
+ 1964010p -0.3
+ 1966000p -0.3
+ 1966010p 0.9
+ 1968000p 0.9
+ 1968010p -0.3
+ 1970000p -0.3
+ 1970010p 0.9
+ 1972000p 0.9
+ 1972010p -0.3
+ 1974000p -0.3
+ 1974010p 0.9
+ 1976000p 0.9
+ 1976010p -0.3
+ 1978000p -0.3
+ 1978010p 0.9
+ 1980000p 0.9
+ 1980010p -0.3
+ 1982000p -0.3
+ 1982010p 0.9
+ 1984000p 0.9
+ 1984010p -0.3
+ 1986000p -0.3
+ 1986010p 0.9
+ 1988000p 0.9
+ 1988010p -0.3
+ 1990000p -0.3
+ 1990010p 0.9
+ 1992000p 0.9
+ 1992010p -0.3
+ 1994000p -0.3
+ 1994010p 0.9
+ 1996000p 0.9
+ 1996010p -0.3
+ 1998000p -0.3
+ 1998010p 0.9
+ 2000000p 0.9
+ 2000010p -0.3
+ 2002000p -0.3
+ 2002010p 0.9
+ 2004000p 0.9
+ 2004010p -0.3
+ 2006000p -0.3
+ 2006010p 0.9
+ 2008000p 0.9
+ 2008010p -0.3
+ 2010000p -0.3
+ 2010010p 0.9
+ 2012000p 0.9
+ 2012010p -0.3
+ 2014000p -0.3
+ 2014010p 0.9
+ 2016000p 0.9
+ 2016010p -0.3
+ 2018000p -0.3
+ 2018010p 0.9
+ 2020000p 0.9
+ 2020010p -0.3
+ 2022000p -0.3
+ 2022010p 0.9
+ 2024000p 0.9
+ 2024010p -0.3
+ 2026000p -0.3
+ 2026010p 0.9
+ 2028000p 0.9
+ 2028010p -0.3
+ 2030000p -0.3
+ 2030010p 0.9
+ 2032000p 0.9
+ 2032010p -0.3
+ 2034000p -0.3
+ 2034010p 0.9
+ 2036000p 0.9
+ 2036010p -0.3
+ 2038000p -0.3
+ 2038010p 0.9
+ 2040000p 0.9
+ 2040010p -0.3
+ 2042000p -0.3
+ 2042010p 0.9
+ 2044000p 0.9
+ 2044010p -0.3
+ 2046000p -0.3
+ 2046010p 0.9
+ 2048000p 0.9
+ 2048010p -0.3
+ \]
V_data_6 (Data\\<6\\> gnd!) vsource type=pwl wave=\[
+ 0    0.9
+ 2000p 0.9
+ 2010p -0.3
+ 4000p -0.3
+ 4010p 0.9
+ 6000p 0.9
+ 6010p -0.3
+ 8000p -0.3
+ 8010p 0.9
+ 10000p 0.9
+ 10010p -0.3
+ 12000p -0.3
+ 12010p 0.9
+ 14000p 0.9
+ 14010p -0.3
+ 16000p -0.3
+ 16010p 0.9
+ 18000p 0.9
+ 18010p -0.3
+ 20000p -0.3
+ 20010p 0.9
+ 22000p 0.9
+ 22010p -0.3
+ 24000p -0.3
+ 24010p 0.9
+ 26000p 0.9
+ 26010p -0.3
+ 28000p -0.3
+ 28010p 0.9
+ 30000p 0.9
+ 30010p -0.3
+ 32000p -0.3
+ 32010p 0.9
+ 34000p 0.9
+ 34010p -0.3
+ 36000p -0.3
+ 36010p 0.9
+ 38000p 0.9
+ 38010p -0.3
+ 40000p -0.3
+ 40010p 0.9
+ 42000p 0.9
+ 42010p -0.3
+ 44000p -0.3
+ 44010p 0.9
+ 46000p 0.9
+ 46010p -0.3
+ 48000p -0.3
+ 48010p 0.9
+ 50000p 0.9
+ 50010p -0.3
+ 52000p -0.3
+ 52010p 0.9
+ 54000p 0.9
+ 54010p -0.3
+ 56000p -0.3
+ 56010p 0.9
+ 58000p 0.9
+ 58010p -0.3
+ 60000p -0.3
+ 60010p 0.9
+ 62000p 0.9
+ 62010p -0.3
+ 64000p -0.3
+ 64010p 0.9
+ 66000p 0.9
+ 66010p -0.3
+ 68000p -0.3
+ 68010p 0.9
+ 70000p 0.9
+ 70010p -0.3
+ 72000p -0.3
+ 72010p 0.9
+ 74000p 0.9
+ 74010p -0.3
+ 76000p -0.3
+ 76010p 0.9
+ 78000p 0.9
+ 78010p -0.3
+ 80000p -0.3
+ 80010p 0.9
+ 82000p 0.9
+ 82010p -0.3
+ 84000p -0.3
+ 84010p 0.9
+ 86000p 0.9
+ 86010p -0.3
+ 88000p -0.3
+ 88010p 0.9
+ 90000p 0.9
+ 90010p -0.3
+ 92000p -0.3
+ 92010p 0.9
+ 94000p 0.9
+ 94010p -0.3
+ 96000p -0.3
+ 96010p 0.9
+ 98000p 0.9
+ 98010p -0.3
+ 100000p -0.3
+ 100010p 0.9
+ 102000p 0.9
+ 102010p -0.3
+ 104000p -0.3
+ 104010p 0.9
+ 106000p 0.9
+ 106010p -0.3
+ 108000p -0.3
+ 108010p 0.9
+ 110000p 0.9
+ 110010p -0.3
+ 112000p -0.3
+ 112010p 0.9
+ 114000p 0.9
+ 114010p -0.3
+ 116000p -0.3
+ 116010p 0.9
+ 118000p 0.9
+ 118010p -0.3
+ 120000p -0.3
+ 120010p 0.9
+ 122000p 0.9
+ 122010p -0.3
+ 124000p -0.3
+ 124010p 0.9
+ 126000p 0.9
+ 126010p -0.3
+ 128000p -0.3
+ 128010p 0.9
+ 130000p 0.9
+ 130010p -0.3
+ 132000p -0.3
+ 132010p 0.9
+ 134000p 0.9
+ 134010p -0.3
+ 136000p -0.3
+ 136010p 0.9
+ 138000p 0.9
+ 138010p -0.3
+ 140000p -0.3
+ 140010p 0.9
+ 142000p 0.9
+ 142010p -0.3
+ 144000p -0.3
+ 144010p 0.9
+ 146000p 0.9
+ 146010p -0.3
+ 148000p -0.3
+ 148010p 0.9
+ 150000p 0.9
+ 150010p -0.3
+ 152000p -0.3
+ 152010p 0.9
+ 154000p 0.9
+ 154010p -0.3
+ 156000p -0.3
+ 156010p 0.9
+ 158000p 0.9
+ 158010p -0.3
+ 160000p -0.3
+ 160010p 0.9
+ 162000p 0.9
+ 162010p -0.3
+ 164000p -0.3
+ 164010p 0.9
+ 166000p 0.9
+ 166010p -0.3
+ 168000p -0.3
+ 168010p 0.9
+ 170000p 0.9
+ 170010p -0.3
+ 172000p -0.3
+ 172010p 0.9
+ 174000p 0.9
+ 174010p -0.3
+ 176000p -0.3
+ 176010p 0.9
+ 178000p 0.9
+ 178010p -0.3
+ 180000p -0.3
+ 180010p 0.9
+ 182000p 0.9
+ 182010p -0.3
+ 184000p -0.3
+ 184010p 0.9
+ 186000p 0.9
+ 186010p -0.3
+ 188000p -0.3
+ 188010p 0.9
+ 190000p 0.9
+ 190010p -0.3
+ 192000p -0.3
+ 192010p 0.9
+ 194000p 0.9
+ 194010p -0.3
+ 196000p -0.3
+ 196010p 0.9
+ 198000p 0.9
+ 198010p -0.3
+ 200000p -0.3
+ 200010p 0.9
+ 202000p 0.9
+ 202010p -0.3
+ 204000p -0.3
+ 204010p 0.9
+ 206000p 0.9
+ 206010p -0.3
+ 208000p -0.3
+ 208010p 0.9
+ 210000p 0.9
+ 210010p -0.3
+ 212000p -0.3
+ 212010p 0.9
+ 214000p 0.9
+ 214010p -0.3
+ 216000p -0.3
+ 216010p 0.9
+ 218000p 0.9
+ 218010p -0.3
+ 220000p -0.3
+ 220010p 0.9
+ 222000p 0.9
+ 222010p -0.3
+ 224000p -0.3
+ 224010p 0.9
+ 226000p 0.9
+ 226010p -0.3
+ 228000p -0.3
+ 228010p 0.9
+ 230000p 0.9
+ 230010p -0.3
+ 232000p -0.3
+ 232010p 0.9
+ 234000p 0.9
+ 234010p -0.3
+ 236000p -0.3
+ 236010p 0.9
+ 238000p 0.9
+ 238010p -0.3
+ 240000p -0.3
+ 240010p 0.9
+ 242000p 0.9
+ 242010p -0.3
+ 244000p -0.3
+ 244010p 0.9
+ 246000p 0.9
+ 246010p -0.3
+ 248000p -0.3
+ 248010p 0.9
+ 250000p 0.9
+ 250010p -0.3
+ 252000p -0.3
+ 252010p 0.9
+ 254000p 0.9
+ 254010p -0.3
+ 256000p -0.3
+ 256010p 0.9
+ 258000p 0.9
+ 258010p -0.3
+ 260000p -0.3
+ 260010p 0.9
+ 262000p 0.9
+ 262010p -0.3
+ 264000p -0.3
+ 264010p 0.9
+ 266000p 0.9
+ 266010p -0.3
+ 268000p -0.3
+ 268010p 0.9
+ 270000p 0.9
+ 270010p -0.3
+ 272000p -0.3
+ 272010p 0.9
+ 274000p 0.9
+ 274010p -0.3
+ 276000p -0.3
+ 276010p 0.9
+ 278000p 0.9
+ 278010p -0.3
+ 280000p -0.3
+ 280010p 0.9
+ 282000p 0.9
+ 282010p -0.3
+ 284000p -0.3
+ 284010p 0.9
+ 286000p 0.9
+ 286010p -0.3
+ 288000p -0.3
+ 288010p 0.9
+ 290000p 0.9
+ 290010p -0.3
+ 292000p -0.3
+ 292010p 0.9
+ 294000p 0.9
+ 294010p -0.3
+ 296000p -0.3
+ 296010p 0.9
+ 298000p 0.9
+ 298010p -0.3
+ 300000p -0.3
+ 300010p 0.9
+ 302000p 0.9
+ 302010p -0.3
+ 304000p -0.3
+ 304010p 0.9
+ 306000p 0.9
+ 306010p -0.3
+ 308000p -0.3
+ 308010p 0.9
+ 310000p 0.9
+ 310010p -0.3
+ 312000p -0.3
+ 312010p 0.9
+ 314000p 0.9
+ 314010p -0.3
+ 316000p -0.3
+ 316010p 0.9
+ 318000p 0.9
+ 318010p -0.3
+ 320000p -0.3
+ 320010p 0.9
+ 322000p 0.9
+ 322010p -0.3
+ 324000p -0.3
+ 324010p 0.9
+ 326000p 0.9
+ 326010p -0.3
+ 328000p -0.3
+ 328010p 0.9
+ 330000p 0.9
+ 330010p -0.3
+ 332000p -0.3
+ 332010p 0.9
+ 334000p 0.9
+ 334010p -0.3
+ 336000p -0.3
+ 336010p 0.9
+ 338000p 0.9
+ 338010p -0.3
+ 340000p -0.3
+ 340010p 0.9
+ 342000p 0.9
+ 342010p -0.3
+ 344000p -0.3
+ 344010p 0.9
+ 346000p 0.9
+ 346010p -0.3
+ 348000p -0.3
+ 348010p 0.9
+ 350000p 0.9
+ 350010p -0.3
+ 352000p -0.3
+ 352010p 0.9
+ 354000p 0.9
+ 354010p -0.3
+ 356000p -0.3
+ 356010p 0.9
+ 358000p 0.9
+ 358010p -0.3
+ 360000p -0.3
+ 360010p 0.9
+ 362000p 0.9
+ 362010p -0.3
+ 364000p -0.3
+ 364010p 0.9
+ 366000p 0.9
+ 366010p -0.3
+ 368000p -0.3
+ 368010p 0.9
+ 370000p 0.9
+ 370010p -0.3
+ 372000p -0.3
+ 372010p 0.9
+ 374000p 0.9
+ 374010p -0.3
+ 376000p -0.3
+ 376010p 0.9
+ 378000p 0.9
+ 378010p -0.3
+ 380000p -0.3
+ 380010p 0.9
+ 382000p 0.9
+ 382010p -0.3
+ 384000p -0.3
+ 384010p 0.9
+ 386000p 0.9
+ 386010p -0.3
+ 388000p -0.3
+ 388010p 0.9
+ 390000p 0.9
+ 390010p -0.3
+ 392000p -0.3
+ 392010p 0.9
+ 394000p 0.9
+ 394010p -0.3
+ 396000p -0.3
+ 396010p 0.9
+ 398000p 0.9
+ 398010p -0.3
+ 400000p -0.3
+ 400010p 0.9
+ 402000p 0.9
+ 402010p -0.3
+ 404000p -0.3
+ 404010p 0.9
+ 406000p 0.9
+ 406010p -0.3
+ 408000p -0.3
+ 408010p 0.9
+ 410000p 0.9
+ 410010p -0.3
+ 412000p -0.3
+ 412010p 0.9
+ 414000p 0.9
+ 414010p -0.3
+ 416000p -0.3
+ 416010p 0.9
+ 418000p 0.9
+ 418010p -0.3
+ 420000p -0.3
+ 420010p 0.9
+ 422000p 0.9
+ 422010p -0.3
+ 424000p -0.3
+ 424010p 0.9
+ 426000p 0.9
+ 426010p -0.3
+ 428000p -0.3
+ 428010p 0.9
+ 430000p 0.9
+ 430010p -0.3
+ 432000p -0.3
+ 432010p 0.9
+ 434000p 0.9
+ 434010p -0.3
+ 436000p -0.3
+ 436010p 0.9
+ 438000p 0.9
+ 438010p -0.3
+ 440000p -0.3
+ 440010p 0.9
+ 442000p 0.9
+ 442010p -0.3
+ 444000p -0.3
+ 444010p 0.9
+ 446000p 0.9
+ 446010p -0.3
+ 448000p -0.3
+ 448010p 0.9
+ 450000p 0.9
+ 450010p -0.3
+ 452000p -0.3
+ 452010p 0.9
+ 454000p 0.9
+ 454010p -0.3
+ 456000p -0.3
+ 456010p 0.9
+ 458000p 0.9
+ 458010p -0.3
+ 460000p -0.3
+ 460010p 0.9
+ 462000p 0.9
+ 462010p -0.3
+ 464000p -0.3
+ 464010p 0.9
+ 466000p 0.9
+ 466010p -0.3
+ 468000p -0.3
+ 468010p 0.9
+ 470000p 0.9
+ 470010p -0.3
+ 472000p -0.3
+ 472010p 0.9
+ 474000p 0.9
+ 474010p -0.3
+ 476000p -0.3
+ 476010p 0.9
+ 478000p 0.9
+ 478010p -0.3
+ 480000p -0.3
+ 480010p 0.9
+ 482000p 0.9
+ 482010p -0.3
+ 484000p -0.3
+ 484010p 0.9
+ 486000p 0.9
+ 486010p -0.3
+ 488000p -0.3
+ 488010p 0.9
+ 490000p 0.9
+ 490010p -0.3
+ 492000p -0.3
+ 492010p 0.9
+ 494000p 0.9
+ 494010p -0.3
+ 496000p -0.3
+ 496010p 0.9
+ 498000p 0.9
+ 498010p -0.3
+ 500000p -0.3
+ 500010p 0.9
+ 502000p 0.9
+ 502010p -0.3
+ 504000p -0.3
+ 504010p 0.9
+ 506000p 0.9
+ 506010p -0.3
+ 508000p -0.3
+ 508010p 0.9
+ 510000p 0.9
+ 510010p -0.3
+ 512000p -0.3
+ 512010p 0.9
+ 514000p 0.9
+ 514010p -0.3
+ 516000p -0.3
+ 516010p 0.9
+ 518000p 0.9
+ 518010p -0.3
+ 520000p -0.3
+ 520010p 0.9
+ 522000p 0.9
+ 522010p -0.3
+ 524000p -0.3
+ 524010p 0.9
+ 526000p 0.9
+ 526010p -0.3
+ 528000p -0.3
+ 528010p 0.9
+ 530000p 0.9
+ 530010p -0.3
+ 532000p -0.3
+ 532010p 0.9
+ 534000p 0.9
+ 534010p -0.3
+ 536000p -0.3
+ 536010p 0.9
+ 538000p 0.9
+ 538010p -0.3
+ 540000p -0.3
+ 540010p 0.9
+ 542000p 0.9
+ 542010p -0.3
+ 544000p -0.3
+ 544010p 0.9
+ 546000p 0.9
+ 546010p -0.3
+ 548000p -0.3
+ 548010p 0.9
+ 550000p 0.9
+ 550010p -0.3
+ 552000p -0.3
+ 552010p 0.9
+ 554000p 0.9
+ 554010p -0.3
+ 556000p -0.3
+ 556010p 0.9
+ 558000p 0.9
+ 558010p -0.3
+ 560000p -0.3
+ 560010p 0.9
+ 562000p 0.9
+ 562010p -0.3
+ 564000p -0.3
+ 564010p 0.9
+ 566000p 0.9
+ 566010p -0.3
+ 568000p -0.3
+ 568010p 0.9
+ 570000p 0.9
+ 570010p -0.3
+ 572000p -0.3
+ 572010p 0.9
+ 574000p 0.9
+ 574010p -0.3
+ 576000p -0.3
+ 576010p 0.9
+ 578000p 0.9
+ 578010p -0.3
+ 580000p -0.3
+ 580010p 0.9
+ 582000p 0.9
+ 582010p -0.3
+ 584000p -0.3
+ 584010p 0.9
+ 586000p 0.9
+ 586010p -0.3
+ 588000p -0.3
+ 588010p 0.9
+ 590000p 0.9
+ 590010p -0.3
+ 592000p -0.3
+ 592010p 0.9
+ 594000p 0.9
+ 594010p -0.3
+ 596000p -0.3
+ 596010p 0.9
+ 598000p 0.9
+ 598010p -0.3
+ 600000p -0.3
+ 600010p 0.9
+ 602000p 0.9
+ 602010p -0.3
+ 604000p -0.3
+ 604010p 0.9
+ 606000p 0.9
+ 606010p -0.3
+ 608000p -0.3
+ 608010p 0.9
+ 610000p 0.9
+ 610010p -0.3
+ 612000p -0.3
+ 612010p 0.9
+ 614000p 0.9
+ 614010p -0.3
+ 616000p -0.3
+ 616010p 0.9
+ 618000p 0.9
+ 618010p -0.3
+ 620000p -0.3
+ 620010p 0.9
+ 622000p 0.9
+ 622010p -0.3
+ 624000p -0.3
+ 624010p 0.9
+ 626000p 0.9
+ 626010p -0.3
+ 628000p -0.3
+ 628010p 0.9
+ 630000p 0.9
+ 630010p -0.3
+ 632000p -0.3
+ 632010p 0.9
+ 634000p 0.9
+ 634010p -0.3
+ 636000p -0.3
+ 636010p 0.9
+ 638000p 0.9
+ 638010p -0.3
+ 640000p -0.3
+ 640010p 0.9
+ 642000p 0.9
+ 642010p -0.3
+ 644000p -0.3
+ 644010p 0.9
+ 646000p 0.9
+ 646010p -0.3
+ 648000p -0.3
+ 648010p 0.9
+ 650000p 0.9
+ 650010p -0.3
+ 652000p -0.3
+ 652010p 0.9
+ 654000p 0.9
+ 654010p -0.3
+ 656000p -0.3
+ 656010p 0.9
+ 658000p 0.9
+ 658010p -0.3
+ 660000p -0.3
+ 660010p 0.9
+ 662000p 0.9
+ 662010p -0.3
+ 664000p -0.3
+ 664010p 0.9
+ 666000p 0.9
+ 666010p -0.3
+ 668000p -0.3
+ 668010p 0.9
+ 670000p 0.9
+ 670010p -0.3
+ 672000p -0.3
+ 672010p 0.9
+ 674000p 0.9
+ 674010p -0.3
+ 676000p -0.3
+ 676010p 0.9
+ 678000p 0.9
+ 678010p -0.3
+ 680000p -0.3
+ 680010p 0.9
+ 682000p 0.9
+ 682010p -0.3
+ 684000p -0.3
+ 684010p 0.9
+ 686000p 0.9
+ 686010p -0.3
+ 688000p -0.3
+ 688010p 0.9
+ 690000p 0.9
+ 690010p -0.3
+ 692000p -0.3
+ 692010p 0.9
+ 694000p 0.9
+ 694010p -0.3
+ 696000p -0.3
+ 696010p 0.9
+ 698000p 0.9
+ 698010p -0.3
+ 700000p -0.3
+ 700010p 0.9
+ 702000p 0.9
+ 702010p -0.3
+ 704000p -0.3
+ 704010p 0.9
+ 706000p 0.9
+ 706010p -0.3
+ 708000p -0.3
+ 708010p 0.9
+ 710000p 0.9
+ 710010p -0.3
+ 712000p -0.3
+ 712010p 0.9
+ 714000p 0.9
+ 714010p -0.3
+ 716000p -0.3
+ 716010p 0.9
+ 718000p 0.9
+ 718010p -0.3
+ 720000p -0.3
+ 720010p 0.9
+ 722000p 0.9
+ 722010p -0.3
+ 724000p -0.3
+ 724010p 0.9
+ 726000p 0.9
+ 726010p -0.3
+ 728000p -0.3
+ 728010p 0.9
+ 730000p 0.9
+ 730010p -0.3
+ 732000p -0.3
+ 732010p 0.9
+ 734000p 0.9
+ 734010p -0.3
+ 736000p -0.3
+ 736010p 0.9
+ 738000p 0.9
+ 738010p -0.3
+ 740000p -0.3
+ 740010p 0.9
+ 742000p 0.9
+ 742010p -0.3
+ 744000p -0.3
+ 744010p 0.9
+ 746000p 0.9
+ 746010p -0.3
+ 748000p -0.3
+ 748010p 0.9
+ 750000p 0.9
+ 750010p -0.3
+ 752000p -0.3
+ 752010p 0.9
+ 754000p 0.9
+ 754010p -0.3
+ 756000p -0.3
+ 756010p 0.9
+ 758000p 0.9
+ 758010p -0.3
+ 760000p -0.3
+ 760010p 0.9
+ 762000p 0.9
+ 762010p -0.3
+ 764000p -0.3
+ 764010p 0.9
+ 766000p 0.9
+ 766010p -0.3
+ 768000p -0.3
+ 768010p 0.9
+ 770000p 0.9
+ 770010p -0.3
+ 772000p -0.3
+ 772010p 0.9
+ 774000p 0.9
+ 774010p -0.3
+ 776000p -0.3
+ 776010p 0.9
+ 778000p 0.9
+ 778010p -0.3
+ 780000p -0.3
+ 780010p 0.9
+ 782000p 0.9
+ 782010p -0.3
+ 784000p -0.3
+ 784010p 0.9
+ 786000p 0.9
+ 786010p -0.3
+ 788000p -0.3
+ 788010p 0.9
+ 790000p 0.9
+ 790010p -0.3
+ 792000p -0.3
+ 792010p 0.9
+ 794000p 0.9
+ 794010p -0.3
+ 796000p -0.3
+ 796010p 0.9
+ 798000p 0.9
+ 798010p -0.3
+ 800000p -0.3
+ 800010p 0.9
+ 802000p 0.9
+ 802010p -0.3
+ 804000p -0.3
+ 804010p 0.9
+ 806000p 0.9
+ 806010p -0.3
+ 808000p -0.3
+ 808010p 0.9
+ 810000p 0.9
+ 810010p -0.3
+ 812000p -0.3
+ 812010p 0.9
+ 814000p 0.9
+ 814010p -0.3
+ 816000p -0.3
+ 816010p 0.9
+ 818000p 0.9
+ 818010p -0.3
+ 820000p -0.3
+ 820010p 0.9
+ 822000p 0.9
+ 822010p -0.3
+ 824000p -0.3
+ 824010p 0.9
+ 826000p 0.9
+ 826010p -0.3
+ 828000p -0.3
+ 828010p 0.9
+ 830000p 0.9
+ 830010p -0.3
+ 832000p -0.3
+ 832010p 0.9
+ 834000p 0.9
+ 834010p -0.3
+ 836000p -0.3
+ 836010p 0.9
+ 838000p 0.9
+ 838010p -0.3
+ 840000p -0.3
+ 840010p 0.9
+ 842000p 0.9
+ 842010p -0.3
+ 844000p -0.3
+ 844010p 0.9
+ 846000p 0.9
+ 846010p -0.3
+ 848000p -0.3
+ 848010p 0.9
+ 850000p 0.9
+ 850010p -0.3
+ 852000p -0.3
+ 852010p 0.9
+ 854000p 0.9
+ 854010p -0.3
+ 856000p -0.3
+ 856010p 0.9
+ 858000p 0.9
+ 858010p -0.3
+ 860000p -0.3
+ 860010p 0.9
+ 862000p 0.9
+ 862010p -0.3
+ 864000p -0.3
+ 864010p 0.9
+ 866000p 0.9
+ 866010p -0.3
+ 868000p -0.3
+ 868010p 0.9
+ 870000p 0.9
+ 870010p -0.3
+ 872000p -0.3
+ 872010p 0.9
+ 874000p 0.9
+ 874010p -0.3
+ 876000p -0.3
+ 876010p 0.9
+ 878000p 0.9
+ 878010p -0.3
+ 880000p -0.3
+ 880010p 0.9
+ 882000p 0.9
+ 882010p -0.3
+ 884000p -0.3
+ 884010p 0.9
+ 886000p 0.9
+ 886010p -0.3
+ 888000p -0.3
+ 888010p 0.9
+ 890000p 0.9
+ 890010p -0.3
+ 892000p -0.3
+ 892010p 0.9
+ 894000p 0.9
+ 894010p -0.3
+ 896000p -0.3
+ 896010p 0.9
+ 898000p 0.9
+ 898010p -0.3
+ 900000p -0.3
+ 900010p 0.9
+ 902000p 0.9
+ 902010p -0.3
+ 904000p -0.3
+ 904010p 0.9
+ 906000p 0.9
+ 906010p -0.3
+ 908000p -0.3
+ 908010p 0.9
+ 910000p 0.9
+ 910010p -0.3
+ 912000p -0.3
+ 912010p 0.9
+ 914000p 0.9
+ 914010p -0.3
+ 916000p -0.3
+ 916010p 0.9
+ 918000p 0.9
+ 918010p -0.3
+ 920000p -0.3
+ 920010p 0.9
+ 922000p 0.9
+ 922010p -0.3
+ 924000p -0.3
+ 924010p 0.9
+ 926000p 0.9
+ 926010p -0.3
+ 928000p -0.3
+ 928010p 0.9
+ 930000p 0.9
+ 930010p -0.3
+ 932000p -0.3
+ 932010p 0.9
+ 934000p 0.9
+ 934010p -0.3
+ 936000p -0.3
+ 936010p 0.9
+ 938000p 0.9
+ 938010p -0.3
+ 940000p -0.3
+ 940010p 0.9
+ 942000p 0.9
+ 942010p -0.3
+ 944000p -0.3
+ 944010p 0.9
+ 946000p 0.9
+ 946010p -0.3
+ 948000p -0.3
+ 948010p 0.9
+ 950000p 0.9
+ 950010p -0.3
+ 952000p -0.3
+ 952010p 0.9
+ 954000p 0.9
+ 954010p -0.3
+ 956000p -0.3
+ 956010p 0.9
+ 958000p 0.9
+ 958010p -0.3
+ 960000p -0.3
+ 960010p 0.9
+ 962000p 0.9
+ 962010p -0.3
+ 964000p -0.3
+ 964010p 0.9
+ 966000p 0.9
+ 966010p -0.3
+ 968000p -0.3
+ 968010p 0.9
+ 970000p 0.9
+ 970010p -0.3
+ 972000p -0.3
+ 972010p 0.9
+ 974000p 0.9
+ 974010p -0.3
+ 976000p -0.3
+ 976010p 0.9
+ 978000p 0.9
+ 978010p -0.3
+ 980000p -0.3
+ 980010p 0.9
+ 982000p 0.9
+ 982010p -0.3
+ 984000p -0.3
+ 984010p 0.9
+ 986000p 0.9
+ 986010p -0.3
+ 988000p -0.3
+ 988010p 0.9
+ 990000p 0.9
+ 990010p -0.3
+ 992000p -0.3
+ 992010p 0.9
+ 994000p 0.9
+ 994010p -0.3
+ 996000p -0.3
+ 996010p 0.9
+ 998000p 0.9
+ 998010p -0.3
+ 1000000p -0.3
+ 1000010p 0.9
+ 1002000p 0.9
+ 1002010p -0.3
+ 1004000p -0.3
+ 1004010p 0.9
+ 1006000p 0.9
+ 1006010p -0.3
+ 1008000p -0.3
+ 1008010p 0.9
+ 1010000p 0.9
+ 1010010p -0.3
+ 1012000p -0.3
+ 1012010p 0.9
+ 1014000p 0.9
+ 1014010p -0.3
+ 1016000p -0.3
+ 1016010p 0.9
+ 1018000p 0.9
+ 1018010p -0.3
+ 1020000p -0.3
+ 1020010p 0.9
+ 1022000p 0.9
+ 1022010p -0.3
+ 1024000p -0.3
+ 1024010p 0.9
+ 1026000p 0.9
+ 1026010p -0.3
+ 1028000p -0.3
+ 1028010p 0.9
+ 1030000p 0.9
+ 1030010p -0.3
+ 1032000p -0.3
+ 1032010p 0.9
+ 1034000p 0.9
+ 1034010p -0.3
+ 1036000p -0.3
+ 1036010p 0.9
+ 1038000p 0.9
+ 1038010p -0.3
+ 1040000p -0.3
+ 1040010p 0.9
+ 1042000p 0.9
+ 1042010p -0.3
+ 1044000p -0.3
+ 1044010p 0.9
+ 1046000p 0.9
+ 1046010p -0.3
+ 1048000p -0.3
+ 1048010p 0.9
+ 1050000p 0.9
+ 1050010p -0.3
+ 1052000p -0.3
+ 1052010p 0.9
+ 1054000p 0.9
+ 1054010p -0.3
+ 1056000p -0.3
+ 1056010p 0.9
+ 1058000p 0.9
+ 1058010p -0.3
+ 1060000p -0.3
+ 1060010p 0.9
+ 1062000p 0.9
+ 1062010p -0.3
+ 1064000p -0.3
+ 1064010p 0.9
+ 1066000p 0.9
+ 1066010p -0.3
+ 1068000p -0.3
+ 1068010p 0.9
+ 1070000p 0.9
+ 1070010p -0.3
+ 1072000p -0.3
+ 1072010p 0.9
+ 1074000p 0.9
+ 1074010p -0.3
+ 1076000p -0.3
+ 1076010p 0.9
+ 1078000p 0.9
+ 1078010p -0.3
+ 1080000p -0.3
+ 1080010p 0.9
+ 1082000p 0.9
+ 1082010p -0.3
+ 1084000p -0.3
+ 1084010p 0.9
+ 1086000p 0.9
+ 1086010p -0.3
+ 1088000p -0.3
+ 1088010p 0.9
+ 1090000p 0.9
+ 1090010p -0.3
+ 1092000p -0.3
+ 1092010p 0.9
+ 1094000p 0.9
+ 1094010p -0.3
+ 1096000p -0.3
+ 1096010p 0.9
+ 1098000p 0.9
+ 1098010p -0.3
+ 1100000p -0.3
+ 1100010p 0.9
+ 1102000p 0.9
+ 1102010p -0.3
+ 1104000p -0.3
+ 1104010p 0.9
+ 1106000p 0.9
+ 1106010p -0.3
+ 1108000p -0.3
+ 1108010p 0.9
+ 1110000p 0.9
+ 1110010p -0.3
+ 1112000p -0.3
+ 1112010p 0.9
+ 1114000p 0.9
+ 1114010p -0.3
+ 1116000p -0.3
+ 1116010p 0.9
+ 1118000p 0.9
+ 1118010p -0.3
+ 1120000p -0.3
+ 1120010p 0.9
+ 1122000p 0.9
+ 1122010p -0.3
+ 1124000p -0.3
+ 1124010p 0.9
+ 1126000p 0.9
+ 1126010p -0.3
+ 1128000p -0.3
+ 1128010p 0.9
+ 1130000p 0.9
+ 1130010p -0.3
+ 1132000p -0.3
+ 1132010p 0.9
+ 1134000p 0.9
+ 1134010p -0.3
+ 1136000p -0.3
+ 1136010p 0.9
+ 1138000p 0.9
+ 1138010p -0.3
+ 1140000p -0.3
+ 1140010p 0.9
+ 1142000p 0.9
+ 1142010p -0.3
+ 1144000p -0.3
+ 1144010p 0.9
+ 1146000p 0.9
+ 1146010p -0.3
+ 1148000p -0.3
+ 1148010p 0.9
+ 1150000p 0.9
+ 1150010p -0.3
+ 1152000p -0.3
+ 1152010p 0.9
+ 1154000p 0.9
+ 1154010p -0.3
+ 1156000p -0.3
+ 1156010p 0.9
+ 1158000p 0.9
+ 1158010p -0.3
+ 1160000p -0.3
+ 1160010p 0.9
+ 1162000p 0.9
+ 1162010p -0.3
+ 1164000p -0.3
+ 1164010p 0.9
+ 1166000p 0.9
+ 1166010p -0.3
+ 1168000p -0.3
+ 1168010p 0.9
+ 1170000p 0.9
+ 1170010p -0.3
+ 1172000p -0.3
+ 1172010p 0.9
+ 1174000p 0.9
+ 1174010p -0.3
+ 1176000p -0.3
+ 1176010p 0.9
+ 1178000p 0.9
+ 1178010p -0.3
+ 1180000p -0.3
+ 1180010p 0.9
+ 1182000p 0.9
+ 1182010p -0.3
+ 1184000p -0.3
+ 1184010p 0.9
+ 1186000p 0.9
+ 1186010p -0.3
+ 1188000p -0.3
+ 1188010p 0.9
+ 1190000p 0.9
+ 1190010p -0.3
+ 1192000p -0.3
+ 1192010p 0.9
+ 1194000p 0.9
+ 1194010p -0.3
+ 1196000p -0.3
+ 1196010p 0.9
+ 1198000p 0.9
+ 1198010p -0.3
+ 1200000p -0.3
+ 1200010p 0.9
+ 1202000p 0.9
+ 1202010p -0.3
+ 1204000p -0.3
+ 1204010p 0.9
+ 1206000p 0.9
+ 1206010p -0.3
+ 1208000p -0.3
+ 1208010p 0.9
+ 1210000p 0.9
+ 1210010p -0.3
+ 1212000p -0.3
+ 1212010p 0.9
+ 1214000p 0.9
+ 1214010p -0.3
+ 1216000p -0.3
+ 1216010p 0.9
+ 1218000p 0.9
+ 1218010p -0.3
+ 1220000p -0.3
+ 1220010p 0.9
+ 1222000p 0.9
+ 1222010p -0.3
+ 1224000p -0.3
+ 1224010p 0.9
+ 1226000p 0.9
+ 1226010p -0.3
+ 1228000p -0.3
+ 1228010p 0.9
+ 1230000p 0.9
+ 1230010p -0.3
+ 1232000p -0.3
+ 1232010p 0.9
+ 1234000p 0.9
+ 1234010p -0.3
+ 1236000p -0.3
+ 1236010p 0.9
+ 1238000p 0.9
+ 1238010p -0.3
+ 1240000p -0.3
+ 1240010p 0.9
+ 1242000p 0.9
+ 1242010p -0.3
+ 1244000p -0.3
+ 1244010p 0.9
+ 1246000p 0.9
+ 1246010p -0.3
+ 1248000p -0.3
+ 1248010p 0.9
+ 1250000p 0.9
+ 1250010p -0.3
+ 1252000p -0.3
+ 1252010p 0.9
+ 1254000p 0.9
+ 1254010p -0.3
+ 1256000p -0.3
+ 1256010p 0.9
+ 1258000p 0.9
+ 1258010p -0.3
+ 1260000p -0.3
+ 1260010p 0.9
+ 1262000p 0.9
+ 1262010p -0.3
+ 1264000p -0.3
+ 1264010p 0.9
+ 1266000p 0.9
+ 1266010p -0.3
+ 1268000p -0.3
+ 1268010p 0.9
+ 1270000p 0.9
+ 1270010p -0.3
+ 1272000p -0.3
+ 1272010p 0.9
+ 1274000p 0.9
+ 1274010p -0.3
+ 1276000p -0.3
+ 1276010p 0.9
+ 1278000p 0.9
+ 1278010p -0.3
+ 1280000p -0.3
+ 1280010p 0.9
+ 1282000p 0.9
+ 1282010p -0.3
+ 1284000p -0.3
+ 1284010p 0.9
+ 1286000p 0.9
+ 1286010p -0.3
+ 1288000p -0.3
+ 1288010p 0.9
+ 1290000p 0.9
+ 1290010p -0.3
+ 1292000p -0.3
+ 1292010p 0.9
+ 1294000p 0.9
+ 1294010p -0.3
+ 1296000p -0.3
+ 1296010p 0.9
+ 1298000p 0.9
+ 1298010p -0.3
+ 1300000p -0.3
+ 1300010p 0.9
+ 1302000p 0.9
+ 1302010p -0.3
+ 1304000p -0.3
+ 1304010p 0.9
+ 1306000p 0.9
+ 1306010p -0.3
+ 1308000p -0.3
+ 1308010p 0.9
+ 1310000p 0.9
+ 1310010p -0.3
+ 1312000p -0.3
+ 1312010p 0.9
+ 1314000p 0.9
+ 1314010p -0.3
+ 1316000p -0.3
+ 1316010p 0.9
+ 1318000p 0.9
+ 1318010p -0.3
+ 1320000p -0.3
+ 1320010p 0.9
+ 1322000p 0.9
+ 1322010p -0.3
+ 1324000p -0.3
+ 1324010p 0.9
+ 1326000p 0.9
+ 1326010p -0.3
+ 1328000p -0.3
+ 1328010p 0.9
+ 1330000p 0.9
+ 1330010p -0.3
+ 1332000p -0.3
+ 1332010p 0.9
+ 1334000p 0.9
+ 1334010p -0.3
+ 1336000p -0.3
+ 1336010p 0.9
+ 1338000p 0.9
+ 1338010p -0.3
+ 1340000p -0.3
+ 1340010p 0.9
+ 1342000p 0.9
+ 1342010p -0.3
+ 1344000p -0.3
+ 1344010p 0.9
+ 1346000p 0.9
+ 1346010p -0.3
+ 1348000p -0.3
+ 1348010p 0.9
+ 1350000p 0.9
+ 1350010p -0.3
+ 1352000p -0.3
+ 1352010p 0.9
+ 1354000p 0.9
+ 1354010p -0.3
+ 1356000p -0.3
+ 1356010p 0.9
+ 1358000p 0.9
+ 1358010p -0.3
+ 1360000p -0.3
+ 1360010p 0.9
+ 1362000p 0.9
+ 1362010p -0.3
+ 1364000p -0.3
+ 1364010p 0.9
+ 1366000p 0.9
+ 1366010p -0.3
+ 1368000p -0.3
+ 1368010p 0.9
+ 1370000p 0.9
+ 1370010p -0.3
+ 1372000p -0.3
+ 1372010p 0.9
+ 1374000p 0.9
+ 1374010p -0.3
+ 1376000p -0.3
+ 1376010p 0.9
+ 1378000p 0.9
+ 1378010p -0.3
+ 1380000p -0.3
+ 1380010p 0.9
+ 1382000p 0.9
+ 1382010p -0.3
+ 1384000p -0.3
+ 1384010p 0.9
+ 1386000p 0.9
+ 1386010p -0.3
+ 1388000p -0.3
+ 1388010p 0.9
+ 1390000p 0.9
+ 1390010p -0.3
+ 1392000p -0.3
+ 1392010p 0.9
+ 1394000p 0.9
+ 1394010p -0.3
+ 1396000p -0.3
+ 1396010p 0.9
+ 1398000p 0.9
+ 1398010p -0.3
+ 1400000p -0.3
+ 1400010p 0.9
+ 1402000p 0.9
+ 1402010p -0.3
+ 1404000p -0.3
+ 1404010p 0.9
+ 1406000p 0.9
+ 1406010p -0.3
+ 1408000p -0.3
+ 1408010p 0.9
+ 1410000p 0.9
+ 1410010p -0.3
+ 1412000p -0.3
+ 1412010p 0.9
+ 1414000p 0.9
+ 1414010p -0.3
+ 1416000p -0.3
+ 1416010p 0.9
+ 1418000p 0.9
+ 1418010p -0.3
+ 1420000p -0.3
+ 1420010p 0.9
+ 1422000p 0.9
+ 1422010p -0.3
+ 1424000p -0.3
+ 1424010p 0.9
+ 1426000p 0.9
+ 1426010p -0.3
+ 1428000p -0.3
+ 1428010p 0.9
+ 1430000p 0.9
+ 1430010p -0.3
+ 1432000p -0.3
+ 1432010p 0.9
+ 1434000p 0.9
+ 1434010p -0.3
+ 1436000p -0.3
+ 1436010p 0.9
+ 1438000p 0.9
+ 1438010p -0.3
+ 1440000p -0.3
+ 1440010p 0.9
+ 1442000p 0.9
+ 1442010p -0.3
+ 1444000p -0.3
+ 1444010p 0.9
+ 1446000p 0.9
+ 1446010p -0.3
+ 1448000p -0.3
+ 1448010p 0.9
+ 1450000p 0.9
+ 1450010p -0.3
+ 1452000p -0.3
+ 1452010p 0.9
+ 1454000p 0.9
+ 1454010p -0.3
+ 1456000p -0.3
+ 1456010p 0.9
+ 1458000p 0.9
+ 1458010p -0.3
+ 1460000p -0.3
+ 1460010p 0.9
+ 1462000p 0.9
+ 1462010p -0.3
+ 1464000p -0.3
+ 1464010p 0.9
+ 1466000p 0.9
+ 1466010p -0.3
+ 1468000p -0.3
+ 1468010p 0.9
+ 1470000p 0.9
+ 1470010p -0.3
+ 1472000p -0.3
+ 1472010p 0.9
+ 1474000p 0.9
+ 1474010p -0.3
+ 1476000p -0.3
+ 1476010p 0.9
+ 1478000p 0.9
+ 1478010p -0.3
+ 1480000p -0.3
+ 1480010p 0.9
+ 1482000p 0.9
+ 1482010p -0.3
+ 1484000p -0.3
+ 1484010p 0.9
+ 1486000p 0.9
+ 1486010p -0.3
+ 1488000p -0.3
+ 1488010p 0.9
+ 1490000p 0.9
+ 1490010p -0.3
+ 1492000p -0.3
+ 1492010p 0.9
+ 1494000p 0.9
+ 1494010p -0.3
+ 1496000p -0.3
+ 1496010p 0.9
+ 1498000p 0.9
+ 1498010p -0.3
+ 1500000p -0.3
+ 1500010p 0.9
+ 1502000p 0.9
+ 1502010p -0.3
+ 1504000p -0.3
+ 1504010p 0.9
+ 1506000p 0.9
+ 1506010p -0.3
+ 1508000p -0.3
+ 1508010p 0.9
+ 1510000p 0.9
+ 1510010p -0.3
+ 1512000p -0.3
+ 1512010p 0.9
+ 1514000p 0.9
+ 1514010p -0.3
+ 1516000p -0.3
+ 1516010p 0.9
+ 1518000p 0.9
+ 1518010p -0.3
+ 1520000p -0.3
+ 1520010p 0.9
+ 1522000p 0.9
+ 1522010p -0.3
+ 1524000p -0.3
+ 1524010p 0.9
+ 1526000p 0.9
+ 1526010p -0.3
+ 1528000p -0.3
+ 1528010p 0.9
+ 1530000p 0.9
+ 1530010p -0.3
+ 1532000p -0.3
+ 1532010p 0.9
+ 1534000p 0.9
+ 1534010p -0.3
+ 1536000p -0.3
+ 1536010p 0.9
+ 1538000p 0.9
+ 1538010p -0.3
+ 1540000p -0.3
+ 1540010p 0.9
+ 1542000p 0.9
+ 1542010p -0.3
+ 1544000p -0.3
+ 1544010p 0.9
+ 1546000p 0.9
+ 1546010p -0.3
+ 1548000p -0.3
+ 1548010p 0.9
+ 1550000p 0.9
+ 1550010p -0.3
+ 1552000p -0.3
+ 1552010p 0.9
+ 1554000p 0.9
+ 1554010p -0.3
+ 1556000p -0.3
+ 1556010p 0.9
+ 1558000p 0.9
+ 1558010p -0.3
+ 1560000p -0.3
+ 1560010p 0.9
+ 1562000p 0.9
+ 1562010p -0.3
+ 1564000p -0.3
+ 1564010p 0.9
+ 1566000p 0.9
+ 1566010p -0.3
+ 1568000p -0.3
+ 1568010p 0.9
+ 1570000p 0.9
+ 1570010p -0.3
+ 1572000p -0.3
+ 1572010p 0.9
+ 1574000p 0.9
+ 1574010p -0.3
+ 1576000p -0.3
+ 1576010p 0.9
+ 1578000p 0.9
+ 1578010p -0.3
+ 1580000p -0.3
+ 1580010p 0.9
+ 1582000p 0.9
+ 1582010p -0.3
+ 1584000p -0.3
+ 1584010p 0.9
+ 1586000p 0.9
+ 1586010p -0.3
+ 1588000p -0.3
+ 1588010p 0.9
+ 1590000p 0.9
+ 1590010p -0.3
+ 1592000p -0.3
+ 1592010p 0.9
+ 1594000p 0.9
+ 1594010p -0.3
+ 1596000p -0.3
+ 1596010p 0.9
+ 1598000p 0.9
+ 1598010p -0.3
+ 1600000p -0.3
+ 1600010p 0.9
+ 1602000p 0.9
+ 1602010p -0.3
+ 1604000p -0.3
+ 1604010p 0.9
+ 1606000p 0.9
+ 1606010p -0.3
+ 1608000p -0.3
+ 1608010p 0.9
+ 1610000p 0.9
+ 1610010p -0.3
+ 1612000p -0.3
+ 1612010p 0.9
+ 1614000p 0.9
+ 1614010p -0.3
+ 1616000p -0.3
+ 1616010p 0.9
+ 1618000p 0.9
+ 1618010p -0.3
+ 1620000p -0.3
+ 1620010p 0.9
+ 1622000p 0.9
+ 1622010p -0.3
+ 1624000p -0.3
+ 1624010p 0.9
+ 1626000p 0.9
+ 1626010p -0.3
+ 1628000p -0.3
+ 1628010p 0.9
+ 1630000p 0.9
+ 1630010p -0.3
+ 1632000p -0.3
+ 1632010p 0.9
+ 1634000p 0.9
+ 1634010p -0.3
+ 1636000p -0.3
+ 1636010p 0.9
+ 1638000p 0.9
+ 1638010p -0.3
+ 1640000p -0.3
+ 1640010p 0.9
+ 1642000p 0.9
+ 1642010p -0.3
+ 1644000p -0.3
+ 1644010p 0.9
+ 1646000p 0.9
+ 1646010p -0.3
+ 1648000p -0.3
+ 1648010p 0.9
+ 1650000p 0.9
+ 1650010p -0.3
+ 1652000p -0.3
+ 1652010p 0.9
+ 1654000p 0.9
+ 1654010p -0.3
+ 1656000p -0.3
+ 1656010p 0.9
+ 1658000p 0.9
+ 1658010p -0.3
+ 1660000p -0.3
+ 1660010p 0.9
+ 1662000p 0.9
+ 1662010p -0.3
+ 1664000p -0.3
+ 1664010p 0.9
+ 1666000p 0.9
+ 1666010p -0.3
+ 1668000p -0.3
+ 1668010p 0.9
+ 1670000p 0.9
+ 1670010p -0.3
+ 1672000p -0.3
+ 1672010p 0.9
+ 1674000p 0.9
+ 1674010p -0.3
+ 1676000p -0.3
+ 1676010p 0.9
+ 1678000p 0.9
+ 1678010p -0.3
+ 1680000p -0.3
+ 1680010p 0.9
+ 1682000p 0.9
+ 1682010p -0.3
+ 1684000p -0.3
+ 1684010p 0.9
+ 1686000p 0.9
+ 1686010p -0.3
+ 1688000p -0.3
+ 1688010p 0.9
+ 1690000p 0.9
+ 1690010p -0.3
+ 1692000p -0.3
+ 1692010p 0.9
+ 1694000p 0.9
+ 1694010p -0.3
+ 1696000p -0.3
+ 1696010p 0.9
+ 1698000p 0.9
+ 1698010p -0.3
+ 1700000p -0.3
+ 1700010p 0.9
+ 1702000p 0.9
+ 1702010p -0.3
+ 1704000p -0.3
+ 1704010p 0.9
+ 1706000p 0.9
+ 1706010p -0.3
+ 1708000p -0.3
+ 1708010p 0.9
+ 1710000p 0.9
+ 1710010p -0.3
+ 1712000p -0.3
+ 1712010p 0.9
+ 1714000p 0.9
+ 1714010p -0.3
+ 1716000p -0.3
+ 1716010p 0.9
+ 1718000p 0.9
+ 1718010p -0.3
+ 1720000p -0.3
+ 1720010p 0.9
+ 1722000p 0.9
+ 1722010p -0.3
+ 1724000p -0.3
+ 1724010p 0.9
+ 1726000p 0.9
+ 1726010p -0.3
+ 1728000p -0.3
+ 1728010p 0.9
+ 1730000p 0.9
+ 1730010p -0.3
+ 1732000p -0.3
+ 1732010p 0.9
+ 1734000p 0.9
+ 1734010p -0.3
+ 1736000p -0.3
+ 1736010p 0.9
+ 1738000p 0.9
+ 1738010p -0.3
+ 1740000p -0.3
+ 1740010p 0.9
+ 1742000p 0.9
+ 1742010p -0.3
+ 1744000p -0.3
+ 1744010p 0.9
+ 1746000p 0.9
+ 1746010p -0.3
+ 1748000p -0.3
+ 1748010p 0.9
+ 1750000p 0.9
+ 1750010p -0.3
+ 1752000p -0.3
+ 1752010p 0.9
+ 1754000p 0.9
+ 1754010p -0.3
+ 1756000p -0.3
+ 1756010p 0.9
+ 1758000p 0.9
+ 1758010p -0.3
+ 1760000p -0.3
+ 1760010p 0.9
+ 1762000p 0.9
+ 1762010p -0.3
+ 1764000p -0.3
+ 1764010p 0.9
+ 1766000p 0.9
+ 1766010p -0.3
+ 1768000p -0.3
+ 1768010p 0.9
+ 1770000p 0.9
+ 1770010p -0.3
+ 1772000p -0.3
+ 1772010p 0.9
+ 1774000p 0.9
+ 1774010p -0.3
+ 1776000p -0.3
+ 1776010p 0.9
+ 1778000p 0.9
+ 1778010p -0.3
+ 1780000p -0.3
+ 1780010p 0.9
+ 1782000p 0.9
+ 1782010p -0.3
+ 1784000p -0.3
+ 1784010p 0.9
+ 1786000p 0.9
+ 1786010p -0.3
+ 1788000p -0.3
+ 1788010p 0.9
+ 1790000p 0.9
+ 1790010p -0.3
+ 1792000p -0.3
+ 1792010p 0.9
+ 1794000p 0.9
+ 1794010p -0.3
+ 1796000p -0.3
+ 1796010p 0.9
+ 1798000p 0.9
+ 1798010p -0.3
+ 1800000p -0.3
+ 1800010p 0.9
+ 1802000p 0.9
+ 1802010p -0.3
+ 1804000p -0.3
+ 1804010p 0.9
+ 1806000p 0.9
+ 1806010p -0.3
+ 1808000p -0.3
+ 1808010p 0.9
+ 1810000p 0.9
+ 1810010p -0.3
+ 1812000p -0.3
+ 1812010p 0.9
+ 1814000p 0.9
+ 1814010p -0.3
+ 1816000p -0.3
+ 1816010p 0.9
+ 1818000p 0.9
+ 1818010p -0.3
+ 1820000p -0.3
+ 1820010p 0.9
+ 1822000p 0.9
+ 1822010p -0.3
+ 1824000p -0.3
+ 1824010p 0.9
+ 1826000p 0.9
+ 1826010p -0.3
+ 1828000p -0.3
+ 1828010p 0.9
+ 1830000p 0.9
+ 1830010p -0.3
+ 1832000p -0.3
+ 1832010p 0.9
+ 1834000p 0.9
+ 1834010p -0.3
+ 1836000p -0.3
+ 1836010p 0.9
+ 1838000p 0.9
+ 1838010p -0.3
+ 1840000p -0.3
+ 1840010p 0.9
+ 1842000p 0.9
+ 1842010p -0.3
+ 1844000p -0.3
+ 1844010p 0.9
+ 1846000p 0.9
+ 1846010p -0.3
+ 1848000p -0.3
+ 1848010p 0.9
+ 1850000p 0.9
+ 1850010p -0.3
+ 1852000p -0.3
+ 1852010p 0.9
+ 1854000p 0.9
+ 1854010p -0.3
+ 1856000p -0.3
+ 1856010p 0.9
+ 1858000p 0.9
+ 1858010p -0.3
+ 1860000p -0.3
+ 1860010p 0.9
+ 1862000p 0.9
+ 1862010p -0.3
+ 1864000p -0.3
+ 1864010p 0.9
+ 1866000p 0.9
+ 1866010p -0.3
+ 1868000p -0.3
+ 1868010p 0.9
+ 1870000p 0.9
+ 1870010p -0.3
+ 1872000p -0.3
+ 1872010p 0.9
+ 1874000p 0.9
+ 1874010p -0.3
+ 1876000p -0.3
+ 1876010p 0.9
+ 1878000p 0.9
+ 1878010p -0.3
+ 1880000p -0.3
+ 1880010p 0.9
+ 1882000p 0.9
+ 1882010p -0.3
+ 1884000p -0.3
+ 1884010p 0.9
+ 1886000p 0.9
+ 1886010p -0.3
+ 1888000p -0.3
+ 1888010p 0.9
+ 1890000p 0.9
+ 1890010p -0.3
+ 1892000p -0.3
+ 1892010p 0.9
+ 1894000p 0.9
+ 1894010p -0.3
+ 1896000p -0.3
+ 1896010p 0.9
+ 1898000p 0.9
+ 1898010p -0.3
+ 1900000p -0.3
+ 1900010p 0.9
+ 1902000p 0.9
+ 1902010p -0.3
+ 1904000p -0.3
+ 1904010p 0.9
+ 1906000p 0.9
+ 1906010p -0.3
+ 1908000p -0.3
+ 1908010p 0.9
+ 1910000p 0.9
+ 1910010p -0.3
+ 1912000p -0.3
+ 1912010p 0.9
+ 1914000p 0.9
+ 1914010p -0.3
+ 1916000p -0.3
+ 1916010p 0.9
+ 1918000p 0.9
+ 1918010p -0.3
+ 1920000p -0.3
+ 1920010p 0.9
+ 1922000p 0.9
+ 1922010p -0.3
+ 1924000p -0.3
+ 1924010p 0.9
+ 1926000p 0.9
+ 1926010p -0.3
+ 1928000p -0.3
+ 1928010p 0.9
+ 1930000p 0.9
+ 1930010p -0.3
+ 1932000p -0.3
+ 1932010p 0.9
+ 1934000p 0.9
+ 1934010p -0.3
+ 1936000p -0.3
+ 1936010p 0.9
+ 1938000p 0.9
+ 1938010p -0.3
+ 1940000p -0.3
+ 1940010p 0.9
+ 1942000p 0.9
+ 1942010p -0.3
+ 1944000p -0.3
+ 1944010p 0.9
+ 1946000p 0.9
+ 1946010p -0.3
+ 1948000p -0.3
+ 1948010p 0.9
+ 1950000p 0.9
+ 1950010p -0.3
+ 1952000p -0.3
+ 1952010p 0.9
+ 1954000p 0.9
+ 1954010p -0.3
+ 1956000p -0.3
+ 1956010p 0.9
+ 1958000p 0.9
+ 1958010p -0.3
+ 1960000p -0.3
+ 1960010p 0.9
+ 1962000p 0.9
+ 1962010p -0.3
+ 1964000p -0.3
+ 1964010p 0.9
+ 1966000p 0.9
+ 1966010p -0.3
+ 1968000p -0.3
+ 1968010p 0.9
+ 1970000p 0.9
+ 1970010p -0.3
+ 1972000p -0.3
+ 1972010p 0.9
+ 1974000p 0.9
+ 1974010p -0.3
+ 1976000p -0.3
+ 1976010p 0.9
+ 1978000p 0.9
+ 1978010p -0.3
+ 1980000p -0.3
+ 1980010p 0.9
+ 1982000p 0.9
+ 1982010p -0.3
+ 1984000p -0.3
+ 1984010p 0.9
+ 1986000p 0.9
+ 1986010p -0.3
+ 1988000p -0.3
+ 1988010p 0.9
+ 1990000p 0.9
+ 1990010p -0.3
+ 1992000p -0.3
+ 1992010p 0.9
+ 1994000p 0.9
+ 1994010p -0.3
+ 1996000p -0.3
+ 1996010p 0.9
+ 1998000p 0.9
+ 1998010p -0.3
+ 2000000p -0.3
+ 2000010p 0.9
+ 2002000p 0.9
+ 2002010p -0.3
+ 2004000p -0.3
+ 2004010p 0.9
+ 2006000p 0.9
+ 2006010p -0.3
+ 2008000p -0.3
+ 2008010p 0.9
+ 2010000p 0.9
+ 2010010p -0.3
+ 2012000p -0.3
+ 2012010p 0.9
+ 2014000p 0.9
+ 2014010p -0.3
+ 2016000p -0.3
+ 2016010p 0.9
+ 2018000p 0.9
+ 2018010p -0.3
+ 2020000p -0.3
+ 2020010p 0.9
+ 2022000p 0.9
+ 2022010p -0.3
+ 2024000p -0.3
+ 2024010p 0.9
+ 2026000p 0.9
+ 2026010p -0.3
+ 2028000p -0.3
+ 2028010p 0.9
+ 2030000p 0.9
+ 2030010p -0.3
+ 2032000p -0.3
+ 2032010p 0.9
+ 2034000p 0.9
+ 2034010p -0.3
+ 2036000p -0.3
+ 2036010p 0.9
+ 2038000p 0.9
+ 2038010p -0.3
+ 2040000p -0.3
+ 2040010p 0.9
+ 2042000p 0.9
+ 2042010p -0.3
+ 2044000p -0.3
+ 2044010p 0.9
+ 2046000p 0.9
+ 2046010p -0.3
+ 2048000p -0.3
+ 2048010p 0.9
+ \]
V_data_bar_6 (Data_bar\\<6\\> gnd!) vsource type=pwl wave=\[
+ 0    -0.3
+ 2000p -0.3
+ 2010p 0.9
+ 4000p 0.9
+ 4010p -0.3
+ 6000p -0.3
+ 6010p 0.9
+ 8000p 0.9
+ 8010p -0.3
+ 10000p -0.3
+ 10010p 0.9
+ 12000p 0.9
+ 12010p -0.3
+ 14000p -0.3
+ 14010p 0.9
+ 16000p 0.9
+ 16010p -0.3
+ 18000p -0.3
+ 18010p 0.9
+ 20000p 0.9
+ 20010p -0.3
+ 22000p -0.3
+ 22010p 0.9
+ 24000p 0.9
+ 24010p -0.3
+ 26000p -0.3
+ 26010p 0.9
+ 28000p 0.9
+ 28010p -0.3
+ 30000p -0.3
+ 30010p 0.9
+ 32000p 0.9
+ 32010p -0.3
+ 34000p -0.3
+ 34010p 0.9
+ 36000p 0.9
+ 36010p -0.3
+ 38000p -0.3
+ 38010p 0.9
+ 40000p 0.9
+ 40010p -0.3
+ 42000p -0.3
+ 42010p 0.9
+ 44000p 0.9
+ 44010p -0.3
+ 46000p -0.3
+ 46010p 0.9
+ 48000p 0.9
+ 48010p -0.3
+ 50000p -0.3
+ 50010p 0.9
+ 52000p 0.9
+ 52010p -0.3
+ 54000p -0.3
+ 54010p 0.9
+ 56000p 0.9
+ 56010p -0.3
+ 58000p -0.3
+ 58010p 0.9
+ 60000p 0.9
+ 60010p -0.3
+ 62000p -0.3
+ 62010p 0.9
+ 64000p 0.9
+ 64010p -0.3
+ 66000p -0.3
+ 66010p 0.9
+ 68000p 0.9
+ 68010p -0.3
+ 70000p -0.3
+ 70010p 0.9
+ 72000p 0.9
+ 72010p -0.3
+ 74000p -0.3
+ 74010p 0.9
+ 76000p 0.9
+ 76010p -0.3
+ 78000p -0.3
+ 78010p 0.9
+ 80000p 0.9
+ 80010p -0.3
+ 82000p -0.3
+ 82010p 0.9
+ 84000p 0.9
+ 84010p -0.3
+ 86000p -0.3
+ 86010p 0.9
+ 88000p 0.9
+ 88010p -0.3
+ 90000p -0.3
+ 90010p 0.9
+ 92000p 0.9
+ 92010p -0.3
+ 94000p -0.3
+ 94010p 0.9
+ 96000p 0.9
+ 96010p -0.3
+ 98000p -0.3
+ 98010p 0.9
+ 100000p 0.9
+ 100010p -0.3
+ 102000p -0.3
+ 102010p 0.9
+ 104000p 0.9
+ 104010p -0.3
+ 106000p -0.3
+ 106010p 0.9
+ 108000p 0.9
+ 108010p -0.3
+ 110000p -0.3
+ 110010p 0.9
+ 112000p 0.9
+ 112010p -0.3
+ 114000p -0.3
+ 114010p 0.9
+ 116000p 0.9
+ 116010p -0.3
+ 118000p -0.3
+ 118010p 0.9
+ 120000p 0.9
+ 120010p -0.3
+ 122000p -0.3
+ 122010p 0.9
+ 124000p 0.9
+ 124010p -0.3
+ 126000p -0.3
+ 126010p 0.9
+ 128000p 0.9
+ 128010p -0.3
+ 130000p -0.3
+ 130010p 0.9
+ 132000p 0.9
+ 132010p -0.3
+ 134000p -0.3
+ 134010p 0.9
+ 136000p 0.9
+ 136010p -0.3
+ 138000p -0.3
+ 138010p 0.9
+ 140000p 0.9
+ 140010p -0.3
+ 142000p -0.3
+ 142010p 0.9
+ 144000p 0.9
+ 144010p -0.3
+ 146000p -0.3
+ 146010p 0.9
+ 148000p 0.9
+ 148010p -0.3
+ 150000p -0.3
+ 150010p 0.9
+ 152000p 0.9
+ 152010p -0.3
+ 154000p -0.3
+ 154010p 0.9
+ 156000p 0.9
+ 156010p -0.3
+ 158000p -0.3
+ 158010p 0.9
+ 160000p 0.9
+ 160010p -0.3
+ 162000p -0.3
+ 162010p 0.9
+ 164000p 0.9
+ 164010p -0.3
+ 166000p -0.3
+ 166010p 0.9
+ 168000p 0.9
+ 168010p -0.3
+ 170000p -0.3
+ 170010p 0.9
+ 172000p 0.9
+ 172010p -0.3
+ 174000p -0.3
+ 174010p 0.9
+ 176000p 0.9
+ 176010p -0.3
+ 178000p -0.3
+ 178010p 0.9
+ 180000p 0.9
+ 180010p -0.3
+ 182000p -0.3
+ 182010p 0.9
+ 184000p 0.9
+ 184010p -0.3
+ 186000p -0.3
+ 186010p 0.9
+ 188000p 0.9
+ 188010p -0.3
+ 190000p -0.3
+ 190010p 0.9
+ 192000p 0.9
+ 192010p -0.3
+ 194000p -0.3
+ 194010p 0.9
+ 196000p 0.9
+ 196010p -0.3
+ 198000p -0.3
+ 198010p 0.9
+ 200000p 0.9
+ 200010p -0.3
+ 202000p -0.3
+ 202010p 0.9
+ 204000p 0.9
+ 204010p -0.3
+ 206000p -0.3
+ 206010p 0.9
+ 208000p 0.9
+ 208010p -0.3
+ 210000p -0.3
+ 210010p 0.9
+ 212000p 0.9
+ 212010p -0.3
+ 214000p -0.3
+ 214010p 0.9
+ 216000p 0.9
+ 216010p -0.3
+ 218000p -0.3
+ 218010p 0.9
+ 220000p 0.9
+ 220010p -0.3
+ 222000p -0.3
+ 222010p 0.9
+ 224000p 0.9
+ 224010p -0.3
+ 226000p -0.3
+ 226010p 0.9
+ 228000p 0.9
+ 228010p -0.3
+ 230000p -0.3
+ 230010p 0.9
+ 232000p 0.9
+ 232010p -0.3
+ 234000p -0.3
+ 234010p 0.9
+ 236000p 0.9
+ 236010p -0.3
+ 238000p -0.3
+ 238010p 0.9
+ 240000p 0.9
+ 240010p -0.3
+ 242000p -0.3
+ 242010p 0.9
+ 244000p 0.9
+ 244010p -0.3
+ 246000p -0.3
+ 246010p 0.9
+ 248000p 0.9
+ 248010p -0.3
+ 250000p -0.3
+ 250010p 0.9
+ 252000p 0.9
+ 252010p -0.3
+ 254000p -0.3
+ 254010p 0.9
+ 256000p 0.9
+ 256010p -0.3
+ 258000p -0.3
+ 258010p 0.9
+ 260000p 0.9
+ 260010p -0.3
+ 262000p -0.3
+ 262010p 0.9
+ 264000p 0.9
+ 264010p -0.3
+ 266000p -0.3
+ 266010p 0.9
+ 268000p 0.9
+ 268010p -0.3
+ 270000p -0.3
+ 270010p 0.9
+ 272000p 0.9
+ 272010p -0.3
+ 274000p -0.3
+ 274010p 0.9
+ 276000p 0.9
+ 276010p -0.3
+ 278000p -0.3
+ 278010p 0.9
+ 280000p 0.9
+ 280010p -0.3
+ 282000p -0.3
+ 282010p 0.9
+ 284000p 0.9
+ 284010p -0.3
+ 286000p -0.3
+ 286010p 0.9
+ 288000p 0.9
+ 288010p -0.3
+ 290000p -0.3
+ 290010p 0.9
+ 292000p 0.9
+ 292010p -0.3
+ 294000p -0.3
+ 294010p 0.9
+ 296000p 0.9
+ 296010p -0.3
+ 298000p -0.3
+ 298010p 0.9
+ 300000p 0.9
+ 300010p -0.3
+ 302000p -0.3
+ 302010p 0.9
+ 304000p 0.9
+ 304010p -0.3
+ 306000p -0.3
+ 306010p 0.9
+ 308000p 0.9
+ 308010p -0.3
+ 310000p -0.3
+ 310010p 0.9
+ 312000p 0.9
+ 312010p -0.3
+ 314000p -0.3
+ 314010p 0.9
+ 316000p 0.9
+ 316010p -0.3
+ 318000p -0.3
+ 318010p 0.9
+ 320000p 0.9
+ 320010p -0.3
+ 322000p -0.3
+ 322010p 0.9
+ 324000p 0.9
+ 324010p -0.3
+ 326000p -0.3
+ 326010p 0.9
+ 328000p 0.9
+ 328010p -0.3
+ 330000p -0.3
+ 330010p 0.9
+ 332000p 0.9
+ 332010p -0.3
+ 334000p -0.3
+ 334010p 0.9
+ 336000p 0.9
+ 336010p -0.3
+ 338000p -0.3
+ 338010p 0.9
+ 340000p 0.9
+ 340010p -0.3
+ 342000p -0.3
+ 342010p 0.9
+ 344000p 0.9
+ 344010p -0.3
+ 346000p -0.3
+ 346010p 0.9
+ 348000p 0.9
+ 348010p -0.3
+ 350000p -0.3
+ 350010p 0.9
+ 352000p 0.9
+ 352010p -0.3
+ 354000p -0.3
+ 354010p 0.9
+ 356000p 0.9
+ 356010p -0.3
+ 358000p -0.3
+ 358010p 0.9
+ 360000p 0.9
+ 360010p -0.3
+ 362000p -0.3
+ 362010p 0.9
+ 364000p 0.9
+ 364010p -0.3
+ 366000p -0.3
+ 366010p 0.9
+ 368000p 0.9
+ 368010p -0.3
+ 370000p -0.3
+ 370010p 0.9
+ 372000p 0.9
+ 372010p -0.3
+ 374000p -0.3
+ 374010p 0.9
+ 376000p 0.9
+ 376010p -0.3
+ 378000p -0.3
+ 378010p 0.9
+ 380000p 0.9
+ 380010p -0.3
+ 382000p -0.3
+ 382010p 0.9
+ 384000p 0.9
+ 384010p -0.3
+ 386000p -0.3
+ 386010p 0.9
+ 388000p 0.9
+ 388010p -0.3
+ 390000p -0.3
+ 390010p 0.9
+ 392000p 0.9
+ 392010p -0.3
+ 394000p -0.3
+ 394010p 0.9
+ 396000p 0.9
+ 396010p -0.3
+ 398000p -0.3
+ 398010p 0.9
+ 400000p 0.9
+ 400010p -0.3
+ 402000p -0.3
+ 402010p 0.9
+ 404000p 0.9
+ 404010p -0.3
+ 406000p -0.3
+ 406010p 0.9
+ 408000p 0.9
+ 408010p -0.3
+ 410000p -0.3
+ 410010p 0.9
+ 412000p 0.9
+ 412010p -0.3
+ 414000p -0.3
+ 414010p 0.9
+ 416000p 0.9
+ 416010p -0.3
+ 418000p -0.3
+ 418010p 0.9
+ 420000p 0.9
+ 420010p -0.3
+ 422000p -0.3
+ 422010p 0.9
+ 424000p 0.9
+ 424010p -0.3
+ 426000p -0.3
+ 426010p 0.9
+ 428000p 0.9
+ 428010p -0.3
+ 430000p -0.3
+ 430010p 0.9
+ 432000p 0.9
+ 432010p -0.3
+ 434000p -0.3
+ 434010p 0.9
+ 436000p 0.9
+ 436010p -0.3
+ 438000p -0.3
+ 438010p 0.9
+ 440000p 0.9
+ 440010p -0.3
+ 442000p -0.3
+ 442010p 0.9
+ 444000p 0.9
+ 444010p -0.3
+ 446000p -0.3
+ 446010p 0.9
+ 448000p 0.9
+ 448010p -0.3
+ 450000p -0.3
+ 450010p 0.9
+ 452000p 0.9
+ 452010p -0.3
+ 454000p -0.3
+ 454010p 0.9
+ 456000p 0.9
+ 456010p -0.3
+ 458000p -0.3
+ 458010p 0.9
+ 460000p 0.9
+ 460010p -0.3
+ 462000p -0.3
+ 462010p 0.9
+ 464000p 0.9
+ 464010p -0.3
+ 466000p -0.3
+ 466010p 0.9
+ 468000p 0.9
+ 468010p -0.3
+ 470000p -0.3
+ 470010p 0.9
+ 472000p 0.9
+ 472010p -0.3
+ 474000p -0.3
+ 474010p 0.9
+ 476000p 0.9
+ 476010p -0.3
+ 478000p -0.3
+ 478010p 0.9
+ 480000p 0.9
+ 480010p -0.3
+ 482000p -0.3
+ 482010p 0.9
+ 484000p 0.9
+ 484010p -0.3
+ 486000p -0.3
+ 486010p 0.9
+ 488000p 0.9
+ 488010p -0.3
+ 490000p -0.3
+ 490010p 0.9
+ 492000p 0.9
+ 492010p -0.3
+ 494000p -0.3
+ 494010p 0.9
+ 496000p 0.9
+ 496010p -0.3
+ 498000p -0.3
+ 498010p 0.9
+ 500000p 0.9
+ 500010p -0.3
+ 502000p -0.3
+ 502010p 0.9
+ 504000p 0.9
+ 504010p -0.3
+ 506000p -0.3
+ 506010p 0.9
+ 508000p 0.9
+ 508010p -0.3
+ 510000p -0.3
+ 510010p 0.9
+ 512000p 0.9
+ 512010p -0.3
+ 514000p -0.3
+ 514010p 0.9
+ 516000p 0.9
+ 516010p -0.3
+ 518000p -0.3
+ 518010p 0.9
+ 520000p 0.9
+ 520010p -0.3
+ 522000p -0.3
+ 522010p 0.9
+ 524000p 0.9
+ 524010p -0.3
+ 526000p -0.3
+ 526010p 0.9
+ 528000p 0.9
+ 528010p -0.3
+ 530000p -0.3
+ 530010p 0.9
+ 532000p 0.9
+ 532010p -0.3
+ 534000p -0.3
+ 534010p 0.9
+ 536000p 0.9
+ 536010p -0.3
+ 538000p -0.3
+ 538010p 0.9
+ 540000p 0.9
+ 540010p -0.3
+ 542000p -0.3
+ 542010p 0.9
+ 544000p 0.9
+ 544010p -0.3
+ 546000p -0.3
+ 546010p 0.9
+ 548000p 0.9
+ 548010p -0.3
+ 550000p -0.3
+ 550010p 0.9
+ 552000p 0.9
+ 552010p -0.3
+ 554000p -0.3
+ 554010p 0.9
+ 556000p 0.9
+ 556010p -0.3
+ 558000p -0.3
+ 558010p 0.9
+ 560000p 0.9
+ 560010p -0.3
+ 562000p -0.3
+ 562010p 0.9
+ 564000p 0.9
+ 564010p -0.3
+ 566000p -0.3
+ 566010p 0.9
+ 568000p 0.9
+ 568010p -0.3
+ 570000p -0.3
+ 570010p 0.9
+ 572000p 0.9
+ 572010p -0.3
+ 574000p -0.3
+ 574010p 0.9
+ 576000p 0.9
+ 576010p -0.3
+ 578000p -0.3
+ 578010p 0.9
+ 580000p 0.9
+ 580010p -0.3
+ 582000p -0.3
+ 582010p 0.9
+ 584000p 0.9
+ 584010p -0.3
+ 586000p -0.3
+ 586010p 0.9
+ 588000p 0.9
+ 588010p -0.3
+ 590000p -0.3
+ 590010p 0.9
+ 592000p 0.9
+ 592010p -0.3
+ 594000p -0.3
+ 594010p 0.9
+ 596000p 0.9
+ 596010p -0.3
+ 598000p -0.3
+ 598010p 0.9
+ 600000p 0.9
+ 600010p -0.3
+ 602000p -0.3
+ 602010p 0.9
+ 604000p 0.9
+ 604010p -0.3
+ 606000p -0.3
+ 606010p 0.9
+ 608000p 0.9
+ 608010p -0.3
+ 610000p -0.3
+ 610010p 0.9
+ 612000p 0.9
+ 612010p -0.3
+ 614000p -0.3
+ 614010p 0.9
+ 616000p 0.9
+ 616010p -0.3
+ 618000p -0.3
+ 618010p 0.9
+ 620000p 0.9
+ 620010p -0.3
+ 622000p -0.3
+ 622010p 0.9
+ 624000p 0.9
+ 624010p -0.3
+ 626000p -0.3
+ 626010p 0.9
+ 628000p 0.9
+ 628010p -0.3
+ 630000p -0.3
+ 630010p 0.9
+ 632000p 0.9
+ 632010p -0.3
+ 634000p -0.3
+ 634010p 0.9
+ 636000p 0.9
+ 636010p -0.3
+ 638000p -0.3
+ 638010p 0.9
+ 640000p 0.9
+ 640010p -0.3
+ 642000p -0.3
+ 642010p 0.9
+ 644000p 0.9
+ 644010p -0.3
+ 646000p -0.3
+ 646010p 0.9
+ 648000p 0.9
+ 648010p -0.3
+ 650000p -0.3
+ 650010p 0.9
+ 652000p 0.9
+ 652010p -0.3
+ 654000p -0.3
+ 654010p 0.9
+ 656000p 0.9
+ 656010p -0.3
+ 658000p -0.3
+ 658010p 0.9
+ 660000p 0.9
+ 660010p -0.3
+ 662000p -0.3
+ 662010p 0.9
+ 664000p 0.9
+ 664010p -0.3
+ 666000p -0.3
+ 666010p 0.9
+ 668000p 0.9
+ 668010p -0.3
+ 670000p -0.3
+ 670010p 0.9
+ 672000p 0.9
+ 672010p -0.3
+ 674000p -0.3
+ 674010p 0.9
+ 676000p 0.9
+ 676010p -0.3
+ 678000p -0.3
+ 678010p 0.9
+ 680000p 0.9
+ 680010p -0.3
+ 682000p -0.3
+ 682010p 0.9
+ 684000p 0.9
+ 684010p -0.3
+ 686000p -0.3
+ 686010p 0.9
+ 688000p 0.9
+ 688010p -0.3
+ 690000p -0.3
+ 690010p 0.9
+ 692000p 0.9
+ 692010p -0.3
+ 694000p -0.3
+ 694010p 0.9
+ 696000p 0.9
+ 696010p -0.3
+ 698000p -0.3
+ 698010p 0.9
+ 700000p 0.9
+ 700010p -0.3
+ 702000p -0.3
+ 702010p 0.9
+ 704000p 0.9
+ 704010p -0.3
+ 706000p -0.3
+ 706010p 0.9
+ 708000p 0.9
+ 708010p -0.3
+ 710000p -0.3
+ 710010p 0.9
+ 712000p 0.9
+ 712010p -0.3
+ 714000p -0.3
+ 714010p 0.9
+ 716000p 0.9
+ 716010p -0.3
+ 718000p -0.3
+ 718010p 0.9
+ 720000p 0.9
+ 720010p -0.3
+ 722000p -0.3
+ 722010p 0.9
+ 724000p 0.9
+ 724010p -0.3
+ 726000p -0.3
+ 726010p 0.9
+ 728000p 0.9
+ 728010p -0.3
+ 730000p -0.3
+ 730010p 0.9
+ 732000p 0.9
+ 732010p -0.3
+ 734000p -0.3
+ 734010p 0.9
+ 736000p 0.9
+ 736010p -0.3
+ 738000p -0.3
+ 738010p 0.9
+ 740000p 0.9
+ 740010p -0.3
+ 742000p -0.3
+ 742010p 0.9
+ 744000p 0.9
+ 744010p -0.3
+ 746000p -0.3
+ 746010p 0.9
+ 748000p 0.9
+ 748010p -0.3
+ 750000p -0.3
+ 750010p 0.9
+ 752000p 0.9
+ 752010p -0.3
+ 754000p -0.3
+ 754010p 0.9
+ 756000p 0.9
+ 756010p -0.3
+ 758000p -0.3
+ 758010p 0.9
+ 760000p 0.9
+ 760010p -0.3
+ 762000p -0.3
+ 762010p 0.9
+ 764000p 0.9
+ 764010p -0.3
+ 766000p -0.3
+ 766010p 0.9
+ 768000p 0.9
+ 768010p -0.3
+ 770000p -0.3
+ 770010p 0.9
+ 772000p 0.9
+ 772010p -0.3
+ 774000p -0.3
+ 774010p 0.9
+ 776000p 0.9
+ 776010p -0.3
+ 778000p -0.3
+ 778010p 0.9
+ 780000p 0.9
+ 780010p -0.3
+ 782000p -0.3
+ 782010p 0.9
+ 784000p 0.9
+ 784010p -0.3
+ 786000p -0.3
+ 786010p 0.9
+ 788000p 0.9
+ 788010p -0.3
+ 790000p -0.3
+ 790010p 0.9
+ 792000p 0.9
+ 792010p -0.3
+ 794000p -0.3
+ 794010p 0.9
+ 796000p 0.9
+ 796010p -0.3
+ 798000p -0.3
+ 798010p 0.9
+ 800000p 0.9
+ 800010p -0.3
+ 802000p -0.3
+ 802010p 0.9
+ 804000p 0.9
+ 804010p -0.3
+ 806000p -0.3
+ 806010p 0.9
+ 808000p 0.9
+ 808010p -0.3
+ 810000p -0.3
+ 810010p 0.9
+ 812000p 0.9
+ 812010p -0.3
+ 814000p -0.3
+ 814010p 0.9
+ 816000p 0.9
+ 816010p -0.3
+ 818000p -0.3
+ 818010p 0.9
+ 820000p 0.9
+ 820010p -0.3
+ 822000p -0.3
+ 822010p 0.9
+ 824000p 0.9
+ 824010p -0.3
+ 826000p -0.3
+ 826010p 0.9
+ 828000p 0.9
+ 828010p -0.3
+ 830000p -0.3
+ 830010p 0.9
+ 832000p 0.9
+ 832010p -0.3
+ 834000p -0.3
+ 834010p 0.9
+ 836000p 0.9
+ 836010p -0.3
+ 838000p -0.3
+ 838010p 0.9
+ 840000p 0.9
+ 840010p -0.3
+ 842000p -0.3
+ 842010p 0.9
+ 844000p 0.9
+ 844010p -0.3
+ 846000p -0.3
+ 846010p 0.9
+ 848000p 0.9
+ 848010p -0.3
+ 850000p -0.3
+ 850010p 0.9
+ 852000p 0.9
+ 852010p -0.3
+ 854000p -0.3
+ 854010p 0.9
+ 856000p 0.9
+ 856010p -0.3
+ 858000p -0.3
+ 858010p 0.9
+ 860000p 0.9
+ 860010p -0.3
+ 862000p -0.3
+ 862010p 0.9
+ 864000p 0.9
+ 864010p -0.3
+ 866000p -0.3
+ 866010p 0.9
+ 868000p 0.9
+ 868010p -0.3
+ 870000p -0.3
+ 870010p 0.9
+ 872000p 0.9
+ 872010p -0.3
+ 874000p -0.3
+ 874010p 0.9
+ 876000p 0.9
+ 876010p -0.3
+ 878000p -0.3
+ 878010p 0.9
+ 880000p 0.9
+ 880010p -0.3
+ 882000p -0.3
+ 882010p 0.9
+ 884000p 0.9
+ 884010p -0.3
+ 886000p -0.3
+ 886010p 0.9
+ 888000p 0.9
+ 888010p -0.3
+ 890000p -0.3
+ 890010p 0.9
+ 892000p 0.9
+ 892010p -0.3
+ 894000p -0.3
+ 894010p 0.9
+ 896000p 0.9
+ 896010p -0.3
+ 898000p -0.3
+ 898010p 0.9
+ 900000p 0.9
+ 900010p -0.3
+ 902000p -0.3
+ 902010p 0.9
+ 904000p 0.9
+ 904010p -0.3
+ 906000p -0.3
+ 906010p 0.9
+ 908000p 0.9
+ 908010p -0.3
+ 910000p -0.3
+ 910010p 0.9
+ 912000p 0.9
+ 912010p -0.3
+ 914000p -0.3
+ 914010p 0.9
+ 916000p 0.9
+ 916010p -0.3
+ 918000p -0.3
+ 918010p 0.9
+ 920000p 0.9
+ 920010p -0.3
+ 922000p -0.3
+ 922010p 0.9
+ 924000p 0.9
+ 924010p -0.3
+ 926000p -0.3
+ 926010p 0.9
+ 928000p 0.9
+ 928010p -0.3
+ 930000p -0.3
+ 930010p 0.9
+ 932000p 0.9
+ 932010p -0.3
+ 934000p -0.3
+ 934010p 0.9
+ 936000p 0.9
+ 936010p -0.3
+ 938000p -0.3
+ 938010p 0.9
+ 940000p 0.9
+ 940010p -0.3
+ 942000p -0.3
+ 942010p 0.9
+ 944000p 0.9
+ 944010p -0.3
+ 946000p -0.3
+ 946010p 0.9
+ 948000p 0.9
+ 948010p -0.3
+ 950000p -0.3
+ 950010p 0.9
+ 952000p 0.9
+ 952010p -0.3
+ 954000p -0.3
+ 954010p 0.9
+ 956000p 0.9
+ 956010p -0.3
+ 958000p -0.3
+ 958010p 0.9
+ 960000p 0.9
+ 960010p -0.3
+ 962000p -0.3
+ 962010p 0.9
+ 964000p 0.9
+ 964010p -0.3
+ 966000p -0.3
+ 966010p 0.9
+ 968000p 0.9
+ 968010p -0.3
+ 970000p -0.3
+ 970010p 0.9
+ 972000p 0.9
+ 972010p -0.3
+ 974000p -0.3
+ 974010p 0.9
+ 976000p 0.9
+ 976010p -0.3
+ 978000p -0.3
+ 978010p 0.9
+ 980000p 0.9
+ 980010p -0.3
+ 982000p -0.3
+ 982010p 0.9
+ 984000p 0.9
+ 984010p -0.3
+ 986000p -0.3
+ 986010p 0.9
+ 988000p 0.9
+ 988010p -0.3
+ 990000p -0.3
+ 990010p 0.9
+ 992000p 0.9
+ 992010p -0.3
+ 994000p -0.3
+ 994010p 0.9
+ 996000p 0.9
+ 996010p -0.3
+ 998000p -0.3
+ 998010p 0.9
+ 1000000p 0.9
+ 1000010p -0.3
+ 1002000p -0.3
+ 1002010p 0.9
+ 1004000p 0.9
+ 1004010p -0.3
+ 1006000p -0.3
+ 1006010p 0.9
+ 1008000p 0.9
+ 1008010p -0.3
+ 1010000p -0.3
+ 1010010p 0.9
+ 1012000p 0.9
+ 1012010p -0.3
+ 1014000p -0.3
+ 1014010p 0.9
+ 1016000p 0.9
+ 1016010p -0.3
+ 1018000p -0.3
+ 1018010p 0.9
+ 1020000p 0.9
+ 1020010p -0.3
+ 1022000p -0.3
+ 1022010p 0.9
+ 1024000p 0.9
+ 1024010p -0.3
+ 1026000p -0.3
+ 1026010p 0.9
+ 1028000p 0.9
+ 1028010p -0.3
+ 1030000p -0.3
+ 1030010p 0.9
+ 1032000p 0.9
+ 1032010p -0.3
+ 1034000p -0.3
+ 1034010p 0.9
+ 1036000p 0.9
+ 1036010p -0.3
+ 1038000p -0.3
+ 1038010p 0.9
+ 1040000p 0.9
+ 1040010p -0.3
+ 1042000p -0.3
+ 1042010p 0.9
+ 1044000p 0.9
+ 1044010p -0.3
+ 1046000p -0.3
+ 1046010p 0.9
+ 1048000p 0.9
+ 1048010p -0.3
+ 1050000p -0.3
+ 1050010p 0.9
+ 1052000p 0.9
+ 1052010p -0.3
+ 1054000p -0.3
+ 1054010p 0.9
+ 1056000p 0.9
+ 1056010p -0.3
+ 1058000p -0.3
+ 1058010p 0.9
+ 1060000p 0.9
+ 1060010p -0.3
+ 1062000p -0.3
+ 1062010p 0.9
+ 1064000p 0.9
+ 1064010p -0.3
+ 1066000p -0.3
+ 1066010p 0.9
+ 1068000p 0.9
+ 1068010p -0.3
+ 1070000p -0.3
+ 1070010p 0.9
+ 1072000p 0.9
+ 1072010p -0.3
+ 1074000p -0.3
+ 1074010p 0.9
+ 1076000p 0.9
+ 1076010p -0.3
+ 1078000p -0.3
+ 1078010p 0.9
+ 1080000p 0.9
+ 1080010p -0.3
+ 1082000p -0.3
+ 1082010p 0.9
+ 1084000p 0.9
+ 1084010p -0.3
+ 1086000p -0.3
+ 1086010p 0.9
+ 1088000p 0.9
+ 1088010p -0.3
+ 1090000p -0.3
+ 1090010p 0.9
+ 1092000p 0.9
+ 1092010p -0.3
+ 1094000p -0.3
+ 1094010p 0.9
+ 1096000p 0.9
+ 1096010p -0.3
+ 1098000p -0.3
+ 1098010p 0.9
+ 1100000p 0.9
+ 1100010p -0.3
+ 1102000p -0.3
+ 1102010p 0.9
+ 1104000p 0.9
+ 1104010p -0.3
+ 1106000p -0.3
+ 1106010p 0.9
+ 1108000p 0.9
+ 1108010p -0.3
+ 1110000p -0.3
+ 1110010p 0.9
+ 1112000p 0.9
+ 1112010p -0.3
+ 1114000p -0.3
+ 1114010p 0.9
+ 1116000p 0.9
+ 1116010p -0.3
+ 1118000p -0.3
+ 1118010p 0.9
+ 1120000p 0.9
+ 1120010p -0.3
+ 1122000p -0.3
+ 1122010p 0.9
+ 1124000p 0.9
+ 1124010p -0.3
+ 1126000p -0.3
+ 1126010p 0.9
+ 1128000p 0.9
+ 1128010p -0.3
+ 1130000p -0.3
+ 1130010p 0.9
+ 1132000p 0.9
+ 1132010p -0.3
+ 1134000p -0.3
+ 1134010p 0.9
+ 1136000p 0.9
+ 1136010p -0.3
+ 1138000p -0.3
+ 1138010p 0.9
+ 1140000p 0.9
+ 1140010p -0.3
+ 1142000p -0.3
+ 1142010p 0.9
+ 1144000p 0.9
+ 1144010p -0.3
+ 1146000p -0.3
+ 1146010p 0.9
+ 1148000p 0.9
+ 1148010p -0.3
+ 1150000p -0.3
+ 1150010p 0.9
+ 1152000p 0.9
+ 1152010p -0.3
+ 1154000p -0.3
+ 1154010p 0.9
+ 1156000p 0.9
+ 1156010p -0.3
+ 1158000p -0.3
+ 1158010p 0.9
+ 1160000p 0.9
+ 1160010p -0.3
+ 1162000p -0.3
+ 1162010p 0.9
+ 1164000p 0.9
+ 1164010p -0.3
+ 1166000p -0.3
+ 1166010p 0.9
+ 1168000p 0.9
+ 1168010p -0.3
+ 1170000p -0.3
+ 1170010p 0.9
+ 1172000p 0.9
+ 1172010p -0.3
+ 1174000p -0.3
+ 1174010p 0.9
+ 1176000p 0.9
+ 1176010p -0.3
+ 1178000p -0.3
+ 1178010p 0.9
+ 1180000p 0.9
+ 1180010p -0.3
+ 1182000p -0.3
+ 1182010p 0.9
+ 1184000p 0.9
+ 1184010p -0.3
+ 1186000p -0.3
+ 1186010p 0.9
+ 1188000p 0.9
+ 1188010p -0.3
+ 1190000p -0.3
+ 1190010p 0.9
+ 1192000p 0.9
+ 1192010p -0.3
+ 1194000p -0.3
+ 1194010p 0.9
+ 1196000p 0.9
+ 1196010p -0.3
+ 1198000p -0.3
+ 1198010p 0.9
+ 1200000p 0.9
+ 1200010p -0.3
+ 1202000p -0.3
+ 1202010p 0.9
+ 1204000p 0.9
+ 1204010p -0.3
+ 1206000p -0.3
+ 1206010p 0.9
+ 1208000p 0.9
+ 1208010p -0.3
+ 1210000p -0.3
+ 1210010p 0.9
+ 1212000p 0.9
+ 1212010p -0.3
+ 1214000p -0.3
+ 1214010p 0.9
+ 1216000p 0.9
+ 1216010p -0.3
+ 1218000p -0.3
+ 1218010p 0.9
+ 1220000p 0.9
+ 1220010p -0.3
+ 1222000p -0.3
+ 1222010p 0.9
+ 1224000p 0.9
+ 1224010p -0.3
+ 1226000p -0.3
+ 1226010p 0.9
+ 1228000p 0.9
+ 1228010p -0.3
+ 1230000p -0.3
+ 1230010p 0.9
+ 1232000p 0.9
+ 1232010p -0.3
+ 1234000p -0.3
+ 1234010p 0.9
+ 1236000p 0.9
+ 1236010p -0.3
+ 1238000p -0.3
+ 1238010p 0.9
+ 1240000p 0.9
+ 1240010p -0.3
+ 1242000p -0.3
+ 1242010p 0.9
+ 1244000p 0.9
+ 1244010p -0.3
+ 1246000p -0.3
+ 1246010p 0.9
+ 1248000p 0.9
+ 1248010p -0.3
+ 1250000p -0.3
+ 1250010p 0.9
+ 1252000p 0.9
+ 1252010p -0.3
+ 1254000p -0.3
+ 1254010p 0.9
+ 1256000p 0.9
+ 1256010p -0.3
+ 1258000p -0.3
+ 1258010p 0.9
+ 1260000p 0.9
+ 1260010p -0.3
+ 1262000p -0.3
+ 1262010p 0.9
+ 1264000p 0.9
+ 1264010p -0.3
+ 1266000p -0.3
+ 1266010p 0.9
+ 1268000p 0.9
+ 1268010p -0.3
+ 1270000p -0.3
+ 1270010p 0.9
+ 1272000p 0.9
+ 1272010p -0.3
+ 1274000p -0.3
+ 1274010p 0.9
+ 1276000p 0.9
+ 1276010p -0.3
+ 1278000p -0.3
+ 1278010p 0.9
+ 1280000p 0.9
+ 1280010p -0.3
+ 1282000p -0.3
+ 1282010p 0.9
+ 1284000p 0.9
+ 1284010p -0.3
+ 1286000p -0.3
+ 1286010p 0.9
+ 1288000p 0.9
+ 1288010p -0.3
+ 1290000p -0.3
+ 1290010p 0.9
+ 1292000p 0.9
+ 1292010p -0.3
+ 1294000p -0.3
+ 1294010p 0.9
+ 1296000p 0.9
+ 1296010p -0.3
+ 1298000p -0.3
+ 1298010p 0.9
+ 1300000p 0.9
+ 1300010p -0.3
+ 1302000p -0.3
+ 1302010p 0.9
+ 1304000p 0.9
+ 1304010p -0.3
+ 1306000p -0.3
+ 1306010p 0.9
+ 1308000p 0.9
+ 1308010p -0.3
+ 1310000p -0.3
+ 1310010p 0.9
+ 1312000p 0.9
+ 1312010p -0.3
+ 1314000p -0.3
+ 1314010p 0.9
+ 1316000p 0.9
+ 1316010p -0.3
+ 1318000p -0.3
+ 1318010p 0.9
+ 1320000p 0.9
+ 1320010p -0.3
+ 1322000p -0.3
+ 1322010p 0.9
+ 1324000p 0.9
+ 1324010p -0.3
+ 1326000p -0.3
+ 1326010p 0.9
+ 1328000p 0.9
+ 1328010p -0.3
+ 1330000p -0.3
+ 1330010p 0.9
+ 1332000p 0.9
+ 1332010p -0.3
+ 1334000p -0.3
+ 1334010p 0.9
+ 1336000p 0.9
+ 1336010p -0.3
+ 1338000p -0.3
+ 1338010p 0.9
+ 1340000p 0.9
+ 1340010p -0.3
+ 1342000p -0.3
+ 1342010p 0.9
+ 1344000p 0.9
+ 1344010p -0.3
+ 1346000p -0.3
+ 1346010p 0.9
+ 1348000p 0.9
+ 1348010p -0.3
+ 1350000p -0.3
+ 1350010p 0.9
+ 1352000p 0.9
+ 1352010p -0.3
+ 1354000p -0.3
+ 1354010p 0.9
+ 1356000p 0.9
+ 1356010p -0.3
+ 1358000p -0.3
+ 1358010p 0.9
+ 1360000p 0.9
+ 1360010p -0.3
+ 1362000p -0.3
+ 1362010p 0.9
+ 1364000p 0.9
+ 1364010p -0.3
+ 1366000p -0.3
+ 1366010p 0.9
+ 1368000p 0.9
+ 1368010p -0.3
+ 1370000p -0.3
+ 1370010p 0.9
+ 1372000p 0.9
+ 1372010p -0.3
+ 1374000p -0.3
+ 1374010p 0.9
+ 1376000p 0.9
+ 1376010p -0.3
+ 1378000p -0.3
+ 1378010p 0.9
+ 1380000p 0.9
+ 1380010p -0.3
+ 1382000p -0.3
+ 1382010p 0.9
+ 1384000p 0.9
+ 1384010p -0.3
+ 1386000p -0.3
+ 1386010p 0.9
+ 1388000p 0.9
+ 1388010p -0.3
+ 1390000p -0.3
+ 1390010p 0.9
+ 1392000p 0.9
+ 1392010p -0.3
+ 1394000p -0.3
+ 1394010p 0.9
+ 1396000p 0.9
+ 1396010p -0.3
+ 1398000p -0.3
+ 1398010p 0.9
+ 1400000p 0.9
+ 1400010p -0.3
+ 1402000p -0.3
+ 1402010p 0.9
+ 1404000p 0.9
+ 1404010p -0.3
+ 1406000p -0.3
+ 1406010p 0.9
+ 1408000p 0.9
+ 1408010p -0.3
+ 1410000p -0.3
+ 1410010p 0.9
+ 1412000p 0.9
+ 1412010p -0.3
+ 1414000p -0.3
+ 1414010p 0.9
+ 1416000p 0.9
+ 1416010p -0.3
+ 1418000p -0.3
+ 1418010p 0.9
+ 1420000p 0.9
+ 1420010p -0.3
+ 1422000p -0.3
+ 1422010p 0.9
+ 1424000p 0.9
+ 1424010p -0.3
+ 1426000p -0.3
+ 1426010p 0.9
+ 1428000p 0.9
+ 1428010p -0.3
+ 1430000p -0.3
+ 1430010p 0.9
+ 1432000p 0.9
+ 1432010p -0.3
+ 1434000p -0.3
+ 1434010p 0.9
+ 1436000p 0.9
+ 1436010p -0.3
+ 1438000p -0.3
+ 1438010p 0.9
+ 1440000p 0.9
+ 1440010p -0.3
+ 1442000p -0.3
+ 1442010p 0.9
+ 1444000p 0.9
+ 1444010p -0.3
+ 1446000p -0.3
+ 1446010p 0.9
+ 1448000p 0.9
+ 1448010p -0.3
+ 1450000p -0.3
+ 1450010p 0.9
+ 1452000p 0.9
+ 1452010p -0.3
+ 1454000p -0.3
+ 1454010p 0.9
+ 1456000p 0.9
+ 1456010p -0.3
+ 1458000p -0.3
+ 1458010p 0.9
+ 1460000p 0.9
+ 1460010p -0.3
+ 1462000p -0.3
+ 1462010p 0.9
+ 1464000p 0.9
+ 1464010p -0.3
+ 1466000p -0.3
+ 1466010p 0.9
+ 1468000p 0.9
+ 1468010p -0.3
+ 1470000p -0.3
+ 1470010p 0.9
+ 1472000p 0.9
+ 1472010p -0.3
+ 1474000p -0.3
+ 1474010p 0.9
+ 1476000p 0.9
+ 1476010p -0.3
+ 1478000p -0.3
+ 1478010p 0.9
+ 1480000p 0.9
+ 1480010p -0.3
+ 1482000p -0.3
+ 1482010p 0.9
+ 1484000p 0.9
+ 1484010p -0.3
+ 1486000p -0.3
+ 1486010p 0.9
+ 1488000p 0.9
+ 1488010p -0.3
+ 1490000p -0.3
+ 1490010p 0.9
+ 1492000p 0.9
+ 1492010p -0.3
+ 1494000p -0.3
+ 1494010p 0.9
+ 1496000p 0.9
+ 1496010p -0.3
+ 1498000p -0.3
+ 1498010p 0.9
+ 1500000p 0.9
+ 1500010p -0.3
+ 1502000p -0.3
+ 1502010p 0.9
+ 1504000p 0.9
+ 1504010p -0.3
+ 1506000p -0.3
+ 1506010p 0.9
+ 1508000p 0.9
+ 1508010p -0.3
+ 1510000p -0.3
+ 1510010p 0.9
+ 1512000p 0.9
+ 1512010p -0.3
+ 1514000p -0.3
+ 1514010p 0.9
+ 1516000p 0.9
+ 1516010p -0.3
+ 1518000p -0.3
+ 1518010p 0.9
+ 1520000p 0.9
+ 1520010p -0.3
+ 1522000p -0.3
+ 1522010p 0.9
+ 1524000p 0.9
+ 1524010p -0.3
+ 1526000p -0.3
+ 1526010p 0.9
+ 1528000p 0.9
+ 1528010p -0.3
+ 1530000p -0.3
+ 1530010p 0.9
+ 1532000p 0.9
+ 1532010p -0.3
+ 1534000p -0.3
+ 1534010p 0.9
+ 1536000p 0.9
+ 1536010p -0.3
+ 1538000p -0.3
+ 1538010p 0.9
+ 1540000p 0.9
+ 1540010p -0.3
+ 1542000p -0.3
+ 1542010p 0.9
+ 1544000p 0.9
+ 1544010p -0.3
+ 1546000p -0.3
+ 1546010p 0.9
+ 1548000p 0.9
+ 1548010p -0.3
+ 1550000p -0.3
+ 1550010p 0.9
+ 1552000p 0.9
+ 1552010p -0.3
+ 1554000p -0.3
+ 1554010p 0.9
+ 1556000p 0.9
+ 1556010p -0.3
+ 1558000p -0.3
+ 1558010p 0.9
+ 1560000p 0.9
+ 1560010p -0.3
+ 1562000p -0.3
+ 1562010p 0.9
+ 1564000p 0.9
+ 1564010p -0.3
+ 1566000p -0.3
+ 1566010p 0.9
+ 1568000p 0.9
+ 1568010p -0.3
+ 1570000p -0.3
+ 1570010p 0.9
+ 1572000p 0.9
+ 1572010p -0.3
+ 1574000p -0.3
+ 1574010p 0.9
+ 1576000p 0.9
+ 1576010p -0.3
+ 1578000p -0.3
+ 1578010p 0.9
+ 1580000p 0.9
+ 1580010p -0.3
+ 1582000p -0.3
+ 1582010p 0.9
+ 1584000p 0.9
+ 1584010p -0.3
+ 1586000p -0.3
+ 1586010p 0.9
+ 1588000p 0.9
+ 1588010p -0.3
+ 1590000p -0.3
+ 1590010p 0.9
+ 1592000p 0.9
+ 1592010p -0.3
+ 1594000p -0.3
+ 1594010p 0.9
+ 1596000p 0.9
+ 1596010p -0.3
+ 1598000p -0.3
+ 1598010p 0.9
+ 1600000p 0.9
+ 1600010p -0.3
+ 1602000p -0.3
+ 1602010p 0.9
+ 1604000p 0.9
+ 1604010p -0.3
+ 1606000p -0.3
+ 1606010p 0.9
+ 1608000p 0.9
+ 1608010p -0.3
+ 1610000p -0.3
+ 1610010p 0.9
+ 1612000p 0.9
+ 1612010p -0.3
+ 1614000p -0.3
+ 1614010p 0.9
+ 1616000p 0.9
+ 1616010p -0.3
+ 1618000p -0.3
+ 1618010p 0.9
+ 1620000p 0.9
+ 1620010p -0.3
+ 1622000p -0.3
+ 1622010p 0.9
+ 1624000p 0.9
+ 1624010p -0.3
+ 1626000p -0.3
+ 1626010p 0.9
+ 1628000p 0.9
+ 1628010p -0.3
+ 1630000p -0.3
+ 1630010p 0.9
+ 1632000p 0.9
+ 1632010p -0.3
+ 1634000p -0.3
+ 1634010p 0.9
+ 1636000p 0.9
+ 1636010p -0.3
+ 1638000p -0.3
+ 1638010p 0.9
+ 1640000p 0.9
+ 1640010p -0.3
+ 1642000p -0.3
+ 1642010p 0.9
+ 1644000p 0.9
+ 1644010p -0.3
+ 1646000p -0.3
+ 1646010p 0.9
+ 1648000p 0.9
+ 1648010p -0.3
+ 1650000p -0.3
+ 1650010p 0.9
+ 1652000p 0.9
+ 1652010p -0.3
+ 1654000p -0.3
+ 1654010p 0.9
+ 1656000p 0.9
+ 1656010p -0.3
+ 1658000p -0.3
+ 1658010p 0.9
+ 1660000p 0.9
+ 1660010p -0.3
+ 1662000p -0.3
+ 1662010p 0.9
+ 1664000p 0.9
+ 1664010p -0.3
+ 1666000p -0.3
+ 1666010p 0.9
+ 1668000p 0.9
+ 1668010p -0.3
+ 1670000p -0.3
+ 1670010p 0.9
+ 1672000p 0.9
+ 1672010p -0.3
+ 1674000p -0.3
+ 1674010p 0.9
+ 1676000p 0.9
+ 1676010p -0.3
+ 1678000p -0.3
+ 1678010p 0.9
+ 1680000p 0.9
+ 1680010p -0.3
+ 1682000p -0.3
+ 1682010p 0.9
+ 1684000p 0.9
+ 1684010p -0.3
+ 1686000p -0.3
+ 1686010p 0.9
+ 1688000p 0.9
+ 1688010p -0.3
+ 1690000p -0.3
+ 1690010p 0.9
+ 1692000p 0.9
+ 1692010p -0.3
+ 1694000p -0.3
+ 1694010p 0.9
+ 1696000p 0.9
+ 1696010p -0.3
+ 1698000p -0.3
+ 1698010p 0.9
+ 1700000p 0.9
+ 1700010p -0.3
+ 1702000p -0.3
+ 1702010p 0.9
+ 1704000p 0.9
+ 1704010p -0.3
+ 1706000p -0.3
+ 1706010p 0.9
+ 1708000p 0.9
+ 1708010p -0.3
+ 1710000p -0.3
+ 1710010p 0.9
+ 1712000p 0.9
+ 1712010p -0.3
+ 1714000p -0.3
+ 1714010p 0.9
+ 1716000p 0.9
+ 1716010p -0.3
+ 1718000p -0.3
+ 1718010p 0.9
+ 1720000p 0.9
+ 1720010p -0.3
+ 1722000p -0.3
+ 1722010p 0.9
+ 1724000p 0.9
+ 1724010p -0.3
+ 1726000p -0.3
+ 1726010p 0.9
+ 1728000p 0.9
+ 1728010p -0.3
+ 1730000p -0.3
+ 1730010p 0.9
+ 1732000p 0.9
+ 1732010p -0.3
+ 1734000p -0.3
+ 1734010p 0.9
+ 1736000p 0.9
+ 1736010p -0.3
+ 1738000p -0.3
+ 1738010p 0.9
+ 1740000p 0.9
+ 1740010p -0.3
+ 1742000p -0.3
+ 1742010p 0.9
+ 1744000p 0.9
+ 1744010p -0.3
+ 1746000p -0.3
+ 1746010p 0.9
+ 1748000p 0.9
+ 1748010p -0.3
+ 1750000p -0.3
+ 1750010p 0.9
+ 1752000p 0.9
+ 1752010p -0.3
+ 1754000p -0.3
+ 1754010p 0.9
+ 1756000p 0.9
+ 1756010p -0.3
+ 1758000p -0.3
+ 1758010p 0.9
+ 1760000p 0.9
+ 1760010p -0.3
+ 1762000p -0.3
+ 1762010p 0.9
+ 1764000p 0.9
+ 1764010p -0.3
+ 1766000p -0.3
+ 1766010p 0.9
+ 1768000p 0.9
+ 1768010p -0.3
+ 1770000p -0.3
+ 1770010p 0.9
+ 1772000p 0.9
+ 1772010p -0.3
+ 1774000p -0.3
+ 1774010p 0.9
+ 1776000p 0.9
+ 1776010p -0.3
+ 1778000p -0.3
+ 1778010p 0.9
+ 1780000p 0.9
+ 1780010p -0.3
+ 1782000p -0.3
+ 1782010p 0.9
+ 1784000p 0.9
+ 1784010p -0.3
+ 1786000p -0.3
+ 1786010p 0.9
+ 1788000p 0.9
+ 1788010p -0.3
+ 1790000p -0.3
+ 1790010p 0.9
+ 1792000p 0.9
+ 1792010p -0.3
+ 1794000p -0.3
+ 1794010p 0.9
+ 1796000p 0.9
+ 1796010p -0.3
+ 1798000p -0.3
+ 1798010p 0.9
+ 1800000p 0.9
+ 1800010p -0.3
+ 1802000p -0.3
+ 1802010p 0.9
+ 1804000p 0.9
+ 1804010p -0.3
+ 1806000p -0.3
+ 1806010p 0.9
+ 1808000p 0.9
+ 1808010p -0.3
+ 1810000p -0.3
+ 1810010p 0.9
+ 1812000p 0.9
+ 1812010p -0.3
+ 1814000p -0.3
+ 1814010p 0.9
+ 1816000p 0.9
+ 1816010p -0.3
+ 1818000p -0.3
+ 1818010p 0.9
+ 1820000p 0.9
+ 1820010p -0.3
+ 1822000p -0.3
+ 1822010p 0.9
+ 1824000p 0.9
+ 1824010p -0.3
+ 1826000p -0.3
+ 1826010p 0.9
+ 1828000p 0.9
+ 1828010p -0.3
+ 1830000p -0.3
+ 1830010p 0.9
+ 1832000p 0.9
+ 1832010p -0.3
+ 1834000p -0.3
+ 1834010p 0.9
+ 1836000p 0.9
+ 1836010p -0.3
+ 1838000p -0.3
+ 1838010p 0.9
+ 1840000p 0.9
+ 1840010p -0.3
+ 1842000p -0.3
+ 1842010p 0.9
+ 1844000p 0.9
+ 1844010p -0.3
+ 1846000p -0.3
+ 1846010p 0.9
+ 1848000p 0.9
+ 1848010p -0.3
+ 1850000p -0.3
+ 1850010p 0.9
+ 1852000p 0.9
+ 1852010p -0.3
+ 1854000p -0.3
+ 1854010p 0.9
+ 1856000p 0.9
+ 1856010p -0.3
+ 1858000p -0.3
+ 1858010p 0.9
+ 1860000p 0.9
+ 1860010p -0.3
+ 1862000p -0.3
+ 1862010p 0.9
+ 1864000p 0.9
+ 1864010p -0.3
+ 1866000p -0.3
+ 1866010p 0.9
+ 1868000p 0.9
+ 1868010p -0.3
+ 1870000p -0.3
+ 1870010p 0.9
+ 1872000p 0.9
+ 1872010p -0.3
+ 1874000p -0.3
+ 1874010p 0.9
+ 1876000p 0.9
+ 1876010p -0.3
+ 1878000p -0.3
+ 1878010p 0.9
+ 1880000p 0.9
+ 1880010p -0.3
+ 1882000p -0.3
+ 1882010p 0.9
+ 1884000p 0.9
+ 1884010p -0.3
+ 1886000p -0.3
+ 1886010p 0.9
+ 1888000p 0.9
+ 1888010p -0.3
+ 1890000p -0.3
+ 1890010p 0.9
+ 1892000p 0.9
+ 1892010p -0.3
+ 1894000p -0.3
+ 1894010p 0.9
+ 1896000p 0.9
+ 1896010p -0.3
+ 1898000p -0.3
+ 1898010p 0.9
+ 1900000p 0.9
+ 1900010p -0.3
+ 1902000p -0.3
+ 1902010p 0.9
+ 1904000p 0.9
+ 1904010p -0.3
+ 1906000p -0.3
+ 1906010p 0.9
+ 1908000p 0.9
+ 1908010p -0.3
+ 1910000p -0.3
+ 1910010p 0.9
+ 1912000p 0.9
+ 1912010p -0.3
+ 1914000p -0.3
+ 1914010p 0.9
+ 1916000p 0.9
+ 1916010p -0.3
+ 1918000p -0.3
+ 1918010p 0.9
+ 1920000p 0.9
+ 1920010p -0.3
+ 1922000p -0.3
+ 1922010p 0.9
+ 1924000p 0.9
+ 1924010p -0.3
+ 1926000p -0.3
+ 1926010p 0.9
+ 1928000p 0.9
+ 1928010p -0.3
+ 1930000p -0.3
+ 1930010p 0.9
+ 1932000p 0.9
+ 1932010p -0.3
+ 1934000p -0.3
+ 1934010p 0.9
+ 1936000p 0.9
+ 1936010p -0.3
+ 1938000p -0.3
+ 1938010p 0.9
+ 1940000p 0.9
+ 1940010p -0.3
+ 1942000p -0.3
+ 1942010p 0.9
+ 1944000p 0.9
+ 1944010p -0.3
+ 1946000p -0.3
+ 1946010p 0.9
+ 1948000p 0.9
+ 1948010p -0.3
+ 1950000p -0.3
+ 1950010p 0.9
+ 1952000p 0.9
+ 1952010p -0.3
+ 1954000p -0.3
+ 1954010p 0.9
+ 1956000p 0.9
+ 1956010p -0.3
+ 1958000p -0.3
+ 1958010p 0.9
+ 1960000p 0.9
+ 1960010p -0.3
+ 1962000p -0.3
+ 1962010p 0.9
+ 1964000p 0.9
+ 1964010p -0.3
+ 1966000p -0.3
+ 1966010p 0.9
+ 1968000p 0.9
+ 1968010p -0.3
+ 1970000p -0.3
+ 1970010p 0.9
+ 1972000p 0.9
+ 1972010p -0.3
+ 1974000p -0.3
+ 1974010p 0.9
+ 1976000p 0.9
+ 1976010p -0.3
+ 1978000p -0.3
+ 1978010p 0.9
+ 1980000p 0.9
+ 1980010p -0.3
+ 1982000p -0.3
+ 1982010p 0.9
+ 1984000p 0.9
+ 1984010p -0.3
+ 1986000p -0.3
+ 1986010p 0.9
+ 1988000p 0.9
+ 1988010p -0.3
+ 1990000p -0.3
+ 1990010p 0.9
+ 1992000p 0.9
+ 1992010p -0.3
+ 1994000p -0.3
+ 1994010p 0.9
+ 1996000p 0.9
+ 1996010p -0.3
+ 1998000p -0.3
+ 1998010p 0.9
+ 2000000p 0.9
+ 2000010p -0.3
+ 2002000p -0.3
+ 2002010p 0.9
+ 2004000p 0.9
+ 2004010p -0.3
+ 2006000p -0.3
+ 2006010p 0.9
+ 2008000p 0.9
+ 2008010p -0.3
+ 2010000p -0.3
+ 2010010p 0.9
+ 2012000p 0.9
+ 2012010p -0.3
+ 2014000p -0.3
+ 2014010p 0.9
+ 2016000p 0.9
+ 2016010p -0.3
+ 2018000p -0.3
+ 2018010p 0.9
+ 2020000p 0.9
+ 2020010p -0.3
+ 2022000p -0.3
+ 2022010p 0.9
+ 2024000p 0.9
+ 2024010p -0.3
+ 2026000p -0.3
+ 2026010p 0.9
+ 2028000p 0.9
+ 2028010p -0.3
+ 2030000p -0.3
+ 2030010p 0.9
+ 2032000p 0.9
+ 2032010p -0.3
+ 2034000p -0.3
+ 2034010p 0.9
+ 2036000p 0.9
+ 2036010p -0.3
+ 2038000p -0.3
+ 2038010p 0.9
+ 2040000p 0.9
+ 2040010p -0.3
+ 2042000p -0.3
+ 2042010p 0.9
+ 2044000p 0.9
+ 2044010p -0.3
+ 2046000p -0.3
+ 2046010p 0.9
+ 2048000p 0.9
+ 2048010p -0.3
+ \]
V_data_7 (Data\\<7\\> gnd!) vsource type=pwl wave=\[
+ 0    0.9
+ 2000p 0.9
+ 2010p -0.3
+ 4000p -0.3
+ 4010p 0.9
+ 6000p 0.9
+ 6010p -0.3
+ 8000p -0.3
+ 8010p 0.9
+ 10000p 0.9
+ 10010p -0.3
+ 12000p -0.3
+ 12010p 0.9
+ 14000p 0.9
+ 14010p -0.3
+ 16000p -0.3
+ 16010p 0.9
+ 18000p 0.9
+ 18010p -0.3
+ 20000p -0.3
+ 20010p 0.9
+ 22000p 0.9
+ 22010p -0.3
+ 24000p -0.3
+ 24010p 0.9
+ 26000p 0.9
+ 26010p -0.3
+ 28000p -0.3
+ 28010p 0.9
+ 30000p 0.9
+ 30010p -0.3
+ 32000p -0.3
+ 32010p 0.9
+ 34000p 0.9
+ 34010p -0.3
+ 36000p -0.3
+ 36010p 0.9
+ 38000p 0.9
+ 38010p -0.3
+ 40000p -0.3
+ 40010p 0.9
+ 42000p 0.9
+ 42010p -0.3
+ 44000p -0.3
+ 44010p 0.9
+ 46000p 0.9
+ 46010p -0.3
+ 48000p -0.3
+ 48010p 0.9
+ 50000p 0.9
+ 50010p -0.3
+ 52000p -0.3
+ 52010p 0.9
+ 54000p 0.9
+ 54010p -0.3
+ 56000p -0.3
+ 56010p 0.9
+ 58000p 0.9
+ 58010p -0.3
+ 60000p -0.3
+ 60010p 0.9
+ 62000p 0.9
+ 62010p -0.3
+ 64000p -0.3
+ 64010p 0.9
+ 66000p 0.9
+ 66010p -0.3
+ 68000p -0.3
+ 68010p 0.9
+ 70000p 0.9
+ 70010p -0.3
+ 72000p -0.3
+ 72010p 0.9
+ 74000p 0.9
+ 74010p -0.3
+ 76000p -0.3
+ 76010p 0.9
+ 78000p 0.9
+ 78010p -0.3
+ 80000p -0.3
+ 80010p 0.9
+ 82000p 0.9
+ 82010p -0.3
+ 84000p -0.3
+ 84010p 0.9
+ 86000p 0.9
+ 86010p -0.3
+ 88000p -0.3
+ 88010p 0.9
+ 90000p 0.9
+ 90010p -0.3
+ 92000p -0.3
+ 92010p 0.9
+ 94000p 0.9
+ 94010p -0.3
+ 96000p -0.3
+ 96010p 0.9
+ 98000p 0.9
+ 98010p -0.3
+ 100000p -0.3
+ 100010p 0.9
+ 102000p 0.9
+ 102010p -0.3
+ 104000p -0.3
+ 104010p 0.9
+ 106000p 0.9
+ 106010p -0.3
+ 108000p -0.3
+ 108010p 0.9
+ 110000p 0.9
+ 110010p -0.3
+ 112000p -0.3
+ 112010p 0.9
+ 114000p 0.9
+ 114010p -0.3
+ 116000p -0.3
+ 116010p 0.9
+ 118000p 0.9
+ 118010p -0.3
+ 120000p -0.3
+ 120010p 0.9
+ 122000p 0.9
+ 122010p -0.3
+ 124000p -0.3
+ 124010p 0.9
+ 126000p 0.9
+ 126010p -0.3
+ 128000p -0.3
+ 128010p 0.9
+ 130000p 0.9
+ 130010p -0.3
+ 132000p -0.3
+ 132010p 0.9
+ 134000p 0.9
+ 134010p -0.3
+ 136000p -0.3
+ 136010p 0.9
+ 138000p 0.9
+ 138010p -0.3
+ 140000p -0.3
+ 140010p 0.9
+ 142000p 0.9
+ 142010p -0.3
+ 144000p -0.3
+ 144010p 0.9
+ 146000p 0.9
+ 146010p -0.3
+ 148000p -0.3
+ 148010p 0.9
+ 150000p 0.9
+ 150010p -0.3
+ 152000p -0.3
+ 152010p 0.9
+ 154000p 0.9
+ 154010p -0.3
+ 156000p -0.3
+ 156010p 0.9
+ 158000p 0.9
+ 158010p -0.3
+ 160000p -0.3
+ 160010p 0.9
+ 162000p 0.9
+ 162010p -0.3
+ 164000p -0.3
+ 164010p 0.9
+ 166000p 0.9
+ 166010p -0.3
+ 168000p -0.3
+ 168010p 0.9
+ 170000p 0.9
+ 170010p -0.3
+ 172000p -0.3
+ 172010p 0.9
+ 174000p 0.9
+ 174010p -0.3
+ 176000p -0.3
+ 176010p 0.9
+ 178000p 0.9
+ 178010p -0.3
+ 180000p -0.3
+ 180010p 0.9
+ 182000p 0.9
+ 182010p -0.3
+ 184000p -0.3
+ 184010p 0.9
+ 186000p 0.9
+ 186010p -0.3
+ 188000p -0.3
+ 188010p 0.9
+ 190000p 0.9
+ 190010p -0.3
+ 192000p -0.3
+ 192010p 0.9
+ 194000p 0.9
+ 194010p -0.3
+ 196000p -0.3
+ 196010p 0.9
+ 198000p 0.9
+ 198010p -0.3
+ 200000p -0.3
+ 200010p 0.9
+ 202000p 0.9
+ 202010p -0.3
+ 204000p -0.3
+ 204010p 0.9
+ 206000p 0.9
+ 206010p -0.3
+ 208000p -0.3
+ 208010p 0.9
+ 210000p 0.9
+ 210010p -0.3
+ 212000p -0.3
+ 212010p 0.9
+ 214000p 0.9
+ 214010p -0.3
+ 216000p -0.3
+ 216010p 0.9
+ 218000p 0.9
+ 218010p -0.3
+ 220000p -0.3
+ 220010p 0.9
+ 222000p 0.9
+ 222010p -0.3
+ 224000p -0.3
+ 224010p 0.9
+ 226000p 0.9
+ 226010p -0.3
+ 228000p -0.3
+ 228010p 0.9
+ 230000p 0.9
+ 230010p -0.3
+ 232000p -0.3
+ 232010p 0.9
+ 234000p 0.9
+ 234010p -0.3
+ 236000p -0.3
+ 236010p 0.9
+ 238000p 0.9
+ 238010p -0.3
+ 240000p -0.3
+ 240010p 0.9
+ 242000p 0.9
+ 242010p -0.3
+ 244000p -0.3
+ 244010p 0.9
+ 246000p 0.9
+ 246010p -0.3
+ 248000p -0.3
+ 248010p 0.9
+ 250000p 0.9
+ 250010p -0.3
+ 252000p -0.3
+ 252010p 0.9
+ 254000p 0.9
+ 254010p -0.3
+ 256000p -0.3
+ 256010p 0.9
+ 258000p 0.9
+ 258010p -0.3
+ 260000p -0.3
+ 260010p 0.9
+ 262000p 0.9
+ 262010p -0.3
+ 264000p -0.3
+ 264010p 0.9
+ 266000p 0.9
+ 266010p -0.3
+ 268000p -0.3
+ 268010p 0.9
+ 270000p 0.9
+ 270010p -0.3
+ 272000p -0.3
+ 272010p 0.9
+ 274000p 0.9
+ 274010p -0.3
+ 276000p -0.3
+ 276010p 0.9
+ 278000p 0.9
+ 278010p -0.3
+ 280000p -0.3
+ 280010p 0.9
+ 282000p 0.9
+ 282010p -0.3
+ 284000p -0.3
+ 284010p 0.9
+ 286000p 0.9
+ 286010p -0.3
+ 288000p -0.3
+ 288010p 0.9
+ 290000p 0.9
+ 290010p -0.3
+ 292000p -0.3
+ 292010p 0.9
+ 294000p 0.9
+ 294010p -0.3
+ 296000p -0.3
+ 296010p 0.9
+ 298000p 0.9
+ 298010p -0.3
+ 300000p -0.3
+ 300010p 0.9
+ 302000p 0.9
+ 302010p -0.3
+ 304000p -0.3
+ 304010p 0.9
+ 306000p 0.9
+ 306010p -0.3
+ 308000p -0.3
+ 308010p 0.9
+ 310000p 0.9
+ 310010p -0.3
+ 312000p -0.3
+ 312010p 0.9
+ 314000p 0.9
+ 314010p -0.3
+ 316000p -0.3
+ 316010p 0.9
+ 318000p 0.9
+ 318010p -0.3
+ 320000p -0.3
+ 320010p 0.9
+ 322000p 0.9
+ 322010p -0.3
+ 324000p -0.3
+ 324010p 0.9
+ 326000p 0.9
+ 326010p -0.3
+ 328000p -0.3
+ 328010p 0.9
+ 330000p 0.9
+ 330010p -0.3
+ 332000p -0.3
+ 332010p 0.9
+ 334000p 0.9
+ 334010p -0.3
+ 336000p -0.3
+ 336010p 0.9
+ 338000p 0.9
+ 338010p -0.3
+ 340000p -0.3
+ 340010p 0.9
+ 342000p 0.9
+ 342010p -0.3
+ 344000p -0.3
+ 344010p 0.9
+ 346000p 0.9
+ 346010p -0.3
+ 348000p -0.3
+ 348010p 0.9
+ 350000p 0.9
+ 350010p -0.3
+ 352000p -0.3
+ 352010p 0.9
+ 354000p 0.9
+ 354010p -0.3
+ 356000p -0.3
+ 356010p 0.9
+ 358000p 0.9
+ 358010p -0.3
+ 360000p -0.3
+ 360010p 0.9
+ 362000p 0.9
+ 362010p -0.3
+ 364000p -0.3
+ 364010p 0.9
+ 366000p 0.9
+ 366010p -0.3
+ 368000p -0.3
+ 368010p 0.9
+ 370000p 0.9
+ 370010p -0.3
+ 372000p -0.3
+ 372010p 0.9
+ 374000p 0.9
+ 374010p -0.3
+ 376000p -0.3
+ 376010p 0.9
+ 378000p 0.9
+ 378010p -0.3
+ 380000p -0.3
+ 380010p 0.9
+ 382000p 0.9
+ 382010p -0.3
+ 384000p -0.3
+ 384010p 0.9
+ 386000p 0.9
+ 386010p -0.3
+ 388000p -0.3
+ 388010p 0.9
+ 390000p 0.9
+ 390010p -0.3
+ 392000p -0.3
+ 392010p 0.9
+ 394000p 0.9
+ 394010p -0.3
+ 396000p -0.3
+ 396010p 0.9
+ 398000p 0.9
+ 398010p -0.3
+ 400000p -0.3
+ 400010p 0.9
+ 402000p 0.9
+ 402010p -0.3
+ 404000p -0.3
+ 404010p 0.9
+ 406000p 0.9
+ 406010p -0.3
+ 408000p -0.3
+ 408010p 0.9
+ 410000p 0.9
+ 410010p -0.3
+ 412000p -0.3
+ 412010p 0.9
+ 414000p 0.9
+ 414010p -0.3
+ 416000p -0.3
+ 416010p 0.9
+ 418000p 0.9
+ 418010p -0.3
+ 420000p -0.3
+ 420010p 0.9
+ 422000p 0.9
+ 422010p -0.3
+ 424000p -0.3
+ 424010p 0.9
+ 426000p 0.9
+ 426010p -0.3
+ 428000p -0.3
+ 428010p 0.9
+ 430000p 0.9
+ 430010p -0.3
+ 432000p -0.3
+ 432010p 0.9
+ 434000p 0.9
+ 434010p -0.3
+ 436000p -0.3
+ 436010p 0.9
+ 438000p 0.9
+ 438010p -0.3
+ 440000p -0.3
+ 440010p 0.9
+ 442000p 0.9
+ 442010p -0.3
+ 444000p -0.3
+ 444010p 0.9
+ 446000p 0.9
+ 446010p -0.3
+ 448000p -0.3
+ 448010p 0.9
+ 450000p 0.9
+ 450010p -0.3
+ 452000p -0.3
+ 452010p 0.9
+ 454000p 0.9
+ 454010p -0.3
+ 456000p -0.3
+ 456010p 0.9
+ 458000p 0.9
+ 458010p -0.3
+ 460000p -0.3
+ 460010p 0.9
+ 462000p 0.9
+ 462010p -0.3
+ 464000p -0.3
+ 464010p 0.9
+ 466000p 0.9
+ 466010p -0.3
+ 468000p -0.3
+ 468010p 0.9
+ 470000p 0.9
+ 470010p -0.3
+ 472000p -0.3
+ 472010p 0.9
+ 474000p 0.9
+ 474010p -0.3
+ 476000p -0.3
+ 476010p 0.9
+ 478000p 0.9
+ 478010p -0.3
+ 480000p -0.3
+ 480010p 0.9
+ 482000p 0.9
+ 482010p -0.3
+ 484000p -0.3
+ 484010p 0.9
+ 486000p 0.9
+ 486010p -0.3
+ 488000p -0.3
+ 488010p 0.9
+ 490000p 0.9
+ 490010p -0.3
+ 492000p -0.3
+ 492010p 0.9
+ 494000p 0.9
+ 494010p -0.3
+ 496000p -0.3
+ 496010p 0.9
+ 498000p 0.9
+ 498010p -0.3
+ 500000p -0.3
+ 500010p 0.9
+ 502000p 0.9
+ 502010p -0.3
+ 504000p -0.3
+ 504010p 0.9
+ 506000p 0.9
+ 506010p -0.3
+ 508000p -0.3
+ 508010p 0.9
+ 510000p 0.9
+ 510010p -0.3
+ 512000p -0.3
+ 512010p 0.9
+ 514000p 0.9
+ 514010p -0.3
+ 516000p -0.3
+ 516010p 0.9
+ 518000p 0.9
+ 518010p -0.3
+ 520000p -0.3
+ 520010p 0.9
+ 522000p 0.9
+ 522010p -0.3
+ 524000p -0.3
+ 524010p 0.9
+ 526000p 0.9
+ 526010p -0.3
+ 528000p -0.3
+ 528010p 0.9
+ 530000p 0.9
+ 530010p -0.3
+ 532000p -0.3
+ 532010p 0.9
+ 534000p 0.9
+ 534010p -0.3
+ 536000p -0.3
+ 536010p 0.9
+ 538000p 0.9
+ 538010p -0.3
+ 540000p -0.3
+ 540010p 0.9
+ 542000p 0.9
+ 542010p -0.3
+ 544000p -0.3
+ 544010p 0.9
+ 546000p 0.9
+ 546010p -0.3
+ 548000p -0.3
+ 548010p 0.9
+ 550000p 0.9
+ 550010p -0.3
+ 552000p -0.3
+ 552010p 0.9
+ 554000p 0.9
+ 554010p -0.3
+ 556000p -0.3
+ 556010p 0.9
+ 558000p 0.9
+ 558010p -0.3
+ 560000p -0.3
+ 560010p 0.9
+ 562000p 0.9
+ 562010p -0.3
+ 564000p -0.3
+ 564010p 0.9
+ 566000p 0.9
+ 566010p -0.3
+ 568000p -0.3
+ 568010p 0.9
+ 570000p 0.9
+ 570010p -0.3
+ 572000p -0.3
+ 572010p 0.9
+ 574000p 0.9
+ 574010p -0.3
+ 576000p -0.3
+ 576010p 0.9
+ 578000p 0.9
+ 578010p -0.3
+ 580000p -0.3
+ 580010p 0.9
+ 582000p 0.9
+ 582010p -0.3
+ 584000p -0.3
+ 584010p 0.9
+ 586000p 0.9
+ 586010p -0.3
+ 588000p -0.3
+ 588010p 0.9
+ 590000p 0.9
+ 590010p -0.3
+ 592000p -0.3
+ 592010p 0.9
+ 594000p 0.9
+ 594010p -0.3
+ 596000p -0.3
+ 596010p 0.9
+ 598000p 0.9
+ 598010p -0.3
+ 600000p -0.3
+ 600010p 0.9
+ 602000p 0.9
+ 602010p -0.3
+ 604000p -0.3
+ 604010p 0.9
+ 606000p 0.9
+ 606010p -0.3
+ 608000p -0.3
+ 608010p 0.9
+ 610000p 0.9
+ 610010p -0.3
+ 612000p -0.3
+ 612010p 0.9
+ 614000p 0.9
+ 614010p -0.3
+ 616000p -0.3
+ 616010p 0.9
+ 618000p 0.9
+ 618010p -0.3
+ 620000p -0.3
+ 620010p 0.9
+ 622000p 0.9
+ 622010p -0.3
+ 624000p -0.3
+ 624010p 0.9
+ 626000p 0.9
+ 626010p -0.3
+ 628000p -0.3
+ 628010p 0.9
+ 630000p 0.9
+ 630010p -0.3
+ 632000p -0.3
+ 632010p 0.9
+ 634000p 0.9
+ 634010p -0.3
+ 636000p -0.3
+ 636010p 0.9
+ 638000p 0.9
+ 638010p -0.3
+ 640000p -0.3
+ 640010p 0.9
+ 642000p 0.9
+ 642010p -0.3
+ 644000p -0.3
+ 644010p 0.9
+ 646000p 0.9
+ 646010p -0.3
+ 648000p -0.3
+ 648010p 0.9
+ 650000p 0.9
+ 650010p -0.3
+ 652000p -0.3
+ 652010p 0.9
+ 654000p 0.9
+ 654010p -0.3
+ 656000p -0.3
+ 656010p 0.9
+ 658000p 0.9
+ 658010p -0.3
+ 660000p -0.3
+ 660010p 0.9
+ 662000p 0.9
+ 662010p -0.3
+ 664000p -0.3
+ 664010p 0.9
+ 666000p 0.9
+ 666010p -0.3
+ 668000p -0.3
+ 668010p 0.9
+ 670000p 0.9
+ 670010p -0.3
+ 672000p -0.3
+ 672010p 0.9
+ 674000p 0.9
+ 674010p -0.3
+ 676000p -0.3
+ 676010p 0.9
+ 678000p 0.9
+ 678010p -0.3
+ 680000p -0.3
+ 680010p 0.9
+ 682000p 0.9
+ 682010p -0.3
+ 684000p -0.3
+ 684010p 0.9
+ 686000p 0.9
+ 686010p -0.3
+ 688000p -0.3
+ 688010p 0.9
+ 690000p 0.9
+ 690010p -0.3
+ 692000p -0.3
+ 692010p 0.9
+ 694000p 0.9
+ 694010p -0.3
+ 696000p -0.3
+ 696010p 0.9
+ 698000p 0.9
+ 698010p -0.3
+ 700000p -0.3
+ 700010p 0.9
+ 702000p 0.9
+ 702010p -0.3
+ 704000p -0.3
+ 704010p 0.9
+ 706000p 0.9
+ 706010p -0.3
+ 708000p -0.3
+ 708010p 0.9
+ 710000p 0.9
+ 710010p -0.3
+ 712000p -0.3
+ 712010p 0.9
+ 714000p 0.9
+ 714010p -0.3
+ 716000p -0.3
+ 716010p 0.9
+ 718000p 0.9
+ 718010p -0.3
+ 720000p -0.3
+ 720010p 0.9
+ 722000p 0.9
+ 722010p -0.3
+ 724000p -0.3
+ 724010p 0.9
+ 726000p 0.9
+ 726010p -0.3
+ 728000p -0.3
+ 728010p 0.9
+ 730000p 0.9
+ 730010p -0.3
+ 732000p -0.3
+ 732010p 0.9
+ 734000p 0.9
+ 734010p -0.3
+ 736000p -0.3
+ 736010p 0.9
+ 738000p 0.9
+ 738010p -0.3
+ 740000p -0.3
+ 740010p 0.9
+ 742000p 0.9
+ 742010p -0.3
+ 744000p -0.3
+ 744010p 0.9
+ 746000p 0.9
+ 746010p -0.3
+ 748000p -0.3
+ 748010p 0.9
+ 750000p 0.9
+ 750010p -0.3
+ 752000p -0.3
+ 752010p 0.9
+ 754000p 0.9
+ 754010p -0.3
+ 756000p -0.3
+ 756010p 0.9
+ 758000p 0.9
+ 758010p -0.3
+ 760000p -0.3
+ 760010p 0.9
+ 762000p 0.9
+ 762010p -0.3
+ 764000p -0.3
+ 764010p 0.9
+ 766000p 0.9
+ 766010p -0.3
+ 768000p -0.3
+ 768010p 0.9
+ 770000p 0.9
+ 770010p -0.3
+ 772000p -0.3
+ 772010p 0.9
+ 774000p 0.9
+ 774010p -0.3
+ 776000p -0.3
+ 776010p 0.9
+ 778000p 0.9
+ 778010p -0.3
+ 780000p -0.3
+ 780010p 0.9
+ 782000p 0.9
+ 782010p -0.3
+ 784000p -0.3
+ 784010p 0.9
+ 786000p 0.9
+ 786010p -0.3
+ 788000p -0.3
+ 788010p 0.9
+ 790000p 0.9
+ 790010p -0.3
+ 792000p -0.3
+ 792010p 0.9
+ 794000p 0.9
+ 794010p -0.3
+ 796000p -0.3
+ 796010p 0.9
+ 798000p 0.9
+ 798010p -0.3
+ 800000p -0.3
+ 800010p 0.9
+ 802000p 0.9
+ 802010p -0.3
+ 804000p -0.3
+ 804010p 0.9
+ 806000p 0.9
+ 806010p -0.3
+ 808000p -0.3
+ 808010p 0.9
+ 810000p 0.9
+ 810010p -0.3
+ 812000p -0.3
+ 812010p 0.9
+ 814000p 0.9
+ 814010p -0.3
+ 816000p -0.3
+ 816010p 0.9
+ 818000p 0.9
+ 818010p -0.3
+ 820000p -0.3
+ 820010p 0.9
+ 822000p 0.9
+ 822010p -0.3
+ 824000p -0.3
+ 824010p 0.9
+ 826000p 0.9
+ 826010p -0.3
+ 828000p -0.3
+ 828010p 0.9
+ 830000p 0.9
+ 830010p -0.3
+ 832000p -0.3
+ 832010p 0.9
+ 834000p 0.9
+ 834010p -0.3
+ 836000p -0.3
+ 836010p 0.9
+ 838000p 0.9
+ 838010p -0.3
+ 840000p -0.3
+ 840010p 0.9
+ 842000p 0.9
+ 842010p -0.3
+ 844000p -0.3
+ 844010p 0.9
+ 846000p 0.9
+ 846010p -0.3
+ 848000p -0.3
+ 848010p 0.9
+ 850000p 0.9
+ 850010p -0.3
+ 852000p -0.3
+ 852010p 0.9
+ 854000p 0.9
+ 854010p -0.3
+ 856000p -0.3
+ 856010p 0.9
+ 858000p 0.9
+ 858010p -0.3
+ 860000p -0.3
+ 860010p 0.9
+ 862000p 0.9
+ 862010p -0.3
+ 864000p -0.3
+ 864010p 0.9
+ 866000p 0.9
+ 866010p -0.3
+ 868000p -0.3
+ 868010p 0.9
+ 870000p 0.9
+ 870010p -0.3
+ 872000p -0.3
+ 872010p 0.9
+ 874000p 0.9
+ 874010p -0.3
+ 876000p -0.3
+ 876010p 0.9
+ 878000p 0.9
+ 878010p -0.3
+ 880000p -0.3
+ 880010p 0.9
+ 882000p 0.9
+ 882010p -0.3
+ 884000p -0.3
+ 884010p 0.9
+ 886000p 0.9
+ 886010p -0.3
+ 888000p -0.3
+ 888010p 0.9
+ 890000p 0.9
+ 890010p -0.3
+ 892000p -0.3
+ 892010p 0.9
+ 894000p 0.9
+ 894010p -0.3
+ 896000p -0.3
+ 896010p 0.9
+ 898000p 0.9
+ 898010p -0.3
+ 900000p -0.3
+ 900010p 0.9
+ 902000p 0.9
+ 902010p -0.3
+ 904000p -0.3
+ 904010p 0.9
+ 906000p 0.9
+ 906010p -0.3
+ 908000p -0.3
+ 908010p 0.9
+ 910000p 0.9
+ 910010p -0.3
+ 912000p -0.3
+ 912010p 0.9
+ 914000p 0.9
+ 914010p -0.3
+ 916000p -0.3
+ 916010p 0.9
+ 918000p 0.9
+ 918010p -0.3
+ 920000p -0.3
+ 920010p 0.9
+ 922000p 0.9
+ 922010p -0.3
+ 924000p -0.3
+ 924010p 0.9
+ 926000p 0.9
+ 926010p -0.3
+ 928000p -0.3
+ 928010p 0.9
+ 930000p 0.9
+ 930010p -0.3
+ 932000p -0.3
+ 932010p 0.9
+ 934000p 0.9
+ 934010p -0.3
+ 936000p -0.3
+ 936010p 0.9
+ 938000p 0.9
+ 938010p -0.3
+ 940000p -0.3
+ 940010p 0.9
+ 942000p 0.9
+ 942010p -0.3
+ 944000p -0.3
+ 944010p 0.9
+ 946000p 0.9
+ 946010p -0.3
+ 948000p -0.3
+ 948010p 0.9
+ 950000p 0.9
+ 950010p -0.3
+ 952000p -0.3
+ 952010p 0.9
+ 954000p 0.9
+ 954010p -0.3
+ 956000p -0.3
+ 956010p 0.9
+ 958000p 0.9
+ 958010p -0.3
+ 960000p -0.3
+ 960010p 0.9
+ 962000p 0.9
+ 962010p -0.3
+ 964000p -0.3
+ 964010p 0.9
+ 966000p 0.9
+ 966010p -0.3
+ 968000p -0.3
+ 968010p 0.9
+ 970000p 0.9
+ 970010p -0.3
+ 972000p -0.3
+ 972010p 0.9
+ 974000p 0.9
+ 974010p -0.3
+ 976000p -0.3
+ 976010p 0.9
+ 978000p 0.9
+ 978010p -0.3
+ 980000p -0.3
+ 980010p 0.9
+ 982000p 0.9
+ 982010p -0.3
+ 984000p -0.3
+ 984010p 0.9
+ 986000p 0.9
+ 986010p -0.3
+ 988000p -0.3
+ 988010p 0.9
+ 990000p 0.9
+ 990010p -0.3
+ 992000p -0.3
+ 992010p 0.9
+ 994000p 0.9
+ 994010p -0.3
+ 996000p -0.3
+ 996010p 0.9
+ 998000p 0.9
+ 998010p -0.3
+ 1000000p -0.3
+ 1000010p 0.9
+ 1002000p 0.9
+ 1002010p -0.3
+ 1004000p -0.3
+ 1004010p 0.9
+ 1006000p 0.9
+ 1006010p -0.3
+ 1008000p -0.3
+ 1008010p 0.9
+ 1010000p 0.9
+ 1010010p -0.3
+ 1012000p -0.3
+ 1012010p 0.9
+ 1014000p 0.9
+ 1014010p -0.3
+ 1016000p -0.3
+ 1016010p 0.9
+ 1018000p 0.9
+ 1018010p -0.3
+ 1020000p -0.3
+ 1020010p 0.9
+ 1022000p 0.9
+ 1022010p -0.3
+ 1024000p -0.3
+ 1024010p 0.9
+ 1026000p 0.9
+ 1026010p -0.3
+ 1028000p -0.3
+ 1028010p 0.9
+ 1030000p 0.9
+ 1030010p -0.3
+ 1032000p -0.3
+ 1032010p 0.9
+ 1034000p 0.9
+ 1034010p -0.3
+ 1036000p -0.3
+ 1036010p 0.9
+ 1038000p 0.9
+ 1038010p -0.3
+ 1040000p -0.3
+ 1040010p 0.9
+ 1042000p 0.9
+ 1042010p -0.3
+ 1044000p -0.3
+ 1044010p 0.9
+ 1046000p 0.9
+ 1046010p -0.3
+ 1048000p -0.3
+ 1048010p 0.9
+ 1050000p 0.9
+ 1050010p -0.3
+ 1052000p -0.3
+ 1052010p 0.9
+ 1054000p 0.9
+ 1054010p -0.3
+ 1056000p -0.3
+ 1056010p 0.9
+ 1058000p 0.9
+ 1058010p -0.3
+ 1060000p -0.3
+ 1060010p 0.9
+ 1062000p 0.9
+ 1062010p -0.3
+ 1064000p -0.3
+ 1064010p 0.9
+ 1066000p 0.9
+ 1066010p -0.3
+ 1068000p -0.3
+ 1068010p 0.9
+ 1070000p 0.9
+ 1070010p -0.3
+ 1072000p -0.3
+ 1072010p 0.9
+ 1074000p 0.9
+ 1074010p -0.3
+ 1076000p -0.3
+ 1076010p 0.9
+ 1078000p 0.9
+ 1078010p -0.3
+ 1080000p -0.3
+ 1080010p 0.9
+ 1082000p 0.9
+ 1082010p -0.3
+ 1084000p -0.3
+ 1084010p 0.9
+ 1086000p 0.9
+ 1086010p -0.3
+ 1088000p -0.3
+ 1088010p 0.9
+ 1090000p 0.9
+ 1090010p -0.3
+ 1092000p -0.3
+ 1092010p 0.9
+ 1094000p 0.9
+ 1094010p -0.3
+ 1096000p -0.3
+ 1096010p 0.9
+ 1098000p 0.9
+ 1098010p -0.3
+ 1100000p -0.3
+ 1100010p 0.9
+ 1102000p 0.9
+ 1102010p -0.3
+ 1104000p -0.3
+ 1104010p 0.9
+ 1106000p 0.9
+ 1106010p -0.3
+ 1108000p -0.3
+ 1108010p 0.9
+ 1110000p 0.9
+ 1110010p -0.3
+ 1112000p -0.3
+ 1112010p 0.9
+ 1114000p 0.9
+ 1114010p -0.3
+ 1116000p -0.3
+ 1116010p 0.9
+ 1118000p 0.9
+ 1118010p -0.3
+ 1120000p -0.3
+ 1120010p 0.9
+ 1122000p 0.9
+ 1122010p -0.3
+ 1124000p -0.3
+ 1124010p 0.9
+ 1126000p 0.9
+ 1126010p -0.3
+ 1128000p -0.3
+ 1128010p 0.9
+ 1130000p 0.9
+ 1130010p -0.3
+ 1132000p -0.3
+ 1132010p 0.9
+ 1134000p 0.9
+ 1134010p -0.3
+ 1136000p -0.3
+ 1136010p 0.9
+ 1138000p 0.9
+ 1138010p -0.3
+ 1140000p -0.3
+ 1140010p 0.9
+ 1142000p 0.9
+ 1142010p -0.3
+ 1144000p -0.3
+ 1144010p 0.9
+ 1146000p 0.9
+ 1146010p -0.3
+ 1148000p -0.3
+ 1148010p 0.9
+ 1150000p 0.9
+ 1150010p -0.3
+ 1152000p -0.3
+ 1152010p 0.9
+ 1154000p 0.9
+ 1154010p -0.3
+ 1156000p -0.3
+ 1156010p 0.9
+ 1158000p 0.9
+ 1158010p -0.3
+ 1160000p -0.3
+ 1160010p 0.9
+ 1162000p 0.9
+ 1162010p -0.3
+ 1164000p -0.3
+ 1164010p 0.9
+ 1166000p 0.9
+ 1166010p -0.3
+ 1168000p -0.3
+ 1168010p 0.9
+ 1170000p 0.9
+ 1170010p -0.3
+ 1172000p -0.3
+ 1172010p 0.9
+ 1174000p 0.9
+ 1174010p -0.3
+ 1176000p -0.3
+ 1176010p 0.9
+ 1178000p 0.9
+ 1178010p -0.3
+ 1180000p -0.3
+ 1180010p 0.9
+ 1182000p 0.9
+ 1182010p -0.3
+ 1184000p -0.3
+ 1184010p 0.9
+ 1186000p 0.9
+ 1186010p -0.3
+ 1188000p -0.3
+ 1188010p 0.9
+ 1190000p 0.9
+ 1190010p -0.3
+ 1192000p -0.3
+ 1192010p 0.9
+ 1194000p 0.9
+ 1194010p -0.3
+ 1196000p -0.3
+ 1196010p 0.9
+ 1198000p 0.9
+ 1198010p -0.3
+ 1200000p -0.3
+ 1200010p 0.9
+ 1202000p 0.9
+ 1202010p -0.3
+ 1204000p -0.3
+ 1204010p 0.9
+ 1206000p 0.9
+ 1206010p -0.3
+ 1208000p -0.3
+ 1208010p 0.9
+ 1210000p 0.9
+ 1210010p -0.3
+ 1212000p -0.3
+ 1212010p 0.9
+ 1214000p 0.9
+ 1214010p -0.3
+ 1216000p -0.3
+ 1216010p 0.9
+ 1218000p 0.9
+ 1218010p -0.3
+ 1220000p -0.3
+ 1220010p 0.9
+ 1222000p 0.9
+ 1222010p -0.3
+ 1224000p -0.3
+ 1224010p 0.9
+ 1226000p 0.9
+ 1226010p -0.3
+ 1228000p -0.3
+ 1228010p 0.9
+ 1230000p 0.9
+ 1230010p -0.3
+ 1232000p -0.3
+ 1232010p 0.9
+ 1234000p 0.9
+ 1234010p -0.3
+ 1236000p -0.3
+ 1236010p 0.9
+ 1238000p 0.9
+ 1238010p -0.3
+ 1240000p -0.3
+ 1240010p 0.9
+ 1242000p 0.9
+ 1242010p -0.3
+ 1244000p -0.3
+ 1244010p 0.9
+ 1246000p 0.9
+ 1246010p -0.3
+ 1248000p -0.3
+ 1248010p 0.9
+ 1250000p 0.9
+ 1250010p -0.3
+ 1252000p -0.3
+ 1252010p 0.9
+ 1254000p 0.9
+ 1254010p -0.3
+ 1256000p -0.3
+ 1256010p 0.9
+ 1258000p 0.9
+ 1258010p -0.3
+ 1260000p -0.3
+ 1260010p 0.9
+ 1262000p 0.9
+ 1262010p -0.3
+ 1264000p -0.3
+ 1264010p 0.9
+ 1266000p 0.9
+ 1266010p -0.3
+ 1268000p -0.3
+ 1268010p 0.9
+ 1270000p 0.9
+ 1270010p -0.3
+ 1272000p -0.3
+ 1272010p 0.9
+ 1274000p 0.9
+ 1274010p -0.3
+ 1276000p -0.3
+ 1276010p 0.9
+ 1278000p 0.9
+ 1278010p -0.3
+ 1280000p -0.3
+ 1280010p 0.9
+ 1282000p 0.9
+ 1282010p -0.3
+ 1284000p -0.3
+ 1284010p 0.9
+ 1286000p 0.9
+ 1286010p -0.3
+ 1288000p -0.3
+ 1288010p 0.9
+ 1290000p 0.9
+ 1290010p -0.3
+ 1292000p -0.3
+ 1292010p 0.9
+ 1294000p 0.9
+ 1294010p -0.3
+ 1296000p -0.3
+ 1296010p 0.9
+ 1298000p 0.9
+ 1298010p -0.3
+ 1300000p -0.3
+ 1300010p 0.9
+ 1302000p 0.9
+ 1302010p -0.3
+ 1304000p -0.3
+ 1304010p 0.9
+ 1306000p 0.9
+ 1306010p -0.3
+ 1308000p -0.3
+ 1308010p 0.9
+ 1310000p 0.9
+ 1310010p -0.3
+ 1312000p -0.3
+ 1312010p 0.9
+ 1314000p 0.9
+ 1314010p -0.3
+ 1316000p -0.3
+ 1316010p 0.9
+ 1318000p 0.9
+ 1318010p -0.3
+ 1320000p -0.3
+ 1320010p 0.9
+ 1322000p 0.9
+ 1322010p -0.3
+ 1324000p -0.3
+ 1324010p 0.9
+ 1326000p 0.9
+ 1326010p -0.3
+ 1328000p -0.3
+ 1328010p 0.9
+ 1330000p 0.9
+ 1330010p -0.3
+ 1332000p -0.3
+ 1332010p 0.9
+ 1334000p 0.9
+ 1334010p -0.3
+ 1336000p -0.3
+ 1336010p 0.9
+ 1338000p 0.9
+ 1338010p -0.3
+ 1340000p -0.3
+ 1340010p 0.9
+ 1342000p 0.9
+ 1342010p -0.3
+ 1344000p -0.3
+ 1344010p 0.9
+ 1346000p 0.9
+ 1346010p -0.3
+ 1348000p -0.3
+ 1348010p 0.9
+ 1350000p 0.9
+ 1350010p -0.3
+ 1352000p -0.3
+ 1352010p 0.9
+ 1354000p 0.9
+ 1354010p -0.3
+ 1356000p -0.3
+ 1356010p 0.9
+ 1358000p 0.9
+ 1358010p -0.3
+ 1360000p -0.3
+ 1360010p 0.9
+ 1362000p 0.9
+ 1362010p -0.3
+ 1364000p -0.3
+ 1364010p 0.9
+ 1366000p 0.9
+ 1366010p -0.3
+ 1368000p -0.3
+ 1368010p 0.9
+ 1370000p 0.9
+ 1370010p -0.3
+ 1372000p -0.3
+ 1372010p 0.9
+ 1374000p 0.9
+ 1374010p -0.3
+ 1376000p -0.3
+ 1376010p 0.9
+ 1378000p 0.9
+ 1378010p -0.3
+ 1380000p -0.3
+ 1380010p 0.9
+ 1382000p 0.9
+ 1382010p -0.3
+ 1384000p -0.3
+ 1384010p 0.9
+ 1386000p 0.9
+ 1386010p -0.3
+ 1388000p -0.3
+ 1388010p 0.9
+ 1390000p 0.9
+ 1390010p -0.3
+ 1392000p -0.3
+ 1392010p 0.9
+ 1394000p 0.9
+ 1394010p -0.3
+ 1396000p -0.3
+ 1396010p 0.9
+ 1398000p 0.9
+ 1398010p -0.3
+ 1400000p -0.3
+ 1400010p 0.9
+ 1402000p 0.9
+ 1402010p -0.3
+ 1404000p -0.3
+ 1404010p 0.9
+ 1406000p 0.9
+ 1406010p -0.3
+ 1408000p -0.3
+ 1408010p 0.9
+ 1410000p 0.9
+ 1410010p -0.3
+ 1412000p -0.3
+ 1412010p 0.9
+ 1414000p 0.9
+ 1414010p -0.3
+ 1416000p -0.3
+ 1416010p 0.9
+ 1418000p 0.9
+ 1418010p -0.3
+ 1420000p -0.3
+ 1420010p 0.9
+ 1422000p 0.9
+ 1422010p -0.3
+ 1424000p -0.3
+ 1424010p 0.9
+ 1426000p 0.9
+ 1426010p -0.3
+ 1428000p -0.3
+ 1428010p 0.9
+ 1430000p 0.9
+ 1430010p -0.3
+ 1432000p -0.3
+ 1432010p 0.9
+ 1434000p 0.9
+ 1434010p -0.3
+ 1436000p -0.3
+ 1436010p 0.9
+ 1438000p 0.9
+ 1438010p -0.3
+ 1440000p -0.3
+ 1440010p 0.9
+ 1442000p 0.9
+ 1442010p -0.3
+ 1444000p -0.3
+ 1444010p 0.9
+ 1446000p 0.9
+ 1446010p -0.3
+ 1448000p -0.3
+ 1448010p 0.9
+ 1450000p 0.9
+ 1450010p -0.3
+ 1452000p -0.3
+ 1452010p 0.9
+ 1454000p 0.9
+ 1454010p -0.3
+ 1456000p -0.3
+ 1456010p 0.9
+ 1458000p 0.9
+ 1458010p -0.3
+ 1460000p -0.3
+ 1460010p 0.9
+ 1462000p 0.9
+ 1462010p -0.3
+ 1464000p -0.3
+ 1464010p 0.9
+ 1466000p 0.9
+ 1466010p -0.3
+ 1468000p -0.3
+ 1468010p 0.9
+ 1470000p 0.9
+ 1470010p -0.3
+ 1472000p -0.3
+ 1472010p 0.9
+ 1474000p 0.9
+ 1474010p -0.3
+ 1476000p -0.3
+ 1476010p 0.9
+ 1478000p 0.9
+ 1478010p -0.3
+ 1480000p -0.3
+ 1480010p 0.9
+ 1482000p 0.9
+ 1482010p -0.3
+ 1484000p -0.3
+ 1484010p 0.9
+ 1486000p 0.9
+ 1486010p -0.3
+ 1488000p -0.3
+ 1488010p 0.9
+ 1490000p 0.9
+ 1490010p -0.3
+ 1492000p -0.3
+ 1492010p 0.9
+ 1494000p 0.9
+ 1494010p -0.3
+ 1496000p -0.3
+ 1496010p 0.9
+ 1498000p 0.9
+ 1498010p -0.3
+ 1500000p -0.3
+ 1500010p 0.9
+ 1502000p 0.9
+ 1502010p -0.3
+ 1504000p -0.3
+ 1504010p 0.9
+ 1506000p 0.9
+ 1506010p -0.3
+ 1508000p -0.3
+ 1508010p 0.9
+ 1510000p 0.9
+ 1510010p -0.3
+ 1512000p -0.3
+ 1512010p 0.9
+ 1514000p 0.9
+ 1514010p -0.3
+ 1516000p -0.3
+ 1516010p 0.9
+ 1518000p 0.9
+ 1518010p -0.3
+ 1520000p -0.3
+ 1520010p 0.9
+ 1522000p 0.9
+ 1522010p -0.3
+ 1524000p -0.3
+ 1524010p 0.9
+ 1526000p 0.9
+ 1526010p -0.3
+ 1528000p -0.3
+ 1528010p 0.9
+ 1530000p 0.9
+ 1530010p -0.3
+ 1532000p -0.3
+ 1532010p 0.9
+ 1534000p 0.9
+ 1534010p -0.3
+ 1536000p -0.3
+ 1536010p 0.9
+ 1538000p 0.9
+ 1538010p -0.3
+ 1540000p -0.3
+ 1540010p 0.9
+ 1542000p 0.9
+ 1542010p -0.3
+ 1544000p -0.3
+ 1544010p 0.9
+ 1546000p 0.9
+ 1546010p -0.3
+ 1548000p -0.3
+ 1548010p 0.9
+ 1550000p 0.9
+ 1550010p -0.3
+ 1552000p -0.3
+ 1552010p 0.9
+ 1554000p 0.9
+ 1554010p -0.3
+ 1556000p -0.3
+ 1556010p 0.9
+ 1558000p 0.9
+ 1558010p -0.3
+ 1560000p -0.3
+ 1560010p 0.9
+ 1562000p 0.9
+ 1562010p -0.3
+ 1564000p -0.3
+ 1564010p 0.9
+ 1566000p 0.9
+ 1566010p -0.3
+ 1568000p -0.3
+ 1568010p 0.9
+ 1570000p 0.9
+ 1570010p -0.3
+ 1572000p -0.3
+ 1572010p 0.9
+ 1574000p 0.9
+ 1574010p -0.3
+ 1576000p -0.3
+ 1576010p 0.9
+ 1578000p 0.9
+ 1578010p -0.3
+ 1580000p -0.3
+ 1580010p 0.9
+ 1582000p 0.9
+ 1582010p -0.3
+ 1584000p -0.3
+ 1584010p 0.9
+ 1586000p 0.9
+ 1586010p -0.3
+ 1588000p -0.3
+ 1588010p 0.9
+ 1590000p 0.9
+ 1590010p -0.3
+ 1592000p -0.3
+ 1592010p 0.9
+ 1594000p 0.9
+ 1594010p -0.3
+ 1596000p -0.3
+ 1596010p 0.9
+ 1598000p 0.9
+ 1598010p -0.3
+ 1600000p -0.3
+ 1600010p 0.9
+ 1602000p 0.9
+ 1602010p -0.3
+ 1604000p -0.3
+ 1604010p 0.9
+ 1606000p 0.9
+ 1606010p -0.3
+ 1608000p -0.3
+ 1608010p 0.9
+ 1610000p 0.9
+ 1610010p -0.3
+ 1612000p -0.3
+ 1612010p 0.9
+ 1614000p 0.9
+ 1614010p -0.3
+ 1616000p -0.3
+ 1616010p 0.9
+ 1618000p 0.9
+ 1618010p -0.3
+ 1620000p -0.3
+ 1620010p 0.9
+ 1622000p 0.9
+ 1622010p -0.3
+ 1624000p -0.3
+ 1624010p 0.9
+ 1626000p 0.9
+ 1626010p -0.3
+ 1628000p -0.3
+ 1628010p 0.9
+ 1630000p 0.9
+ 1630010p -0.3
+ 1632000p -0.3
+ 1632010p 0.9
+ 1634000p 0.9
+ 1634010p -0.3
+ 1636000p -0.3
+ 1636010p 0.9
+ 1638000p 0.9
+ 1638010p -0.3
+ 1640000p -0.3
+ 1640010p 0.9
+ 1642000p 0.9
+ 1642010p -0.3
+ 1644000p -0.3
+ 1644010p 0.9
+ 1646000p 0.9
+ 1646010p -0.3
+ 1648000p -0.3
+ 1648010p 0.9
+ 1650000p 0.9
+ 1650010p -0.3
+ 1652000p -0.3
+ 1652010p 0.9
+ 1654000p 0.9
+ 1654010p -0.3
+ 1656000p -0.3
+ 1656010p 0.9
+ 1658000p 0.9
+ 1658010p -0.3
+ 1660000p -0.3
+ 1660010p 0.9
+ 1662000p 0.9
+ 1662010p -0.3
+ 1664000p -0.3
+ 1664010p 0.9
+ 1666000p 0.9
+ 1666010p -0.3
+ 1668000p -0.3
+ 1668010p 0.9
+ 1670000p 0.9
+ 1670010p -0.3
+ 1672000p -0.3
+ 1672010p 0.9
+ 1674000p 0.9
+ 1674010p -0.3
+ 1676000p -0.3
+ 1676010p 0.9
+ 1678000p 0.9
+ 1678010p -0.3
+ 1680000p -0.3
+ 1680010p 0.9
+ 1682000p 0.9
+ 1682010p -0.3
+ 1684000p -0.3
+ 1684010p 0.9
+ 1686000p 0.9
+ 1686010p -0.3
+ 1688000p -0.3
+ 1688010p 0.9
+ 1690000p 0.9
+ 1690010p -0.3
+ 1692000p -0.3
+ 1692010p 0.9
+ 1694000p 0.9
+ 1694010p -0.3
+ 1696000p -0.3
+ 1696010p 0.9
+ 1698000p 0.9
+ 1698010p -0.3
+ 1700000p -0.3
+ 1700010p 0.9
+ 1702000p 0.9
+ 1702010p -0.3
+ 1704000p -0.3
+ 1704010p 0.9
+ 1706000p 0.9
+ 1706010p -0.3
+ 1708000p -0.3
+ 1708010p 0.9
+ 1710000p 0.9
+ 1710010p -0.3
+ 1712000p -0.3
+ 1712010p 0.9
+ 1714000p 0.9
+ 1714010p -0.3
+ 1716000p -0.3
+ 1716010p 0.9
+ 1718000p 0.9
+ 1718010p -0.3
+ 1720000p -0.3
+ 1720010p 0.9
+ 1722000p 0.9
+ 1722010p -0.3
+ 1724000p -0.3
+ 1724010p 0.9
+ 1726000p 0.9
+ 1726010p -0.3
+ 1728000p -0.3
+ 1728010p 0.9
+ 1730000p 0.9
+ 1730010p -0.3
+ 1732000p -0.3
+ 1732010p 0.9
+ 1734000p 0.9
+ 1734010p -0.3
+ 1736000p -0.3
+ 1736010p 0.9
+ 1738000p 0.9
+ 1738010p -0.3
+ 1740000p -0.3
+ 1740010p 0.9
+ 1742000p 0.9
+ 1742010p -0.3
+ 1744000p -0.3
+ 1744010p 0.9
+ 1746000p 0.9
+ 1746010p -0.3
+ 1748000p -0.3
+ 1748010p 0.9
+ 1750000p 0.9
+ 1750010p -0.3
+ 1752000p -0.3
+ 1752010p 0.9
+ 1754000p 0.9
+ 1754010p -0.3
+ 1756000p -0.3
+ 1756010p 0.9
+ 1758000p 0.9
+ 1758010p -0.3
+ 1760000p -0.3
+ 1760010p 0.9
+ 1762000p 0.9
+ 1762010p -0.3
+ 1764000p -0.3
+ 1764010p 0.9
+ 1766000p 0.9
+ 1766010p -0.3
+ 1768000p -0.3
+ 1768010p 0.9
+ 1770000p 0.9
+ 1770010p -0.3
+ 1772000p -0.3
+ 1772010p 0.9
+ 1774000p 0.9
+ 1774010p -0.3
+ 1776000p -0.3
+ 1776010p 0.9
+ 1778000p 0.9
+ 1778010p -0.3
+ 1780000p -0.3
+ 1780010p 0.9
+ 1782000p 0.9
+ 1782010p -0.3
+ 1784000p -0.3
+ 1784010p 0.9
+ 1786000p 0.9
+ 1786010p -0.3
+ 1788000p -0.3
+ 1788010p 0.9
+ 1790000p 0.9
+ 1790010p -0.3
+ 1792000p -0.3
+ 1792010p 0.9
+ 1794000p 0.9
+ 1794010p -0.3
+ 1796000p -0.3
+ 1796010p 0.9
+ 1798000p 0.9
+ 1798010p -0.3
+ 1800000p -0.3
+ 1800010p 0.9
+ 1802000p 0.9
+ 1802010p -0.3
+ 1804000p -0.3
+ 1804010p 0.9
+ 1806000p 0.9
+ 1806010p -0.3
+ 1808000p -0.3
+ 1808010p 0.9
+ 1810000p 0.9
+ 1810010p -0.3
+ 1812000p -0.3
+ 1812010p 0.9
+ 1814000p 0.9
+ 1814010p -0.3
+ 1816000p -0.3
+ 1816010p 0.9
+ 1818000p 0.9
+ 1818010p -0.3
+ 1820000p -0.3
+ 1820010p 0.9
+ 1822000p 0.9
+ 1822010p -0.3
+ 1824000p -0.3
+ 1824010p 0.9
+ 1826000p 0.9
+ 1826010p -0.3
+ 1828000p -0.3
+ 1828010p 0.9
+ 1830000p 0.9
+ 1830010p -0.3
+ 1832000p -0.3
+ 1832010p 0.9
+ 1834000p 0.9
+ 1834010p -0.3
+ 1836000p -0.3
+ 1836010p 0.9
+ 1838000p 0.9
+ 1838010p -0.3
+ 1840000p -0.3
+ 1840010p 0.9
+ 1842000p 0.9
+ 1842010p -0.3
+ 1844000p -0.3
+ 1844010p 0.9
+ 1846000p 0.9
+ 1846010p -0.3
+ 1848000p -0.3
+ 1848010p 0.9
+ 1850000p 0.9
+ 1850010p -0.3
+ 1852000p -0.3
+ 1852010p 0.9
+ 1854000p 0.9
+ 1854010p -0.3
+ 1856000p -0.3
+ 1856010p 0.9
+ 1858000p 0.9
+ 1858010p -0.3
+ 1860000p -0.3
+ 1860010p 0.9
+ 1862000p 0.9
+ 1862010p -0.3
+ 1864000p -0.3
+ 1864010p 0.9
+ 1866000p 0.9
+ 1866010p -0.3
+ 1868000p -0.3
+ 1868010p 0.9
+ 1870000p 0.9
+ 1870010p -0.3
+ 1872000p -0.3
+ 1872010p 0.9
+ 1874000p 0.9
+ 1874010p -0.3
+ 1876000p -0.3
+ 1876010p 0.9
+ 1878000p 0.9
+ 1878010p -0.3
+ 1880000p -0.3
+ 1880010p 0.9
+ 1882000p 0.9
+ 1882010p -0.3
+ 1884000p -0.3
+ 1884010p 0.9
+ 1886000p 0.9
+ 1886010p -0.3
+ 1888000p -0.3
+ 1888010p 0.9
+ 1890000p 0.9
+ 1890010p -0.3
+ 1892000p -0.3
+ 1892010p 0.9
+ 1894000p 0.9
+ 1894010p -0.3
+ 1896000p -0.3
+ 1896010p 0.9
+ 1898000p 0.9
+ 1898010p -0.3
+ 1900000p -0.3
+ 1900010p 0.9
+ 1902000p 0.9
+ 1902010p -0.3
+ 1904000p -0.3
+ 1904010p 0.9
+ 1906000p 0.9
+ 1906010p -0.3
+ 1908000p -0.3
+ 1908010p 0.9
+ 1910000p 0.9
+ 1910010p -0.3
+ 1912000p -0.3
+ 1912010p 0.9
+ 1914000p 0.9
+ 1914010p -0.3
+ 1916000p -0.3
+ 1916010p 0.9
+ 1918000p 0.9
+ 1918010p -0.3
+ 1920000p -0.3
+ 1920010p 0.9
+ 1922000p 0.9
+ 1922010p -0.3
+ 1924000p -0.3
+ 1924010p 0.9
+ 1926000p 0.9
+ 1926010p -0.3
+ 1928000p -0.3
+ 1928010p 0.9
+ 1930000p 0.9
+ 1930010p -0.3
+ 1932000p -0.3
+ 1932010p 0.9
+ 1934000p 0.9
+ 1934010p -0.3
+ 1936000p -0.3
+ 1936010p 0.9
+ 1938000p 0.9
+ 1938010p -0.3
+ 1940000p -0.3
+ 1940010p 0.9
+ 1942000p 0.9
+ 1942010p -0.3
+ 1944000p -0.3
+ 1944010p 0.9
+ 1946000p 0.9
+ 1946010p -0.3
+ 1948000p -0.3
+ 1948010p 0.9
+ 1950000p 0.9
+ 1950010p -0.3
+ 1952000p -0.3
+ 1952010p 0.9
+ 1954000p 0.9
+ 1954010p -0.3
+ 1956000p -0.3
+ 1956010p 0.9
+ 1958000p 0.9
+ 1958010p -0.3
+ 1960000p -0.3
+ 1960010p 0.9
+ 1962000p 0.9
+ 1962010p -0.3
+ 1964000p -0.3
+ 1964010p 0.9
+ 1966000p 0.9
+ 1966010p -0.3
+ 1968000p -0.3
+ 1968010p 0.9
+ 1970000p 0.9
+ 1970010p -0.3
+ 1972000p -0.3
+ 1972010p 0.9
+ 1974000p 0.9
+ 1974010p -0.3
+ 1976000p -0.3
+ 1976010p 0.9
+ 1978000p 0.9
+ 1978010p -0.3
+ 1980000p -0.3
+ 1980010p 0.9
+ 1982000p 0.9
+ 1982010p -0.3
+ 1984000p -0.3
+ 1984010p 0.9
+ 1986000p 0.9
+ 1986010p -0.3
+ 1988000p -0.3
+ 1988010p 0.9
+ 1990000p 0.9
+ 1990010p -0.3
+ 1992000p -0.3
+ 1992010p 0.9
+ 1994000p 0.9
+ 1994010p -0.3
+ 1996000p -0.3
+ 1996010p 0.9
+ 1998000p 0.9
+ 1998010p -0.3
+ 2000000p -0.3
+ 2000010p 0.9
+ 2002000p 0.9
+ 2002010p -0.3
+ 2004000p -0.3
+ 2004010p 0.9
+ 2006000p 0.9
+ 2006010p -0.3
+ 2008000p -0.3
+ 2008010p 0.9
+ 2010000p 0.9
+ 2010010p -0.3
+ 2012000p -0.3
+ 2012010p 0.9
+ 2014000p 0.9
+ 2014010p -0.3
+ 2016000p -0.3
+ 2016010p 0.9
+ 2018000p 0.9
+ 2018010p -0.3
+ 2020000p -0.3
+ 2020010p 0.9
+ 2022000p 0.9
+ 2022010p -0.3
+ 2024000p -0.3
+ 2024010p 0.9
+ 2026000p 0.9
+ 2026010p -0.3
+ 2028000p -0.3
+ 2028010p 0.9
+ 2030000p 0.9
+ 2030010p -0.3
+ 2032000p -0.3
+ 2032010p 0.9
+ 2034000p 0.9
+ 2034010p -0.3
+ 2036000p -0.3
+ 2036010p 0.9
+ 2038000p 0.9
+ 2038010p -0.3
+ 2040000p -0.3
+ 2040010p 0.9
+ 2042000p 0.9
+ 2042010p -0.3
+ 2044000p -0.3
+ 2044010p 0.9
+ 2046000p 0.9
+ 2046010p -0.3
+ 2048000p -0.3
+ 2048010p 0.9
+ \]
V_data_bar_7 (Data_bar\\<7\\> gnd!) vsource type=pwl wave=\[
+ 0    -0.3
+ 2000p -0.3
+ 2010p 0.9
+ 4000p 0.9
+ 4010p -0.3
+ 6000p -0.3
+ 6010p 0.9
+ 8000p 0.9
+ 8010p -0.3
+ 10000p -0.3
+ 10010p 0.9
+ 12000p 0.9
+ 12010p -0.3
+ 14000p -0.3
+ 14010p 0.9
+ 16000p 0.9
+ 16010p -0.3
+ 18000p -0.3
+ 18010p 0.9
+ 20000p 0.9
+ 20010p -0.3
+ 22000p -0.3
+ 22010p 0.9
+ 24000p 0.9
+ 24010p -0.3
+ 26000p -0.3
+ 26010p 0.9
+ 28000p 0.9
+ 28010p -0.3
+ 30000p -0.3
+ 30010p 0.9
+ 32000p 0.9
+ 32010p -0.3
+ 34000p -0.3
+ 34010p 0.9
+ 36000p 0.9
+ 36010p -0.3
+ 38000p -0.3
+ 38010p 0.9
+ 40000p 0.9
+ 40010p -0.3
+ 42000p -0.3
+ 42010p 0.9
+ 44000p 0.9
+ 44010p -0.3
+ 46000p -0.3
+ 46010p 0.9
+ 48000p 0.9
+ 48010p -0.3
+ 50000p -0.3
+ 50010p 0.9
+ 52000p 0.9
+ 52010p -0.3
+ 54000p -0.3
+ 54010p 0.9
+ 56000p 0.9
+ 56010p -0.3
+ 58000p -0.3
+ 58010p 0.9
+ 60000p 0.9
+ 60010p -0.3
+ 62000p -0.3
+ 62010p 0.9
+ 64000p 0.9
+ 64010p -0.3
+ 66000p -0.3
+ 66010p 0.9
+ 68000p 0.9
+ 68010p -0.3
+ 70000p -0.3
+ 70010p 0.9
+ 72000p 0.9
+ 72010p -0.3
+ 74000p -0.3
+ 74010p 0.9
+ 76000p 0.9
+ 76010p -0.3
+ 78000p -0.3
+ 78010p 0.9
+ 80000p 0.9
+ 80010p -0.3
+ 82000p -0.3
+ 82010p 0.9
+ 84000p 0.9
+ 84010p -0.3
+ 86000p -0.3
+ 86010p 0.9
+ 88000p 0.9
+ 88010p -0.3
+ 90000p -0.3
+ 90010p 0.9
+ 92000p 0.9
+ 92010p -0.3
+ 94000p -0.3
+ 94010p 0.9
+ 96000p 0.9
+ 96010p -0.3
+ 98000p -0.3
+ 98010p 0.9
+ 100000p 0.9
+ 100010p -0.3
+ 102000p -0.3
+ 102010p 0.9
+ 104000p 0.9
+ 104010p -0.3
+ 106000p -0.3
+ 106010p 0.9
+ 108000p 0.9
+ 108010p -0.3
+ 110000p -0.3
+ 110010p 0.9
+ 112000p 0.9
+ 112010p -0.3
+ 114000p -0.3
+ 114010p 0.9
+ 116000p 0.9
+ 116010p -0.3
+ 118000p -0.3
+ 118010p 0.9
+ 120000p 0.9
+ 120010p -0.3
+ 122000p -0.3
+ 122010p 0.9
+ 124000p 0.9
+ 124010p -0.3
+ 126000p -0.3
+ 126010p 0.9
+ 128000p 0.9
+ 128010p -0.3
+ 130000p -0.3
+ 130010p 0.9
+ 132000p 0.9
+ 132010p -0.3
+ 134000p -0.3
+ 134010p 0.9
+ 136000p 0.9
+ 136010p -0.3
+ 138000p -0.3
+ 138010p 0.9
+ 140000p 0.9
+ 140010p -0.3
+ 142000p -0.3
+ 142010p 0.9
+ 144000p 0.9
+ 144010p -0.3
+ 146000p -0.3
+ 146010p 0.9
+ 148000p 0.9
+ 148010p -0.3
+ 150000p -0.3
+ 150010p 0.9
+ 152000p 0.9
+ 152010p -0.3
+ 154000p -0.3
+ 154010p 0.9
+ 156000p 0.9
+ 156010p -0.3
+ 158000p -0.3
+ 158010p 0.9
+ 160000p 0.9
+ 160010p -0.3
+ 162000p -0.3
+ 162010p 0.9
+ 164000p 0.9
+ 164010p -0.3
+ 166000p -0.3
+ 166010p 0.9
+ 168000p 0.9
+ 168010p -0.3
+ 170000p -0.3
+ 170010p 0.9
+ 172000p 0.9
+ 172010p -0.3
+ 174000p -0.3
+ 174010p 0.9
+ 176000p 0.9
+ 176010p -0.3
+ 178000p -0.3
+ 178010p 0.9
+ 180000p 0.9
+ 180010p -0.3
+ 182000p -0.3
+ 182010p 0.9
+ 184000p 0.9
+ 184010p -0.3
+ 186000p -0.3
+ 186010p 0.9
+ 188000p 0.9
+ 188010p -0.3
+ 190000p -0.3
+ 190010p 0.9
+ 192000p 0.9
+ 192010p -0.3
+ 194000p -0.3
+ 194010p 0.9
+ 196000p 0.9
+ 196010p -0.3
+ 198000p -0.3
+ 198010p 0.9
+ 200000p 0.9
+ 200010p -0.3
+ 202000p -0.3
+ 202010p 0.9
+ 204000p 0.9
+ 204010p -0.3
+ 206000p -0.3
+ 206010p 0.9
+ 208000p 0.9
+ 208010p -0.3
+ 210000p -0.3
+ 210010p 0.9
+ 212000p 0.9
+ 212010p -0.3
+ 214000p -0.3
+ 214010p 0.9
+ 216000p 0.9
+ 216010p -0.3
+ 218000p -0.3
+ 218010p 0.9
+ 220000p 0.9
+ 220010p -0.3
+ 222000p -0.3
+ 222010p 0.9
+ 224000p 0.9
+ 224010p -0.3
+ 226000p -0.3
+ 226010p 0.9
+ 228000p 0.9
+ 228010p -0.3
+ 230000p -0.3
+ 230010p 0.9
+ 232000p 0.9
+ 232010p -0.3
+ 234000p -0.3
+ 234010p 0.9
+ 236000p 0.9
+ 236010p -0.3
+ 238000p -0.3
+ 238010p 0.9
+ 240000p 0.9
+ 240010p -0.3
+ 242000p -0.3
+ 242010p 0.9
+ 244000p 0.9
+ 244010p -0.3
+ 246000p -0.3
+ 246010p 0.9
+ 248000p 0.9
+ 248010p -0.3
+ 250000p -0.3
+ 250010p 0.9
+ 252000p 0.9
+ 252010p -0.3
+ 254000p -0.3
+ 254010p 0.9
+ 256000p 0.9
+ 256010p -0.3
+ 258000p -0.3
+ 258010p 0.9
+ 260000p 0.9
+ 260010p -0.3
+ 262000p -0.3
+ 262010p 0.9
+ 264000p 0.9
+ 264010p -0.3
+ 266000p -0.3
+ 266010p 0.9
+ 268000p 0.9
+ 268010p -0.3
+ 270000p -0.3
+ 270010p 0.9
+ 272000p 0.9
+ 272010p -0.3
+ 274000p -0.3
+ 274010p 0.9
+ 276000p 0.9
+ 276010p -0.3
+ 278000p -0.3
+ 278010p 0.9
+ 280000p 0.9
+ 280010p -0.3
+ 282000p -0.3
+ 282010p 0.9
+ 284000p 0.9
+ 284010p -0.3
+ 286000p -0.3
+ 286010p 0.9
+ 288000p 0.9
+ 288010p -0.3
+ 290000p -0.3
+ 290010p 0.9
+ 292000p 0.9
+ 292010p -0.3
+ 294000p -0.3
+ 294010p 0.9
+ 296000p 0.9
+ 296010p -0.3
+ 298000p -0.3
+ 298010p 0.9
+ 300000p 0.9
+ 300010p -0.3
+ 302000p -0.3
+ 302010p 0.9
+ 304000p 0.9
+ 304010p -0.3
+ 306000p -0.3
+ 306010p 0.9
+ 308000p 0.9
+ 308010p -0.3
+ 310000p -0.3
+ 310010p 0.9
+ 312000p 0.9
+ 312010p -0.3
+ 314000p -0.3
+ 314010p 0.9
+ 316000p 0.9
+ 316010p -0.3
+ 318000p -0.3
+ 318010p 0.9
+ 320000p 0.9
+ 320010p -0.3
+ 322000p -0.3
+ 322010p 0.9
+ 324000p 0.9
+ 324010p -0.3
+ 326000p -0.3
+ 326010p 0.9
+ 328000p 0.9
+ 328010p -0.3
+ 330000p -0.3
+ 330010p 0.9
+ 332000p 0.9
+ 332010p -0.3
+ 334000p -0.3
+ 334010p 0.9
+ 336000p 0.9
+ 336010p -0.3
+ 338000p -0.3
+ 338010p 0.9
+ 340000p 0.9
+ 340010p -0.3
+ 342000p -0.3
+ 342010p 0.9
+ 344000p 0.9
+ 344010p -0.3
+ 346000p -0.3
+ 346010p 0.9
+ 348000p 0.9
+ 348010p -0.3
+ 350000p -0.3
+ 350010p 0.9
+ 352000p 0.9
+ 352010p -0.3
+ 354000p -0.3
+ 354010p 0.9
+ 356000p 0.9
+ 356010p -0.3
+ 358000p -0.3
+ 358010p 0.9
+ 360000p 0.9
+ 360010p -0.3
+ 362000p -0.3
+ 362010p 0.9
+ 364000p 0.9
+ 364010p -0.3
+ 366000p -0.3
+ 366010p 0.9
+ 368000p 0.9
+ 368010p -0.3
+ 370000p -0.3
+ 370010p 0.9
+ 372000p 0.9
+ 372010p -0.3
+ 374000p -0.3
+ 374010p 0.9
+ 376000p 0.9
+ 376010p -0.3
+ 378000p -0.3
+ 378010p 0.9
+ 380000p 0.9
+ 380010p -0.3
+ 382000p -0.3
+ 382010p 0.9
+ 384000p 0.9
+ 384010p -0.3
+ 386000p -0.3
+ 386010p 0.9
+ 388000p 0.9
+ 388010p -0.3
+ 390000p -0.3
+ 390010p 0.9
+ 392000p 0.9
+ 392010p -0.3
+ 394000p -0.3
+ 394010p 0.9
+ 396000p 0.9
+ 396010p -0.3
+ 398000p -0.3
+ 398010p 0.9
+ 400000p 0.9
+ 400010p -0.3
+ 402000p -0.3
+ 402010p 0.9
+ 404000p 0.9
+ 404010p -0.3
+ 406000p -0.3
+ 406010p 0.9
+ 408000p 0.9
+ 408010p -0.3
+ 410000p -0.3
+ 410010p 0.9
+ 412000p 0.9
+ 412010p -0.3
+ 414000p -0.3
+ 414010p 0.9
+ 416000p 0.9
+ 416010p -0.3
+ 418000p -0.3
+ 418010p 0.9
+ 420000p 0.9
+ 420010p -0.3
+ 422000p -0.3
+ 422010p 0.9
+ 424000p 0.9
+ 424010p -0.3
+ 426000p -0.3
+ 426010p 0.9
+ 428000p 0.9
+ 428010p -0.3
+ 430000p -0.3
+ 430010p 0.9
+ 432000p 0.9
+ 432010p -0.3
+ 434000p -0.3
+ 434010p 0.9
+ 436000p 0.9
+ 436010p -0.3
+ 438000p -0.3
+ 438010p 0.9
+ 440000p 0.9
+ 440010p -0.3
+ 442000p -0.3
+ 442010p 0.9
+ 444000p 0.9
+ 444010p -0.3
+ 446000p -0.3
+ 446010p 0.9
+ 448000p 0.9
+ 448010p -0.3
+ 450000p -0.3
+ 450010p 0.9
+ 452000p 0.9
+ 452010p -0.3
+ 454000p -0.3
+ 454010p 0.9
+ 456000p 0.9
+ 456010p -0.3
+ 458000p -0.3
+ 458010p 0.9
+ 460000p 0.9
+ 460010p -0.3
+ 462000p -0.3
+ 462010p 0.9
+ 464000p 0.9
+ 464010p -0.3
+ 466000p -0.3
+ 466010p 0.9
+ 468000p 0.9
+ 468010p -0.3
+ 470000p -0.3
+ 470010p 0.9
+ 472000p 0.9
+ 472010p -0.3
+ 474000p -0.3
+ 474010p 0.9
+ 476000p 0.9
+ 476010p -0.3
+ 478000p -0.3
+ 478010p 0.9
+ 480000p 0.9
+ 480010p -0.3
+ 482000p -0.3
+ 482010p 0.9
+ 484000p 0.9
+ 484010p -0.3
+ 486000p -0.3
+ 486010p 0.9
+ 488000p 0.9
+ 488010p -0.3
+ 490000p -0.3
+ 490010p 0.9
+ 492000p 0.9
+ 492010p -0.3
+ 494000p -0.3
+ 494010p 0.9
+ 496000p 0.9
+ 496010p -0.3
+ 498000p -0.3
+ 498010p 0.9
+ 500000p 0.9
+ 500010p -0.3
+ 502000p -0.3
+ 502010p 0.9
+ 504000p 0.9
+ 504010p -0.3
+ 506000p -0.3
+ 506010p 0.9
+ 508000p 0.9
+ 508010p -0.3
+ 510000p -0.3
+ 510010p 0.9
+ 512000p 0.9
+ 512010p -0.3
+ 514000p -0.3
+ 514010p 0.9
+ 516000p 0.9
+ 516010p -0.3
+ 518000p -0.3
+ 518010p 0.9
+ 520000p 0.9
+ 520010p -0.3
+ 522000p -0.3
+ 522010p 0.9
+ 524000p 0.9
+ 524010p -0.3
+ 526000p -0.3
+ 526010p 0.9
+ 528000p 0.9
+ 528010p -0.3
+ 530000p -0.3
+ 530010p 0.9
+ 532000p 0.9
+ 532010p -0.3
+ 534000p -0.3
+ 534010p 0.9
+ 536000p 0.9
+ 536010p -0.3
+ 538000p -0.3
+ 538010p 0.9
+ 540000p 0.9
+ 540010p -0.3
+ 542000p -0.3
+ 542010p 0.9
+ 544000p 0.9
+ 544010p -0.3
+ 546000p -0.3
+ 546010p 0.9
+ 548000p 0.9
+ 548010p -0.3
+ 550000p -0.3
+ 550010p 0.9
+ 552000p 0.9
+ 552010p -0.3
+ 554000p -0.3
+ 554010p 0.9
+ 556000p 0.9
+ 556010p -0.3
+ 558000p -0.3
+ 558010p 0.9
+ 560000p 0.9
+ 560010p -0.3
+ 562000p -0.3
+ 562010p 0.9
+ 564000p 0.9
+ 564010p -0.3
+ 566000p -0.3
+ 566010p 0.9
+ 568000p 0.9
+ 568010p -0.3
+ 570000p -0.3
+ 570010p 0.9
+ 572000p 0.9
+ 572010p -0.3
+ 574000p -0.3
+ 574010p 0.9
+ 576000p 0.9
+ 576010p -0.3
+ 578000p -0.3
+ 578010p 0.9
+ 580000p 0.9
+ 580010p -0.3
+ 582000p -0.3
+ 582010p 0.9
+ 584000p 0.9
+ 584010p -0.3
+ 586000p -0.3
+ 586010p 0.9
+ 588000p 0.9
+ 588010p -0.3
+ 590000p -0.3
+ 590010p 0.9
+ 592000p 0.9
+ 592010p -0.3
+ 594000p -0.3
+ 594010p 0.9
+ 596000p 0.9
+ 596010p -0.3
+ 598000p -0.3
+ 598010p 0.9
+ 600000p 0.9
+ 600010p -0.3
+ 602000p -0.3
+ 602010p 0.9
+ 604000p 0.9
+ 604010p -0.3
+ 606000p -0.3
+ 606010p 0.9
+ 608000p 0.9
+ 608010p -0.3
+ 610000p -0.3
+ 610010p 0.9
+ 612000p 0.9
+ 612010p -0.3
+ 614000p -0.3
+ 614010p 0.9
+ 616000p 0.9
+ 616010p -0.3
+ 618000p -0.3
+ 618010p 0.9
+ 620000p 0.9
+ 620010p -0.3
+ 622000p -0.3
+ 622010p 0.9
+ 624000p 0.9
+ 624010p -0.3
+ 626000p -0.3
+ 626010p 0.9
+ 628000p 0.9
+ 628010p -0.3
+ 630000p -0.3
+ 630010p 0.9
+ 632000p 0.9
+ 632010p -0.3
+ 634000p -0.3
+ 634010p 0.9
+ 636000p 0.9
+ 636010p -0.3
+ 638000p -0.3
+ 638010p 0.9
+ 640000p 0.9
+ 640010p -0.3
+ 642000p -0.3
+ 642010p 0.9
+ 644000p 0.9
+ 644010p -0.3
+ 646000p -0.3
+ 646010p 0.9
+ 648000p 0.9
+ 648010p -0.3
+ 650000p -0.3
+ 650010p 0.9
+ 652000p 0.9
+ 652010p -0.3
+ 654000p -0.3
+ 654010p 0.9
+ 656000p 0.9
+ 656010p -0.3
+ 658000p -0.3
+ 658010p 0.9
+ 660000p 0.9
+ 660010p -0.3
+ 662000p -0.3
+ 662010p 0.9
+ 664000p 0.9
+ 664010p -0.3
+ 666000p -0.3
+ 666010p 0.9
+ 668000p 0.9
+ 668010p -0.3
+ 670000p -0.3
+ 670010p 0.9
+ 672000p 0.9
+ 672010p -0.3
+ 674000p -0.3
+ 674010p 0.9
+ 676000p 0.9
+ 676010p -0.3
+ 678000p -0.3
+ 678010p 0.9
+ 680000p 0.9
+ 680010p -0.3
+ 682000p -0.3
+ 682010p 0.9
+ 684000p 0.9
+ 684010p -0.3
+ 686000p -0.3
+ 686010p 0.9
+ 688000p 0.9
+ 688010p -0.3
+ 690000p -0.3
+ 690010p 0.9
+ 692000p 0.9
+ 692010p -0.3
+ 694000p -0.3
+ 694010p 0.9
+ 696000p 0.9
+ 696010p -0.3
+ 698000p -0.3
+ 698010p 0.9
+ 700000p 0.9
+ 700010p -0.3
+ 702000p -0.3
+ 702010p 0.9
+ 704000p 0.9
+ 704010p -0.3
+ 706000p -0.3
+ 706010p 0.9
+ 708000p 0.9
+ 708010p -0.3
+ 710000p -0.3
+ 710010p 0.9
+ 712000p 0.9
+ 712010p -0.3
+ 714000p -0.3
+ 714010p 0.9
+ 716000p 0.9
+ 716010p -0.3
+ 718000p -0.3
+ 718010p 0.9
+ 720000p 0.9
+ 720010p -0.3
+ 722000p -0.3
+ 722010p 0.9
+ 724000p 0.9
+ 724010p -0.3
+ 726000p -0.3
+ 726010p 0.9
+ 728000p 0.9
+ 728010p -0.3
+ 730000p -0.3
+ 730010p 0.9
+ 732000p 0.9
+ 732010p -0.3
+ 734000p -0.3
+ 734010p 0.9
+ 736000p 0.9
+ 736010p -0.3
+ 738000p -0.3
+ 738010p 0.9
+ 740000p 0.9
+ 740010p -0.3
+ 742000p -0.3
+ 742010p 0.9
+ 744000p 0.9
+ 744010p -0.3
+ 746000p -0.3
+ 746010p 0.9
+ 748000p 0.9
+ 748010p -0.3
+ 750000p -0.3
+ 750010p 0.9
+ 752000p 0.9
+ 752010p -0.3
+ 754000p -0.3
+ 754010p 0.9
+ 756000p 0.9
+ 756010p -0.3
+ 758000p -0.3
+ 758010p 0.9
+ 760000p 0.9
+ 760010p -0.3
+ 762000p -0.3
+ 762010p 0.9
+ 764000p 0.9
+ 764010p -0.3
+ 766000p -0.3
+ 766010p 0.9
+ 768000p 0.9
+ 768010p -0.3
+ 770000p -0.3
+ 770010p 0.9
+ 772000p 0.9
+ 772010p -0.3
+ 774000p -0.3
+ 774010p 0.9
+ 776000p 0.9
+ 776010p -0.3
+ 778000p -0.3
+ 778010p 0.9
+ 780000p 0.9
+ 780010p -0.3
+ 782000p -0.3
+ 782010p 0.9
+ 784000p 0.9
+ 784010p -0.3
+ 786000p -0.3
+ 786010p 0.9
+ 788000p 0.9
+ 788010p -0.3
+ 790000p -0.3
+ 790010p 0.9
+ 792000p 0.9
+ 792010p -0.3
+ 794000p -0.3
+ 794010p 0.9
+ 796000p 0.9
+ 796010p -0.3
+ 798000p -0.3
+ 798010p 0.9
+ 800000p 0.9
+ 800010p -0.3
+ 802000p -0.3
+ 802010p 0.9
+ 804000p 0.9
+ 804010p -0.3
+ 806000p -0.3
+ 806010p 0.9
+ 808000p 0.9
+ 808010p -0.3
+ 810000p -0.3
+ 810010p 0.9
+ 812000p 0.9
+ 812010p -0.3
+ 814000p -0.3
+ 814010p 0.9
+ 816000p 0.9
+ 816010p -0.3
+ 818000p -0.3
+ 818010p 0.9
+ 820000p 0.9
+ 820010p -0.3
+ 822000p -0.3
+ 822010p 0.9
+ 824000p 0.9
+ 824010p -0.3
+ 826000p -0.3
+ 826010p 0.9
+ 828000p 0.9
+ 828010p -0.3
+ 830000p -0.3
+ 830010p 0.9
+ 832000p 0.9
+ 832010p -0.3
+ 834000p -0.3
+ 834010p 0.9
+ 836000p 0.9
+ 836010p -0.3
+ 838000p -0.3
+ 838010p 0.9
+ 840000p 0.9
+ 840010p -0.3
+ 842000p -0.3
+ 842010p 0.9
+ 844000p 0.9
+ 844010p -0.3
+ 846000p -0.3
+ 846010p 0.9
+ 848000p 0.9
+ 848010p -0.3
+ 850000p -0.3
+ 850010p 0.9
+ 852000p 0.9
+ 852010p -0.3
+ 854000p -0.3
+ 854010p 0.9
+ 856000p 0.9
+ 856010p -0.3
+ 858000p -0.3
+ 858010p 0.9
+ 860000p 0.9
+ 860010p -0.3
+ 862000p -0.3
+ 862010p 0.9
+ 864000p 0.9
+ 864010p -0.3
+ 866000p -0.3
+ 866010p 0.9
+ 868000p 0.9
+ 868010p -0.3
+ 870000p -0.3
+ 870010p 0.9
+ 872000p 0.9
+ 872010p -0.3
+ 874000p -0.3
+ 874010p 0.9
+ 876000p 0.9
+ 876010p -0.3
+ 878000p -0.3
+ 878010p 0.9
+ 880000p 0.9
+ 880010p -0.3
+ 882000p -0.3
+ 882010p 0.9
+ 884000p 0.9
+ 884010p -0.3
+ 886000p -0.3
+ 886010p 0.9
+ 888000p 0.9
+ 888010p -0.3
+ 890000p -0.3
+ 890010p 0.9
+ 892000p 0.9
+ 892010p -0.3
+ 894000p -0.3
+ 894010p 0.9
+ 896000p 0.9
+ 896010p -0.3
+ 898000p -0.3
+ 898010p 0.9
+ 900000p 0.9
+ 900010p -0.3
+ 902000p -0.3
+ 902010p 0.9
+ 904000p 0.9
+ 904010p -0.3
+ 906000p -0.3
+ 906010p 0.9
+ 908000p 0.9
+ 908010p -0.3
+ 910000p -0.3
+ 910010p 0.9
+ 912000p 0.9
+ 912010p -0.3
+ 914000p -0.3
+ 914010p 0.9
+ 916000p 0.9
+ 916010p -0.3
+ 918000p -0.3
+ 918010p 0.9
+ 920000p 0.9
+ 920010p -0.3
+ 922000p -0.3
+ 922010p 0.9
+ 924000p 0.9
+ 924010p -0.3
+ 926000p -0.3
+ 926010p 0.9
+ 928000p 0.9
+ 928010p -0.3
+ 930000p -0.3
+ 930010p 0.9
+ 932000p 0.9
+ 932010p -0.3
+ 934000p -0.3
+ 934010p 0.9
+ 936000p 0.9
+ 936010p -0.3
+ 938000p -0.3
+ 938010p 0.9
+ 940000p 0.9
+ 940010p -0.3
+ 942000p -0.3
+ 942010p 0.9
+ 944000p 0.9
+ 944010p -0.3
+ 946000p -0.3
+ 946010p 0.9
+ 948000p 0.9
+ 948010p -0.3
+ 950000p -0.3
+ 950010p 0.9
+ 952000p 0.9
+ 952010p -0.3
+ 954000p -0.3
+ 954010p 0.9
+ 956000p 0.9
+ 956010p -0.3
+ 958000p -0.3
+ 958010p 0.9
+ 960000p 0.9
+ 960010p -0.3
+ 962000p -0.3
+ 962010p 0.9
+ 964000p 0.9
+ 964010p -0.3
+ 966000p -0.3
+ 966010p 0.9
+ 968000p 0.9
+ 968010p -0.3
+ 970000p -0.3
+ 970010p 0.9
+ 972000p 0.9
+ 972010p -0.3
+ 974000p -0.3
+ 974010p 0.9
+ 976000p 0.9
+ 976010p -0.3
+ 978000p -0.3
+ 978010p 0.9
+ 980000p 0.9
+ 980010p -0.3
+ 982000p -0.3
+ 982010p 0.9
+ 984000p 0.9
+ 984010p -0.3
+ 986000p -0.3
+ 986010p 0.9
+ 988000p 0.9
+ 988010p -0.3
+ 990000p -0.3
+ 990010p 0.9
+ 992000p 0.9
+ 992010p -0.3
+ 994000p -0.3
+ 994010p 0.9
+ 996000p 0.9
+ 996010p -0.3
+ 998000p -0.3
+ 998010p 0.9
+ 1000000p 0.9
+ 1000010p -0.3
+ 1002000p -0.3
+ 1002010p 0.9
+ 1004000p 0.9
+ 1004010p -0.3
+ 1006000p -0.3
+ 1006010p 0.9
+ 1008000p 0.9
+ 1008010p -0.3
+ 1010000p -0.3
+ 1010010p 0.9
+ 1012000p 0.9
+ 1012010p -0.3
+ 1014000p -0.3
+ 1014010p 0.9
+ 1016000p 0.9
+ 1016010p -0.3
+ 1018000p -0.3
+ 1018010p 0.9
+ 1020000p 0.9
+ 1020010p -0.3
+ 1022000p -0.3
+ 1022010p 0.9
+ 1024000p 0.9
+ 1024010p -0.3
+ 1026000p -0.3
+ 1026010p 0.9
+ 1028000p 0.9
+ 1028010p -0.3
+ 1030000p -0.3
+ 1030010p 0.9
+ 1032000p 0.9
+ 1032010p -0.3
+ 1034000p -0.3
+ 1034010p 0.9
+ 1036000p 0.9
+ 1036010p -0.3
+ 1038000p -0.3
+ 1038010p 0.9
+ 1040000p 0.9
+ 1040010p -0.3
+ 1042000p -0.3
+ 1042010p 0.9
+ 1044000p 0.9
+ 1044010p -0.3
+ 1046000p -0.3
+ 1046010p 0.9
+ 1048000p 0.9
+ 1048010p -0.3
+ 1050000p -0.3
+ 1050010p 0.9
+ 1052000p 0.9
+ 1052010p -0.3
+ 1054000p -0.3
+ 1054010p 0.9
+ 1056000p 0.9
+ 1056010p -0.3
+ 1058000p -0.3
+ 1058010p 0.9
+ 1060000p 0.9
+ 1060010p -0.3
+ 1062000p -0.3
+ 1062010p 0.9
+ 1064000p 0.9
+ 1064010p -0.3
+ 1066000p -0.3
+ 1066010p 0.9
+ 1068000p 0.9
+ 1068010p -0.3
+ 1070000p -0.3
+ 1070010p 0.9
+ 1072000p 0.9
+ 1072010p -0.3
+ 1074000p -0.3
+ 1074010p 0.9
+ 1076000p 0.9
+ 1076010p -0.3
+ 1078000p -0.3
+ 1078010p 0.9
+ 1080000p 0.9
+ 1080010p -0.3
+ 1082000p -0.3
+ 1082010p 0.9
+ 1084000p 0.9
+ 1084010p -0.3
+ 1086000p -0.3
+ 1086010p 0.9
+ 1088000p 0.9
+ 1088010p -0.3
+ 1090000p -0.3
+ 1090010p 0.9
+ 1092000p 0.9
+ 1092010p -0.3
+ 1094000p -0.3
+ 1094010p 0.9
+ 1096000p 0.9
+ 1096010p -0.3
+ 1098000p -0.3
+ 1098010p 0.9
+ 1100000p 0.9
+ 1100010p -0.3
+ 1102000p -0.3
+ 1102010p 0.9
+ 1104000p 0.9
+ 1104010p -0.3
+ 1106000p -0.3
+ 1106010p 0.9
+ 1108000p 0.9
+ 1108010p -0.3
+ 1110000p -0.3
+ 1110010p 0.9
+ 1112000p 0.9
+ 1112010p -0.3
+ 1114000p -0.3
+ 1114010p 0.9
+ 1116000p 0.9
+ 1116010p -0.3
+ 1118000p -0.3
+ 1118010p 0.9
+ 1120000p 0.9
+ 1120010p -0.3
+ 1122000p -0.3
+ 1122010p 0.9
+ 1124000p 0.9
+ 1124010p -0.3
+ 1126000p -0.3
+ 1126010p 0.9
+ 1128000p 0.9
+ 1128010p -0.3
+ 1130000p -0.3
+ 1130010p 0.9
+ 1132000p 0.9
+ 1132010p -0.3
+ 1134000p -0.3
+ 1134010p 0.9
+ 1136000p 0.9
+ 1136010p -0.3
+ 1138000p -0.3
+ 1138010p 0.9
+ 1140000p 0.9
+ 1140010p -0.3
+ 1142000p -0.3
+ 1142010p 0.9
+ 1144000p 0.9
+ 1144010p -0.3
+ 1146000p -0.3
+ 1146010p 0.9
+ 1148000p 0.9
+ 1148010p -0.3
+ 1150000p -0.3
+ 1150010p 0.9
+ 1152000p 0.9
+ 1152010p -0.3
+ 1154000p -0.3
+ 1154010p 0.9
+ 1156000p 0.9
+ 1156010p -0.3
+ 1158000p -0.3
+ 1158010p 0.9
+ 1160000p 0.9
+ 1160010p -0.3
+ 1162000p -0.3
+ 1162010p 0.9
+ 1164000p 0.9
+ 1164010p -0.3
+ 1166000p -0.3
+ 1166010p 0.9
+ 1168000p 0.9
+ 1168010p -0.3
+ 1170000p -0.3
+ 1170010p 0.9
+ 1172000p 0.9
+ 1172010p -0.3
+ 1174000p -0.3
+ 1174010p 0.9
+ 1176000p 0.9
+ 1176010p -0.3
+ 1178000p -0.3
+ 1178010p 0.9
+ 1180000p 0.9
+ 1180010p -0.3
+ 1182000p -0.3
+ 1182010p 0.9
+ 1184000p 0.9
+ 1184010p -0.3
+ 1186000p -0.3
+ 1186010p 0.9
+ 1188000p 0.9
+ 1188010p -0.3
+ 1190000p -0.3
+ 1190010p 0.9
+ 1192000p 0.9
+ 1192010p -0.3
+ 1194000p -0.3
+ 1194010p 0.9
+ 1196000p 0.9
+ 1196010p -0.3
+ 1198000p -0.3
+ 1198010p 0.9
+ 1200000p 0.9
+ 1200010p -0.3
+ 1202000p -0.3
+ 1202010p 0.9
+ 1204000p 0.9
+ 1204010p -0.3
+ 1206000p -0.3
+ 1206010p 0.9
+ 1208000p 0.9
+ 1208010p -0.3
+ 1210000p -0.3
+ 1210010p 0.9
+ 1212000p 0.9
+ 1212010p -0.3
+ 1214000p -0.3
+ 1214010p 0.9
+ 1216000p 0.9
+ 1216010p -0.3
+ 1218000p -0.3
+ 1218010p 0.9
+ 1220000p 0.9
+ 1220010p -0.3
+ 1222000p -0.3
+ 1222010p 0.9
+ 1224000p 0.9
+ 1224010p -0.3
+ 1226000p -0.3
+ 1226010p 0.9
+ 1228000p 0.9
+ 1228010p -0.3
+ 1230000p -0.3
+ 1230010p 0.9
+ 1232000p 0.9
+ 1232010p -0.3
+ 1234000p -0.3
+ 1234010p 0.9
+ 1236000p 0.9
+ 1236010p -0.3
+ 1238000p -0.3
+ 1238010p 0.9
+ 1240000p 0.9
+ 1240010p -0.3
+ 1242000p -0.3
+ 1242010p 0.9
+ 1244000p 0.9
+ 1244010p -0.3
+ 1246000p -0.3
+ 1246010p 0.9
+ 1248000p 0.9
+ 1248010p -0.3
+ 1250000p -0.3
+ 1250010p 0.9
+ 1252000p 0.9
+ 1252010p -0.3
+ 1254000p -0.3
+ 1254010p 0.9
+ 1256000p 0.9
+ 1256010p -0.3
+ 1258000p -0.3
+ 1258010p 0.9
+ 1260000p 0.9
+ 1260010p -0.3
+ 1262000p -0.3
+ 1262010p 0.9
+ 1264000p 0.9
+ 1264010p -0.3
+ 1266000p -0.3
+ 1266010p 0.9
+ 1268000p 0.9
+ 1268010p -0.3
+ 1270000p -0.3
+ 1270010p 0.9
+ 1272000p 0.9
+ 1272010p -0.3
+ 1274000p -0.3
+ 1274010p 0.9
+ 1276000p 0.9
+ 1276010p -0.3
+ 1278000p -0.3
+ 1278010p 0.9
+ 1280000p 0.9
+ 1280010p -0.3
+ 1282000p -0.3
+ 1282010p 0.9
+ 1284000p 0.9
+ 1284010p -0.3
+ 1286000p -0.3
+ 1286010p 0.9
+ 1288000p 0.9
+ 1288010p -0.3
+ 1290000p -0.3
+ 1290010p 0.9
+ 1292000p 0.9
+ 1292010p -0.3
+ 1294000p -0.3
+ 1294010p 0.9
+ 1296000p 0.9
+ 1296010p -0.3
+ 1298000p -0.3
+ 1298010p 0.9
+ 1300000p 0.9
+ 1300010p -0.3
+ 1302000p -0.3
+ 1302010p 0.9
+ 1304000p 0.9
+ 1304010p -0.3
+ 1306000p -0.3
+ 1306010p 0.9
+ 1308000p 0.9
+ 1308010p -0.3
+ 1310000p -0.3
+ 1310010p 0.9
+ 1312000p 0.9
+ 1312010p -0.3
+ 1314000p -0.3
+ 1314010p 0.9
+ 1316000p 0.9
+ 1316010p -0.3
+ 1318000p -0.3
+ 1318010p 0.9
+ 1320000p 0.9
+ 1320010p -0.3
+ 1322000p -0.3
+ 1322010p 0.9
+ 1324000p 0.9
+ 1324010p -0.3
+ 1326000p -0.3
+ 1326010p 0.9
+ 1328000p 0.9
+ 1328010p -0.3
+ 1330000p -0.3
+ 1330010p 0.9
+ 1332000p 0.9
+ 1332010p -0.3
+ 1334000p -0.3
+ 1334010p 0.9
+ 1336000p 0.9
+ 1336010p -0.3
+ 1338000p -0.3
+ 1338010p 0.9
+ 1340000p 0.9
+ 1340010p -0.3
+ 1342000p -0.3
+ 1342010p 0.9
+ 1344000p 0.9
+ 1344010p -0.3
+ 1346000p -0.3
+ 1346010p 0.9
+ 1348000p 0.9
+ 1348010p -0.3
+ 1350000p -0.3
+ 1350010p 0.9
+ 1352000p 0.9
+ 1352010p -0.3
+ 1354000p -0.3
+ 1354010p 0.9
+ 1356000p 0.9
+ 1356010p -0.3
+ 1358000p -0.3
+ 1358010p 0.9
+ 1360000p 0.9
+ 1360010p -0.3
+ 1362000p -0.3
+ 1362010p 0.9
+ 1364000p 0.9
+ 1364010p -0.3
+ 1366000p -0.3
+ 1366010p 0.9
+ 1368000p 0.9
+ 1368010p -0.3
+ 1370000p -0.3
+ 1370010p 0.9
+ 1372000p 0.9
+ 1372010p -0.3
+ 1374000p -0.3
+ 1374010p 0.9
+ 1376000p 0.9
+ 1376010p -0.3
+ 1378000p -0.3
+ 1378010p 0.9
+ 1380000p 0.9
+ 1380010p -0.3
+ 1382000p -0.3
+ 1382010p 0.9
+ 1384000p 0.9
+ 1384010p -0.3
+ 1386000p -0.3
+ 1386010p 0.9
+ 1388000p 0.9
+ 1388010p -0.3
+ 1390000p -0.3
+ 1390010p 0.9
+ 1392000p 0.9
+ 1392010p -0.3
+ 1394000p -0.3
+ 1394010p 0.9
+ 1396000p 0.9
+ 1396010p -0.3
+ 1398000p -0.3
+ 1398010p 0.9
+ 1400000p 0.9
+ 1400010p -0.3
+ 1402000p -0.3
+ 1402010p 0.9
+ 1404000p 0.9
+ 1404010p -0.3
+ 1406000p -0.3
+ 1406010p 0.9
+ 1408000p 0.9
+ 1408010p -0.3
+ 1410000p -0.3
+ 1410010p 0.9
+ 1412000p 0.9
+ 1412010p -0.3
+ 1414000p -0.3
+ 1414010p 0.9
+ 1416000p 0.9
+ 1416010p -0.3
+ 1418000p -0.3
+ 1418010p 0.9
+ 1420000p 0.9
+ 1420010p -0.3
+ 1422000p -0.3
+ 1422010p 0.9
+ 1424000p 0.9
+ 1424010p -0.3
+ 1426000p -0.3
+ 1426010p 0.9
+ 1428000p 0.9
+ 1428010p -0.3
+ 1430000p -0.3
+ 1430010p 0.9
+ 1432000p 0.9
+ 1432010p -0.3
+ 1434000p -0.3
+ 1434010p 0.9
+ 1436000p 0.9
+ 1436010p -0.3
+ 1438000p -0.3
+ 1438010p 0.9
+ 1440000p 0.9
+ 1440010p -0.3
+ 1442000p -0.3
+ 1442010p 0.9
+ 1444000p 0.9
+ 1444010p -0.3
+ 1446000p -0.3
+ 1446010p 0.9
+ 1448000p 0.9
+ 1448010p -0.3
+ 1450000p -0.3
+ 1450010p 0.9
+ 1452000p 0.9
+ 1452010p -0.3
+ 1454000p -0.3
+ 1454010p 0.9
+ 1456000p 0.9
+ 1456010p -0.3
+ 1458000p -0.3
+ 1458010p 0.9
+ 1460000p 0.9
+ 1460010p -0.3
+ 1462000p -0.3
+ 1462010p 0.9
+ 1464000p 0.9
+ 1464010p -0.3
+ 1466000p -0.3
+ 1466010p 0.9
+ 1468000p 0.9
+ 1468010p -0.3
+ 1470000p -0.3
+ 1470010p 0.9
+ 1472000p 0.9
+ 1472010p -0.3
+ 1474000p -0.3
+ 1474010p 0.9
+ 1476000p 0.9
+ 1476010p -0.3
+ 1478000p -0.3
+ 1478010p 0.9
+ 1480000p 0.9
+ 1480010p -0.3
+ 1482000p -0.3
+ 1482010p 0.9
+ 1484000p 0.9
+ 1484010p -0.3
+ 1486000p -0.3
+ 1486010p 0.9
+ 1488000p 0.9
+ 1488010p -0.3
+ 1490000p -0.3
+ 1490010p 0.9
+ 1492000p 0.9
+ 1492010p -0.3
+ 1494000p -0.3
+ 1494010p 0.9
+ 1496000p 0.9
+ 1496010p -0.3
+ 1498000p -0.3
+ 1498010p 0.9
+ 1500000p 0.9
+ 1500010p -0.3
+ 1502000p -0.3
+ 1502010p 0.9
+ 1504000p 0.9
+ 1504010p -0.3
+ 1506000p -0.3
+ 1506010p 0.9
+ 1508000p 0.9
+ 1508010p -0.3
+ 1510000p -0.3
+ 1510010p 0.9
+ 1512000p 0.9
+ 1512010p -0.3
+ 1514000p -0.3
+ 1514010p 0.9
+ 1516000p 0.9
+ 1516010p -0.3
+ 1518000p -0.3
+ 1518010p 0.9
+ 1520000p 0.9
+ 1520010p -0.3
+ 1522000p -0.3
+ 1522010p 0.9
+ 1524000p 0.9
+ 1524010p -0.3
+ 1526000p -0.3
+ 1526010p 0.9
+ 1528000p 0.9
+ 1528010p -0.3
+ 1530000p -0.3
+ 1530010p 0.9
+ 1532000p 0.9
+ 1532010p -0.3
+ 1534000p -0.3
+ 1534010p 0.9
+ 1536000p 0.9
+ 1536010p -0.3
+ 1538000p -0.3
+ 1538010p 0.9
+ 1540000p 0.9
+ 1540010p -0.3
+ 1542000p -0.3
+ 1542010p 0.9
+ 1544000p 0.9
+ 1544010p -0.3
+ 1546000p -0.3
+ 1546010p 0.9
+ 1548000p 0.9
+ 1548010p -0.3
+ 1550000p -0.3
+ 1550010p 0.9
+ 1552000p 0.9
+ 1552010p -0.3
+ 1554000p -0.3
+ 1554010p 0.9
+ 1556000p 0.9
+ 1556010p -0.3
+ 1558000p -0.3
+ 1558010p 0.9
+ 1560000p 0.9
+ 1560010p -0.3
+ 1562000p -0.3
+ 1562010p 0.9
+ 1564000p 0.9
+ 1564010p -0.3
+ 1566000p -0.3
+ 1566010p 0.9
+ 1568000p 0.9
+ 1568010p -0.3
+ 1570000p -0.3
+ 1570010p 0.9
+ 1572000p 0.9
+ 1572010p -0.3
+ 1574000p -0.3
+ 1574010p 0.9
+ 1576000p 0.9
+ 1576010p -0.3
+ 1578000p -0.3
+ 1578010p 0.9
+ 1580000p 0.9
+ 1580010p -0.3
+ 1582000p -0.3
+ 1582010p 0.9
+ 1584000p 0.9
+ 1584010p -0.3
+ 1586000p -0.3
+ 1586010p 0.9
+ 1588000p 0.9
+ 1588010p -0.3
+ 1590000p -0.3
+ 1590010p 0.9
+ 1592000p 0.9
+ 1592010p -0.3
+ 1594000p -0.3
+ 1594010p 0.9
+ 1596000p 0.9
+ 1596010p -0.3
+ 1598000p -0.3
+ 1598010p 0.9
+ 1600000p 0.9
+ 1600010p -0.3
+ 1602000p -0.3
+ 1602010p 0.9
+ 1604000p 0.9
+ 1604010p -0.3
+ 1606000p -0.3
+ 1606010p 0.9
+ 1608000p 0.9
+ 1608010p -0.3
+ 1610000p -0.3
+ 1610010p 0.9
+ 1612000p 0.9
+ 1612010p -0.3
+ 1614000p -0.3
+ 1614010p 0.9
+ 1616000p 0.9
+ 1616010p -0.3
+ 1618000p -0.3
+ 1618010p 0.9
+ 1620000p 0.9
+ 1620010p -0.3
+ 1622000p -0.3
+ 1622010p 0.9
+ 1624000p 0.9
+ 1624010p -0.3
+ 1626000p -0.3
+ 1626010p 0.9
+ 1628000p 0.9
+ 1628010p -0.3
+ 1630000p -0.3
+ 1630010p 0.9
+ 1632000p 0.9
+ 1632010p -0.3
+ 1634000p -0.3
+ 1634010p 0.9
+ 1636000p 0.9
+ 1636010p -0.3
+ 1638000p -0.3
+ 1638010p 0.9
+ 1640000p 0.9
+ 1640010p -0.3
+ 1642000p -0.3
+ 1642010p 0.9
+ 1644000p 0.9
+ 1644010p -0.3
+ 1646000p -0.3
+ 1646010p 0.9
+ 1648000p 0.9
+ 1648010p -0.3
+ 1650000p -0.3
+ 1650010p 0.9
+ 1652000p 0.9
+ 1652010p -0.3
+ 1654000p -0.3
+ 1654010p 0.9
+ 1656000p 0.9
+ 1656010p -0.3
+ 1658000p -0.3
+ 1658010p 0.9
+ 1660000p 0.9
+ 1660010p -0.3
+ 1662000p -0.3
+ 1662010p 0.9
+ 1664000p 0.9
+ 1664010p -0.3
+ 1666000p -0.3
+ 1666010p 0.9
+ 1668000p 0.9
+ 1668010p -0.3
+ 1670000p -0.3
+ 1670010p 0.9
+ 1672000p 0.9
+ 1672010p -0.3
+ 1674000p -0.3
+ 1674010p 0.9
+ 1676000p 0.9
+ 1676010p -0.3
+ 1678000p -0.3
+ 1678010p 0.9
+ 1680000p 0.9
+ 1680010p -0.3
+ 1682000p -0.3
+ 1682010p 0.9
+ 1684000p 0.9
+ 1684010p -0.3
+ 1686000p -0.3
+ 1686010p 0.9
+ 1688000p 0.9
+ 1688010p -0.3
+ 1690000p -0.3
+ 1690010p 0.9
+ 1692000p 0.9
+ 1692010p -0.3
+ 1694000p -0.3
+ 1694010p 0.9
+ 1696000p 0.9
+ 1696010p -0.3
+ 1698000p -0.3
+ 1698010p 0.9
+ 1700000p 0.9
+ 1700010p -0.3
+ 1702000p -0.3
+ 1702010p 0.9
+ 1704000p 0.9
+ 1704010p -0.3
+ 1706000p -0.3
+ 1706010p 0.9
+ 1708000p 0.9
+ 1708010p -0.3
+ 1710000p -0.3
+ 1710010p 0.9
+ 1712000p 0.9
+ 1712010p -0.3
+ 1714000p -0.3
+ 1714010p 0.9
+ 1716000p 0.9
+ 1716010p -0.3
+ 1718000p -0.3
+ 1718010p 0.9
+ 1720000p 0.9
+ 1720010p -0.3
+ 1722000p -0.3
+ 1722010p 0.9
+ 1724000p 0.9
+ 1724010p -0.3
+ 1726000p -0.3
+ 1726010p 0.9
+ 1728000p 0.9
+ 1728010p -0.3
+ 1730000p -0.3
+ 1730010p 0.9
+ 1732000p 0.9
+ 1732010p -0.3
+ 1734000p -0.3
+ 1734010p 0.9
+ 1736000p 0.9
+ 1736010p -0.3
+ 1738000p -0.3
+ 1738010p 0.9
+ 1740000p 0.9
+ 1740010p -0.3
+ 1742000p -0.3
+ 1742010p 0.9
+ 1744000p 0.9
+ 1744010p -0.3
+ 1746000p -0.3
+ 1746010p 0.9
+ 1748000p 0.9
+ 1748010p -0.3
+ 1750000p -0.3
+ 1750010p 0.9
+ 1752000p 0.9
+ 1752010p -0.3
+ 1754000p -0.3
+ 1754010p 0.9
+ 1756000p 0.9
+ 1756010p -0.3
+ 1758000p -0.3
+ 1758010p 0.9
+ 1760000p 0.9
+ 1760010p -0.3
+ 1762000p -0.3
+ 1762010p 0.9
+ 1764000p 0.9
+ 1764010p -0.3
+ 1766000p -0.3
+ 1766010p 0.9
+ 1768000p 0.9
+ 1768010p -0.3
+ 1770000p -0.3
+ 1770010p 0.9
+ 1772000p 0.9
+ 1772010p -0.3
+ 1774000p -0.3
+ 1774010p 0.9
+ 1776000p 0.9
+ 1776010p -0.3
+ 1778000p -0.3
+ 1778010p 0.9
+ 1780000p 0.9
+ 1780010p -0.3
+ 1782000p -0.3
+ 1782010p 0.9
+ 1784000p 0.9
+ 1784010p -0.3
+ 1786000p -0.3
+ 1786010p 0.9
+ 1788000p 0.9
+ 1788010p -0.3
+ 1790000p -0.3
+ 1790010p 0.9
+ 1792000p 0.9
+ 1792010p -0.3
+ 1794000p -0.3
+ 1794010p 0.9
+ 1796000p 0.9
+ 1796010p -0.3
+ 1798000p -0.3
+ 1798010p 0.9
+ 1800000p 0.9
+ 1800010p -0.3
+ 1802000p -0.3
+ 1802010p 0.9
+ 1804000p 0.9
+ 1804010p -0.3
+ 1806000p -0.3
+ 1806010p 0.9
+ 1808000p 0.9
+ 1808010p -0.3
+ 1810000p -0.3
+ 1810010p 0.9
+ 1812000p 0.9
+ 1812010p -0.3
+ 1814000p -0.3
+ 1814010p 0.9
+ 1816000p 0.9
+ 1816010p -0.3
+ 1818000p -0.3
+ 1818010p 0.9
+ 1820000p 0.9
+ 1820010p -0.3
+ 1822000p -0.3
+ 1822010p 0.9
+ 1824000p 0.9
+ 1824010p -0.3
+ 1826000p -0.3
+ 1826010p 0.9
+ 1828000p 0.9
+ 1828010p -0.3
+ 1830000p -0.3
+ 1830010p 0.9
+ 1832000p 0.9
+ 1832010p -0.3
+ 1834000p -0.3
+ 1834010p 0.9
+ 1836000p 0.9
+ 1836010p -0.3
+ 1838000p -0.3
+ 1838010p 0.9
+ 1840000p 0.9
+ 1840010p -0.3
+ 1842000p -0.3
+ 1842010p 0.9
+ 1844000p 0.9
+ 1844010p -0.3
+ 1846000p -0.3
+ 1846010p 0.9
+ 1848000p 0.9
+ 1848010p -0.3
+ 1850000p -0.3
+ 1850010p 0.9
+ 1852000p 0.9
+ 1852010p -0.3
+ 1854000p -0.3
+ 1854010p 0.9
+ 1856000p 0.9
+ 1856010p -0.3
+ 1858000p -0.3
+ 1858010p 0.9
+ 1860000p 0.9
+ 1860010p -0.3
+ 1862000p -0.3
+ 1862010p 0.9
+ 1864000p 0.9
+ 1864010p -0.3
+ 1866000p -0.3
+ 1866010p 0.9
+ 1868000p 0.9
+ 1868010p -0.3
+ 1870000p -0.3
+ 1870010p 0.9
+ 1872000p 0.9
+ 1872010p -0.3
+ 1874000p -0.3
+ 1874010p 0.9
+ 1876000p 0.9
+ 1876010p -0.3
+ 1878000p -0.3
+ 1878010p 0.9
+ 1880000p 0.9
+ 1880010p -0.3
+ 1882000p -0.3
+ 1882010p 0.9
+ 1884000p 0.9
+ 1884010p -0.3
+ 1886000p -0.3
+ 1886010p 0.9
+ 1888000p 0.9
+ 1888010p -0.3
+ 1890000p -0.3
+ 1890010p 0.9
+ 1892000p 0.9
+ 1892010p -0.3
+ 1894000p -0.3
+ 1894010p 0.9
+ 1896000p 0.9
+ 1896010p -0.3
+ 1898000p -0.3
+ 1898010p 0.9
+ 1900000p 0.9
+ 1900010p -0.3
+ 1902000p -0.3
+ 1902010p 0.9
+ 1904000p 0.9
+ 1904010p -0.3
+ 1906000p -0.3
+ 1906010p 0.9
+ 1908000p 0.9
+ 1908010p -0.3
+ 1910000p -0.3
+ 1910010p 0.9
+ 1912000p 0.9
+ 1912010p -0.3
+ 1914000p -0.3
+ 1914010p 0.9
+ 1916000p 0.9
+ 1916010p -0.3
+ 1918000p -0.3
+ 1918010p 0.9
+ 1920000p 0.9
+ 1920010p -0.3
+ 1922000p -0.3
+ 1922010p 0.9
+ 1924000p 0.9
+ 1924010p -0.3
+ 1926000p -0.3
+ 1926010p 0.9
+ 1928000p 0.9
+ 1928010p -0.3
+ 1930000p -0.3
+ 1930010p 0.9
+ 1932000p 0.9
+ 1932010p -0.3
+ 1934000p -0.3
+ 1934010p 0.9
+ 1936000p 0.9
+ 1936010p -0.3
+ 1938000p -0.3
+ 1938010p 0.9
+ 1940000p 0.9
+ 1940010p -0.3
+ 1942000p -0.3
+ 1942010p 0.9
+ 1944000p 0.9
+ 1944010p -0.3
+ 1946000p -0.3
+ 1946010p 0.9
+ 1948000p 0.9
+ 1948010p -0.3
+ 1950000p -0.3
+ 1950010p 0.9
+ 1952000p 0.9
+ 1952010p -0.3
+ 1954000p -0.3
+ 1954010p 0.9
+ 1956000p 0.9
+ 1956010p -0.3
+ 1958000p -0.3
+ 1958010p 0.9
+ 1960000p 0.9
+ 1960010p -0.3
+ 1962000p -0.3
+ 1962010p 0.9
+ 1964000p 0.9
+ 1964010p -0.3
+ 1966000p -0.3
+ 1966010p 0.9
+ 1968000p 0.9
+ 1968010p -0.3
+ 1970000p -0.3
+ 1970010p 0.9
+ 1972000p 0.9
+ 1972010p -0.3
+ 1974000p -0.3
+ 1974010p 0.9
+ 1976000p 0.9
+ 1976010p -0.3
+ 1978000p -0.3
+ 1978010p 0.9
+ 1980000p 0.9
+ 1980010p -0.3
+ 1982000p -0.3
+ 1982010p 0.9
+ 1984000p 0.9
+ 1984010p -0.3
+ 1986000p -0.3
+ 1986010p 0.9
+ 1988000p 0.9
+ 1988010p -0.3
+ 1990000p -0.3
+ 1990010p 0.9
+ 1992000p 0.9
+ 1992010p -0.3
+ 1994000p -0.3
+ 1994010p 0.9
+ 1996000p 0.9
+ 1996010p -0.3
+ 1998000p -0.3
+ 1998010p 0.9
+ 2000000p 0.9
+ 2000010p -0.3
+ 2002000p -0.3
+ 2002010p 0.9
+ 2004000p 0.9
+ 2004010p -0.3
+ 2006000p -0.3
+ 2006010p 0.9
+ 2008000p 0.9
+ 2008010p -0.3
+ 2010000p -0.3
+ 2010010p 0.9
+ 2012000p 0.9
+ 2012010p -0.3
+ 2014000p -0.3
+ 2014010p 0.9
+ 2016000p 0.9
+ 2016010p -0.3
+ 2018000p -0.3
+ 2018010p 0.9
+ 2020000p 0.9
+ 2020010p -0.3
+ 2022000p -0.3
+ 2022010p 0.9
+ 2024000p 0.9
+ 2024010p -0.3
+ 2026000p -0.3
+ 2026010p 0.9
+ 2028000p 0.9
+ 2028010p -0.3
+ 2030000p -0.3
+ 2030010p 0.9
+ 2032000p 0.9
+ 2032010p -0.3
+ 2034000p -0.3
+ 2034010p 0.9
+ 2036000p 0.9
+ 2036010p -0.3
+ 2038000p -0.3
+ 2038010p 0.9
+ 2040000p 0.9
+ 2040010p -0.3
+ 2042000p -0.3
+ 2042010p 0.9
+ 2044000p 0.9
+ 2044010p -0.3
+ 2046000p -0.3
+ 2046010p 0.9
+ 2048000p 0.9
+ 2048010p -0.3
+ \]
V_data_8 (Data\\<8\\> gnd!) vsource type=pwl wave=\[
+ 0    0.9
+ 2000p 0.9
+ 2010p -0.3
+ 4000p -0.3
+ 4010p 0.9
+ 6000p 0.9
+ 6010p -0.3
+ 8000p -0.3
+ 8010p 0.9
+ 10000p 0.9
+ 10010p -0.3
+ 12000p -0.3
+ 12010p 0.9
+ 14000p 0.9
+ 14010p -0.3
+ 16000p -0.3
+ 16010p 0.9
+ 18000p 0.9
+ 18010p -0.3
+ 20000p -0.3
+ 20010p 0.9
+ 22000p 0.9
+ 22010p -0.3
+ 24000p -0.3
+ 24010p 0.9
+ 26000p 0.9
+ 26010p -0.3
+ 28000p -0.3
+ 28010p 0.9
+ 30000p 0.9
+ 30010p -0.3
+ 32000p -0.3
+ 32010p 0.9
+ 34000p 0.9
+ 34010p -0.3
+ 36000p -0.3
+ 36010p 0.9
+ 38000p 0.9
+ 38010p -0.3
+ 40000p -0.3
+ 40010p 0.9
+ 42000p 0.9
+ 42010p -0.3
+ 44000p -0.3
+ 44010p 0.9
+ 46000p 0.9
+ 46010p -0.3
+ 48000p -0.3
+ 48010p 0.9
+ 50000p 0.9
+ 50010p -0.3
+ 52000p -0.3
+ 52010p 0.9
+ 54000p 0.9
+ 54010p -0.3
+ 56000p -0.3
+ 56010p 0.9
+ 58000p 0.9
+ 58010p -0.3
+ 60000p -0.3
+ 60010p 0.9
+ 62000p 0.9
+ 62010p -0.3
+ 64000p -0.3
+ 64010p 0.9
+ 66000p 0.9
+ 66010p -0.3
+ 68000p -0.3
+ 68010p 0.9
+ 70000p 0.9
+ 70010p -0.3
+ 72000p -0.3
+ 72010p 0.9
+ 74000p 0.9
+ 74010p -0.3
+ 76000p -0.3
+ 76010p 0.9
+ 78000p 0.9
+ 78010p -0.3
+ 80000p -0.3
+ 80010p 0.9
+ 82000p 0.9
+ 82010p -0.3
+ 84000p -0.3
+ 84010p 0.9
+ 86000p 0.9
+ 86010p -0.3
+ 88000p -0.3
+ 88010p 0.9
+ 90000p 0.9
+ 90010p -0.3
+ 92000p -0.3
+ 92010p 0.9
+ 94000p 0.9
+ 94010p -0.3
+ 96000p -0.3
+ 96010p 0.9
+ 98000p 0.9
+ 98010p -0.3
+ 100000p -0.3
+ 100010p 0.9
+ 102000p 0.9
+ 102010p -0.3
+ 104000p -0.3
+ 104010p 0.9
+ 106000p 0.9
+ 106010p -0.3
+ 108000p -0.3
+ 108010p 0.9
+ 110000p 0.9
+ 110010p -0.3
+ 112000p -0.3
+ 112010p 0.9
+ 114000p 0.9
+ 114010p -0.3
+ 116000p -0.3
+ 116010p 0.9
+ 118000p 0.9
+ 118010p -0.3
+ 120000p -0.3
+ 120010p 0.9
+ 122000p 0.9
+ 122010p -0.3
+ 124000p -0.3
+ 124010p 0.9
+ 126000p 0.9
+ 126010p -0.3
+ 128000p -0.3
+ 128010p 0.9
+ 130000p 0.9
+ 130010p -0.3
+ 132000p -0.3
+ 132010p 0.9
+ 134000p 0.9
+ 134010p -0.3
+ 136000p -0.3
+ 136010p 0.9
+ 138000p 0.9
+ 138010p -0.3
+ 140000p -0.3
+ 140010p 0.9
+ 142000p 0.9
+ 142010p -0.3
+ 144000p -0.3
+ 144010p 0.9
+ 146000p 0.9
+ 146010p -0.3
+ 148000p -0.3
+ 148010p 0.9
+ 150000p 0.9
+ 150010p -0.3
+ 152000p -0.3
+ 152010p 0.9
+ 154000p 0.9
+ 154010p -0.3
+ 156000p -0.3
+ 156010p 0.9
+ 158000p 0.9
+ 158010p -0.3
+ 160000p -0.3
+ 160010p 0.9
+ 162000p 0.9
+ 162010p -0.3
+ 164000p -0.3
+ 164010p 0.9
+ 166000p 0.9
+ 166010p -0.3
+ 168000p -0.3
+ 168010p 0.9
+ 170000p 0.9
+ 170010p -0.3
+ 172000p -0.3
+ 172010p 0.9
+ 174000p 0.9
+ 174010p -0.3
+ 176000p -0.3
+ 176010p 0.9
+ 178000p 0.9
+ 178010p -0.3
+ 180000p -0.3
+ 180010p 0.9
+ 182000p 0.9
+ 182010p -0.3
+ 184000p -0.3
+ 184010p 0.9
+ 186000p 0.9
+ 186010p -0.3
+ 188000p -0.3
+ 188010p 0.9
+ 190000p 0.9
+ 190010p -0.3
+ 192000p -0.3
+ 192010p 0.9
+ 194000p 0.9
+ 194010p -0.3
+ 196000p -0.3
+ 196010p 0.9
+ 198000p 0.9
+ 198010p -0.3
+ 200000p -0.3
+ 200010p 0.9
+ 202000p 0.9
+ 202010p -0.3
+ 204000p -0.3
+ 204010p 0.9
+ 206000p 0.9
+ 206010p -0.3
+ 208000p -0.3
+ 208010p 0.9
+ 210000p 0.9
+ 210010p -0.3
+ 212000p -0.3
+ 212010p 0.9
+ 214000p 0.9
+ 214010p -0.3
+ 216000p -0.3
+ 216010p 0.9
+ 218000p 0.9
+ 218010p -0.3
+ 220000p -0.3
+ 220010p 0.9
+ 222000p 0.9
+ 222010p -0.3
+ 224000p -0.3
+ 224010p 0.9
+ 226000p 0.9
+ 226010p -0.3
+ 228000p -0.3
+ 228010p 0.9
+ 230000p 0.9
+ 230010p -0.3
+ 232000p -0.3
+ 232010p 0.9
+ 234000p 0.9
+ 234010p -0.3
+ 236000p -0.3
+ 236010p 0.9
+ 238000p 0.9
+ 238010p -0.3
+ 240000p -0.3
+ 240010p 0.9
+ 242000p 0.9
+ 242010p -0.3
+ 244000p -0.3
+ 244010p 0.9
+ 246000p 0.9
+ 246010p -0.3
+ 248000p -0.3
+ 248010p 0.9
+ 250000p 0.9
+ 250010p -0.3
+ 252000p -0.3
+ 252010p 0.9
+ 254000p 0.9
+ 254010p -0.3
+ 256000p -0.3
+ 256010p 0.9
+ 258000p 0.9
+ 258010p -0.3
+ 260000p -0.3
+ 260010p 0.9
+ 262000p 0.9
+ 262010p -0.3
+ 264000p -0.3
+ 264010p 0.9
+ 266000p 0.9
+ 266010p -0.3
+ 268000p -0.3
+ 268010p 0.9
+ 270000p 0.9
+ 270010p -0.3
+ 272000p -0.3
+ 272010p 0.9
+ 274000p 0.9
+ 274010p -0.3
+ 276000p -0.3
+ 276010p 0.9
+ 278000p 0.9
+ 278010p -0.3
+ 280000p -0.3
+ 280010p 0.9
+ 282000p 0.9
+ 282010p -0.3
+ 284000p -0.3
+ 284010p 0.9
+ 286000p 0.9
+ 286010p -0.3
+ 288000p -0.3
+ 288010p 0.9
+ 290000p 0.9
+ 290010p -0.3
+ 292000p -0.3
+ 292010p 0.9
+ 294000p 0.9
+ 294010p -0.3
+ 296000p -0.3
+ 296010p 0.9
+ 298000p 0.9
+ 298010p -0.3
+ 300000p -0.3
+ 300010p 0.9
+ 302000p 0.9
+ 302010p -0.3
+ 304000p -0.3
+ 304010p 0.9
+ 306000p 0.9
+ 306010p -0.3
+ 308000p -0.3
+ 308010p 0.9
+ 310000p 0.9
+ 310010p -0.3
+ 312000p -0.3
+ 312010p 0.9
+ 314000p 0.9
+ 314010p -0.3
+ 316000p -0.3
+ 316010p 0.9
+ 318000p 0.9
+ 318010p -0.3
+ 320000p -0.3
+ 320010p 0.9
+ 322000p 0.9
+ 322010p -0.3
+ 324000p -0.3
+ 324010p 0.9
+ 326000p 0.9
+ 326010p -0.3
+ 328000p -0.3
+ 328010p 0.9
+ 330000p 0.9
+ 330010p -0.3
+ 332000p -0.3
+ 332010p 0.9
+ 334000p 0.9
+ 334010p -0.3
+ 336000p -0.3
+ 336010p 0.9
+ 338000p 0.9
+ 338010p -0.3
+ 340000p -0.3
+ 340010p 0.9
+ 342000p 0.9
+ 342010p -0.3
+ 344000p -0.3
+ 344010p 0.9
+ 346000p 0.9
+ 346010p -0.3
+ 348000p -0.3
+ 348010p 0.9
+ 350000p 0.9
+ 350010p -0.3
+ 352000p -0.3
+ 352010p 0.9
+ 354000p 0.9
+ 354010p -0.3
+ 356000p -0.3
+ 356010p 0.9
+ 358000p 0.9
+ 358010p -0.3
+ 360000p -0.3
+ 360010p 0.9
+ 362000p 0.9
+ 362010p -0.3
+ 364000p -0.3
+ 364010p 0.9
+ 366000p 0.9
+ 366010p -0.3
+ 368000p -0.3
+ 368010p 0.9
+ 370000p 0.9
+ 370010p -0.3
+ 372000p -0.3
+ 372010p 0.9
+ 374000p 0.9
+ 374010p -0.3
+ 376000p -0.3
+ 376010p 0.9
+ 378000p 0.9
+ 378010p -0.3
+ 380000p -0.3
+ 380010p 0.9
+ 382000p 0.9
+ 382010p -0.3
+ 384000p -0.3
+ 384010p 0.9
+ 386000p 0.9
+ 386010p -0.3
+ 388000p -0.3
+ 388010p 0.9
+ 390000p 0.9
+ 390010p -0.3
+ 392000p -0.3
+ 392010p 0.9
+ 394000p 0.9
+ 394010p -0.3
+ 396000p -0.3
+ 396010p 0.9
+ 398000p 0.9
+ 398010p -0.3
+ 400000p -0.3
+ 400010p 0.9
+ 402000p 0.9
+ 402010p -0.3
+ 404000p -0.3
+ 404010p 0.9
+ 406000p 0.9
+ 406010p -0.3
+ 408000p -0.3
+ 408010p 0.9
+ 410000p 0.9
+ 410010p -0.3
+ 412000p -0.3
+ 412010p 0.9
+ 414000p 0.9
+ 414010p -0.3
+ 416000p -0.3
+ 416010p 0.9
+ 418000p 0.9
+ 418010p -0.3
+ 420000p -0.3
+ 420010p 0.9
+ 422000p 0.9
+ 422010p -0.3
+ 424000p -0.3
+ 424010p 0.9
+ 426000p 0.9
+ 426010p -0.3
+ 428000p -0.3
+ 428010p 0.9
+ 430000p 0.9
+ 430010p -0.3
+ 432000p -0.3
+ 432010p 0.9
+ 434000p 0.9
+ 434010p -0.3
+ 436000p -0.3
+ 436010p 0.9
+ 438000p 0.9
+ 438010p -0.3
+ 440000p -0.3
+ 440010p 0.9
+ 442000p 0.9
+ 442010p -0.3
+ 444000p -0.3
+ 444010p 0.9
+ 446000p 0.9
+ 446010p -0.3
+ 448000p -0.3
+ 448010p 0.9
+ 450000p 0.9
+ 450010p -0.3
+ 452000p -0.3
+ 452010p 0.9
+ 454000p 0.9
+ 454010p -0.3
+ 456000p -0.3
+ 456010p 0.9
+ 458000p 0.9
+ 458010p -0.3
+ 460000p -0.3
+ 460010p 0.9
+ 462000p 0.9
+ 462010p -0.3
+ 464000p -0.3
+ 464010p 0.9
+ 466000p 0.9
+ 466010p -0.3
+ 468000p -0.3
+ 468010p 0.9
+ 470000p 0.9
+ 470010p -0.3
+ 472000p -0.3
+ 472010p 0.9
+ 474000p 0.9
+ 474010p -0.3
+ 476000p -0.3
+ 476010p 0.9
+ 478000p 0.9
+ 478010p -0.3
+ 480000p -0.3
+ 480010p 0.9
+ 482000p 0.9
+ 482010p -0.3
+ 484000p -0.3
+ 484010p 0.9
+ 486000p 0.9
+ 486010p -0.3
+ 488000p -0.3
+ 488010p 0.9
+ 490000p 0.9
+ 490010p -0.3
+ 492000p -0.3
+ 492010p 0.9
+ 494000p 0.9
+ 494010p -0.3
+ 496000p -0.3
+ 496010p 0.9
+ 498000p 0.9
+ 498010p -0.3
+ 500000p -0.3
+ 500010p 0.9
+ 502000p 0.9
+ 502010p -0.3
+ 504000p -0.3
+ 504010p 0.9
+ 506000p 0.9
+ 506010p -0.3
+ 508000p -0.3
+ 508010p 0.9
+ 510000p 0.9
+ 510010p -0.3
+ 512000p -0.3
+ 512010p 0.9
+ 514000p 0.9
+ 514010p -0.3
+ 516000p -0.3
+ 516010p 0.9
+ 518000p 0.9
+ 518010p -0.3
+ 520000p -0.3
+ 520010p 0.9
+ 522000p 0.9
+ 522010p -0.3
+ 524000p -0.3
+ 524010p 0.9
+ 526000p 0.9
+ 526010p -0.3
+ 528000p -0.3
+ 528010p 0.9
+ 530000p 0.9
+ 530010p -0.3
+ 532000p -0.3
+ 532010p 0.9
+ 534000p 0.9
+ 534010p -0.3
+ 536000p -0.3
+ 536010p 0.9
+ 538000p 0.9
+ 538010p -0.3
+ 540000p -0.3
+ 540010p 0.9
+ 542000p 0.9
+ 542010p -0.3
+ 544000p -0.3
+ 544010p 0.9
+ 546000p 0.9
+ 546010p -0.3
+ 548000p -0.3
+ 548010p 0.9
+ 550000p 0.9
+ 550010p -0.3
+ 552000p -0.3
+ 552010p 0.9
+ 554000p 0.9
+ 554010p -0.3
+ 556000p -0.3
+ 556010p 0.9
+ 558000p 0.9
+ 558010p -0.3
+ 560000p -0.3
+ 560010p 0.9
+ 562000p 0.9
+ 562010p -0.3
+ 564000p -0.3
+ 564010p 0.9
+ 566000p 0.9
+ 566010p -0.3
+ 568000p -0.3
+ 568010p 0.9
+ 570000p 0.9
+ 570010p -0.3
+ 572000p -0.3
+ 572010p 0.9
+ 574000p 0.9
+ 574010p -0.3
+ 576000p -0.3
+ 576010p 0.9
+ 578000p 0.9
+ 578010p -0.3
+ 580000p -0.3
+ 580010p 0.9
+ 582000p 0.9
+ 582010p -0.3
+ 584000p -0.3
+ 584010p 0.9
+ 586000p 0.9
+ 586010p -0.3
+ 588000p -0.3
+ 588010p 0.9
+ 590000p 0.9
+ 590010p -0.3
+ 592000p -0.3
+ 592010p 0.9
+ 594000p 0.9
+ 594010p -0.3
+ 596000p -0.3
+ 596010p 0.9
+ 598000p 0.9
+ 598010p -0.3
+ 600000p -0.3
+ 600010p 0.9
+ 602000p 0.9
+ 602010p -0.3
+ 604000p -0.3
+ 604010p 0.9
+ 606000p 0.9
+ 606010p -0.3
+ 608000p -0.3
+ 608010p 0.9
+ 610000p 0.9
+ 610010p -0.3
+ 612000p -0.3
+ 612010p 0.9
+ 614000p 0.9
+ 614010p -0.3
+ 616000p -0.3
+ 616010p 0.9
+ 618000p 0.9
+ 618010p -0.3
+ 620000p -0.3
+ 620010p 0.9
+ 622000p 0.9
+ 622010p -0.3
+ 624000p -0.3
+ 624010p 0.9
+ 626000p 0.9
+ 626010p -0.3
+ 628000p -0.3
+ 628010p 0.9
+ 630000p 0.9
+ 630010p -0.3
+ 632000p -0.3
+ 632010p 0.9
+ 634000p 0.9
+ 634010p -0.3
+ 636000p -0.3
+ 636010p 0.9
+ 638000p 0.9
+ 638010p -0.3
+ 640000p -0.3
+ 640010p 0.9
+ 642000p 0.9
+ 642010p -0.3
+ 644000p -0.3
+ 644010p 0.9
+ 646000p 0.9
+ 646010p -0.3
+ 648000p -0.3
+ 648010p 0.9
+ 650000p 0.9
+ 650010p -0.3
+ 652000p -0.3
+ 652010p 0.9
+ 654000p 0.9
+ 654010p -0.3
+ 656000p -0.3
+ 656010p 0.9
+ 658000p 0.9
+ 658010p -0.3
+ 660000p -0.3
+ 660010p 0.9
+ 662000p 0.9
+ 662010p -0.3
+ 664000p -0.3
+ 664010p 0.9
+ 666000p 0.9
+ 666010p -0.3
+ 668000p -0.3
+ 668010p 0.9
+ 670000p 0.9
+ 670010p -0.3
+ 672000p -0.3
+ 672010p 0.9
+ 674000p 0.9
+ 674010p -0.3
+ 676000p -0.3
+ 676010p 0.9
+ 678000p 0.9
+ 678010p -0.3
+ 680000p -0.3
+ 680010p 0.9
+ 682000p 0.9
+ 682010p -0.3
+ 684000p -0.3
+ 684010p 0.9
+ 686000p 0.9
+ 686010p -0.3
+ 688000p -0.3
+ 688010p 0.9
+ 690000p 0.9
+ 690010p -0.3
+ 692000p -0.3
+ 692010p 0.9
+ 694000p 0.9
+ 694010p -0.3
+ 696000p -0.3
+ 696010p 0.9
+ 698000p 0.9
+ 698010p -0.3
+ 700000p -0.3
+ 700010p 0.9
+ 702000p 0.9
+ 702010p -0.3
+ 704000p -0.3
+ 704010p 0.9
+ 706000p 0.9
+ 706010p -0.3
+ 708000p -0.3
+ 708010p 0.9
+ 710000p 0.9
+ 710010p -0.3
+ 712000p -0.3
+ 712010p 0.9
+ 714000p 0.9
+ 714010p -0.3
+ 716000p -0.3
+ 716010p 0.9
+ 718000p 0.9
+ 718010p -0.3
+ 720000p -0.3
+ 720010p 0.9
+ 722000p 0.9
+ 722010p -0.3
+ 724000p -0.3
+ 724010p 0.9
+ 726000p 0.9
+ 726010p -0.3
+ 728000p -0.3
+ 728010p 0.9
+ 730000p 0.9
+ 730010p -0.3
+ 732000p -0.3
+ 732010p 0.9
+ 734000p 0.9
+ 734010p -0.3
+ 736000p -0.3
+ 736010p 0.9
+ 738000p 0.9
+ 738010p -0.3
+ 740000p -0.3
+ 740010p 0.9
+ 742000p 0.9
+ 742010p -0.3
+ 744000p -0.3
+ 744010p 0.9
+ 746000p 0.9
+ 746010p -0.3
+ 748000p -0.3
+ 748010p 0.9
+ 750000p 0.9
+ 750010p -0.3
+ 752000p -0.3
+ 752010p 0.9
+ 754000p 0.9
+ 754010p -0.3
+ 756000p -0.3
+ 756010p 0.9
+ 758000p 0.9
+ 758010p -0.3
+ 760000p -0.3
+ 760010p 0.9
+ 762000p 0.9
+ 762010p -0.3
+ 764000p -0.3
+ 764010p 0.9
+ 766000p 0.9
+ 766010p -0.3
+ 768000p -0.3
+ 768010p 0.9
+ 770000p 0.9
+ 770010p -0.3
+ 772000p -0.3
+ 772010p 0.9
+ 774000p 0.9
+ 774010p -0.3
+ 776000p -0.3
+ 776010p 0.9
+ 778000p 0.9
+ 778010p -0.3
+ 780000p -0.3
+ 780010p 0.9
+ 782000p 0.9
+ 782010p -0.3
+ 784000p -0.3
+ 784010p 0.9
+ 786000p 0.9
+ 786010p -0.3
+ 788000p -0.3
+ 788010p 0.9
+ 790000p 0.9
+ 790010p -0.3
+ 792000p -0.3
+ 792010p 0.9
+ 794000p 0.9
+ 794010p -0.3
+ 796000p -0.3
+ 796010p 0.9
+ 798000p 0.9
+ 798010p -0.3
+ 800000p -0.3
+ 800010p 0.9
+ 802000p 0.9
+ 802010p -0.3
+ 804000p -0.3
+ 804010p 0.9
+ 806000p 0.9
+ 806010p -0.3
+ 808000p -0.3
+ 808010p 0.9
+ 810000p 0.9
+ 810010p -0.3
+ 812000p -0.3
+ 812010p 0.9
+ 814000p 0.9
+ 814010p -0.3
+ 816000p -0.3
+ 816010p 0.9
+ 818000p 0.9
+ 818010p -0.3
+ 820000p -0.3
+ 820010p 0.9
+ 822000p 0.9
+ 822010p -0.3
+ 824000p -0.3
+ 824010p 0.9
+ 826000p 0.9
+ 826010p -0.3
+ 828000p -0.3
+ 828010p 0.9
+ 830000p 0.9
+ 830010p -0.3
+ 832000p -0.3
+ 832010p 0.9
+ 834000p 0.9
+ 834010p -0.3
+ 836000p -0.3
+ 836010p 0.9
+ 838000p 0.9
+ 838010p -0.3
+ 840000p -0.3
+ 840010p 0.9
+ 842000p 0.9
+ 842010p -0.3
+ 844000p -0.3
+ 844010p 0.9
+ 846000p 0.9
+ 846010p -0.3
+ 848000p -0.3
+ 848010p 0.9
+ 850000p 0.9
+ 850010p -0.3
+ 852000p -0.3
+ 852010p 0.9
+ 854000p 0.9
+ 854010p -0.3
+ 856000p -0.3
+ 856010p 0.9
+ 858000p 0.9
+ 858010p -0.3
+ 860000p -0.3
+ 860010p 0.9
+ 862000p 0.9
+ 862010p -0.3
+ 864000p -0.3
+ 864010p 0.9
+ 866000p 0.9
+ 866010p -0.3
+ 868000p -0.3
+ 868010p 0.9
+ 870000p 0.9
+ 870010p -0.3
+ 872000p -0.3
+ 872010p 0.9
+ 874000p 0.9
+ 874010p -0.3
+ 876000p -0.3
+ 876010p 0.9
+ 878000p 0.9
+ 878010p -0.3
+ 880000p -0.3
+ 880010p 0.9
+ 882000p 0.9
+ 882010p -0.3
+ 884000p -0.3
+ 884010p 0.9
+ 886000p 0.9
+ 886010p -0.3
+ 888000p -0.3
+ 888010p 0.9
+ 890000p 0.9
+ 890010p -0.3
+ 892000p -0.3
+ 892010p 0.9
+ 894000p 0.9
+ 894010p -0.3
+ 896000p -0.3
+ 896010p 0.9
+ 898000p 0.9
+ 898010p -0.3
+ 900000p -0.3
+ 900010p 0.9
+ 902000p 0.9
+ 902010p -0.3
+ 904000p -0.3
+ 904010p 0.9
+ 906000p 0.9
+ 906010p -0.3
+ 908000p -0.3
+ 908010p 0.9
+ 910000p 0.9
+ 910010p -0.3
+ 912000p -0.3
+ 912010p 0.9
+ 914000p 0.9
+ 914010p -0.3
+ 916000p -0.3
+ 916010p 0.9
+ 918000p 0.9
+ 918010p -0.3
+ 920000p -0.3
+ 920010p 0.9
+ 922000p 0.9
+ 922010p -0.3
+ 924000p -0.3
+ 924010p 0.9
+ 926000p 0.9
+ 926010p -0.3
+ 928000p -0.3
+ 928010p 0.9
+ 930000p 0.9
+ 930010p -0.3
+ 932000p -0.3
+ 932010p 0.9
+ 934000p 0.9
+ 934010p -0.3
+ 936000p -0.3
+ 936010p 0.9
+ 938000p 0.9
+ 938010p -0.3
+ 940000p -0.3
+ 940010p 0.9
+ 942000p 0.9
+ 942010p -0.3
+ 944000p -0.3
+ 944010p 0.9
+ 946000p 0.9
+ 946010p -0.3
+ 948000p -0.3
+ 948010p 0.9
+ 950000p 0.9
+ 950010p -0.3
+ 952000p -0.3
+ 952010p 0.9
+ 954000p 0.9
+ 954010p -0.3
+ 956000p -0.3
+ 956010p 0.9
+ 958000p 0.9
+ 958010p -0.3
+ 960000p -0.3
+ 960010p 0.9
+ 962000p 0.9
+ 962010p -0.3
+ 964000p -0.3
+ 964010p 0.9
+ 966000p 0.9
+ 966010p -0.3
+ 968000p -0.3
+ 968010p 0.9
+ 970000p 0.9
+ 970010p -0.3
+ 972000p -0.3
+ 972010p 0.9
+ 974000p 0.9
+ 974010p -0.3
+ 976000p -0.3
+ 976010p 0.9
+ 978000p 0.9
+ 978010p -0.3
+ 980000p -0.3
+ 980010p 0.9
+ 982000p 0.9
+ 982010p -0.3
+ 984000p -0.3
+ 984010p 0.9
+ 986000p 0.9
+ 986010p -0.3
+ 988000p -0.3
+ 988010p 0.9
+ 990000p 0.9
+ 990010p -0.3
+ 992000p -0.3
+ 992010p 0.9
+ 994000p 0.9
+ 994010p -0.3
+ 996000p -0.3
+ 996010p 0.9
+ 998000p 0.9
+ 998010p -0.3
+ 1000000p -0.3
+ 1000010p 0.9
+ 1002000p 0.9
+ 1002010p -0.3
+ 1004000p -0.3
+ 1004010p 0.9
+ 1006000p 0.9
+ 1006010p -0.3
+ 1008000p -0.3
+ 1008010p 0.9
+ 1010000p 0.9
+ 1010010p -0.3
+ 1012000p -0.3
+ 1012010p 0.9
+ 1014000p 0.9
+ 1014010p -0.3
+ 1016000p -0.3
+ 1016010p 0.9
+ 1018000p 0.9
+ 1018010p -0.3
+ 1020000p -0.3
+ 1020010p 0.9
+ 1022000p 0.9
+ 1022010p -0.3
+ 1024000p -0.3
+ 1024010p 0.9
+ 1026000p 0.9
+ 1026010p -0.3
+ 1028000p -0.3
+ 1028010p 0.9
+ 1030000p 0.9
+ 1030010p -0.3
+ 1032000p -0.3
+ 1032010p 0.9
+ 1034000p 0.9
+ 1034010p -0.3
+ 1036000p -0.3
+ 1036010p 0.9
+ 1038000p 0.9
+ 1038010p -0.3
+ 1040000p -0.3
+ 1040010p 0.9
+ 1042000p 0.9
+ 1042010p -0.3
+ 1044000p -0.3
+ 1044010p 0.9
+ 1046000p 0.9
+ 1046010p -0.3
+ 1048000p -0.3
+ 1048010p 0.9
+ 1050000p 0.9
+ 1050010p -0.3
+ 1052000p -0.3
+ 1052010p 0.9
+ 1054000p 0.9
+ 1054010p -0.3
+ 1056000p -0.3
+ 1056010p 0.9
+ 1058000p 0.9
+ 1058010p -0.3
+ 1060000p -0.3
+ 1060010p 0.9
+ 1062000p 0.9
+ 1062010p -0.3
+ 1064000p -0.3
+ 1064010p 0.9
+ 1066000p 0.9
+ 1066010p -0.3
+ 1068000p -0.3
+ 1068010p 0.9
+ 1070000p 0.9
+ 1070010p -0.3
+ 1072000p -0.3
+ 1072010p 0.9
+ 1074000p 0.9
+ 1074010p -0.3
+ 1076000p -0.3
+ 1076010p 0.9
+ 1078000p 0.9
+ 1078010p -0.3
+ 1080000p -0.3
+ 1080010p 0.9
+ 1082000p 0.9
+ 1082010p -0.3
+ 1084000p -0.3
+ 1084010p 0.9
+ 1086000p 0.9
+ 1086010p -0.3
+ 1088000p -0.3
+ 1088010p 0.9
+ 1090000p 0.9
+ 1090010p -0.3
+ 1092000p -0.3
+ 1092010p 0.9
+ 1094000p 0.9
+ 1094010p -0.3
+ 1096000p -0.3
+ 1096010p 0.9
+ 1098000p 0.9
+ 1098010p -0.3
+ 1100000p -0.3
+ 1100010p 0.9
+ 1102000p 0.9
+ 1102010p -0.3
+ 1104000p -0.3
+ 1104010p 0.9
+ 1106000p 0.9
+ 1106010p -0.3
+ 1108000p -0.3
+ 1108010p 0.9
+ 1110000p 0.9
+ 1110010p -0.3
+ 1112000p -0.3
+ 1112010p 0.9
+ 1114000p 0.9
+ 1114010p -0.3
+ 1116000p -0.3
+ 1116010p 0.9
+ 1118000p 0.9
+ 1118010p -0.3
+ 1120000p -0.3
+ 1120010p 0.9
+ 1122000p 0.9
+ 1122010p -0.3
+ 1124000p -0.3
+ 1124010p 0.9
+ 1126000p 0.9
+ 1126010p -0.3
+ 1128000p -0.3
+ 1128010p 0.9
+ 1130000p 0.9
+ 1130010p -0.3
+ 1132000p -0.3
+ 1132010p 0.9
+ 1134000p 0.9
+ 1134010p -0.3
+ 1136000p -0.3
+ 1136010p 0.9
+ 1138000p 0.9
+ 1138010p -0.3
+ 1140000p -0.3
+ 1140010p 0.9
+ 1142000p 0.9
+ 1142010p -0.3
+ 1144000p -0.3
+ 1144010p 0.9
+ 1146000p 0.9
+ 1146010p -0.3
+ 1148000p -0.3
+ 1148010p 0.9
+ 1150000p 0.9
+ 1150010p -0.3
+ 1152000p -0.3
+ 1152010p 0.9
+ 1154000p 0.9
+ 1154010p -0.3
+ 1156000p -0.3
+ 1156010p 0.9
+ 1158000p 0.9
+ 1158010p -0.3
+ 1160000p -0.3
+ 1160010p 0.9
+ 1162000p 0.9
+ 1162010p -0.3
+ 1164000p -0.3
+ 1164010p 0.9
+ 1166000p 0.9
+ 1166010p -0.3
+ 1168000p -0.3
+ 1168010p 0.9
+ 1170000p 0.9
+ 1170010p -0.3
+ 1172000p -0.3
+ 1172010p 0.9
+ 1174000p 0.9
+ 1174010p -0.3
+ 1176000p -0.3
+ 1176010p 0.9
+ 1178000p 0.9
+ 1178010p -0.3
+ 1180000p -0.3
+ 1180010p 0.9
+ 1182000p 0.9
+ 1182010p -0.3
+ 1184000p -0.3
+ 1184010p 0.9
+ 1186000p 0.9
+ 1186010p -0.3
+ 1188000p -0.3
+ 1188010p 0.9
+ 1190000p 0.9
+ 1190010p -0.3
+ 1192000p -0.3
+ 1192010p 0.9
+ 1194000p 0.9
+ 1194010p -0.3
+ 1196000p -0.3
+ 1196010p 0.9
+ 1198000p 0.9
+ 1198010p -0.3
+ 1200000p -0.3
+ 1200010p 0.9
+ 1202000p 0.9
+ 1202010p -0.3
+ 1204000p -0.3
+ 1204010p 0.9
+ 1206000p 0.9
+ 1206010p -0.3
+ 1208000p -0.3
+ 1208010p 0.9
+ 1210000p 0.9
+ 1210010p -0.3
+ 1212000p -0.3
+ 1212010p 0.9
+ 1214000p 0.9
+ 1214010p -0.3
+ 1216000p -0.3
+ 1216010p 0.9
+ 1218000p 0.9
+ 1218010p -0.3
+ 1220000p -0.3
+ 1220010p 0.9
+ 1222000p 0.9
+ 1222010p -0.3
+ 1224000p -0.3
+ 1224010p 0.9
+ 1226000p 0.9
+ 1226010p -0.3
+ 1228000p -0.3
+ 1228010p 0.9
+ 1230000p 0.9
+ 1230010p -0.3
+ 1232000p -0.3
+ 1232010p 0.9
+ 1234000p 0.9
+ 1234010p -0.3
+ 1236000p -0.3
+ 1236010p 0.9
+ 1238000p 0.9
+ 1238010p -0.3
+ 1240000p -0.3
+ 1240010p 0.9
+ 1242000p 0.9
+ 1242010p -0.3
+ 1244000p -0.3
+ 1244010p 0.9
+ 1246000p 0.9
+ 1246010p -0.3
+ 1248000p -0.3
+ 1248010p 0.9
+ 1250000p 0.9
+ 1250010p -0.3
+ 1252000p -0.3
+ 1252010p 0.9
+ 1254000p 0.9
+ 1254010p -0.3
+ 1256000p -0.3
+ 1256010p 0.9
+ 1258000p 0.9
+ 1258010p -0.3
+ 1260000p -0.3
+ 1260010p 0.9
+ 1262000p 0.9
+ 1262010p -0.3
+ 1264000p -0.3
+ 1264010p 0.9
+ 1266000p 0.9
+ 1266010p -0.3
+ 1268000p -0.3
+ 1268010p 0.9
+ 1270000p 0.9
+ 1270010p -0.3
+ 1272000p -0.3
+ 1272010p 0.9
+ 1274000p 0.9
+ 1274010p -0.3
+ 1276000p -0.3
+ 1276010p 0.9
+ 1278000p 0.9
+ 1278010p -0.3
+ 1280000p -0.3
+ 1280010p 0.9
+ 1282000p 0.9
+ 1282010p -0.3
+ 1284000p -0.3
+ 1284010p 0.9
+ 1286000p 0.9
+ 1286010p -0.3
+ 1288000p -0.3
+ 1288010p 0.9
+ 1290000p 0.9
+ 1290010p -0.3
+ 1292000p -0.3
+ 1292010p 0.9
+ 1294000p 0.9
+ 1294010p -0.3
+ 1296000p -0.3
+ 1296010p 0.9
+ 1298000p 0.9
+ 1298010p -0.3
+ 1300000p -0.3
+ 1300010p 0.9
+ 1302000p 0.9
+ 1302010p -0.3
+ 1304000p -0.3
+ 1304010p 0.9
+ 1306000p 0.9
+ 1306010p -0.3
+ 1308000p -0.3
+ 1308010p 0.9
+ 1310000p 0.9
+ 1310010p -0.3
+ 1312000p -0.3
+ 1312010p 0.9
+ 1314000p 0.9
+ 1314010p -0.3
+ 1316000p -0.3
+ 1316010p 0.9
+ 1318000p 0.9
+ 1318010p -0.3
+ 1320000p -0.3
+ 1320010p 0.9
+ 1322000p 0.9
+ 1322010p -0.3
+ 1324000p -0.3
+ 1324010p 0.9
+ 1326000p 0.9
+ 1326010p -0.3
+ 1328000p -0.3
+ 1328010p 0.9
+ 1330000p 0.9
+ 1330010p -0.3
+ 1332000p -0.3
+ 1332010p 0.9
+ 1334000p 0.9
+ 1334010p -0.3
+ 1336000p -0.3
+ 1336010p 0.9
+ 1338000p 0.9
+ 1338010p -0.3
+ 1340000p -0.3
+ 1340010p 0.9
+ 1342000p 0.9
+ 1342010p -0.3
+ 1344000p -0.3
+ 1344010p 0.9
+ 1346000p 0.9
+ 1346010p -0.3
+ 1348000p -0.3
+ 1348010p 0.9
+ 1350000p 0.9
+ 1350010p -0.3
+ 1352000p -0.3
+ 1352010p 0.9
+ 1354000p 0.9
+ 1354010p -0.3
+ 1356000p -0.3
+ 1356010p 0.9
+ 1358000p 0.9
+ 1358010p -0.3
+ 1360000p -0.3
+ 1360010p 0.9
+ 1362000p 0.9
+ 1362010p -0.3
+ 1364000p -0.3
+ 1364010p 0.9
+ 1366000p 0.9
+ 1366010p -0.3
+ 1368000p -0.3
+ 1368010p 0.9
+ 1370000p 0.9
+ 1370010p -0.3
+ 1372000p -0.3
+ 1372010p 0.9
+ 1374000p 0.9
+ 1374010p -0.3
+ 1376000p -0.3
+ 1376010p 0.9
+ 1378000p 0.9
+ 1378010p -0.3
+ 1380000p -0.3
+ 1380010p 0.9
+ 1382000p 0.9
+ 1382010p -0.3
+ 1384000p -0.3
+ 1384010p 0.9
+ 1386000p 0.9
+ 1386010p -0.3
+ 1388000p -0.3
+ 1388010p 0.9
+ 1390000p 0.9
+ 1390010p -0.3
+ 1392000p -0.3
+ 1392010p 0.9
+ 1394000p 0.9
+ 1394010p -0.3
+ 1396000p -0.3
+ 1396010p 0.9
+ 1398000p 0.9
+ 1398010p -0.3
+ 1400000p -0.3
+ 1400010p 0.9
+ 1402000p 0.9
+ 1402010p -0.3
+ 1404000p -0.3
+ 1404010p 0.9
+ 1406000p 0.9
+ 1406010p -0.3
+ 1408000p -0.3
+ 1408010p 0.9
+ 1410000p 0.9
+ 1410010p -0.3
+ 1412000p -0.3
+ 1412010p 0.9
+ 1414000p 0.9
+ 1414010p -0.3
+ 1416000p -0.3
+ 1416010p 0.9
+ 1418000p 0.9
+ 1418010p -0.3
+ 1420000p -0.3
+ 1420010p 0.9
+ 1422000p 0.9
+ 1422010p -0.3
+ 1424000p -0.3
+ 1424010p 0.9
+ 1426000p 0.9
+ 1426010p -0.3
+ 1428000p -0.3
+ 1428010p 0.9
+ 1430000p 0.9
+ 1430010p -0.3
+ 1432000p -0.3
+ 1432010p 0.9
+ 1434000p 0.9
+ 1434010p -0.3
+ 1436000p -0.3
+ 1436010p 0.9
+ 1438000p 0.9
+ 1438010p -0.3
+ 1440000p -0.3
+ 1440010p 0.9
+ 1442000p 0.9
+ 1442010p -0.3
+ 1444000p -0.3
+ 1444010p 0.9
+ 1446000p 0.9
+ 1446010p -0.3
+ 1448000p -0.3
+ 1448010p 0.9
+ 1450000p 0.9
+ 1450010p -0.3
+ 1452000p -0.3
+ 1452010p 0.9
+ 1454000p 0.9
+ 1454010p -0.3
+ 1456000p -0.3
+ 1456010p 0.9
+ 1458000p 0.9
+ 1458010p -0.3
+ 1460000p -0.3
+ 1460010p 0.9
+ 1462000p 0.9
+ 1462010p -0.3
+ 1464000p -0.3
+ 1464010p 0.9
+ 1466000p 0.9
+ 1466010p -0.3
+ 1468000p -0.3
+ 1468010p 0.9
+ 1470000p 0.9
+ 1470010p -0.3
+ 1472000p -0.3
+ 1472010p 0.9
+ 1474000p 0.9
+ 1474010p -0.3
+ 1476000p -0.3
+ 1476010p 0.9
+ 1478000p 0.9
+ 1478010p -0.3
+ 1480000p -0.3
+ 1480010p 0.9
+ 1482000p 0.9
+ 1482010p -0.3
+ 1484000p -0.3
+ 1484010p 0.9
+ 1486000p 0.9
+ 1486010p -0.3
+ 1488000p -0.3
+ 1488010p 0.9
+ 1490000p 0.9
+ 1490010p -0.3
+ 1492000p -0.3
+ 1492010p 0.9
+ 1494000p 0.9
+ 1494010p -0.3
+ 1496000p -0.3
+ 1496010p 0.9
+ 1498000p 0.9
+ 1498010p -0.3
+ 1500000p -0.3
+ 1500010p 0.9
+ 1502000p 0.9
+ 1502010p -0.3
+ 1504000p -0.3
+ 1504010p 0.9
+ 1506000p 0.9
+ 1506010p -0.3
+ 1508000p -0.3
+ 1508010p 0.9
+ 1510000p 0.9
+ 1510010p -0.3
+ 1512000p -0.3
+ 1512010p 0.9
+ 1514000p 0.9
+ 1514010p -0.3
+ 1516000p -0.3
+ 1516010p 0.9
+ 1518000p 0.9
+ 1518010p -0.3
+ 1520000p -0.3
+ 1520010p 0.9
+ 1522000p 0.9
+ 1522010p -0.3
+ 1524000p -0.3
+ 1524010p 0.9
+ 1526000p 0.9
+ 1526010p -0.3
+ 1528000p -0.3
+ 1528010p 0.9
+ 1530000p 0.9
+ 1530010p -0.3
+ 1532000p -0.3
+ 1532010p 0.9
+ 1534000p 0.9
+ 1534010p -0.3
+ 1536000p -0.3
+ 1536010p 0.9
+ 1538000p 0.9
+ 1538010p -0.3
+ 1540000p -0.3
+ 1540010p 0.9
+ 1542000p 0.9
+ 1542010p -0.3
+ 1544000p -0.3
+ 1544010p 0.9
+ 1546000p 0.9
+ 1546010p -0.3
+ 1548000p -0.3
+ 1548010p 0.9
+ 1550000p 0.9
+ 1550010p -0.3
+ 1552000p -0.3
+ 1552010p 0.9
+ 1554000p 0.9
+ 1554010p -0.3
+ 1556000p -0.3
+ 1556010p 0.9
+ 1558000p 0.9
+ 1558010p -0.3
+ 1560000p -0.3
+ 1560010p 0.9
+ 1562000p 0.9
+ 1562010p -0.3
+ 1564000p -0.3
+ 1564010p 0.9
+ 1566000p 0.9
+ 1566010p -0.3
+ 1568000p -0.3
+ 1568010p 0.9
+ 1570000p 0.9
+ 1570010p -0.3
+ 1572000p -0.3
+ 1572010p 0.9
+ 1574000p 0.9
+ 1574010p -0.3
+ 1576000p -0.3
+ 1576010p 0.9
+ 1578000p 0.9
+ 1578010p -0.3
+ 1580000p -0.3
+ 1580010p 0.9
+ 1582000p 0.9
+ 1582010p -0.3
+ 1584000p -0.3
+ 1584010p 0.9
+ 1586000p 0.9
+ 1586010p -0.3
+ 1588000p -0.3
+ 1588010p 0.9
+ 1590000p 0.9
+ 1590010p -0.3
+ 1592000p -0.3
+ 1592010p 0.9
+ 1594000p 0.9
+ 1594010p -0.3
+ 1596000p -0.3
+ 1596010p 0.9
+ 1598000p 0.9
+ 1598010p -0.3
+ 1600000p -0.3
+ 1600010p 0.9
+ 1602000p 0.9
+ 1602010p -0.3
+ 1604000p -0.3
+ 1604010p 0.9
+ 1606000p 0.9
+ 1606010p -0.3
+ 1608000p -0.3
+ 1608010p 0.9
+ 1610000p 0.9
+ 1610010p -0.3
+ 1612000p -0.3
+ 1612010p 0.9
+ 1614000p 0.9
+ 1614010p -0.3
+ 1616000p -0.3
+ 1616010p 0.9
+ 1618000p 0.9
+ 1618010p -0.3
+ 1620000p -0.3
+ 1620010p 0.9
+ 1622000p 0.9
+ 1622010p -0.3
+ 1624000p -0.3
+ 1624010p 0.9
+ 1626000p 0.9
+ 1626010p -0.3
+ 1628000p -0.3
+ 1628010p 0.9
+ 1630000p 0.9
+ 1630010p -0.3
+ 1632000p -0.3
+ 1632010p 0.9
+ 1634000p 0.9
+ 1634010p -0.3
+ 1636000p -0.3
+ 1636010p 0.9
+ 1638000p 0.9
+ 1638010p -0.3
+ 1640000p -0.3
+ 1640010p 0.9
+ 1642000p 0.9
+ 1642010p -0.3
+ 1644000p -0.3
+ 1644010p 0.9
+ 1646000p 0.9
+ 1646010p -0.3
+ 1648000p -0.3
+ 1648010p 0.9
+ 1650000p 0.9
+ 1650010p -0.3
+ 1652000p -0.3
+ 1652010p 0.9
+ 1654000p 0.9
+ 1654010p -0.3
+ 1656000p -0.3
+ 1656010p 0.9
+ 1658000p 0.9
+ 1658010p -0.3
+ 1660000p -0.3
+ 1660010p 0.9
+ 1662000p 0.9
+ 1662010p -0.3
+ 1664000p -0.3
+ 1664010p 0.9
+ 1666000p 0.9
+ 1666010p -0.3
+ 1668000p -0.3
+ 1668010p 0.9
+ 1670000p 0.9
+ 1670010p -0.3
+ 1672000p -0.3
+ 1672010p 0.9
+ 1674000p 0.9
+ 1674010p -0.3
+ 1676000p -0.3
+ 1676010p 0.9
+ 1678000p 0.9
+ 1678010p -0.3
+ 1680000p -0.3
+ 1680010p 0.9
+ 1682000p 0.9
+ 1682010p -0.3
+ 1684000p -0.3
+ 1684010p 0.9
+ 1686000p 0.9
+ 1686010p -0.3
+ 1688000p -0.3
+ 1688010p 0.9
+ 1690000p 0.9
+ 1690010p -0.3
+ 1692000p -0.3
+ 1692010p 0.9
+ 1694000p 0.9
+ 1694010p -0.3
+ 1696000p -0.3
+ 1696010p 0.9
+ 1698000p 0.9
+ 1698010p -0.3
+ 1700000p -0.3
+ 1700010p 0.9
+ 1702000p 0.9
+ 1702010p -0.3
+ 1704000p -0.3
+ 1704010p 0.9
+ 1706000p 0.9
+ 1706010p -0.3
+ 1708000p -0.3
+ 1708010p 0.9
+ 1710000p 0.9
+ 1710010p -0.3
+ 1712000p -0.3
+ 1712010p 0.9
+ 1714000p 0.9
+ 1714010p -0.3
+ 1716000p -0.3
+ 1716010p 0.9
+ 1718000p 0.9
+ 1718010p -0.3
+ 1720000p -0.3
+ 1720010p 0.9
+ 1722000p 0.9
+ 1722010p -0.3
+ 1724000p -0.3
+ 1724010p 0.9
+ 1726000p 0.9
+ 1726010p -0.3
+ 1728000p -0.3
+ 1728010p 0.9
+ 1730000p 0.9
+ 1730010p -0.3
+ 1732000p -0.3
+ 1732010p 0.9
+ 1734000p 0.9
+ 1734010p -0.3
+ 1736000p -0.3
+ 1736010p 0.9
+ 1738000p 0.9
+ 1738010p -0.3
+ 1740000p -0.3
+ 1740010p 0.9
+ 1742000p 0.9
+ 1742010p -0.3
+ 1744000p -0.3
+ 1744010p 0.9
+ 1746000p 0.9
+ 1746010p -0.3
+ 1748000p -0.3
+ 1748010p 0.9
+ 1750000p 0.9
+ 1750010p -0.3
+ 1752000p -0.3
+ 1752010p 0.9
+ 1754000p 0.9
+ 1754010p -0.3
+ 1756000p -0.3
+ 1756010p 0.9
+ 1758000p 0.9
+ 1758010p -0.3
+ 1760000p -0.3
+ 1760010p 0.9
+ 1762000p 0.9
+ 1762010p -0.3
+ 1764000p -0.3
+ 1764010p 0.9
+ 1766000p 0.9
+ 1766010p -0.3
+ 1768000p -0.3
+ 1768010p 0.9
+ 1770000p 0.9
+ 1770010p -0.3
+ 1772000p -0.3
+ 1772010p 0.9
+ 1774000p 0.9
+ 1774010p -0.3
+ 1776000p -0.3
+ 1776010p 0.9
+ 1778000p 0.9
+ 1778010p -0.3
+ 1780000p -0.3
+ 1780010p 0.9
+ 1782000p 0.9
+ 1782010p -0.3
+ 1784000p -0.3
+ 1784010p 0.9
+ 1786000p 0.9
+ 1786010p -0.3
+ 1788000p -0.3
+ 1788010p 0.9
+ 1790000p 0.9
+ 1790010p -0.3
+ 1792000p -0.3
+ 1792010p 0.9
+ 1794000p 0.9
+ 1794010p -0.3
+ 1796000p -0.3
+ 1796010p 0.9
+ 1798000p 0.9
+ 1798010p -0.3
+ 1800000p -0.3
+ 1800010p 0.9
+ 1802000p 0.9
+ 1802010p -0.3
+ 1804000p -0.3
+ 1804010p 0.9
+ 1806000p 0.9
+ 1806010p -0.3
+ 1808000p -0.3
+ 1808010p 0.9
+ 1810000p 0.9
+ 1810010p -0.3
+ 1812000p -0.3
+ 1812010p 0.9
+ 1814000p 0.9
+ 1814010p -0.3
+ 1816000p -0.3
+ 1816010p 0.9
+ 1818000p 0.9
+ 1818010p -0.3
+ 1820000p -0.3
+ 1820010p 0.9
+ 1822000p 0.9
+ 1822010p -0.3
+ 1824000p -0.3
+ 1824010p 0.9
+ 1826000p 0.9
+ 1826010p -0.3
+ 1828000p -0.3
+ 1828010p 0.9
+ 1830000p 0.9
+ 1830010p -0.3
+ 1832000p -0.3
+ 1832010p 0.9
+ 1834000p 0.9
+ 1834010p -0.3
+ 1836000p -0.3
+ 1836010p 0.9
+ 1838000p 0.9
+ 1838010p -0.3
+ 1840000p -0.3
+ 1840010p 0.9
+ 1842000p 0.9
+ 1842010p -0.3
+ 1844000p -0.3
+ 1844010p 0.9
+ 1846000p 0.9
+ 1846010p -0.3
+ 1848000p -0.3
+ 1848010p 0.9
+ 1850000p 0.9
+ 1850010p -0.3
+ 1852000p -0.3
+ 1852010p 0.9
+ 1854000p 0.9
+ 1854010p -0.3
+ 1856000p -0.3
+ 1856010p 0.9
+ 1858000p 0.9
+ 1858010p -0.3
+ 1860000p -0.3
+ 1860010p 0.9
+ 1862000p 0.9
+ 1862010p -0.3
+ 1864000p -0.3
+ 1864010p 0.9
+ 1866000p 0.9
+ 1866010p -0.3
+ 1868000p -0.3
+ 1868010p 0.9
+ 1870000p 0.9
+ 1870010p -0.3
+ 1872000p -0.3
+ 1872010p 0.9
+ 1874000p 0.9
+ 1874010p -0.3
+ 1876000p -0.3
+ 1876010p 0.9
+ 1878000p 0.9
+ 1878010p -0.3
+ 1880000p -0.3
+ 1880010p 0.9
+ 1882000p 0.9
+ 1882010p -0.3
+ 1884000p -0.3
+ 1884010p 0.9
+ 1886000p 0.9
+ 1886010p -0.3
+ 1888000p -0.3
+ 1888010p 0.9
+ 1890000p 0.9
+ 1890010p -0.3
+ 1892000p -0.3
+ 1892010p 0.9
+ 1894000p 0.9
+ 1894010p -0.3
+ 1896000p -0.3
+ 1896010p 0.9
+ 1898000p 0.9
+ 1898010p -0.3
+ 1900000p -0.3
+ 1900010p 0.9
+ 1902000p 0.9
+ 1902010p -0.3
+ 1904000p -0.3
+ 1904010p 0.9
+ 1906000p 0.9
+ 1906010p -0.3
+ 1908000p -0.3
+ 1908010p 0.9
+ 1910000p 0.9
+ 1910010p -0.3
+ 1912000p -0.3
+ 1912010p 0.9
+ 1914000p 0.9
+ 1914010p -0.3
+ 1916000p -0.3
+ 1916010p 0.9
+ 1918000p 0.9
+ 1918010p -0.3
+ 1920000p -0.3
+ 1920010p 0.9
+ 1922000p 0.9
+ 1922010p -0.3
+ 1924000p -0.3
+ 1924010p 0.9
+ 1926000p 0.9
+ 1926010p -0.3
+ 1928000p -0.3
+ 1928010p 0.9
+ 1930000p 0.9
+ 1930010p -0.3
+ 1932000p -0.3
+ 1932010p 0.9
+ 1934000p 0.9
+ 1934010p -0.3
+ 1936000p -0.3
+ 1936010p 0.9
+ 1938000p 0.9
+ 1938010p -0.3
+ 1940000p -0.3
+ 1940010p 0.9
+ 1942000p 0.9
+ 1942010p -0.3
+ 1944000p -0.3
+ 1944010p 0.9
+ 1946000p 0.9
+ 1946010p -0.3
+ 1948000p -0.3
+ 1948010p 0.9
+ 1950000p 0.9
+ 1950010p -0.3
+ 1952000p -0.3
+ 1952010p 0.9
+ 1954000p 0.9
+ 1954010p -0.3
+ 1956000p -0.3
+ 1956010p 0.9
+ 1958000p 0.9
+ 1958010p -0.3
+ 1960000p -0.3
+ 1960010p 0.9
+ 1962000p 0.9
+ 1962010p -0.3
+ 1964000p -0.3
+ 1964010p 0.9
+ 1966000p 0.9
+ 1966010p -0.3
+ 1968000p -0.3
+ 1968010p 0.9
+ 1970000p 0.9
+ 1970010p -0.3
+ 1972000p -0.3
+ 1972010p 0.9
+ 1974000p 0.9
+ 1974010p -0.3
+ 1976000p -0.3
+ 1976010p 0.9
+ 1978000p 0.9
+ 1978010p -0.3
+ 1980000p -0.3
+ 1980010p 0.9
+ 1982000p 0.9
+ 1982010p -0.3
+ 1984000p -0.3
+ 1984010p 0.9
+ 1986000p 0.9
+ 1986010p -0.3
+ 1988000p -0.3
+ 1988010p 0.9
+ 1990000p 0.9
+ 1990010p -0.3
+ 1992000p -0.3
+ 1992010p 0.9
+ 1994000p 0.9
+ 1994010p -0.3
+ 1996000p -0.3
+ 1996010p 0.9
+ 1998000p 0.9
+ 1998010p -0.3
+ 2000000p -0.3
+ 2000010p 0.9
+ 2002000p 0.9
+ 2002010p -0.3
+ 2004000p -0.3
+ 2004010p 0.9
+ 2006000p 0.9
+ 2006010p -0.3
+ 2008000p -0.3
+ 2008010p 0.9
+ 2010000p 0.9
+ 2010010p -0.3
+ 2012000p -0.3
+ 2012010p 0.9
+ 2014000p 0.9
+ 2014010p -0.3
+ 2016000p -0.3
+ 2016010p 0.9
+ 2018000p 0.9
+ 2018010p -0.3
+ 2020000p -0.3
+ 2020010p 0.9
+ 2022000p 0.9
+ 2022010p -0.3
+ 2024000p -0.3
+ 2024010p 0.9
+ 2026000p 0.9
+ 2026010p -0.3
+ 2028000p -0.3
+ 2028010p 0.9
+ 2030000p 0.9
+ 2030010p -0.3
+ 2032000p -0.3
+ 2032010p 0.9
+ 2034000p 0.9
+ 2034010p -0.3
+ 2036000p -0.3
+ 2036010p 0.9
+ 2038000p 0.9
+ 2038010p -0.3
+ 2040000p -0.3
+ 2040010p 0.9
+ 2042000p 0.9
+ 2042010p -0.3
+ 2044000p -0.3
+ 2044010p 0.9
+ 2046000p 0.9
+ 2046010p -0.3
+ 2048000p -0.3
+ 2048010p 0.9
+ \]
V_data_bar_8 (Data_bar\\<8\\> gnd!) vsource type=pwl wave=\[
+ 0    -0.3
+ 2000p -0.3
+ 2010p 0.9
+ 4000p 0.9
+ 4010p -0.3
+ 6000p -0.3
+ 6010p 0.9
+ 8000p 0.9
+ 8010p -0.3
+ 10000p -0.3
+ 10010p 0.9
+ 12000p 0.9
+ 12010p -0.3
+ 14000p -0.3
+ 14010p 0.9
+ 16000p 0.9
+ 16010p -0.3
+ 18000p -0.3
+ 18010p 0.9
+ 20000p 0.9
+ 20010p -0.3
+ 22000p -0.3
+ 22010p 0.9
+ 24000p 0.9
+ 24010p -0.3
+ 26000p -0.3
+ 26010p 0.9
+ 28000p 0.9
+ 28010p -0.3
+ 30000p -0.3
+ 30010p 0.9
+ 32000p 0.9
+ 32010p -0.3
+ 34000p -0.3
+ 34010p 0.9
+ 36000p 0.9
+ 36010p -0.3
+ 38000p -0.3
+ 38010p 0.9
+ 40000p 0.9
+ 40010p -0.3
+ 42000p -0.3
+ 42010p 0.9
+ 44000p 0.9
+ 44010p -0.3
+ 46000p -0.3
+ 46010p 0.9
+ 48000p 0.9
+ 48010p -0.3
+ 50000p -0.3
+ 50010p 0.9
+ 52000p 0.9
+ 52010p -0.3
+ 54000p -0.3
+ 54010p 0.9
+ 56000p 0.9
+ 56010p -0.3
+ 58000p -0.3
+ 58010p 0.9
+ 60000p 0.9
+ 60010p -0.3
+ 62000p -0.3
+ 62010p 0.9
+ 64000p 0.9
+ 64010p -0.3
+ 66000p -0.3
+ 66010p 0.9
+ 68000p 0.9
+ 68010p -0.3
+ 70000p -0.3
+ 70010p 0.9
+ 72000p 0.9
+ 72010p -0.3
+ 74000p -0.3
+ 74010p 0.9
+ 76000p 0.9
+ 76010p -0.3
+ 78000p -0.3
+ 78010p 0.9
+ 80000p 0.9
+ 80010p -0.3
+ 82000p -0.3
+ 82010p 0.9
+ 84000p 0.9
+ 84010p -0.3
+ 86000p -0.3
+ 86010p 0.9
+ 88000p 0.9
+ 88010p -0.3
+ 90000p -0.3
+ 90010p 0.9
+ 92000p 0.9
+ 92010p -0.3
+ 94000p -0.3
+ 94010p 0.9
+ 96000p 0.9
+ 96010p -0.3
+ 98000p -0.3
+ 98010p 0.9
+ 100000p 0.9
+ 100010p -0.3
+ 102000p -0.3
+ 102010p 0.9
+ 104000p 0.9
+ 104010p -0.3
+ 106000p -0.3
+ 106010p 0.9
+ 108000p 0.9
+ 108010p -0.3
+ 110000p -0.3
+ 110010p 0.9
+ 112000p 0.9
+ 112010p -0.3
+ 114000p -0.3
+ 114010p 0.9
+ 116000p 0.9
+ 116010p -0.3
+ 118000p -0.3
+ 118010p 0.9
+ 120000p 0.9
+ 120010p -0.3
+ 122000p -0.3
+ 122010p 0.9
+ 124000p 0.9
+ 124010p -0.3
+ 126000p -0.3
+ 126010p 0.9
+ 128000p 0.9
+ 128010p -0.3
+ 130000p -0.3
+ 130010p 0.9
+ 132000p 0.9
+ 132010p -0.3
+ 134000p -0.3
+ 134010p 0.9
+ 136000p 0.9
+ 136010p -0.3
+ 138000p -0.3
+ 138010p 0.9
+ 140000p 0.9
+ 140010p -0.3
+ 142000p -0.3
+ 142010p 0.9
+ 144000p 0.9
+ 144010p -0.3
+ 146000p -0.3
+ 146010p 0.9
+ 148000p 0.9
+ 148010p -0.3
+ 150000p -0.3
+ 150010p 0.9
+ 152000p 0.9
+ 152010p -0.3
+ 154000p -0.3
+ 154010p 0.9
+ 156000p 0.9
+ 156010p -0.3
+ 158000p -0.3
+ 158010p 0.9
+ 160000p 0.9
+ 160010p -0.3
+ 162000p -0.3
+ 162010p 0.9
+ 164000p 0.9
+ 164010p -0.3
+ 166000p -0.3
+ 166010p 0.9
+ 168000p 0.9
+ 168010p -0.3
+ 170000p -0.3
+ 170010p 0.9
+ 172000p 0.9
+ 172010p -0.3
+ 174000p -0.3
+ 174010p 0.9
+ 176000p 0.9
+ 176010p -0.3
+ 178000p -0.3
+ 178010p 0.9
+ 180000p 0.9
+ 180010p -0.3
+ 182000p -0.3
+ 182010p 0.9
+ 184000p 0.9
+ 184010p -0.3
+ 186000p -0.3
+ 186010p 0.9
+ 188000p 0.9
+ 188010p -0.3
+ 190000p -0.3
+ 190010p 0.9
+ 192000p 0.9
+ 192010p -0.3
+ 194000p -0.3
+ 194010p 0.9
+ 196000p 0.9
+ 196010p -0.3
+ 198000p -0.3
+ 198010p 0.9
+ 200000p 0.9
+ 200010p -0.3
+ 202000p -0.3
+ 202010p 0.9
+ 204000p 0.9
+ 204010p -0.3
+ 206000p -0.3
+ 206010p 0.9
+ 208000p 0.9
+ 208010p -0.3
+ 210000p -0.3
+ 210010p 0.9
+ 212000p 0.9
+ 212010p -0.3
+ 214000p -0.3
+ 214010p 0.9
+ 216000p 0.9
+ 216010p -0.3
+ 218000p -0.3
+ 218010p 0.9
+ 220000p 0.9
+ 220010p -0.3
+ 222000p -0.3
+ 222010p 0.9
+ 224000p 0.9
+ 224010p -0.3
+ 226000p -0.3
+ 226010p 0.9
+ 228000p 0.9
+ 228010p -0.3
+ 230000p -0.3
+ 230010p 0.9
+ 232000p 0.9
+ 232010p -0.3
+ 234000p -0.3
+ 234010p 0.9
+ 236000p 0.9
+ 236010p -0.3
+ 238000p -0.3
+ 238010p 0.9
+ 240000p 0.9
+ 240010p -0.3
+ 242000p -0.3
+ 242010p 0.9
+ 244000p 0.9
+ 244010p -0.3
+ 246000p -0.3
+ 246010p 0.9
+ 248000p 0.9
+ 248010p -0.3
+ 250000p -0.3
+ 250010p 0.9
+ 252000p 0.9
+ 252010p -0.3
+ 254000p -0.3
+ 254010p 0.9
+ 256000p 0.9
+ 256010p -0.3
+ 258000p -0.3
+ 258010p 0.9
+ 260000p 0.9
+ 260010p -0.3
+ 262000p -0.3
+ 262010p 0.9
+ 264000p 0.9
+ 264010p -0.3
+ 266000p -0.3
+ 266010p 0.9
+ 268000p 0.9
+ 268010p -0.3
+ 270000p -0.3
+ 270010p 0.9
+ 272000p 0.9
+ 272010p -0.3
+ 274000p -0.3
+ 274010p 0.9
+ 276000p 0.9
+ 276010p -0.3
+ 278000p -0.3
+ 278010p 0.9
+ 280000p 0.9
+ 280010p -0.3
+ 282000p -0.3
+ 282010p 0.9
+ 284000p 0.9
+ 284010p -0.3
+ 286000p -0.3
+ 286010p 0.9
+ 288000p 0.9
+ 288010p -0.3
+ 290000p -0.3
+ 290010p 0.9
+ 292000p 0.9
+ 292010p -0.3
+ 294000p -0.3
+ 294010p 0.9
+ 296000p 0.9
+ 296010p -0.3
+ 298000p -0.3
+ 298010p 0.9
+ 300000p 0.9
+ 300010p -0.3
+ 302000p -0.3
+ 302010p 0.9
+ 304000p 0.9
+ 304010p -0.3
+ 306000p -0.3
+ 306010p 0.9
+ 308000p 0.9
+ 308010p -0.3
+ 310000p -0.3
+ 310010p 0.9
+ 312000p 0.9
+ 312010p -0.3
+ 314000p -0.3
+ 314010p 0.9
+ 316000p 0.9
+ 316010p -0.3
+ 318000p -0.3
+ 318010p 0.9
+ 320000p 0.9
+ 320010p -0.3
+ 322000p -0.3
+ 322010p 0.9
+ 324000p 0.9
+ 324010p -0.3
+ 326000p -0.3
+ 326010p 0.9
+ 328000p 0.9
+ 328010p -0.3
+ 330000p -0.3
+ 330010p 0.9
+ 332000p 0.9
+ 332010p -0.3
+ 334000p -0.3
+ 334010p 0.9
+ 336000p 0.9
+ 336010p -0.3
+ 338000p -0.3
+ 338010p 0.9
+ 340000p 0.9
+ 340010p -0.3
+ 342000p -0.3
+ 342010p 0.9
+ 344000p 0.9
+ 344010p -0.3
+ 346000p -0.3
+ 346010p 0.9
+ 348000p 0.9
+ 348010p -0.3
+ 350000p -0.3
+ 350010p 0.9
+ 352000p 0.9
+ 352010p -0.3
+ 354000p -0.3
+ 354010p 0.9
+ 356000p 0.9
+ 356010p -0.3
+ 358000p -0.3
+ 358010p 0.9
+ 360000p 0.9
+ 360010p -0.3
+ 362000p -0.3
+ 362010p 0.9
+ 364000p 0.9
+ 364010p -0.3
+ 366000p -0.3
+ 366010p 0.9
+ 368000p 0.9
+ 368010p -0.3
+ 370000p -0.3
+ 370010p 0.9
+ 372000p 0.9
+ 372010p -0.3
+ 374000p -0.3
+ 374010p 0.9
+ 376000p 0.9
+ 376010p -0.3
+ 378000p -0.3
+ 378010p 0.9
+ 380000p 0.9
+ 380010p -0.3
+ 382000p -0.3
+ 382010p 0.9
+ 384000p 0.9
+ 384010p -0.3
+ 386000p -0.3
+ 386010p 0.9
+ 388000p 0.9
+ 388010p -0.3
+ 390000p -0.3
+ 390010p 0.9
+ 392000p 0.9
+ 392010p -0.3
+ 394000p -0.3
+ 394010p 0.9
+ 396000p 0.9
+ 396010p -0.3
+ 398000p -0.3
+ 398010p 0.9
+ 400000p 0.9
+ 400010p -0.3
+ 402000p -0.3
+ 402010p 0.9
+ 404000p 0.9
+ 404010p -0.3
+ 406000p -0.3
+ 406010p 0.9
+ 408000p 0.9
+ 408010p -0.3
+ 410000p -0.3
+ 410010p 0.9
+ 412000p 0.9
+ 412010p -0.3
+ 414000p -0.3
+ 414010p 0.9
+ 416000p 0.9
+ 416010p -0.3
+ 418000p -0.3
+ 418010p 0.9
+ 420000p 0.9
+ 420010p -0.3
+ 422000p -0.3
+ 422010p 0.9
+ 424000p 0.9
+ 424010p -0.3
+ 426000p -0.3
+ 426010p 0.9
+ 428000p 0.9
+ 428010p -0.3
+ 430000p -0.3
+ 430010p 0.9
+ 432000p 0.9
+ 432010p -0.3
+ 434000p -0.3
+ 434010p 0.9
+ 436000p 0.9
+ 436010p -0.3
+ 438000p -0.3
+ 438010p 0.9
+ 440000p 0.9
+ 440010p -0.3
+ 442000p -0.3
+ 442010p 0.9
+ 444000p 0.9
+ 444010p -0.3
+ 446000p -0.3
+ 446010p 0.9
+ 448000p 0.9
+ 448010p -0.3
+ 450000p -0.3
+ 450010p 0.9
+ 452000p 0.9
+ 452010p -0.3
+ 454000p -0.3
+ 454010p 0.9
+ 456000p 0.9
+ 456010p -0.3
+ 458000p -0.3
+ 458010p 0.9
+ 460000p 0.9
+ 460010p -0.3
+ 462000p -0.3
+ 462010p 0.9
+ 464000p 0.9
+ 464010p -0.3
+ 466000p -0.3
+ 466010p 0.9
+ 468000p 0.9
+ 468010p -0.3
+ 470000p -0.3
+ 470010p 0.9
+ 472000p 0.9
+ 472010p -0.3
+ 474000p -0.3
+ 474010p 0.9
+ 476000p 0.9
+ 476010p -0.3
+ 478000p -0.3
+ 478010p 0.9
+ 480000p 0.9
+ 480010p -0.3
+ 482000p -0.3
+ 482010p 0.9
+ 484000p 0.9
+ 484010p -0.3
+ 486000p -0.3
+ 486010p 0.9
+ 488000p 0.9
+ 488010p -0.3
+ 490000p -0.3
+ 490010p 0.9
+ 492000p 0.9
+ 492010p -0.3
+ 494000p -0.3
+ 494010p 0.9
+ 496000p 0.9
+ 496010p -0.3
+ 498000p -0.3
+ 498010p 0.9
+ 500000p 0.9
+ 500010p -0.3
+ 502000p -0.3
+ 502010p 0.9
+ 504000p 0.9
+ 504010p -0.3
+ 506000p -0.3
+ 506010p 0.9
+ 508000p 0.9
+ 508010p -0.3
+ 510000p -0.3
+ 510010p 0.9
+ 512000p 0.9
+ 512010p -0.3
+ 514000p -0.3
+ 514010p 0.9
+ 516000p 0.9
+ 516010p -0.3
+ 518000p -0.3
+ 518010p 0.9
+ 520000p 0.9
+ 520010p -0.3
+ 522000p -0.3
+ 522010p 0.9
+ 524000p 0.9
+ 524010p -0.3
+ 526000p -0.3
+ 526010p 0.9
+ 528000p 0.9
+ 528010p -0.3
+ 530000p -0.3
+ 530010p 0.9
+ 532000p 0.9
+ 532010p -0.3
+ 534000p -0.3
+ 534010p 0.9
+ 536000p 0.9
+ 536010p -0.3
+ 538000p -0.3
+ 538010p 0.9
+ 540000p 0.9
+ 540010p -0.3
+ 542000p -0.3
+ 542010p 0.9
+ 544000p 0.9
+ 544010p -0.3
+ 546000p -0.3
+ 546010p 0.9
+ 548000p 0.9
+ 548010p -0.3
+ 550000p -0.3
+ 550010p 0.9
+ 552000p 0.9
+ 552010p -0.3
+ 554000p -0.3
+ 554010p 0.9
+ 556000p 0.9
+ 556010p -0.3
+ 558000p -0.3
+ 558010p 0.9
+ 560000p 0.9
+ 560010p -0.3
+ 562000p -0.3
+ 562010p 0.9
+ 564000p 0.9
+ 564010p -0.3
+ 566000p -0.3
+ 566010p 0.9
+ 568000p 0.9
+ 568010p -0.3
+ 570000p -0.3
+ 570010p 0.9
+ 572000p 0.9
+ 572010p -0.3
+ 574000p -0.3
+ 574010p 0.9
+ 576000p 0.9
+ 576010p -0.3
+ 578000p -0.3
+ 578010p 0.9
+ 580000p 0.9
+ 580010p -0.3
+ 582000p -0.3
+ 582010p 0.9
+ 584000p 0.9
+ 584010p -0.3
+ 586000p -0.3
+ 586010p 0.9
+ 588000p 0.9
+ 588010p -0.3
+ 590000p -0.3
+ 590010p 0.9
+ 592000p 0.9
+ 592010p -0.3
+ 594000p -0.3
+ 594010p 0.9
+ 596000p 0.9
+ 596010p -0.3
+ 598000p -0.3
+ 598010p 0.9
+ 600000p 0.9
+ 600010p -0.3
+ 602000p -0.3
+ 602010p 0.9
+ 604000p 0.9
+ 604010p -0.3
+ 606000p -0.3
+ 606010p 0.9
+ 608000p 0.9
+ 608010p -0.3
+ 610000p -0.3
+ 610010p 0.9
+ 612000p 0.9
+ 612010p -0.3
+ 614000p -0.3
+ 614010p 0.9
+ 616000p 0.9
+ 616010p -0.3
+ 618000p -0.3
+ 618010p 0.9
+ 620000p 0.9
+ 620010p -0.3
+ 622000p -0.3
+ 622010p 0.9
+ 624000p 0.9
+ 624010p -0.3
+ 626000p -0.3
+ 626010p 0.9
+ 628000p 0.9
+ 628010p -0.3
+ 630000p -0.3
+ 630010p 0.9
+ 632000p 0.9
+ 632010p -0.3
+ 634000p -0.3
+ 634010p 0.9
+ 636000p 0.9
+ 636010p -0.3
+ 638000p -0.3
+ 638010p 0.9
+ 640000p 0.9
+ 640010p -0.3
+ 642000p -0.3
+ 642010p 0.9
+ 644000p 0.9
+ 644010p -0.3
+ 646000p -0.3
+ 646010p 0.9
+ 648000p 0.9
+ 648010p -0.3
+ 650000p -0.3
+ 650010p 0.9
+ 652000p 0.9
+ 652010p -0.3
+ 654000p -0.3
+ 654010p 0.9
+ 656000p 0.9
+ 656010p -0.3
+ 658000p -0.3
+ 658010p 0.9
+ 660000p 0.9
+ 660010p -0.3
+ 662000p -0.3
+ 662010p 0.9
+ 664000p 0.9
+ 664010p -0.3
+ 666000p -0.3
+ 666010p 0.9
+ 668000p 0.9
+ 668010p -0.3
+ 670000p -0.3
+ 670010p 0.9
+ 672000p 0.9
+ 672010p -0.3
+ 674000p -0.3
+ 674010p 0.9
+ 676000p 0.9
+ 676010p -0.3
+ 678000p -0.3
+ 678010p 0.9
+ 680000p 0.9
+ 680010p -0.3
+ 682000p -0.3
+ 682010p 0.9
+ 684000p 0.9
+ 684010p -0.3
+ 686000p -0.3
+ 686010p 0.9
+ 688000p 0.9
+ 688010p -0.3
+ 690000p -0.3
+ 690010p 0.9
+ 692000p 0.9
+ 692010p -0.3
+ 694000p -0.3
+ 694010p 0.9
+ 696000p 0.9
+ 696010p -0.3
+ 698000p -0.3
+ 698010p 0.9
+ 700000p 0.9
+ 700010p -0.3
+ 702000p -0.3
+ 702010p 0.9
+ 704000p 0.9
+ 704010p -0.3
+ 706000p -0.3
+ 706010p 0.9
+ 708000p 0.9
+ 708010p -0.3
+ 710000p -0.3
+ 710010p 0.9
+ 712000p 0.9
+ 712010p -0.3
+ 714000p -0.3
+ 714010p 0.9
+ 716000p 0.9
+ 716010p -0.3
+ 718000p -0.3
+ 718010p 0.9
+ 720000p 0.9
+ 720010p -0.3
+ 722000p -0.3
+ 722010p 0.9
+ 724000p 0.9
+ 724010p -0.3
+ 726000p -0.3
+ 726010p 0.9
+ 728000p 0.9
+ 728010p -0.3
+ 730000p -0.3
+ 730010p 0.9
+ 732000p 0.9
+ 732010p -0.3
+ 734000p -0.3
+ 734010p 0.9
+ 736000p 0.9
+ 736010p -0.3
+ 738000p -0.3
+ 738010p 0.9
+ 740000p 0.9
+ 740010p -0.3
+ 742000p -0.3
+ 742010p 0.9
+ 744000p 0.9
+ 744010p -0.3
+ 746000p -0.3
+ 746010p 0.9
+ 748000p 0.9
+ 748010p -0.3
+ 750000p -0.3
+ 750010p 0.9
+ 752000p 0.9
+ 752010p -0.3
+ 754000p -0.3
+ 754010p 0.9
+ 756000p 0.9
+ 756010p -0.3
+ 758000p -0.3
+ 758010p 0.9
+ 760000p 0.9
+ 760010p -0.3
+ 762000p -0.3
+ 762010p 0.9
+ 764000p 0.9
+ 764010p -0.3
+ 766000p -0.3
+ 766010p 0.9
+ 768000p 0.9
+ 768010p -0.3
+ 770000p -0.3
+ 770010p 0.9
+ 772000p 0.9
+ 772010p -0.3
+ 774000p -0.3
+ 774010p 0.9
+ 776000p 0.9
+ 776010p -0.3
+ 778000p -0.3
+ 778010p 0.9
+ 780000p 0.9
+ 780010p -0.3
+ 782000p -0.3
+ 782010p 0.9
+ 784000p 0.9
+ 784010p -0.3
+ 786000p -0.3
+ 786010p 0.9
+ 788000p 0.9
+ 788010p -0.3
+ 790000p -0.3
+ 790010p 0.9
+ 792000p 0.9
+ 792010p -0.3
+ 794000p -0.3
+ 794010p 0.9
+ 796000p 0.9
+ 796010p -0.3
+ 798000p -0.3
+ 798010p 0.9
+ 800000p 0.9
+ 800010p -0.3
+ 802000p -0.3
+ 802010p 0.9
+ 804000p 0.9
+ 804010p -0.3
+ 806000p -0.3
+ 806010p 0.9
+ 808000p 0.9
+ 808010p -0.3
+ 810000p -0.3
+ 810010p 0.9
+ 812000p 0.9
+ 812010p -0.3
+ 814000p -0.3
+ 814010p 0.9
+ 816000p 0.9
+ 816010p -0.3
+ 818000p -0.3
+ 818010p 0.9
+ 820000p 0.9
+ 820010p -0.3
+ 822000p -0.3
+ 822010p 0.9
+ 824000p 0.9
+ 824010p -0.3
+ 826000p -0.3
+ 826010p 0.9
+ 828000p 0.9
+ 828010p -0.3
+ 830000p -0.3
+ 830010p 0.9
+ 832000p 0.9
+ 832010p -0.3
+ 834000p -0.3
+ 834010p 0.9
+ 836000p 0.9
+ 836010p -0.3
+ 838000p -0.3
+ 838010p 0.9
+ 840000p 0.9
+ 840010p -0.3
+ 842000p -0.3
+ 842010p 0.9
+ 844000p 0.9
+ 844010p -0.3
+ 846000p -0.3
+ 846010p 0.9
+ 848000p 0.9
+ 848010p -0.3
+ 850000p -0.3
+ 850010p 0.9
+ 852000p 0.9
+ 852010p -0.3
+ 854000p -0.3
+ 854010p 0.9
+ 856000p 0.9
+ 856010p -0.3
+ 858000p -0.3
+ 858010p 0.9
+ 860000p 0.9
+ 860010p -0.3
+ 862000p -0.3
+ 862010p 0.9
+ 864000p 0.9
+ 864010p -0.3
+ 866000p -0.3
+ 866010p 0.9
+ 868000p 0.9
+ 868010p -0.3
+ 870000p -0.3
+ 870010p 0.9
+ 872000p 0.9
+ 872010p -0.3
+ 874000p -0.3
+ 874010p 0.9
+ 876000p 0.9
+ 876010p -0.3
+ 878000p -0.3
+ 878010p 0.9
+ 880000p 0.9
+ 880010p -0.3
+ 882000p -0.3
+ 882010p 0.9
+ 884000p 0.9
+ 884010p -0.3
+ 886000p -0.3
+ 886010p 0.9
+ 888000p 0.9
+ 888010p -0.3
+ 890000p -0.3
+ 890010p 0.9
+ 892000p 0.9
+ 892010p -0.3
+ 894000p -0.3
+ 894010p 0.9
+ 896000p 0.9
+ 896010p -0.3
+ 898000p -0.3
+ 898010p 0.9
+ 900000p 0.9
+ 900010p -0.3
+ 902000p -0.3
+ 902010p 0.9
+ 904000p 0.9
+ 904010p -0.3
+ 906000p -0.3
+ 906010p 0.9
+ 908000p 0.9
+ 908010p -0.3
+ 910000p -0.3
+ 910010p 0.9
+ 912000p 0.9
+ 912010p -0.3
+ 914000p -0.3
+ 914010p 0.9
+ 916000p 0.9
+ 916010p -0.3
+ 918000p -0.3
+ 918010p 0.9
+ 920000p 0.9
+ 920010p -0.3
+ 922000p -0.3
+ 922010p 0.9
+ 924000p 0.9
+ 924010p -0.3
+ 926000p -0.3
+ 926010p 0.9
+ 928000p 0.9
+ 928010p -0.3
+ 930000p -0.3
+ 930010p 0.9
+ 932000p 0.9
+ 932010p -0.3
+ 934000p -0.3
+ 934010p 0.9
+ 936000p 0.9
+ 936010p -0.3
+ 938000p -0.3
+ 938010p 0.9
+ 940000p 0.9
+ 940010p -0.3
+ 942000p -0.3
+ 942010p 0.9
+ 944000p 0.9
+ 944010p -0.3
+ 946000p -0.3
+ 946010p 0.9
+ 948000p 0.9
+ 948010p -0.3
+ 950000p -0.3
+ 950010p 0.9
+ 952000p 0.9
+ 952010p -0.3
+ 954000p -0.3
+ 954010p 0.9
+ 956000p 0.9
+ 956010p -0.3
+ 958000p -0.3
+ 958010p 0.9
+ 960000p 0.9
+ 960010p -0.3
+ 962000p -0.3
+ 962010p 0.9
+ 964000p 0.9
+ 964010p -0.3
+ 966000p -0.3
+ 966010p 0.9
+ 968000p 0.9
+ 968010p -0.3
+ 970000p -0.3
+ 970010p 0.9
+ 972000p 0.9
+ 972010p -0.3
+ 974000p -0.3
+ 974010p 0.9
+ 976000p 0.9
+ 976010p -0.3
+ 978000p -0.3
+ 978010p 0.9
+ 980000p 0.9
+ 980010p -0.3
+ 982000p -0.3
+ 982010p 0.9
+ 984000p 0.9
+ 984010p -0.3
+ 986000p -0.3
+ 986010p 0.9
+ 988000p 0.9
+ 988010p -0.3
+ 990000p -0.3
+ 990010p 0.9
+ 992000p 0.9
+ 992010p -0.3
+ 994000p -0.3
+ 994010p 0.9
+ 996000p 0.9
+ 996010p -0.3
+ 998000p -0.3
+ 998010p 0.9
+ 1000000p 0.9
+ 1000010p -0.3
+ 1002000p -0.3
+ 1002010p 0.9
+ 1004000p 0.9
+ 1004010p -0.3
+ 1006000p -0.3
+ 1006010p 0.9
+ 1008000p 0.9
+ 1008010p -0.3
+ 1010000p -0.3
+ 1010010p 0.9
+ 1012000p 0.9
+ 1012010p -0.3
+ 1014000p -0.3
+ 1014010p 0.9
+ 1016000p 0.9
+ 1016010p -0.3
+ 1018000p -0.3
+ 1018010p 0.9
+ 1020000p 0.9
+ 1020010p -0.3
+ 1022000p -0.3
+ 1022010p 0.9
+ 1024000p 0.9
+ 1024010p -0.3
+ 1026000p -0.3
+ 1026010p 0.9
+ 1028000p 0.9
+ 1028010p -0.3
+ 1030000p -0.3
+ 1030010p 0.9
+ 1032000p 0.9
+ 1032010p -0.3
+ 1034000p -0.3
+ 1034010p 0.9
+ 1036000p 0.9
+ 1036010p -0.3
+ 1038000p -0.3
+ 1038010p 0.9
+ 1040000p 0.9
+ 1040010p -0.3
+ 1042000p -0.3
+ 1042010p 0.9
+ 1044000p 0.9
+ 1044010p -0.3
+ 1046000p -0.3
+ 1046010p 0.9
+ 1048000p 0.9
+ 1048010p -0.3
+ 1050000p -0.3
+ 1050010p 0.9
+ 1052000p 0.9
+ 1052010p -0.3
+ 1054000p -0.3
+ 1054010p 0.9
+ 1056000p 0.9
+ 1056010p -0.3
+ 1058000p -0.3
+ 1058010p 0.9
+ 1060000p 0.9
+ 1060010p -0.3
+ 1062000p -0.3
+ 1062010p 0.9
+ 1064000p 0.9
+ 1064010p -0.3
+ 1066000p -0.3
+ 1066010p 0.9
+ 1068000p 0.9
+ 1068010p -0.3
+ 1070000p -0.3
+ 1070010p 0.9
+ 1072000p 0.9
+ 1072010p -0.3
+ 1074000p -0.3
+ 1074010p 0.9
+ 1076000p 0.9
+ 1076010p -0.3
+ 1078000p -0.3
+ 1078010p 0.9
+ 1080000p 0.9
+ 1080010p -0.3
+ 1082000p -0.3
+ 1082010p 0.9
+ 1084000p 0.9
+ 1084010p -0.3
+ 1086000p -0.3
+ 1086010p 0.9
+ 1088000p 0.9
+ 1088010p -0.3
+ 1090000p -0.3
+ 1090010p 0.9
+ 1092000p 0.9
+ 1092010p -0.3
+ 1094000p -0.3
+ 1094010p 0.9
+ 1096000p 0.9
+ 1096010p -0.3
+ 1098000p -0.3
+ 1098010p 0.9
+ 1100000p 0.9
+ 1100010p -0.3
+ 1102000p -0.3
+ 1102010p 0.9
+ 1104000p 0.9
+ 1104010p -0.3
+ 1106000p -0.3
+ 1106010p 0.9
+ 1108000p 0.9
+ 1108010p -0.3
+ 1110000p -0.3
+ 1110010p 0.9
+ 1112000p 0.9
+ 1112010p -0.3
+ 1114000p -0.3
+ 1114010p 0.9
+ 1116000p 0.9
+ 1116010p -0.3
+ 1118000p -0.3
+ 1118010p 0.9
+ 1120000p 0.9
+ 1120010p -0.3
+ 1122000p -0.3
+ 1122010p 0.9
+ 1124000p 0.9
+ 1124010p -0.3
+ 1126000p -0.3
+ 1126010p 0.9
+ 1128000p 0.9
+ 1128010p -0.3
+ 1130000p -0.3
+ 1130010p 0.9
+ 1132000p 0.9
+ 1132010p -0.3
+ 1134000p -0.3
+ 1134010p 0.9
+ 1136000p 0.9
+ 1136010p -0.3
+ 1138000p -0.3
+ 1138010p 0.9
+ 1140000p 0.9
+ 1140010p -0.3
+ 1142000p -0.3
+ 1142010p 0.9
+ 1144000p 0.9
+ 1144010p -0.3
+ 1146000p -0.3
+ 1146010p 0.9
+ 1148000p 0.9
+ 1148010p -0.3
+ 1150000p -0.3
+ 1150010p 0.9
+ 1152000p 0.9
+ 1152010p -0.3
+ 1154000p -0.3
+ 1154010p 0.9
+ 1156000p 0.9
+ 1156010p -0.3
+ 1158000p -0.3
+ 1158010p 0.9
+ 1160000p 0.9
+ 1160010p -0.3
+ 1162000p -0.3
+ 1162010p 0.9
+ 1164000p 0.9
+ 1164010p -0.3
+ 1166000p -0.3
+ 1166010p 0.9
+ 1168000p 0.9
+ 1168010p -0.3
+ 1170000p -0.3
+ 1170010p 0.9
+ 1172000p 0.9
+ 1172010p -0.3
+ 1174000p -0.3
+ 1174010p 0.9
+ 1176000p 0.9
+ 1176010p -0.3
+ 1178000p -0.3
+ 1178010p 0.9
+ 1180000p 0.9
+ 1180010p -0.3
+ 1182000p -0.3
+ 1182010p 0.9
+ 1184000p 0.9
+ 1184010p -0.3
+ 1186000p -0.3
+ 1186010p 0.9
+ 1188000p 0.9
+ 1188010p -0.3
+ 1190000p -0.3
+ 1190010p 0.9
+ 1192000p 0.9
+ 1192010p -0.3
+ 1194000p -0.3
+ 1194010p 0.9
+ 1196000p 0.9
+ 1196010p -0.3
+ 1198000p -0.3
+ 1198010p 0.9
+ 1200000p 0.9
+ 1200010p -0.3
+ 1202000p -0.3
+ 1202010p 0.9
+ 1204000p 0.9
+ 1204010p -0.3
+ 1206000p -0.3
+ 1206010p 0.9
+ 1208000p 0.9
+ 1208010p -0.3
+ 1210000p -0.3
+ 1210010p 0.9
+ 1212000p 0.9
+ 1212010p -0.3
+ 1214000p -0.3
+ 1214010p 0.9
+ 1216000p 0.9
+ 1216010p -0.3
+ 1218000p -0.3
+ 1218010p 0.9
+ 1220000p 0.9
+ 1220010p -0.3
+ 1222000p -0.3
+ 1222010p 0.9
+ 1224000p 0.9
+ 1224010p -0.3
+ 1226000p -0.3
+ 1226010p 0.9
+ 1228000p 0.9
+ 1228010p -0.3
+ 1230000p -0.3
+ 1230010p 0.9
+ 1232000p 0.9
+ 1232010p -0.3
+ 1234000p -0.3
+ 1234010p 0.9
+ 1236000p 0.9
+ 1236010p -0.3
+ 1238000p -0.3
+ 1238010p 0.9
+ 1240000p 0.9
+ 1240010p -0.3
+ 1242000p -0.3
+ 1242010p 0.9
+ 1244000p 0.9
+ 1244010p -0.3
+ 1246000p -0.3
+ 1246010p 0.9
+ 1248000p 0.9
+ 1248010p -0.3
+ 1250000p -0.3
+ 1250010p 0.9
+ 1252000p 0.9
+ 1252010p -0.3
+ 1254000p -0.3
+ 1254010p 0.9
+ 1256000p 0.9
+ 1256010p -0.3
+ 1258000p -0.3
+ 1258010p 0.9
+ 1260000p 0.9
+ 1260010p -0.3
+ 1262000p -0.3
+ 1262010p 0.9
+ 1264000p 0.9
+ 1264010p -0.3
+ 1266000p -0.3
+ 1266010p 0.9
+ 1268000p 0.9
+ 1268010p -0.3
+ 1270000p -0.3
+ 1270010p 0.9
+ 1272000p 0.9
+ 1272010p -0.3
+ 1274000p -0.3
+ 1274010p 0.9
+ 1276000p 0.9
+ 1276010p -0.3
+ 1278000p -0.3
+ 1278010p 0.9
+ 1280000p 0.9
+ 1280010p -0.3
+ 1282000p -0.3
+ 1282010p 0.9
+ 1284000p 0.9
+ 1284010p -0.3
+ 1286000p -0.3
+ 1286010p 0.9
+ 1288000p 0.9
+ 1288010p -0.3
+ 1290000p -0.3
+ 1290010p 0.9
+ 1292000p 0.9
+ 1292010p -0.3
+ 1294000p -0.3
+ 1294010p 0.9
+ 1296000p 0.9
+ 1296010p -0.3
+ 1298000p -0.3
+ 1298010p 0.9
+ 1300000p 0.9
+ 1300010p -0.3
+ 1302000p -0.3
+ 1302010p 0.9
+ 1304000p 0.9
+ 1304010p -0.3
+ 1306000p -0.3
+ 1306010p 0.9
+ 1308000p 0.9
+ 1308010p -0.3
+ 1310000p -0.3
+ 1310010p 0.9
+ 1312000p 0.9
+ 1312010p -0.3
+ 1314000p -0.3
+ 1314010p 0.9
+ 1316000p 0.9
+ 1316010p -0.3
+ 1318000p -0.3
+ 1318010p 0.9
+ 1320000p 0.9
+ 1320010p -0.3
+ 1322000p -0.3
+ 1322010p 0.9
+ 1324000p 0.9
+ 1324010p -0.3
+ 1326000p -0.3
+ 1326010p 0.9
+ 1328000p 0.9
+ 1328010p -0.3
+ 1330000p -0.3
+ 1330010p 0.9
+ 1332000p 0.9
+ 1332010p -0.3
+ 1334000p -0.3
+ 1334010p 0.9
+ 1336000p 0.9
+ 1336010p -0.3
+ 1338000p -0.3
+ 1338010p 0.9
+ 1340000p 0.9
+ 1340010p -0.3
+ 1342000p -0.3
+ 1342010p 0.9
+ 1344000p 0.9
+ 1344010p -0.3
+ 1346000p -0.3
+ 1346010p 0.9
+ 1348000p 0.9
+ 1348010p -0.3
+ 1350000p -0.3
+ 1350010p 0.9
+ 1352000p 0.9
+ 1352010p -0.3
+ 1354000p -0.3
+ 1354010p 0.9
+ 1356000p 0.9
+ 1356010p -0.3
+ 1358000p -0.3
+ 1358010p 0.9
+ 1360000p 0.9
+ 1360010p -0.3
+ 1362000p -0.3
+ 1362010p 0.9
+ 1364000p 0.9
+ 1364010p -0.3
+ 1366000p -0.3
+ 1366010p 0.9
+ 1368000p 0.9
+ 1368010p -0.3
+ 1370000p -0.3
+ 1370010p 0.9
+ 1372000p 0.9
+ 1372010p -0.3
+ 1374000p -0.3
+ 1374010p 0.9
+ 1376000p 0.9
+ 1376010p -0.3
+ 1378000p -0.3
+ 1378010p 0.9
+ 1380000p 0.9
+ 1380010p -0.3
+ 1382000p -0.3
+ 1382010p 0.9
+ 1384000p 0.9
+ 1384010p -0.3
+ 1386000p -0.3
+ 1386010p 0.9
+ 1388000p 0.9
+ 1388010p -0.3
+ 1390000p -0.3
+ 1390010p 0.9
+ 1392000p 0.9
+ 1392010p -0.3
+ 1394000p -0.3
+ 1394010p 0.9
+ 1396000p 0.9
+ 1396010p -0.3
+ 1398000p -0.3
+ 1398010p 0.9
+ 1400000p 0.9
+ 1400010p -0.3
+ 1402000p -0.3
+ 1402010p 0.9
+ 1404000p 0.9
+ 1404010p -0.3
+ 1406000p -0.3
+ 1406010p 0.9
+ 1408000p 0.9
+ 1408010p -0.3
+ 1410000p -0.3
+ 1410010p 0.9
+ 1412000p 0.9
+ 1412010p -0.3
+ 1414000p -0.3
+ 1414010p 0.9
+ 1416000p 0.9
+ 1416010p -0.3
+ 1418000p -0.3
+ 1418010p 0.9
+ 1420000p 0.9
+ 1420010p -0.3
+ 1422000p -0.3
+ 1422010p 0.9
+ 1424000p 0.9
+ 1424010p -0.3
+ 1426000p -0.3
+ 1426010p 0.9
+ 1428000p 0.9
+ 1428010p -0.3
+ 1430000p -0.3
+ 1430010p 0.9
+ 1432000p 0.9
+ 1432010p -0.3
+ 1434000p -0.3
+ 1434010p 0.9
+ 1436000p 0.9
+ 1436010p -0.3
+ 1438000p -0.3
+ 1438010p 0.9
+ 1440000p 0.9
+ 1440010p -0.3
+ 1442000p -0.3
+ 1442010p 0.9
+ 1444000p 0.9
+ 1444010p -0.3
+ 1446000p -0.3
+ 1446010p 0.9
+ 1448000p 0.9
+ 1448010p -0.3
+ 1450000p -0.3
+ 1450010p 0.9
+ 1452000p 0.9
+ 1452010p -0.3
+ 1454000p -0.3
+ 1454010p 0.9
+ 1456000p 0.9
+ 1456010p -0.3
+ 1458000p -0.3
+ 1458010p 0.9
+ 1460000p 0.9
+ 1460010p -0.3
+ 1462000p -0.3
+ 1462010p 0.9
+ 1464000p 0.9
+ 1464010p -0.3
+ 1466000p -0.3
+ 1466010p 0.9
+ 1468000p 0.9
+ 1468010p -0.3
+ 1470000p -0.3
+ 1470010p 0.9
+ 1472000p 0.9
+ 1472010p -0.3
+ 1474000p -0.3
+ 1474010p 0.9
+ 1476000p 0.9
+ 1476010p -0.3
+ 1478000p -0.3
+ 1478010p 0.9
+ 1480000p 0.9
+ 1480010p -0.3
+ 1482000p -0.3
+ 1482010p 0.9
+ 1484000p 0.9
+ 1484010p -0.3
+ 1486000p -0.3
+ 1486010p 0.9
+ 1488000p 0.9
+ 1488010p -0.3
+ 1490000p -0.3
+ 1490010p 0.9
+ 1492000p 0.9
+ 1492010p -0.3
+ 1494000p -0.3
+ 1494010p 0.9
+ 1496000p 0.9
+ 1496010p -0.3
+ 1498000p -0.3
+ 1498010p 0.9
+ 1500000p 0.9
+ 1500010p -0.3
+ 1502000p -0.3
+ 1502010p 0.9
+ 1504000p 0.9
+ 1504010p -0.3
+ 1506000p -0.3
+ 1506010p 0.9
+ 1508000p 0.9
+ 1508010p -0.3
+ 1510000p -0.3
+ 1510010p 0.9
+ 1512000p 0.9
+ 1512010p -0.3
+ 1514000p -0.3
+ 1514010p 0.9
+ 1516000p 0.9
+ 1516010p -0.3
+ 1518000p -0.3
+ 1518010p 0.9
+ 1520000p 0.9
+ 1520010p -0.3
+ 1522000p -0.3
+ 1522010p 0.9
+ 1524000p 0.9
+ 1524010p -0.3
+ 1526000p -0.3
+ 1526010p 0.9
+ 1528000p 0.9
+ 1528010p -0.3
+ 1530000p -0.3
+ 1530010p 0.9
+ 1532000p 0.9
+ 1532010p -0.3
+ 1534000p -0.3
+ 1534010p 0.9
+ 1536000p 0.9
+ 1536010p -0.3
+ 1538000p -0.3
+ 1538010p 0.9
+ 1540000p 0.9
+ 1540010p -0.3
+ 1542000p -0.3
+ 1542010p 0.9
+ 1544000p 0.9
+ 1544010p -0.3
+ 1546000p -0.3
+ 1546010p 0.9
+ 1548000p 0.9
+ 1548010p -0.3
+ 1550000p -0.3
+ 1550010p 0.9
+ 1552000p 0.9
+ 1552010p -0.3
+ 1554000p -0.3
+ 1554010p 0.9
+ 1556000p 0.9
+ 1556010p -0.3
+ 1558000p -0.3
+ 1558010p 0.9
+ 1560000p 0.9
+ 1560010p -0.3
+ 1562000p -0.3
+ 1562010p 0.9
+ 1564000p 0.9
+ 1564010p -0.3
+ 1566000p -0.3
+ 1566010p 0.9
+ 1568000p 0.9
+ 1568010p -0.3
+ 1570000p -0.3
+ 1570010p 0.9
+ 1572000p 0.9
+ 1572010p -0.3
+ 1574000p -0.3
+ 1574010p 0.9
+ 1576000p 0.9
+ 1576010p -0.3
+ 1578000p -0.3
+ 1578010p 0.9
+ 1580000p 0.9
+ 1580010p -0.3
+ 1582000p -0.3
+ 1582010p 0.9
+ 1584000p 0.9
+ 1584010p -0.3
+ 1586000p -0.3
+ 1586010p 0.9
+ 1588000p 0.9
+ 1588010p -0.3
+ 1590000p -0.3
+ 1590010p 0.9
+ 1592000p 0.9
+ 1592010p -0.3
+ 1594000p -0.3
+ 1594010p 0.9
+ 1596000p 0.9
+ 1596010p -0.3
+ 1598000p -0.3
+ 1598010p 0.9
+ 1600000p 0.9
+ 1600010p -0.3
+ 1602000p -0.3
+ 1602010p 0.9
+ 1604000p 0.9
+ 1604010p -0.3
+ 1606000p -0.3
+ 1606010p 0.9
+ 1608000p 0.9
+ 1608010p -0.3
+ 1610000p -0.3
+ 1610010p 0.9
+ 1612000p 0.9
+ 1612010p -0.3
+ 1614000p -0.3
+ 1614010p 0.9
+ 1616000p 0.9
+ 1616010p -0.3
+ 1618000p -0.3
+ 1618010p 0.9
+ 1620000p 0.9
+ 1620010p -0.3
+ 1622000p -0.3
+ 1622010p 0.9
+ 1624000p 0.9
+ 1624010p -0.3
+ 1626000p -0.3
+ 1626010p 0.9
+ 1628000p 0.9
+ 1628010p -0.3
+ 1630000p -0.3
+ 1630010p 0.9
+ 1632000p 0.9
+ 1632010p -0.3
+ 1634000p -0.3
+ 1634010p 0.9
+ 1636000p 0.9
+ 1636010p -0.3
+ 1638000p -0.3
+ 1638010p 0.9
+ 1640000p 0.9
+ 1640010p -0.3
+ 1642000p -0.3
+ 1642010p 0.9
+ 1644000p 0.9
+ 1644010p -0.3
+ 1646000p -0.3
+ 1646010p 0.9
+ 1648000p 0.9
+ 1648010p -0.3
+ 1650000p -0.3
+ 1650010p 0.9
+ 1652000p 0.9
+ 1652010p -0.3
+ 1654000p -0.3
+ 1654010p 0.9
+ 1656000p 0.9
+ 1656010p -0.3
+ 1658000p -0.3
+ 1658010p 0.9
+ 1660000p 0.9
+ 1660010p -0.3
+ 1662000p -0.3
+ 1662010p 0.9
+ 1664000p 0.9
+ 1664010p -0.3
+ 1666000p -0.3
+ 1666010p 0.9
+ 1668000p 0.9
+ 1668010p -0.3
+ 1670000p -0.3
+ 1670010p 0.9
+ 1672000p 0.9
+ 1672010p -0.3
+ 1674000p -0.3
+ 1674010p 0.9
+ 1676000p 0.9
+ 1676010p -0.3
+ 1678000p -0.3
+ 1678010p 0.9
+ 1680000p 0.9
+ 1680010p -0.3
+ 1682000p -0.3
+ 1682010p 0.9
+ 1684000p 0.9
+ 1684010p -0.3
+ 1686000p -0.3
+ 1686010p 0.9
+ 1688000p 0.9
+ 1688010p -0.3
+ 1690000p -0.3
+ 1690010p 0.9
+ 1692000p 0.9
+ 1692010p -0.3
+ 1694000p -0.3
+ 1694010p 0.9
+ 1696000p 0.9
+ 1696010p -0.3
+ 1698000p -0.3
+ 1698010p 0.9
+ 1700000p 0.9
+ 1700010p -0.3
+ 1702000p -0.3
+ 1702010p 0.9
+ 1704000p 0.9
+ 1704010p -0.3
+ 1706000p -0.3
+ 1706010p 0.9
+ 1708000p 0.9
+ 1708010p -0.3
+ 1710000p -0.3
+ 1710010p 0.9
+ 1712000p 0.9
+ 1712010p -0.3
+ 1714000p -0.3
+ 1714010p 0.9
+ 1716000p 0.9
+ 1716010p -0.3
+ 1718000p -0.3
+ 1718010p 0.9
+ 1720000p 0.9
+ 1720010p -0.3
+ 1722000p -0.3
+ 1722010p 0.9
+ 1724000p 0.9
+ 1724010p -0.3
+ 1726000p -0.3
+ 1726010p 0.9
+ 1728000p 0.9
+ 1728010p -0.3
+ 1730000p -0.3
+ 1730010p 0.9
+ 1732000p 0.9
+ 1732010p -0.3
+ 1734000p -0.3
+ 1734010p 0.9
+ 1736000p 0.9
+ 1736010p -0.3
+ 1738000p -0.3
+ 1738010p 0.9
+ 1740000p 0.9
+ 1740010p -0.3
+ 1742000p -0.3
+ 1742010p 0.9
+ 1744000p 0.9
+ 1744010p -0.3
+ 1746000p -0.3
+ 1746010p 0.9
+ 1748000p 0.9
+ 1748010p -0.3
+ 1750000p -0.3
+ 1750010p 0.9
+ 1752000p 0.9
+ 1752010p -0.3
+ 1754000p -0.3
+ 1754010p 0.9
+ 1756000p 0.9
+ 1756010p -0.3
+ 1758000p -0.3
+ 1758010p 0.9
+ 1760000p 0.9
+ 1760010p -0.3
+ 1762000p -0.3
+ 1762010p 0.9
+ 1764000p 0.9
+ 1764010p -0.3
+ 1766000p -0.3
+ 1766010p 0.9
+ 1768000p 0.9
+ 1768010p -0.3
+ 1770000p -0.3
+ 1770010p 0.9
+ 1772000p 0.9
+ 1772010p -0.3
+ 1774000p -0.3
+ 1774010p 0.9
+ 1776000p 0.9
+ 1776010p -0.3
+ 1778000p -0.3
+ 1778010p 0.9
+ 1780000p 0.9
+ 1780010p -0.3
+ 1782000p -0.3
+ 1782010p 0.9
+ 1784000p 0.9
+ 1784010p -0.3
+ 1786000p -0.3
+ 1786010p 0.9
+ 1788000p 0.9
+ 1788010p -0.3
+ 1790000p -0.3
+ 1790010p 0.9
+ 1792000p 0.9
+ 1792010p -0.3
+ 1794000p -0.3
+ 1794010p 0.9
+ 1796000p 0.9
+ 1796010p -0.3
+ 1798000p -0.3
+ 1798010p 0.9
+ 1800000p 0.9
+ 1800010p -0.3
+ 1802000p -0.3
+ 1802010p 0.9
+ 1804000p 0.9
+ 1804010p -0.3
+ 1806000p -0.3
+ 1806010p 0.9
+ 1808000p 0.9
+ 1808010p -0.3
+ 1810000p -0.3
+ 1810010p 0.9
+ 1812000p 0.9
+ 1812010p -0.3
+ 1814000p -0.3
+ 1814010p 0.9
+ 1816000p 0.9
+ 1816010p -0.3
+ 1818000p -0.3
+ 1818010p 0.9
+ 1820000p 0.9
+ 1820010p -0.3
+ 1822000p -0.3
+ 1822010p 0.9
+ 1824000p 0.9
+ 1824010p -0.3
+ 1826000p -0.3
+ 1826010p 0.9
+ 1828000p 0.9
+ 1828010p -0.3
+ 1830000p -0.3
+ 1830010p 0.9
+ 1832000p 0.9
+ 1832010p -0.3
+ 1834000p -0.3
+ 1834010p 0.9
+ 1836000p 0.9
+ 1836010p -0.3
+ 1838000p -0.3
+ 1838010p 0.9
+ 1840000p 0.9
+ 1840010p -0.3
+ 1842000p -0.3
+ 1842010p 0.9
+ 1844000p 0.9
+ 1844010p -0.3
+ 1846000p -0.3
+ 1846010p 0.9
+ 1848000p 0.9
+ 1848010p -0.3
+ 1850000p -0.3
+ 1850010p 0.9
+ 1852000p 0.9
+ 1852010p -0.3
+ 1854000p -0.3
+ 1854010p 0.9
+ 1856000p 0.9
+ 1856010p -0.3
+ 1858000p -0.3
+ 1858010p 0.9
+ 1860000p 0.9
+ 1860010p -0.3
+ 1862000p -0.3
+ 1862010p 0.9
+ 1864000p 0.9
+ 1864010p -0.3
+ 1866000p -0.3
+ 1866010p 0.9
+ 1868000p 0.9
+ 1868010p -0.3
+ 1870000p -0.3
+ 1870010p 0.9
+ 1872000p 0.9
+ 1872010p -0.3
+ 1874000p -0.3
+ 1874010p 0.9
+ 1876000p 0.9
+ 1876010p -0.3
+ 1878000p -0.3
+ 1878010p 0.9
+ 1880000p 0.9
+ 1880010p -0.3
+ 1882000p -0.3
+ 1882010p 0.9
+ 1884000p 0.9
+ 1884010p -0.3
+ 1886000p -0.3
+ 1886010p 0.9
+ 1888000p 0.9
+ 1888010p -0.3
+ 1890000p -0.3
+ 1890010p 0.9
+ 1892000p 0.9
+ 1892010p -0.3
+ 1894000p -0.3
+ 1894010p 0.9
+ 1896000p 0.9
+ 1896010p -0.3
+ 1898000p -0.3
+ 1898010p 0.9
+ 1900000p 0.9
+ 1900010p -0.3
+ 1902000p -0.3
+ 1902010p 0.9
+ 1904000p 0.9
+ 1904010p -0.3
+ 1906000p -0.3
+ 1906010p 0.9
+ 1908000p 0.9
+ 1908010p -0.3
+ 1910000p -0.3
+ 1910010p 0.9
+ 1912000p 0.9
+ 1912010p -0.3
+ 1914000p -0.3
+ 1914010p 0.9
+ 1916000p 0.9
+ 1916010p -0.3
+ 1918000p -0.3
+ 1918010p 0.9
+ 1920000p 0.9
+ 1920010p -0.3
+ 1922000p -0.3
+ 1922010p 0.9
+ 1924000p 0.9
+ 1924010p -0.3
+ 1926000p -0.3
+ 1926010p 0.9
+ 1928000p 0.9
+ 1928010p -0.3
+ 1930000p -0.3
+ 1930010p 0.9
+ 1932000p 0.9
+ 1932010p -0.3
+ 1934000p -0.3
+ 1934010p 0.9
+ 1936000p 0.9
+ 1936010p -0.3
+ 1938000p -0.3
+ 1938010p 0.9
+ 1940000p 0.9
+ 1940010p -0.3
+ 1942000p -0.3
+ 1942010p 0.9
+ 1944000p 0.9
+ 1944010p -0.3
+ 1946000p -0.3
+ 1946010p 0.9
+ 1948000p 0.9
+ 1948010p -0.3
+ 1950000p -0.3
+ 1950010p 0.9
+ 1952000p 0.9
+ 1952010p -0.3
+ 1954000p -0.3
+ 1954010p 0.9
+ 1956000p 0.9
+ 1956010p -0.3
+ 1958000p -0.3
+ 1958010p 0.9
+ 1960000p 0.9
+ 1960010p -0.3
+ 1962000p -0.3
+ 1962010p 0.9
+ 1964000p 0.9
+ 1964010p -0.3
+ 1966000p -0.3
+ 1966010p 0.9
+ 1968000p 0.9
+ 1968010p -0.3
+ 1970000p -0.3
+ 1970010p 0.9
+ 1972000p 0.9
+ 1972010p -0.3
+ 1974000p -0.3
+ 1974010p 0.9
+ 1976000p 0.9
+ 1976010p -0.3
+ 1978000p -0.3
+ 1978010p 0.9
+ 1980000p 0.9
+ 1980010p -0.3
+ 1982000p -0.3
+ 1982010p 0.9
+ 1984000p 0.9
+ 1984010p -0.3
+ 1986000p -0.3
+ 1986010p 0.9
+ 1988000p 0.9
+ 1988010p -0.3
+ 1990000p -0.3
+ 1990010p 0.9
+ 1992000p 0.9
+ 1992010p -0.3
+ 1994000p -0.3
+ 1994010p 0.9
+ 1996000p 0.9
+ 1996010p -0.3
+ 1998000p -0.3
+ 1998010p 0.9
+ 2000000p 0.9
+ 2000010p -0.3
+ 2002000p -0.3
+ 2002010p 0.9
+ 2004000p 0.9
+ 2004010p -0.3
+ 2006000p -0.3
+ 2006010p 0.9
+ 2008000p 0.9
+ 2008010p -0.3
+ 2010000p -0.3
+ 2010010p 0.9
+ 2012000p 0.9
+ 2012010p -0.3
+ 2014000p -0.3
+ 2014010p 0.9
+ 2016000p 0.9
+ 2016010p -0.3
+ 2018000p -0.3
+ 2018010p 0.9
+ 2020000p 0.9
+ 2020010p -0.3
+ 2022000p -0.3
+ 2022010p 0.9
+ 2024000p 0.9
+ 2024010p -0.3
+ 2026000p -0.3
+ 2026010p 0.9
+ 2028000p 0.9
+ 2028010p -0.3
+ 2030000p -0.3
+ 2030010p 0.9
+ 2032000p 0.9
+ 2032010p -0.3
+ 2034000p -0.3
+ 2034010p 0.9
+ 2036000p 0.9
+ 2036010p -0.3
+ 2038000p -0.3
+ 2038010p 0.9
+ 2040000p 0.9
+ 2040010p -0.3
+ 2042000p -0.3
+ 2042010p 0.9
+ 2044000p 0.9
+ 2044010p -0.3
+ 2046000p -0.3
+ 2046010p 0.9
+ 2048000p 0.9
+ 2048010p -0.3
+ \]
V_data_9 (Data\\<9\\> gnd!) vsource type=pwl wave=\[
+ 0    0.9
+ 2000p 0.9
+ 2010p -0.3
+ 4000p -0.3
+ 4010p 0.9
+ 6000p 0.9
+ 6010p -0.3
+ 8000p -0.3
+ 8010p 0.9
+ 10000p 0.9
+ 10010p -0.3
+ 12000p -0.3
+ 12010p 0.9
+ 14000p 0.9
+ 14010p -0.3
+ 16000p -0.3
+ 16010p 0.9
+ 18000p 0.9
+ 18010p -0.3
+ 20000p -0.3
+ 20010p 0.9
+ 22000p 0.9
+ 22010p -0.3
+ 24000p -0.3
+ 24010p 0.9
+ 26000p 0.9
+ 26010p -0.3
+ 28000p -0.3
+ 28010p 0.9
+ 30000p 0.9
+ 30010p -0.3
+ 32000p -0.3
+ 32010p 0.9
+ 34000p 0.9
+ 34010p -0.3
+ 36000p -0.3
+ 36010p 0.9
+ 38000p 0.9
+ 38010p -0.3
+ 40000p -0.3
+ 40010p 0.9
+ 42000p 0.9
+ 42010p -0.3
+ 44000p -0.3
+ 44010p 0.9
+ 46000p 0.9
+ 46010p -0.3
+ 48000p -0.3
+ 48010p 0.9
+ 50000p 0.9
+ 50010p -0.3
+ 52000p -0.3
+ 52010p 0.9
+ 54000p 0.9
+ 54010p -0.3
+ 56000p -0.3
+ 56010p 0.9
+ 58000p 0.9
+ 58010p -0.3
+ 60000p -0.3
+ 60010p 0.9
+ 62000p 0.9
+ 62010p -0.3
+ 64000p -0.3
+ 64010p 0.9
+ 66000p 0.9
+ 66010p -0.3
+ 68000p -0.3
+ 68010p 0.9
+ 70000p 0.9
+ 70010p -0.3
+ 72000p -0.3
+ 72010p 0.9
+ 74000p 0.9
+ 74010p -0.3
+ 76000p -0.3
+ 76010p 0.9
+ 78000p 0.9
+ 78010p -0.3
+ 80000p -0.3
+ 80010p 0.9
+ 82000p 0.9
+ 82010p -0.3
+ 84000p -0.3
+ 84010p 0.9
+ 86000p 0.9
+ 86010p -0.3
+ 88000p -0.3
+ 88010p 0.9
+ 90000p 0.9
+ 90010p -0.3
+ 92000p -0.3
+ 92010p 0.9
+ 94000p 0.9
+ 94010p -0.3
+ 96000p -0.3
+ 96010p 0.9
+ 98000p 0.9
+ 98010p -0.3
+ 100000p -0.3
+ 100010p 0.9
+ 102000p 0.9
+ 102010p -0.3
+ 104000p -0.3
+ 104010p 0.9
+ 106000p 0.9
+ 106010p -0.3
+ 108000p -0.3
+ 108010p 0.9
+ 110000p 0.9
+ 110010p -0.3
+ 112000p -0.3
+ 112010p 0.9
+ 114000p 0.9
+ 114010p -0.3
+ 116000p -0.3
+ 116010p 0.9
+ 118000p 0.9
+ 118010p -0.3
+ 120000p -0.3
+ 120010p 0.9
+ 122000p 0.9
+ 122010p -0.3
+ 124000p -0.3
+ 124010p 0.9
+ 126000p 0.9
+ 126010p -0.3
+ 128000p -0.3
+ 128010p 0.9
+ 130000p 0.9
+ 130010p -0.3
+ 132000p -0.3
+ 132010p 0.9
+ 134000p 0.9
+ 134010p -0.3
+ 136000p -0.3
+ 136010p 0.9
+ 138000p 0.9
+ 138010p -0.3
+ 140000p -0.3
+ 140010p 0.9
+ 142000p 0.9
+ 142010p -0.3
+ 144000p -0.3
+ 144010p 0.9
+ 146000p 0.9
+ 146010p -0.3
+ 148000p -0.3
+ 148010p 0.9
+ 150000p 0.9
+ 150010p -0.3
+ 152000p -0.3
+ 152010p 0.9
+ 154000p 0.9
+ 154010p -0.3
+ 156000p -0.3
+ 156010p 0.9
+ 158000p 0.9
+ 158010p -0.3
+ 160000p -0.3
+ 160010p 0.9
+ 162000p 0.9
+ 162010p -0.3
+ 164000p -0.3
+ 164010p 0.9
+ 166000p 0.9
+ 166010p -0.3
+ 168000p -0.3
+ 168010p 0.9
+ 170000p 0.9
+ 170010p -0.3
+ 172000p -0.3
+ 172010p 0.9
+ 174000p 0.9
+ 174010p -0.3
+ 176000p -0.3
+ 176010p 0.9
+ 178000p 0.9
+ 178010p -0.3
+ 180000p -0.3
+ 180010p 0.9
+ 182000p 0.9
+ 182010p -0.3
+ 184000p -0.3
+ 184010p 0.9
+ 186000p 0.9
+ 186010p -0.3
+ 188000p -0.3
+ 188010p 0.9
+ 190000p 0.9
+ 190010p -0.3
+ 192000p -0.3
+ 192010p 0.9
+ 194000p 0.9
+ 194010p -0.3
+ 196000p -0.3
+ 196010p 0.9
+ 198000p 0.9
+ 198010p -0.3
+ 200000p -0.3
+ 200010p 0.9
+ 202000p 0.9
+ 202010p -0.3
+ 204000p -0.3
+ 204010p 0.9
+ 206000p 0.9
+ 206010p -0.3
+ 208000p -0.3
+ 208010p 0.9
+ 210000p 0.9
+ 210010p -0.3
+ 212000p -0.3
+ 212010p 0.9
+ 214000p 0.9
+ 214010p -0.3
+ 216000p -0.3
+ 216010p 0.9
+ 218000p 0.9
+ 218010p -0.3
+ 220000p -0.3
+ 220010p 0.9
+ 222000p 0.9
+ 222010p -0.3
+ 224000p -0.3
+ 224010p 0.9
+ 226000p 0.9
+ 226010p -0.3
+ 228000p -0.3
+ 228010p 0.9
+ 230000p 0.9
+ 230010p -0.3
+ 232000p -0.3
+ 232010p 0.9
+ 234000p 0.9
+ 234010p -0.3
+ 236000p -0.3
+ 236010p 0.9
+ 238000p 0.9
+ 238010p -0.3
+ 240000p -0.3
+ 240010p 0.9
+ 242000p 0.9
+ 242010p -0.3
+ 244000p -0.3
+ 244010p 0.9
+ 246000p 0.9
+ 246010p -0.3
+ 248000p -0.3
+ 248010p 0.9
+ 250000p 0.9
+ 250010p -0.3
+ 252000p -0.3
+ 252010p 0.9
+ 254000p 0.9
+ 254010p -0.3
+ 256000p -0.3
+ 256010p 0.9
+ 258000p 0.9
+ 258010p -0.3
+ 260000p -0.3
+ 260010p 0.9
+ 262000p 0.9
+ 262010p -0.3
+ 264000p -0.3
+ 264010p 0.9
+ 266000p 0.9
+ 266010p -0.3
+ 268000p -0.3
+ 268010p 0.9
+ 270000p 0.9
+ 270010p -0.3
+ 272000p -0.3
+ 272010p 0.9
+ 274000p 0.9
+ 274010p -0.3
+ 276000p -0.3
+ 276010p 0.9
+ 278000p 0.9
+ 278010p -0.3
+ 280000p -0.3
+ 280010p 0.9
+ 282000p 0.9
+ 282010p -0.3
+ 284000p -0.3
+ 284010p 0.9
+ 286000p 0.9
+ 286010p -0.3
+ 288000p -0.3
+ 288010p 0.9
+ 290000p 0.9
+ 290010p -0.3
+ 292000p -0.3
+ 292010p 0.9
+ 294000p 0.9
+ 294010p -0.3
+ 296000p -0.3
+ 296010p 0.9
+ 298000p 0.9
+ 298010p -0.3
+ 300000p -0.3
+ 300010p 0.9
+ 302000p 0.9
+ 302010p -0.3
+ 304000p -0.3
+ 304010p 0.9
+ 306000p 0.9
+ 306010p -0.3
+ 308000p -0.3
+ 308010p 0.9
+ 310000p 0.9
+ 310010p -0.3
+ 312000p -0.3
+ 312010p 0.9
+ 314000p 0.9
+ 314010p -0.3
+ 316000p -0.3
+ 316010p 0.9
+ 318000p 0.9
+ 318010p -0.3
+ 320000p -0.3
+ 320010p 0.9
+ 322000p 0.9
+ 322010p -0.3
+ 324000p -0.3
+ 324010p 0.9
+ 326000p 0.9
+ 326010p -0.3
+ 328000p -0.3
+ 328010p 0.9
+ 330000p 0.9
+ 330010p -0.3
+ 332000p -0.3
+ 332010p 0.9
+ 334000p 0.9
+ 334010p -0.3
+ 336000p -0.3
+ 336010p 0.9
+ 338000p 0.9
+ 338010p -0.3
+ 340000p -0.3
+ 340010p 0.9
+ 342000p 0.9
+ 342010p -0.3
+ 344000p -0.3
+ 344010p 0.9
+ 346000p 0.9
+ 346010p -0.3
+ 348000p -0.3
+ 348010p 0.9
+ 350000p 0.9
+ 350010p -0.3
+ 352000p -0.3
+ 352010p 0.9
+ 354000p 0.9
+ 354010p -0.3
+ 356000p -0.3
+ 356010p 0.9
+ 358000p 0.9
+ 358010p -0.3
+ 360000p -0.3
+ 360010p 0.9
+ 362000p 0.9
+ 362010p -0.3
+ 364000p -0.3
+ 364010p 0.9
+ 366000p 0.9
+ 366010p -0.3
+ 368000p -0.3
+ 368010p 0.9
+ 370000p 0.9
+ 370010p -0.3
+ 372000p -0.3
+ 372010p 0.9
+ 374000p 0.9
+ 374010p -0.3
+ 376000p -0.3
+ 376010p 0.9
+ 378000p 0.9
+ 378010p -0.3
+ 380000p -0.3
+ 380010p 0.9
+ 382000p 0.9
+ 382010p -0.3
+ 384000p -0.3
+ 384010p 0.9
+ 386000p 0.9
+ 386010p -0.3
+ 388000p -0.3
+ 388010p 0.9
+ 390000p 0.9
+ 390010p -0.3
+ 392000p -0.3
+ 392010p 0.9
+ 394000p 0.9
+ 394010p -0.3
+ 396000p -0.3
+ 396010p 0.9
+ 398000p 0.9
+ 398010p -0.3
+ 400000p -0.3
+ 400010p 0.9
+ 402000p 0.9
+ 402010p -0.3
+ 404000p -0.3
+ 404010p 0.9
+ 406000p 0.9
+ 406010p -0.3
+ 408000p -0.3
+ 408010p 0.9
+ 410000p 0.9
+ 410010p -0.3
+ 412000p -0.3
+ 412010p 0.9
+ 414000p 0.9
+ 414010p -0.3
+ 416000p -0.3
+ 416010p 0.9
+ 418000p 0.9
+ 418010p -0.3
+ 420000p -0.3
+ 420010p 0.9
+ 422000p 0.9
+ 422010p -0.3
+ 424000p -0.3
+ 424010p 0.9
+ 426000p 0.9
+ 426010p -0.3
+ 428000p -0.3
+ 428010p 0.9
+ 430000p 0.9
+ 430010p -0.3
+ 432000p -0.3
+ 432010p 0.9
+ 434000p 0.9
+ 434010p -0.3
+ 436000p -0.3
+ 436010p 0.9
+ 438000p 0.9
+ 438010p -0.3
+ 440000p -0.3
+ 440010p 0.9
+ 442000p 0.9
+ 442010p -0.3
+ 444000p -0.3
+ 444010p 0.9
+ 446000p 0.9
+ 446010p -0.3
+ 448000p -0.3
+ 448010p 0.9
+ 450000p 0.9
+ 450010p -0.3
+ 452000p -0.3
+ 452010p 0.9
+ 454000p 0.9
+ 454010p -0.3
+ 456000p -0.3
+ 456010p 0.9
+ 458000p 0.9
+ 458010p -0.3
+ 460000p -0.3
+ 460010p 0.9
+ 462000p 0.9
+ 462010p -0.3
+ 464000p -0.3
+ 464010p 0.9
+ 466000p 0.9
+ 466010p -0.3
+ 468000p -0.3
+ 468010p 0.9
+ 470000p 0.9
+ 470010p -0.3
+ 472000p -0.3
+ 472010p 0.9
+ 474000p 0.9
+ 474010p -0.3
+ 476000p -0.3
+ 476010p 0.9
+ 478000p 0.9
+ 478010p -0.3
+ 480000p -0.3
+ 480010p 0.9
+ 482000p 0.9
+ 482010p -0.3
+ 484000p -0.3
+ 484010p 0.9
+ 486000p 0.9
+ 486010p -0.3
+ 488000p -0.3
+ 488010p 0.9
+ 490000p 0.9
+ 490010p -0.3
+ 492000p -0.3
+ 492010p 0.9
+ 494000p 0.9
+ 494010p -0.3
+ 496000p -0.3
+ 496010p 0.9
+ 498000p 0.9
+ 498010p -0.3
+ 500000p -0.3
+ 500010p 0.9
+ 502000p 0.9
+ 502010p -0.3
+ 504000p -0.3
+ 504010p 0.9
+ 506000p 0.9
+ 506010p -0.3
+ 508000p -0.3
+ 508010p 0.9
+ 510000p 0.9
+ 510010p -0.3
+ 512000p -0.3
+ 512010p 0.9
+ 514000p 0.9
+ 514010p -0.3
+ 516000p -0.3
+ 516010p 0.9
+ 518000p 0.9
+ 518010p -0.3
+ 520000p -0.3
+ 520010p 0.9
+ 522000p 0.9
+ 522010p -0.3
+ 524000p -0.3
+ 524010p 0.9
+ 526000p 0.9
+ 526010p -0.3
+ 528000p -0.3
+ 528010p 0.9
+ 530000p 0.9
+ 530010p -0.3
+ 532000p -0.3
+ 532010p 0.9
+ 534000p 0.9
+ 534010p -0.3
+ 536000p -0.3
+ 536010p 0.9
+ 538000p 0.9
+ 538010p -0.3
+ 540000p -0.3
+ 540010p 0.9
+ 542000p 0.9
+ 542010p -0.3
+ 544000p -0.3
+ 544010p 0.9
+ 546000p 0.9
+ 546010p -0.3
+ 548000p -0.3
+ 548010p 0.9
+ 550000p 0.9
+ 550010p -0.3
+ 552000p -0.3
+ 552010p 0.9
+ 554000p 0.9
+ 554010p -0.3
+ 556000p -0.3
+ 556010p 0.9
+ 558000p 0.9
+ 558010p -0.3
+ 560000p -0.3
+ 560010p 0.9
+ 562000p 0.9
+ 562010p -0.3
+ 564000p -0.3
+ 564010p 0.9
+ 566000p 0.9
+ 566010p -0.3
+ 568000p -0.3
+ 568010p 0.9
+ 570000p 0.9
+ 570010p -0.3
+ 572000p -0.3
+ 572010p 0.9
+ 574000p 0.9
+ 574010p -0.3
+ 576000p -0.3
+ 576010p 0.9
+ 578000p 0.9
+ 578010p -0.3
+ 580000p -0.3
+ 580010p 0.9
+ 582000p 0.9
+ 582010p -0.3
+ 584000p -0.3
+ 584010p 0.9
+ 586000p 0.9
+ 586010p -0.3
+ 588000p -0.3
+ 588010p 0.9
+ 590000p 0.9
+ 590010p -0.3
+ 592000p -0.3
+ 592010p 0.9
+ 594000p 0.9
+ 594010p -0.3
+ 596000p -0.3
+ 596010p 0.9
+ 598000p 0.9
+ 598010p -0.3
+ 600000p -0.3
+ 600010p 0.9
+ 602000p 0.9
+ 602010p -0.3
+ 604000p -0.3
+ 604010p 0.9
+ 606000p 0.9
+ 606010p -0.3
+ 608000p -0.3
+ 608010p 0.9
+ 610000p 0.9
+ 610010p -0.3
+ 612000p -0.3
+ 612010p 0.9
+ 614000p 0.9
+ 614010p -0.3
+ 616000p -0.3
+ 616010p 0.9
+ 618000p 0.9
+ 618010p -0.3
+ 620000p -0.3
+ 620010p 0.9
+ 622000p 0.9
+ 622010p -0.3
+ 624000p -0.3
+ 624010p 0.9
+ 626000p 0.9
+ 626010p -0.3
+ 628000p -0.3
+ 628010p 0.9
+ 630000p 0.9
+ 630010p -0.3
+ 632000p -0.3
+ 632010p 0.9
+ 634000p 0.9
+ 634010p -0.3
+ 636000p -0.3
+ 636010p 0.9
+ 638000p 0.9
+ 638010p -0.3
+ 640000p -0.3
+ 640010p 0.9
+ 642000p 0.9
+ 642010p -0.3
+ 644000p -0.3
+ 644010p 0.9
+ 646000p 0.9
+ 646010p -0.3
+ 648000p -0.3
+ 648010p 0.9
+ 650000p 0.9
+ 650010p -0.3
+ 652000p -0.3
+ 652010p 0.9
+ 654000p 0.9
+ 654010p -0.3
+ 656000p -0.3
+ 656010p 0.9
+ 658000p 0.9
+ 658010p -0.3
+ 660000p -0.3
+ 660010p 0.9
+ 662000p 0.9
+ 662010p -0.3
+ 664000p -0.3
+ 664010p 0.9
+ 666000p 0.9
+ 666010p -0.3
+ 668000p -0.3
+ 668010p 0.9
+ 670000p 0.9
+ 670010p -0.3
+ 672000p -0.3
+ 672010p 0.9
+ 674000p 0.9
+ 674010p -0.3
+ 676000p -0.3
+ 676010p 0.9
+ 678000p 0.9
+ 678010p -0.3
+ 680000p -0.3
+ 680010p 0.9
+ 682000p 0.9
+ 682010p -0.3
+ 684000p -0.3
+ 684010p 0.9
+ 686000p 0.9
+ 686010p -0.3
+ 688000p -0.3
+ 688010p 0.9
+ 690000p 0.9
+ 690010p -0.3
+ 692000p -0.3
+ 692010p 0.9
+ 694000p 0.9
+ 694010p -0.3
+ 696000p -0.3
+ 696010p 0.9
+ 698000p 0.9
+ 698010p -0.3
+ 700000p -0.3
+ 700010p 0.9
+ 702000p 0.9
+ 702010p -0.3
+ 704000p -0.3
+ 704010p 0.9
+ 706000p 0.9
+ 706010p -0.3
+ 708000p -0.3
+ 708010p 0.9
+ 710000p 0.9
+ 710010p -0.3
+ 712000p -0.3
+ 712010p 0.9
+ 714000p 0.9
+ 714010p -0.3
+ 716000p -0.3
+ 716010p 0.9
+ 718000p 0.9
+ 718010p -0.3
+ 720000p -0.3
+ 720010p 0.9
+ 722000p 0.9
+ 722010p -0.3
+ 724000p -0.3
+ 724010p 0.9
+ 726000p 0.9
+ 726010p -0.3
+ 728000p -0.3
+ 728010p 0.9
+ 730000p 0.9
+ 730010p -0.3
+ 732000p -0.3
+ 732010p 0.9
+ 734000p 0.9
+ 734010p -0.3
+ 736000p -0.3
+ 736010p 0.9
+ 738000p 0.9
+ 738010p -0.3
+ 740000p -0.3
+ 740010p 0.9
+ 742000p 0.9
+ 742010p -0.3
+ 744000p -0.3
+ 744010p 0.9
+ 746000p 0.9
+ 746010p -0.3
+ 748000p -0.3
+ 748010p 0.9
+ 750000p 0.9
+ 750010p -0.3
+ 752000p -0.3
+ 752010p 0.9
+ 754000p 0.9
+ 754010p -0.3
+ 756000p -0.3
+ 756010p 0.9
+ 758000p 0.9
+ 758010p -0.3
+ 760000p -0.3
+ 760010p 0.9
+ 762000p 0.9
+ 762010p -0.3
+ 764000p -0.3
+ 764010p 0.9
+ 766000p 0.9
+ 766010p -0.3
+ 768000p -0.3
+ 768010p 0.9
+ 770000p 0.9
+ 770010p -0.3
+ 772000p -0.3
+ 772010p 0.9
+ 774000p 0.9
+ 774010p -0.3
+ 776000p -0.3
+ 776010p 0.9
+ 778000p 0.9
+ 778010p -0.3
+ 780000p -0.3
+ 780010p 0.9
+ 782000p 0.9
+ 782010p -0.3
+ 784000p -0.3
+ 784010p 0.9
+ 786000p 0.9
+ 786010p -0.3
+ 788000p -0.3
+ 788010p 0.9
+ 790000p 0.9
+ 790010p -0.3
+ 792000p -0.3
+ 792010p 0.9
+ 794000p 0.9
+ 794010p -0.3
+ 796000p -0.3
+ 796010p 0.9
+ 798000p 0.9
+ 798010p -0.3
+ 800000p -0.3
+ 800010p 0.9
+ 802000p 0.9
+ 802010p -0.3
+ 804000p -0.3
+ 804010p 0.9
+ 806000p 0.9
+ 806010p -0.3
+ 808000p -0.3
+ 808010p 0.9
+ 810000p 0.9
+ 810010p -0.3
+ 812000p -0.3
+ 812010p 0.9
+ 814000p 0.9
+ 814010p -0.3
+ 816000p -0.3
+ 816010p 0.9
+ 818000p 0.9
+ 818010p -0.3
+ 820000p -0.3
+ 820010p 0.9
+ 822000p 0.9
+ 822010p -0.3
+ 824000p -0.3
+ 824010p 0.9
+ 826000p 0.9
+ 826010p -0.3
+ 828000p -0.3
+ 828010p 0.9
+ 830000p 0.9
+ 830010p -0.3
+ 832000p -0.3
+ 832010p 0.9
+ 834000p 0.9
+ 834010p -0.3
+ 836000p -0.3
+ 836010p 0.9
+ 838000p 0.9
+ 838010p -0.3
+ 840000p -0.3
+ 840010p 0.9
+ 842000p 0.9
+ 842010p -0.3
+ 844000p -0.3
+ 844010p 0.9
+ 846000p 0.9
+ 846010p -0.3
+ 848000p -0.3
+ 848010p 0.9
+ 850000p 0.9
+ 850010p -0.3
+ 852000p -0.3
+ 852010p 0.9
+ 854000p 0.9
+ 854010p -0.3
+ 856000p -0.3
+ 856010p 0.9
+ 858000p 0.9
+ 858010p -0.3
+ 860000p -0.3
+ 860010p 0.9
+ 862000p 0.9
+ 862010p -0.3
+ 864000p -0.3
+ 864010p 0.9
+ 866000p 0.9
+ 866010p -0.3
+ 868000p -0.3
+ 868010p 0.9
+ 870000p 0.9
+ 870010p -0.3
+ 872000p -0.3
+ 872010p 0.9
+ 874000p 0.9
+ 874010p -0.3
+ 876000p -0.3
+ 876010p 0.9
+ 878000p 0.9
+ 878010p -0.3
+ 880000p -0.3
+ 880010p 0.9
+ 882000p 0.9
+ 882010p -0.3
+ 884000p -0.3
+ 884010p 0.9
+ 886000p 0.9
+ 886010p -0.3
+ 888000p -0.3
+ 888010p 0.9
+ 890000p 0.9
+ 890010p -0.3
+ 892000p -0.3
+ 892010p 0.9
+ 894000p 0.9
+ 894010p -0.3
+ 896000p -0.3
+ 896010p 0.9
+ 898000p 0.9
+ 898010p -0.3
+ 900000p -0.3
+ 900010p 0.9
+ 902000p 0.9
+ 902010p -0.3
+ 904000p -0.3
+ 904010p 0.9
+ 906000p 0.9
+ 906010p -0.3
+ 908000p -0.3
+ 908010p 0.9
+ 910000p 0.9
+ 910010p -0.3
+ 912000p -0.3
+ 912010p 0.9
+ 914000p 0.9
+ 914010p -0.3
+ 916000p -0.3
+ 916010p 0.9
+ 918000p 0.9
+ 918010p -0.3
+ 920000p -0.3
+ 920010p 0.9
+ 922000p 0.9
+ 922010p -0.3
+ 924000p -0.3
+ 924010p 0.9
+ 926000p 0.9
+ 926010p -0.3
+ 928000p -0.3
+ 928010p 0.9
+ 930000p 0.9
+ 930010p -0.3
+ 932000p -0.3
+ 932010p 0.9
+ 934000p 0.9
+ 934010p -0.3
+ 936000p -0.3
+ 936010p 0.9
+ 938000p 0.9
+ 938010p -0.3
+ 940000p -0.3
+ 940010p 0.9
+ 942000p 0.9
+ 942010p -0.3
+ 944000p -0.3
+ 944010p 0.9
+ 946000p 0.9
+ 946010p -0.3
+ 948000p -0.3
+ 948010p 0.9
+ 950000p 0.9
+ 950010p -0.3
+ 952000p -0.3
+ 952010p 0.9
+ 954000p 0.9
+ 954010p -0.3
+ 956000p -0.3
+ 956010p 0.9
+ 958000p 0.9
+ 958010p -0.3
+ 960000p -0.3
+ 960010p 0.9
+ 962000p 0.9
+ 962010p -0.3
+ 964000p -0.3
+ 964010p 0.9
+ 966000p 0.9
+ 966010p -0.3
+ 968000p -0.3
+ 968010p 0.9
+ 970000p 0.9
+ 970010p -0.3
+ 972000p -0.3
+ 972010p 0.9
+ 974000p 0.9
+ 974010p -0.3
+ 976000p -0.3
+ 976010p 0.9
+ 978000p 0.9
+ 978010p -0.3
+ 980000p -0.3
+ 980010p 0.9
+ 982000p 0.9
+ 982010p -0.3
+ 984000p -0.3
+ 984010p 0.9
+ 986000p 0.9
+ 986010p -0.3
+ 988000p -0.3
+ 988010p 0.9
+ 990000p 0.9
+ 990010p -0.3
+ 992000p -0.3
+ 992010p 0.9
+ 994000p 0.9
+ 994010p -0.3
+ 996000p -0.3
+ 996010p 0.9
+ 998000p 0.9
+ 998010p -0.3
+ 1000000p -0.3
+ 1000010p 0.9
+ 1002000p 0.9
+ 1002010p -0.3
+ 1004000p -0.3
+ 1004010p 0.9
+ 1006000p 0.9
+ 1006010p -0.3
+ 1008000p -0.3
+ 1008010p 0.9
+ 1010000p 0.9
+ 1010010p -0.3
+ 1012000p -0.3
+ 1012010p 0.9
+ 1014000p 0.9
+ 1014010p -0.3
+ 1016000p -0.3
+ 1016010p 0.9
+ 1018000p 0.9
+ 1018010p -0.3
+ 1020000p -0.3
+ 1020010p 0.9
+ 1022000p 0.9
+ 1022010p -0.3
+ 1024000p -0.3
+ 1024010p 0.9
+ 1026000p 0.9
+ 1026010p -0.3
+ 1028000p -0.3
+ 1028010p 0.9
+ 1030000p 0.9
+ 1030010p -0.3
+ 1032000p -0.3
+ 1032010p 0.9
+ 1034000p 0.9
+ 1034010p -0.3
+ 1036000p -0.3
+ 1036010p 0.9
+ 1038000p 0.9
+ 1038010p -0.3
+ 1040000p -0.3
+ 1040010p 0.9
+ 1042000p 0.9
+ 1042010p -0.3
+ 1044000p -0.3
+ 1044010p 0.9
+ 1046000p 0.9
+ 1046010p -0.3
+ 1048000p -0.3
+ 1048010p 0.9
+ 1050000p 0.9
+ 1050010p -0.3
+ 1052000p -0.3
+ 1052010p 0.9
+ 1054000p 0.9
+ 1054010p -0.3
+ 1056000p -0.3
+ 1056010p 0.9
+ 1058000p 0.9
+ 1058010p -0.3
+ 1060000p -0.3
+ 1060010p 0.9
+ 1062000p 0.9
+ 1062010p -0.3
+ 1064000p -0.3
+ 1064010p 0.9
+ 1066000p 0.9
+ 1066010p -0.3
+ 1068000p -0.3
+ 1068010p 0.9
+ 1070000p 0.9
+ 1070010p -0.3
+ 1072000p -0.3
+ 1072010p 0.9
+ 1074000p 0.9
+ 1074010p -0.3
+ 1076000p -0.3
+ 1076010p 0.9
+ 1078000p 0.9
+ 1078010p -0.3
+ 1080000p -0.3
+ 1080010p 0.9
+ 1082000p 0.9
+ 1082010p -0.3
+ 1084000p -0.3
+ 1084010p 0.9
+ 1086000p 0.9
+ 1086010p -0.3
+ 1088000p -0.3
+ 1088010p 0.9
+ 1090000p 0.9
+ 1090010p -0.3
+ 1092000p -0.3
+ 1092010p 0.9
+ 1094000p 0.9
+ 1094010p -0.3
+ 1096000p -0.3
+ 1096010p 0.9
+ 1098000p 0.9
+ 1098010p -0.3
+ 1100000p -0.3
+ 1100010p 0.9
+ 1102000p 0.9
+ 1102010p -0.3
+ 1104000p -0.3
+ 1104010p 0.9
+ 1106000p 0.9
+ 1106010p -0.3
+ 1108000p -0.3
+ 1108010p 0.9
+ 1110000p 0.9
+ 1110010p -0.3
+ 1112000p -0.3
+ 1112010p 0.9
+ 1114000p 0.9
+ 1114010p -0.3
+ 1116000p -0.3
+ 1116010p 0.9
+ 1118000p 0.9
+ 1118010p -0.3
+ 1120000p -0.3
+ 1120010p 0.9
+ 1122000p 0.9
+ 1122010p -0.3
+ 1124000p -0.3
+ 1124010p 0.9
+ 1126000p 0.9
+ 1126010p -0.3
+ 1128000p -0.3
+ 1128010p 0.9
+ 1130000p 0.9
+ 1130010p -0.3
+ 1132000p -0.3
+ 1132010p 0.9
+ 1134000p 0.9
+ 1134010p -0.3
+ 1136000p -0.3
+ 1136010p 0.9
+ 1138000p 0.9
+ 1138010p -0.3
+ 1140000p -0.3
+ 1140010p 0.9
+ 1142000p 0.9
+ 1142010p -0.3
+ 1144000p -0.3
+ 1144010p 0.9
+ 1146000p 0.9
+ 1146010p -0.3
+ 1148000p -0.3
+ 1148010p 0.9
+ 1150000p 0.9
+ 1150010p -0.3
+ 1152000p -0.3
+ 1152010p 0.9
+ 1154000p 0.9
+ 1154010p -0.3
+ 1156000p -0.3
+ 1156010p 0.9
+ 1158000p 0.9
+ 1158010p -0.3
+ 1160000p -0.3
+ 1160010p 0.9
+ 1162000p 0.9
+ 1162010p -0.3
+ 1164000p -0.3
+ 1164010p 0.9
+ 1166000p 0.9
+ 1166010p -0.3
+ 1168000p -0.3
+ 1168010p 0.9
+ 1170000p 0.9
+ 1170010p -0.3
+ 1172000p -0.3
+ 1172010p 0.9
+ 1174000p 0.9
+ 1174010p -0.3
+ 1176000p -0.3
+ 1176010p 0.9
+ 1178000p 0.9
+ 1178010p -0.3
+ 1180000p -0.3
+ 1180010p 0.9
+ 1182000p 0.9
+ 1182010p -0.3
+ 1184000p -0.3
+ 1184010p 0.9
+ 1186000p 0.9
+ 1186010p -0.3
+ 1188000p -0.3
+ 1188010p 0.9
+ 1190000p 0.9
+ 1190010p -0.3
+ 1192000p -0.3
+ 1192010p 0.9
+ 1194000p 0.9
+ 1194010p -0.3
+ 1196000p -0.3
+ 1196010p 0.9
+ 1198000p 0.9
+ 1198010p -0.3
+ 1200000p -0.3
+ 1200010p 0.9
+ 1202000p 0.9
+ 1202010p -0.3
+ 1204000p -0.3
+ 1204010p 0.9
+ 1206000p 0.9
+ 1206010p -0.3
+ 1208000p -0.3
+ 1208010p 0.9
+ 1210000p 0.9
+ 1210010p -0.3
+ 1212000p -0.3
+ 1212010p 0.9
+ 1214000p 0.9
+ 1214010p -0.3
+ 1216000p -0.3
+ 1216010p 0.9
+ 1218000p 0.9
+ 1218010p -0.3
+ 1220000p -0.3
+ 1220010p 0.9
+ 1222000p 0.9
+ 1222010p -0.3
+ 1224000p -0.3
+ 1224010p 0.9
+ 1226000p 0.9
+ 1226010p -0.3
+ 1228000p -0.3
+ 1228010p 0.9
+ 1230000p 0.9
+ 1230010p -0.3
+ 1232000p -0.3
+ 1232010p 0.9
+ 1234000p 0.9
+ 1234010p -0.3
+ 1236000p -0.3
+ 1236010p 0.9
+ 1238000p 0.9
+ 1238010p -0.3
+ 1240000p -0.3
+ 1240010p 0.9
+ 1242000p 0.9
+ 1242010p -0.3
+ 1244000p -0.3
+ 1244010p 0.9
+ 1246000p 0.9
+ 1246010p -0.3
+ 1248000p -0.3
+ 1248010p 0.9
+ 1250000p 0.9
+ 1250010p -0.3
+ 1252000p -0.3
+ 1252010p 0.9
+ 1254000p 0.9
+ 1254010p -0.3
+ 1256000p -0.3
+ 1256010p 0.9
+ 1258000p 0.9
+ 1258010p -0.3
+ 1260000p -0.3
+ 1260010p 0.9
+ 1262000p 0.9
+ 1262010p -0.3
+ 1264000p -0.3
+ 1264010p 0.9
+ 1266000p 0.9
+ 1266010p -0.3
+ 1268000p -0.3
+ 1268010p 0.9
+ 1270000p 0.9
+ 1270010p -0.3
+ 1272000p -0.3
+ 1272010p 0.9
+ 1274000p 0.9
+ 1274010p -0.3
+ 1276000p -0.3
+ 1276010p 0.9
+ 1278000p 0.9
+ 1278010p -0.3
+ 1280000p -0.3
+ 1280010p 0.9
+ 1282000p 0.9
+ 1282010p -0.3
+ 1284000p -0.3
+ 1284010p 0.9
+ 1286000p 0.9
+ 1286010p -0.3
+ 1288000p -0.3
+ 1288010p 0.9
+ 1290000p 0.9
+ 1290010p -0.3
+ 1292000p -0.3
+ 1292010p 0.9
+ 1294000p 0.9
+ 1294010p -0.3
+ 1296000p -0.3
+ 1296010p 0.9
+ 1298000p 0.9
+ 1298010p -0.3
+ 1300000p -0.3
+ 1300010p 0.9
+ 1302000p 0.9
+ 1302010p -0.3
+ 1304000p -0.3
+ 1304010p 0.9
+ 1306000p 0.9
+ 1306010p -0.3
+ 1308000p -0.3
+ 1308010p 0.9
+ 1310000p 0.9
+ 1310010p -0.3
+ 1312000p -0.3
+ 1312010p 0.9
+ 1314000p 0.9
+ 1314010p -0.3
+ 1316000p -0.3
+ 1316010p 0.9
+ 1318000p 0.9
+ 1318010p -0.3
+ 1320000p -0.3
+ 1320010p 0.9
+ 1322000p 0.9
+ 1322010p -0.3
+ 1324000p -0.3
+ 1324010p 0.9
+ 1326000p 0.9
+ 1326010p -0.3
+ 1328000p -0.3
+ 1328010p 0.9
+ 1330000p 0.9
+ 1330010p -0.3
+ 1332000p -0.3
+ 1332010p 0.9
+ 1334000p 0.9
+ 1334010p -0.3
+ 1336000p -0.3
+ 1336010p 0.9
+ 1338000p 0.9
+ 1338010p -0.3
+ 1340000p -0.3
+ 1340010p 0.9
+ 1342000p 0.9
+ 1342010p -0.3
+ 1344000p -0.3
+ 1344010p 0.9
+ 1346000p 0.9
+ 1346010p -0.3
+ 1348000p -0.3
+ 1348010p 0.9
+ 1350000p 0.9
+ 1350010p -0.3
+ 1352000p -0.3
+ 1352010p 0.9
+ 1354000p 0.9
+ 1354010p -0.3
+ 1356000p -0.3
+ 1356010p 0.9
+ 1358000p 0.9
+ 1358010p -0.3
+ 1360000p -0.3
+ 1360010p 0.9
+ 1362000p 0.9
+ 1362010p -0.3
+ 1364000p -0.3
+ 1364010p 0.9
+ 1366000p 0.9
+ 1366010p -0.3
+ 1368000p -0.3
+ 1368010p 0.9
+ 1370000p 0.9
+ 1370010p -0.3
+ 1372000p -0.3
+ 1372010p 0.9
+ 1374000p 0.9
+ 1374010p -0.3
+ 1376000p -0.3
+ 1376010p 0.9
+ 1378000p 0.9
+ 1378010p -0.3
+ 1380000p -0.3
+ 1380010p 0.9
+ 1382000p 0.9
+ 1382010p -0.3
+ 1384000p -0.3
+ 1384010p 0.9
+ 1386000p 0.9
+ 1386010p -0.3
+ 1388000p -0.3
+ 1388010p 0.9
+ 1390000p 0.9
+ 1390010p -0.3
+ 1392000p -0.3
+ 1392010p 0.9
+ 1394000p 0.9
+ 1394010p -0.3
+ 1396000p -0.3
+ 1396010p 0.9
+ 1398000p 0.9
+ 1398010p -0.3
+ 1400000p -0.3
+ 1400010p 0.9
+ 1402000p 0.9
+ 1402010p -0.3
+ 1404000p -0.3
+ 1404010p 0.9
+ 1406000p 0.9
+ 1406010p -0.3
+ 1408000p -0.3
+ 1408010p 0.9
+ 1410000p 0.9
+ 1410010p -0.3
+ 1412000p -0.3
+ 1412010p 0.9
+ 1414000p 0.9
+ 1414010p -0.3
+ 1416000p -0.3
+ 1416010p 0.9
+ 1418000p 0.9
+ 1418010p -0.3
+ 1420000p -0.3
+ 1420010p 0.9
+ 1422000p 0.9
+ 1422010p -0.3
+ 1424000p -0.3
+ 1424010p 0.9
+ 1426000p 0.9
+ 1426010p -0.3
+ 1428000p -0.3
+ 1428010p 0.9
+ 1430000p 0.9
+ 1430010p -0.3
+ 1432000p -0.3
+ 1432010p 0.9
+ 1434000p 0.9
+ 1434010p -0.3
+ 1436000p -0.3
+ 1436010p 0.9
+ 1438000p 0.9
+ 1438010p -0.3
+ 1440000p -0.3
+ 1440010p 0.9
+ 1442000p 0.9
+ 1442010p -0.3
+ 1444000p -0.3
+ 1444010p 0.9
+ 1446000p 0.9
+ 1446010p -0.3
+ 1448000p -0.3
+ 1448010p 0.9
+ 1450000p 0.9
+ 1450010p -0.3
+ 1452000p -0.3
+ 1452010p 0.9
+ 1454000p 0.9
+ 1454010p -0.3
+ 1456000p -0.3
+ 1456010p 0.9
+ 1458000p 0.9
+ 1458010p -0.3
+ 1460000p -0.3
+ 1460010p 0.9
+ 1462000p 0.9
+ 1462010p -0.3
+ 1464000p -0.3
+ 1464010p 0.9
+ 1466000p 0.9
+ 1466010p -0.3
+ 1468000p -0.3
+ 1468010p 0.9
+ 1470000p 0.9
+ 1470010p -0.3
+ 1472000p -0.3
+ 1472010p 0.9
+ 1474000p 0.9
+ 1474010p -0.3
+ 1476000p -0.3
+ 1476010p 0.9
+ 1478000p 0.9
+ 1478010p -0.3
+ 1480000p -0.3
+ 1480010p 0.9
+ 1482000p 0.9
+ 1482010p -0.3
+ 1484000p -0.3
+ 1484010p 0.9
+ 1486000p 0.9
+ 1486010p -0.3
+ 1488000p -0.3
+ 1488010p 0.9
+ 1490000p 0.9
+ 1490010p -0.3
+ 1492000p -0.3
+ 1492010p 0.9
+ 1494000p 0.9
+ 1494010p -0.3
+ 1496000p -0.3
+ 1496010p 0.9
+ 1498000p 0.9
+ 1498010p -0.3
+ 1500000p -0.3
+ 1500010p 0.9
+ 1502000p 0.9
+ 1502010p -0.3
+ 1504000p -0.3
+ 1504010p 0.9
+ 1506000p 0.9
+ 1506010p -0.3
+ 1508000p -0.3
+ 1508010p 0.9
+ 1510000p 0.9
+ 1510010p -0.3
+ 1512000p -0.3
+ 1512010p 0.9
+ 1514000p 0.9
+ 1514010p -0.3
+ 1516000p -0.3
+ 1516010p 0.9
+ 1518000p 0.9
+ 1518010p -0.3
+ 1520000p -0.3
+ 1520010p 0.9
+ 1522000p 0.9
+ 1522010p -0.3
+ 1524000p -0.3
+ 1524010p 0.9
+ 1526000p 0.9
+ 1526010p -0.3
+ 1528000p -0.3
+ 1528010p 0.9
+ 1530000p 0.9
+ 1530010p -0.3
+ 1532000p -0.3
+ 1532010p 0.9
+ 1534000p 0.9
+ 1534010p -0.3
+ 1536000p -0.3
+ 1536010p 0.9
+ 1538000p 0.9
+ 1538010p -0.3
+ 1540000p -0.3
+ 1540010p 0.9
+ 1542000p 0.9
+ 1542010p -0.3
+ 1544000p -0.3
+ 1544010p 0.9
+ 1546000p 0.9
+ 1546010p -0.3
+ 1548000p -0.3
+ 1548010p 0.9
+ 1550000p 0.9
+ 1550010p -0.3
+ 1552000p -0.3
+ 1552010p 0.9
+ 1554000p 0.9
+ 1554010p -0.3
+ 1556000p -0.3
+ 1556010p 0.9
+ 1558000p 0.9
+ 1558010p -0.3
+ 1560000p -0.3
+ 1560010p 0.9
+ 1562000p 0.9
+ 1562010p -0.3
+ 1564000p -0.3
+ 1564010p 0.9
+ 1566000p 0.9
+ 1566010p -0.3
+ 1568000p -0.3
+ 1568010p 0.9
+ 1570000p 0.9
+ 1570010p -0.3
+ 1572000p -0.3
+ 1572010p 0.9
+ 1574000p 0.9
+ 1574010p -0.3
+ 1576000p -0.3
+ 1576010p 0.9
+ 1578000p 0.9
+ 1578010p -0.3
+ 1580000p -0.3
+ 1580010p 0.9
+ 1582000p 0.9
+ 1582010p -0.3
+ 1584000p -0.3
+ 1584010p 0.9
+ 1586000p 0.9
+ 1586010p -0.3
+ 1588000p -0.3
+ 1588010p 0.9
+ 1590000p 0.9
+ 1590010p -0.3
+ 1592000p -0.3
+ 1592010p 0.9
+ 1594000p 0.9
+ 1594010p -0.3
+ 1596000p -0.3
+ 1596010p 0.9
+ 1598000p 0.9
+ 1598010p -0.3
+ 1600000p -0.3
+ 1600010p 0.9
+ 1602000p 0.9
+ 1602010p -0.3
+ 1604000p -0.3
+ 1604010p 0.9
+ 1606000p 0.9
+ 1606010p -0.3
+ 1608000p -0.3
+ 1608010p 0.9
+ 1610000p 0.9
+ 1610010p -0.3
+ 1612000p -0.3
+ 1612010p 0.9
+ 1614000p 0.9
+ 1614010p -0.3
+ 1616000p -0.3
+ 1616010p 0.9
+ 1618000p 0.9
+ 1618010p -0.3
+ 1620000p -0.3
+ 1620010p 0.9
+ 1622000p 0.9
+ 1622010p -0.3
+ 1624000p -0.3
+ 1624010p 0.9
+ 1626000p 0.9
+ 1626010p -0.3
+ 1628000p -0.3
+ 1628010p 0.9
+ 1630000p 0.9
+ 1630010p -0.3
+ 1632000p -0.3
+ 1632010p 0.9
+ 1634000p 0.9
+ 1634010p -0.3
+ 1636000p -0.3
+ 1636010p 0.9
+ 1638000p 0.9
+ 1638010p -0.3
+ 1640000p -0.3
+ 1640010p 0.9
+ 1642000p 0.9
+ 1642010p -0.3
+ 1644000p -0.3
+ 1644010p 0.9
+ 1646000p 0.9
+ 1646010p -0.3
+ 1648000p -0.3
+ 1648010p 0.9
+ 1650000p 0.9
+ 1650010p -0.3
+ 1652000p -0.3
+ 1652010p 0.9
+ 1654000p 0.9
+ 1654010p -0.3
+ 1656000p -0.3
+ 1656010p 0.9
+ 1658000p 0.9
+ 1658010p -0.3
+ 1660000p -0.3
+ 1660010p 0.9
+ 1662000p 0.9
+ 1662010p -0.3
+ 1664000p -0.3
+ 1664010p 0.9
+ 1666000p 0.9
+ 1666010p -0.3
+ 1668000p -0.3
+ 1668010p 0.9
+ 1670000p 0.9
+ 1670010p -0.3
+ 1672000p -0.3
+ 1672010p 0.9
+ 1674000p 0.9
+ 1674010p -0.3
+ 1676000p -0.3
+ 1676010p 0.9
+ 1678000p 0.9
+ 1678010p -0.3
+ 1680000p -0.3
+ 1680010p 0.9
+ 1682000p 0.9
+ 1682010p -0.3
+ 1684000p -0.3
+ 1684010p 0.9
+ 1686000p 0.9
+ 1686010p -0.3
+ 1688000p -0.3
+ 1688010p 0.9
+ 1690000p 0.9
+ 1690010p -0.3
+ 1692000p -0.3
+ 1692010p 0.9
+ 1694000p 0.9
+ 1694010p -0.3
+ 1696000p -0.3
+ 1696010p 0.9
+ 1698000p 0.9
+ 1698010p -0.3
+ 1700000p -0.3
+ 1700010p 0.9
+ 1702000p 0.9
+ 1702010p -0.3
+ 1704000p -0.3
+ 1704010p 0.9
+ 1706000p 0.9
+ 1706010p -0.3
+ 1708000p -0.3
+ 1708010p 0.9
+ 1710000p 0.9
+ 1710010p -0.3
+ 1712000p -0.3
+ 1712010p 0.9
+ 1714000p 0.9
+ 1714010p -0.3
+ 1716000p -0.3
+ 1716010p 0.9
+ 1718000p 0.9
+ 1718010p -0.3
+ 1720000p -0.3
+ 1720010p 0.9
+ 1722000p 0.9
+ 1722010p -0.3
+ 1724000p -0.3
+ 1724010p 0.9
+ 1726000p 0.9
+ 1726010p -0.3
+ 1728000p -0.3
+ 1728010p 0.9
+ 1730000p 0.9
+ 1730010p -0.3
+ 1732000p -0.3
+ 1732010p 0.9
+ 1734000p 0.9
+ 1734010p -0.3
+ 1736000p -0.3
+ 1736010p 0.9
+ 1738000p 0.9
+ 1738010p -0.3
+ 1740000p -0.3
+ 1740010p 0.9
+ 1742000p 0.9
+ 1742010p -0.3
+ 1744000p -0.3
+ 1744010p 0.9
+ 1746000p 0.9
+ 1746010p -0.3
+ 1748000p -0.3
+ 1748010p 0.9
+ 1750000p 0.9
+ 1750010p -0.3
+ 1752000p -0.3
+ 1752010p 0.9
+ 1754000p 0.9
+ 1754010p -0.3
+ 1756000p -0.3
+ 1756010p 0.9
+ 1758000p 0.9
+ 1758010p -0.3
+ 1760000p -0.3
+ 1760010p 0.9
+ 1762000p 0.9
+ 1762010p -0.3
+ 1764000p -0.3
+ 1764010p 0.9
+ 1766000p 0.9
+ 1766010p -0.3
+ 1768000p -0.3
+ 1768010p 0.9
+ 1770000p 0.9
+ 1770010p -0.3
+ 1772000p -0.3
+ 1772010p 0.9
+ 1774000p 0.9
+ 1774010p -0.3
+ 1776000p -0.3
+ 1776010p 0.9
+ 1778000p 0.9
+ 1778010p -0.3
+ 1780000p -0.3
+ 1780010p 0.9
+ 1782000p 0.9
+ 1782010p -0.3
+ 1784000p -0.3
+ 1784010p 0.9
+ 1786000p 0.9
+ 1786010p -0.3
+ 1788000p -0.3
+ 1788010p 0.9
+ 1790000p 0.9
+ 1790010p -0.3
+ 1792000p -0.3
+ 1792010p 0.9
+ 1794000p 0.9
+ 1794010p -0.3
+ 1796000p -0.3
+ 1796010p 0.9
+ 1798000p 0.9
+ 1798010p -0.3
+ 1800000p -0.3
+ 1800010p 0.9
+ 1802000p 0.9
+ 1802010p -0.3
+ 1804000p -0.3
+ 1804010p 0.9
+ 1806000p 0.9
+ 1806010p -0.3
+ 1808000p -0.3
+ 1808010p 0.9
+ 1810000p 0.9
+ 1810010p -0.3
+ 1812000p -0.3
+ 1812010p 0.9
+ 1814000p 0.9
+ 1814010p -0.3
+ 1816000p -0.3
+ 1816010p 0.9
+ 1818000p 0.9
+ 1818010p -0.3
+ 1820000p -0.3
+ 1820010p 0.9
+ 1822000p 0.9
+ 1822010p -0.3
+ 1824000p -0.3
+ 1824010p 0.9
+ 1826000p 0.9
+ 1826010p -0.3
+ 1828000p -0.3
+ 1828010p 0.9
+ 1830000p 0.9
+ 1830010p -0.3
+ 1832000p -0.3
+ 1832010p 0.9
+ 1834000p 0.9
+ 1834010p -0.3
+ 1836000p -0.3
+ 1836010p 0.9
+ 1838000p 0.9
+ 1838010p -0.3
+ 1840000p -0.3
+ 1840010p 0.9
+ 1842000p 0.9
+ 1842010p -0.3
+ 1844000p -0.3
+ 1844010p 0.9
+ 1846000p 0.9
+ 1846010p -0.3
+ 1848000p -0.3
+ 1848010p 0.9
+ 1850000p 0.9
+ 1850010p -0.3
+ 1852000p -0.3
+ 1852010p 0.9
+ 1854000p 0.9
+ 1854010p -0.3
+ 1856000p -0.3
+ 1856010p 0.9
+ 1858000p 0.9
+ 1858010p -0.3
+ 1860000p -0.3
+ 1860010p 0.9
+ 1862000p 0.9
+ 1862010p -0.3
+ 1864000p -0.3
+ 1864010p 0.9
+ 1866000p 0.9
+ 1866010p -0.3
+ 1868000p -0.3
+ 1868010p 0.9
+ 1870000p 0.9
+ 1870010p -0.3
+ 1872000p -0.3
+ 1872010p 0.9
+ 1874000p 0.9
+ 1874010p -0.3
+ 1876000p -0.3
+ 1876010p 0.9
+ 1878000p 0.9
+ 1878010p -0.3
+ 1880000p -0.3
+ 1880010p 0.9
+ 1882000p 0.9
+ 1882010p -0.3
+ 1884000p -0.3
+ 1884010p 0.9
+ 1886000p 0.9
+ 1886010p -0.3
+ 1888000p -0.3
+ 1888010p 0.9
+ 1890000p 0.9
+ 1890010p -0.3
+ 1892000p -0.3
+ 1892010p 0.9
+ 1894000p 0.9
+ 1894010p -0.3
+ 1896000p -0.3
+ 1896010p 0.9
+ 1898000p 0.9
+ 1898010p -0.3
+ 1900000p -0.3
+ 1900010p 0.9
+ 1902000p 0.9
+ 1902010p -0.3
+ 1904000p -0.3
+ 1904010p 0.9
+ 1906000p 0.9
+ 1906010p -0.3
+ 1908000p -0.3
+ 1908010p 0.9
+ 1910000p 0.9
+ 1910010p -0.3
+ 1912000p -0.3
+ 1912010p 0.9
+ 1914000p 0.9
+ 1914010p -0.3
+ 1916000p -0.3
+ 1916010p 0.9
+ 1918000p 0.9
+ 1918010p -0.3
+ 1920000p -0.3
+ 1920010p 0.9
+ 1922000p 0.9
+ 1922010p -0.3
+ 1924000p -0.3
+ 1924010p 0.9
+ 1926000p 0.9
+ 1926010p -0.3
+ 1928000p -0.3
+ 1928010p 0.9
+ 1930000p 0.9
+ 1930010p -0.3
+ 1932000p -0.3
+ 1932010p 0.9
+ 1934000p 0.9
+ 1934010p -0.3
+ 1936000p -0.3
+ 1936010p 0.9
+ 1938000p 0.9
+ 1938010p -0.3
+ 1940000p -0.3
+ 1940010p 0.9
+ 1942000p 0.9
+ 1942010p -0.3
+ 1944000p -0.3
+ 1944010p 0.9
+ 1946000p 0.9
+ 1946010p -0.3
+ 1948000p -0.3
+ 1948010p 0.9
+ 1950000p 0.9
+ 1950010p -0.3
+ 1952000p -0.3
+ 1952010p 0.9
+ 1954000p 0.9
+ 1954010p -0.3
+ 1956000p -0.3
+ 1956010p 0.9
+ 1958000p 0.9
+ 1958010p -0.3
+ 1960000p -0.3
+ 1960010p 0.9
+ 1962000p 0.9
+ 1962010p -0.3
+ 1964000p -0.3
+ 1964010p 0.9
+ 1966000p 0.9
+ 1966010p -0.3
+ 1968000p -0.3
+ 1968010p 0.9
+ 1970000p 0.9
+ 1970010p -0.3
+ 1972000p -0.3
+ 1972010p 0.9
+ 1974000p 0.9
+ 1974010p -0.3
+ 1976000p -0.3
+ 1976010p 0.9
+ 1978000p 0.9
+ 1978010p -0.3
+ 1980000p -0.3
+ 1980010p 0.9
+ 1982000p 0.9
+ 1982010p -0.3
+ 1984000p -0.3
+ 1984010p 0.9
+ 1986000p 0.9
+ 1986010p -0.3
+ 1988000p -0.3
+ 1988010p 0.9
+ 1990000p 0.9
+ 1990010p -0.3
+ 1992000p -0.3
+ 1992010p 0.9
+ 1994000p 0.9
+ 1994010p -0.3
+ 1996000p -0.3
+ 1996010p 0.9
+ 1998000p 0.9
+ 1998010p -0.3
+ 2000000p -0.3
+ 2000010p 0.9
+ 2002000p 0.9
+ 2002010p -0.3
+ 2004000p -0.3
+ 2004010p 0.9
+ 2006000p 0.9
+ 2006010p -0.3
+ 2008000p -0.3
+ 2008010p 0.9
+ 2010000p 0.9
+ 2010010p -0.3
+ 2012000p -0.3
+ 2012010p 0.9
+ 2014000p 0.9
+ 2014010p -0.3
+ 2016000p -0.3
+ 2016010p 0.9
+ 2018000p 0.9
+ 2018010p -0.3
+ 2020000p -0.3
+ 2020010p 0.9
+ 2022000p 0.9
+ 2022010p -0.3
+ 2024000p -0.3
+ 2024010p 0.9
+ 2026000p 0.9
+ 2026010p -0.3
+ 2028000p -0.3
+ 2028010p 0.9
+ 2030000p 0.9
+ 2030010p -0.3
+ 2032000p -0.3
+ 2032010p 0.9
+ 2034000p 0.9
+ 2034010p -0.3
+ 2036000p -0.3
+ 2036010p 0.9
+ 2038000p 0.9
+ 2038010p -0.3
+ 2040000p -0.3
+ 2040010p 0.9
+ 2042000p 0.9
+ 2042010p -0.3
+ 2044000p -0.3
+ 2044010p 0.9
+ 2046000p 0.9
+ 2046010p -0.3
+ 2048000p -0.3
+ 2048010p 0.9
+ \]
V_data_bar_9 (Data_bar\\<9\\> gnd!) vsource type=pwl wave=\[
+ 0    -0.3
+ 2000p -0.3
+ 2010p 0.9
+ 4000p 0.9
+ 4010p -0.3
+ 6000p -0.3
+ 6010p 0.9
+ 8000p 0.9
+ 8010p -0.3
+ 10000p -0.3
+ 10010p 0.9
+ 12000p 0.9
+ 12010p -0.3
+ 14000p -0.3
+ 14010p 0.9
+ 16000p 0.9
+ 16010p -0.3
+ 18000p -0.3
+ 18010p 0.9
+ 20000p 0.9
+ 20010p -0.3
+ 22000p -0.3
+ 22010p 0.9
+ 24000p 0.9
+ 24010p -0.3
+ 26000p -0.3
+ 26010p 0.9
+ 28000p 0.9
+ 28010p -0.3
+ 30000p -0.3
+ 30010p 0.9
+ 32000p 0.9
+ 32010p -0.3
+ 34000p -0.3
+ 34010p 0.9
+ 36000p 0.9
+ 36010p -0.3
+ 38000p -0.3
+ 38010p 0.9
+ 40000p 0.9
+ 40010p -0.3
+ 42000p -0.3
+ 42010p 0.9
+ 44000p 0.9
+ 44010p -0.3
+ 46000p -0.3
+ 46010p 0.9
+ 48000p 0.9
+ 48010p -0.3
+ 50000p -0.3
+ 50010p 0.9
+ 52000p 0.9
+ 52010p -0.3
+ 54000p -0.3
+ 54010p 0.9
+ 56000p 0.9
+ 56010p -0.3
+ 58000p -0.3
+ 58010p 0.9
+ 60000p 0.9
+ 60010p -0.3
+ 62000p -0.3
+ 62010p 0.9
+ 64000p 0.9
+ 64010p -0.3
+ 66000p -0.3
+ 66010p 0.9
+ 68000p 0.9
+ 68010p -0.3
+ 70000p -0.3
+ 70010p 0.9
+ 72000p 0.9
+ 72010p -0.3
+ 74000p -0.3
+ 74010p 0.9
+ 76000p 0.9
+ 76010p -0.3
+ 78000p -0.3
+ 78010p 0.9
+ 80000p 0.9
+ 80010p -0.3
+ 82000p -0.3
+ 82010p 0.9
+ 84000p 0.9
+ 84010p -0.3
+ 86000p -0.3
+ 86010p 0.9
+ 88000p 0.9
+ 88010p -0.3
+ 90000p -0.3
+ 90010p 0.9
+ 92000p 0.9
+ 92010p -0.3
+ 94000p -0.3
+ 94010p 0.9
+ 96000p 0.9
+ 96010p -0.3
+ 98000p -0.3
+ 98010p 0.9
+ 100000p 0.9
+ 100010p -0.3
+ 102000p -0.3
+ 102010p 0.9
+ 104000p 0.9
+ 104010p -0.3
+ 106000p -0.3
+ 106010p 0.9
+ 108000p 0.9
+ 108010p -0.3
+ 110000p -0.3
+ 110010p 0.9
+ 112000p 0.9
+ 112010p -0.3
+ 114000p -0.3
+ 114010p 0.9
+ 116000p 0.9
+ 116010p -0.3
+ 118000p -0.3
+ 118010p 0.9
+ 120000p 0.9
+ 120010p -0.3
+ 122000p -0.3
+ 122010p 0.9
+ 124000p 0.9
+ 124010p -0.3
+ 126000p -0.3
+ 126010p 0.9
+ 128000p 0.9
+ 128010p -0.3
+ 130000p -0.3
+ 130010p 0.9
+ 132000p 0.9
+ 132010p -0.3
+ 134000p -0.3
+ 134010p 0.9
+ 136000p 0.9
+ 136010p -0.3
+ 138000p -0.3
+ 138010p 0.9
+ 140000p 0.9
+ 140010p -0.3
+ 142000p -0.3
+ 142010p 0.9
+ 144000p 0.9
+ 144010p -0.3
+ 146000p -0.3
+ 146010p 0.9
+ 148000p 0.9
+ 148010p -0.3
+ 150000p -0.3
+ 150010p 0.9
+ 152000p 0.9
+ 152010p -0.3
+ 154000p -0.3
+ 154010p 0.9
+ 156000p 0.9
+ 156010p -0.3
+ 158000p -0.3
+ 158010p 0.9
+ 160000p 0.9
+ 160010p -0.3
+ 162000p -0.3
+ 162010p 0.9
+ 164000p 0.9
+ 164010p -0.3
+ 166000p -0.3
+ 166010p 0.9
+ 168000p 0.9
+ 168010p -0.3
+ 170000p -0.3
+ 170010p 0.9
+ 172000p 0.9
+ 172010p -0.3
+ 174000p -0.3
+ 174010p 0.9
+ 176000p 0.9
+ 176010p -0.3
+ 178000p -0.3
+ 178010p 0.9
+ 180000p 0.9
+ 180010p -0.3
+ 182000p -0.3
+ 182010p 0.9
+ 184000p 0.9
+ 184010p -0.3
+ 186000p -0.3
+ 186010p 0.9
+ 188000p 0.9
+ 188010p -0.3
+ 190000p -0.3
+ 190010p 0.9
+ 192000p 0.9
+ 192010p -0.3
+ 194000p -0.3
+ 194010p 0.9
+ 196000p 0.9
+ 196010p -0.3
+ 198000p -0.3
+ 198010p 0.9
+ 200000p 0.9
+ 200010p -0.3
+ 202000p -0.3
+ 202010p 0.9
+ 204000p 0.9
+ 204010p -0.3
+ 206000p -0.3
+ 206010p 0.9
+ 208000p 0.9
+ 208010p -0.3
+ 210000p -0.3
+ 210010p 0.9
+ 212000p 0.9
+ 212010p -0.3
+ 214000p -0.3
+ 214010p 0.9
+ 216000p 0.9
+ 216010p -0.3
+ 218000p -0.3
+ 218010p 0.9
+ 220000p 0.9
+ 220010p -0.3
+ 222000p -0.3
+ 222010p 0.9
+ 224000p 0.9
+ 224010p -0.3
+ 226000p -0.3
+ 226010p 0.9
+ 228000p 0.9
+ 228010p -0.3
+ 230000p -0.3
+ 230010p 0.9
+ 232000p 0.9
+ 232010p -0.3
+ 234000p -0.3
+ 234010p 0.9
+ 236000p 0.9
+ 236010p -0.3
+ 238000p -0.3
+ 238010p 0.9
+ 240000p 0.9
+ 240010p -0.3
+ 242000p -0.3
+ 242010p 0.9
+ 244000p 0.9
+ 244010p -0.3
+ 246000p -0.3
+ 246010p 0.9
+ 248000p 0.9
+ 248010p -0.3
+ 250000p -0.3
+ 250010p 0.9
+ 252000p 0.9
+ 252010p -0.3
+ 254000p -0.3
+ 254010p 0.9
+ 256000p 0.9
+ 256010p -0.3
+ 258000p -0.3
+ 258010p 0.9
+ 260000p 0.9
+ 260010p -0.3
+ 262000p -0.3
+ 262010p 0.9
+ 264000p 0.9
+ 264010p -0.3
+ 266000p -0.3
+ 266010p 0.9
+ 268000p 0.9
+ 268010p -0.3
+ 270000p -0.3
+ 270010p 0.9
+ 272000p 0.9
+ 272010p -0.3
+ 274000p -0.3
+ 274010p 0.9
+ 276000p 0.9
+ 276010p -0.3
+ 278000p -0.3
+ 278010p 0.9
+ 280000p 0.9
+ 280010p -0.3
+ 282000p -0.3
+ 282010p 0.9
+ 284000p 0.9
+ 284010p -0.3
+ 286000p -0.3
+ 286010p 0.9
+ 288000p 0.9
+ 288010p -0.3
+ 290000p -0.3
+ 290010p 0.9
+ 292000p 0.9
+ 292010p -0.3
+ 294000p -0.3
+ 294010p 0.9
+ 296000p 0.9
+ 296010p -0.3
+ 298000p -0.3
+ 298010p 0.9
+ 300000p 0.9
+ 300010p -0.3
+ 302000p -0.3
+ 302010p 0.9
+ 304000p 0.9
+ 304010p -0.3
+ 306000p -0.3
+ 306010p 0.9
+ 308000p 0.9
+ 308010p -0.3
+ 310000p -0.3
+ 310010p 0.9
+ 312000p 0.9
+ 312010p -0.3
+ 314000p -0.3
+ 314010p 0.9
+ 316000p 0.9
+ 316010p -0.3
+ 318000p -0.3
+ 318010p 0.9
+ 320000p 0.9
+ 320010p -0.3
+ 322000p -0.3
+ 322010p 0.9
+ 324000p 0.9
+ 324010p -0.3
+ 326000p -0.3
+ 326010p 0.9
+ 328000p 0.9
+ 328010p -0.3
+ 330000p -0.3
+ 330010p 0.9
+ 332000p 0.9
+ 332010p -0.3
+ 334000p -0.3
+ 334010p 0.9
+ 336000p 0.9
+ 336010p -0.3
+ 338000p -0.3
+ 338010p 0.9
+ 340000p 0.9
+ 340010p -0.3
+ 342000p -0.3
+ 342010p 0.9
+ 344000p 0.9
+ 344010p -0.3
+ 346000p -0.3
+ 346010p 0.9
+ 348000p 0.9
+ 348010p -0.3
+ 350000p -0.3
+ 350010p 0.9
+ 352000p 0.9
+ 352010p -0.3
+ 354000p -0.3
+ 354010p 0.9
+ 356000p 0.9
+ 356010p -0.3
+ 358000p -0.3
+ 358010p 0.9
+ 360000p 0.9
+ 360010p -0.3
+ 362000p -0.3
+ 362010p 0.9
+ 364000p 0.9
+ 364010p -0.3
+ 366000p -0.3
+ 366010p 0.9
+ 368000p 0.9
+ 368010p -0.3
+ 370000p -0.3
+ 370010p 0.9
+ 372000p 0.9
+ 372010p -0.3
+ 374000p -0.3
+ 374010p 0.9
+ 376000p 0.9
+ 376010p -0.3
+ 378000p -0.3
+ 378010p 0.9
+ 380000p 0.9
+ 380010p -0.3
+ 382000p -0.3
+ 382010p 0.9
+ 384000p 0.9
+ 384010p -0.3
+ 386000p -0.3
+ 386010p 0.9
+ 388000p 0.9
+ 388010p -0.3
+ 390000p -0.3
+ 390010p 0.9
+ 392000p 0.9
+ 392010p -0.3
+ 394000p -0.3
+ 394010p 0.9
+ 396000p 0.9
+ 396010p -0.3
+ 398000p -0.3
+ 398010p 0.9
+ 400000p 0.9
+ 400010p -0.3
+ 402000p -0.3
+ 402010p 0.9
+ 404000p 0.9
+ 404010p -0.3
+ 406000p -0.3
+ 406010p 0.9
+ 408000p 0.9
+ 408010p -0.3
+ 410000p -0.3
+ 410010p 0.9
+ 412000p 0.9
+ 412010p -0.3
+ 414000p -0.3
+ 414010p 0.9
+ 416000p 0.9
+ 416010p -0.3
+ 418000p -0.3
+ 418010p 0.9
+ 420000p 0.9
+ 420010p -0.3
+ 422000p -0.3
+ 422010p 0.9
+ 424000p 0.9
+ 424010p -0.3
+ 426000p -0.3
+ 426010p 0.9
+ 428000p 0.9
+ 428010p -0.3
+ 430000p -0.3
+ 430010p 0.9
+ 432000p 0.9
+ 432010p -0.3
+ 434000p -0.3
+ 434010p 0.9
+ 436000p 0.9
+ 436010p -0.3
+ 438000p -0.3
+ 438010p 0.9
+ 440000p 0.9
+ 440010p -0.3
+ 442000p -0.3
+ 442010p 0.9
+ 444000p 0.9
+ 444010p -0.3
+ 446000p -0.3
+ 446010p 0.9
+ 448000p 0.9
+ 448010p -0.3
+ 450000p -0.3
+ 450010p 0.9
+ 452000p 0.9
+ 452010p -0.3
+ 454000p -0.3
+ 454010p 0.9
+ 456000p 0.9
+ 456010p -0.3
+ 458000p -0.3
+ 458010p 0.9
+ 460000p 0.9
+ 460010p -0.3
+ 462000p -0.3
+ 462010p 0.9
+ 464000p 0.9
+ 464010p -0.3
+ 466000p -0.3
+ 466010p 0.9
+ 468000p 0.9
+ 468010p -0.3
+ 470000p -0.3
+ 470010p 0.9
+ 472000p 0.9
+ 472010p -0.3
+ 474000p -0.3
+ 474010p 0.9
+ 476000p 0.9
+ 476010p -0.3
+ 478000p -0.3
+ 478010p 0.9
+ 480000p 0.9
+ 480010p -0.3
+ 482000p -0.3
+ 482010p 0.9
+ 484000p 0.9
+ 484010p -0.3
+ 486000p -0.3
+ 486010p 0.9
+ 488000p 0.9
+ 488010p -0.3
+ 490000p -0.3
+ 490010p 0.9
+ 492000p 0.9
+ 492010p -0.3
+ 494000p -0.3
+ 494010p 0.9
+ 496000p 0.9
+ 496010p -0.3
+ 498000p -0.3
+ 498010p 0.9
+ 500000p 0.9
+ 500010p -0.3
+ 502000p -0.3
+ 502010p 0.9
+ 504000p 0.9
+ 504010p -0.3
+ 506000p -0.3
+ 506010p 0.9
+ 508000p 0.9
+ 508010p -0.3
+ 510000p -0.3
+ 510010p 0.9
+ 512000p 0.9
+ 512010p -0.3
+ 514000p -0.3
+ 514010p 0.9
+ 516000p 0.9
+ 516010p -0.3
+ 518000p -0.3
+ 518010p 0.9
+ 520000p 0.9
+ 520010p -0.3
+ 522000p -0.3
+ 522010p 0.9
+ 524000p 0.9
+ 524010p -0.3
+ 526000p -0.3
+ 526010p 0.9
+ 528000p 0.9
+ 528010p -0.3
+ 530000p -0.3
+ 530010p 0.9
+ 532000p 0.9
+ 532010p -0.3
+ 534000p -0.3
+ 534010p 0.9
+ 536000p 0.9
+ 536010p -0.3
+ 538000p -0.3
+ 538010p 0.9
+ 540000p 0.9
+ 540010p -0.3
+ 542000p -0.3
+ 542010p 0.9
+ 544000p 0.9
+ 544010p -0.3
+ 546000p -0.3
+ 546010p 0.9
+ 548000p 0.9
+ 548010p -0.3
+ 550000p -0.3
+ 550010p 0.9
+ 552000p 0.9
+ 552010p -0.3
+ 554000p -0.3
+ 554010p 0.9
+ 556000p 0.9
+ 556010p -0.3
+ 558000p -0.3
+ 558010p 0.9
+ 560000p 0.9
+ 560010p -0.3
+ 562000p -0.3
+ 562010p 0.9
+ 564000p 0.9
+ 564010p -0.3
+ 566000p -0.3
+ 566010p 0.9
+ 568000p 0.9
+ 568010p -0.3
+ 570000p -0.3
+ 570010p 0.9
+ 572000p 0.9
+ 572010p -0.3
+ 574000p -0.3
+ 574010p 0.9
+ 576000p 0.9
+ 576010p -0.3
+ 578000p -0.3
+ 578010p 0.9
+ 580000p 0.9
+ 580010p -0.3
+ 582000p -0.3
+ 582010p 0.9
+ 584000p 0.9
+ 584010p -0.3
+ 586000p -0.3
+ 586010p 0.9
+ 588000p 0.9
+ 588010p -0.3
+ 590000p -0.3
+ 590010p 0.9
+ 592000p 0.9
+ 592010p -0.3
+ 594000p -0.3
+ 594010p 0.9
+ 596000p 0.9
+ 596010p -0.3
+ 598000p -0.3
+ 598010p 0.9
+ 600000p 0.9
+ 600010p -0.3
+ 602000p -0.3
+ 602010p 0.9
+ 604000p 0.9
+ 604010p -0.3
+ 606000p -0.3
+ 606010p 0.9
+ 608000p 0.9
+ 608010p -0.3
+ 610000p -0.3
+ 610010p 0.9
+ 612000p 0.9
+ 612010p -0.3
+ 614000p -0.3
+ 614010p 0.9
+ 616000p 0.9
+ 616010p -0.3
+ 618000p -0.3
+ 618010p 0.9
+ 620000p 0.9
+ 620010p -0.3
+ 622000p -0.3
+ 622010p 0.9
+ 624000p 0.9
+ 624010p -0.3
+ 626000p -0.3
+ 626010p 0.9
+ 628000p 0.9
+ 628010p -0.3
+ 630000p -0.3
+ 630010p 0.9
+ 632000p 0.9
+ 632010p -0.3
+ 634000p -0.3
+ 634010p 0.9
+ 636000p 0.9
+ 636010p -0.3
+ 638000p -0.3
+ 638010p 0.9
+ 640000p 0.9
+ 640010p -0.3
+ 642000p -0.3
+ 642010p 0.9
+ 644000p 0.9
+ 644010p -0.3
+ 646000p -0.3
+ 646010p 0.9
+ 648000p 0.9
+ 648010p -0.3
+ 650000p -0.3
+ 650010p 0.9
+ 652000p 0.9
+ 652010p -0.3
+ 654000p -0.3
+ 654010p 0.9
+ 656000p 0.9
+ 656010p -0.3
+ 658000p -0.3
+ 658010p 0.9
+ 660000p 0.9
+ 660010p -0.3
+ 662000p -0.3
+ 662010p 0.9
+ 664000p 0.9
+ 664010p -0.3
+ 666000p -0.3
+ 666010p 0.9
+ 668000p 0.9
+ 668010p -0.3
+ 670000p -0.3
+ 670010p 0.9
+ 672000p 0.9
+ 672010p -0.3
+ 674000p -0.3
+ 674010p 0.9
+ 676000p 0.9
+ 676010p -0.3
+ 678000p -0.3
+ 678010p 0.9
+ 680000p 0.9
+ 680010p -0.3
+ 682000p -0.3
+ 682010p 0.9
+ 684000p 0.9
+ 684010p -0.3
+ 686000p -0.3
+ 686010p 0.9
+ 688000p 0.9
+ 688010p -0.3
+ 690000p -0.3
+ 690010p 0.9
+ 692000p 0.9
+ 692010p -0.3
+ 694000p -0.3
+ 694010p 0.9
+ 696000p 0.9
+ 696010p -0.3
+ 698000p -0.3
+ 698010p 0.9
+ 700000p 0.9
+ 700010p -0.3
+ 702000p -0.3
+ 702010p 0.9
+ 704000p 0.9
+ 704010p -0.3
+ 706000p -0.3
+ 706010p 0.9
+ 708000p 0.9
+ 708010p -0.3
+ 710000p -0.3
+ 710010p 0.9
+ 712000p 0.9
+ 712010p -0.3
+ 714000p -0.3
+ 714010p 0.9
+ 716000p 0.9
+ 716010p -0.3
+ 718000p -0.3
+ 718010p 0.9
+ 720000p 0.9
+ 720010p -0.3
+ 722000p -0.3
+ 722010p 0.9
+ 724000p 0.9
+ 724010p -0.3
+ 726000p -0.3
+ 726010p 0.9
+ 728000p 0.9
+ 728010p -0.3
+ 730000p -0.3
+ 730010p 0.9
+ 732000p 0.9
+ 732010p -0.3
+ 734000p -0.3
+ 734010p 0.9
+ 736000p 0.9
+ 736010p -0.3
+ 738000p -0.3
+ 738010p 0.9
+ 740000p 0.9
+ 740010p -0.3
+ 742000p -0.3
+ 742010p 0.9
+ 744000p 0.9
+ 744010p -0.3
+ 746000p -0.3
+ 746010p 0.9
+ 748000p 0.9
+ 748010p -0.3
+ 750000p -0.3
+ 750010p 0.9
+ 752000p 0.9
+ 752010p -0.3
+ 754000p -0.3
+ 754010p 0.9
+ 756000p 0.9
+ 756010p -0.3
+ 758000p -0.3
+ 758010p 0.9
+ 760000p 0.9
+ 760010p -0.3
+ 762000p -0.3
+ 762010p 0.9
+ 764000p 0.9
+ 764010p -0.3
+ 766000p -0.3
+ 766010p 0.9
+ 768000p 0.9
+ 768010p -0.3
+ 770000p -0.3
+ 770010p 0.9
+ 772000p 0.9
+ 772010p -0.3
+ 774000p -0.3
+ 774010p 0.9
+ 776000p 0.9
+ 776010p -0.3
+ 778000p -0.3
+ 778010p 0.9
+ 780000p 0.9
+ 780010p -0.3
+ 782000p -0.3
+ 782010p 0.9
+ 784000p 0.9
+ 784010p -0.3
+ 786000p -0.3
+ 786010p 0.9
+ 788000p 0.9
+ 788010p -0.3
+ 790000p -0.3
+ 790010p 0.9
+ 792000p 0.9
+ 792010p -0.3
+ 794000p -0.3
+ 794010p 0.9
+ 796000p 0.9
+ 796010p -0.3
+ 798000p -0.3
+ 798010p 0.9
+ 800000p 0.9
+ 800010p -0.3
+ 802000p -0.3
+ 802010p 0.9
+ 804000p 0.9
+ 804010p -0.3
+ 806000p -0.3
+ 806010p 0.9
+ 808000p 0.9
+ 808010p -0.3
+ 810000p -0.3
+ 810010p 0.9
+ 812000p 0.9
+ 812010p -0.3
+ 814000p -0.3
+ 814010p 0.9
+ 816000p 0.9
+ 816010p -0.3
+ 818000p -0.3
+ 818010p 0.9
+ 820000p 0.9
+ 820010p -0.3
+ 822000p -0.3
+ 822010p 0.9
+ 824000p 0.9
+ 824010p -0.3
+ 826000p -0.3
+ 826010p 0.9
+ 828000p 0.9
+ 828010p -0.3
+ 830000p -0.3
+ 830010p 0.9
+ 832000p 0.9
+ 832010p -0.3
+ 834000p -0.3
+ 834010p 0.9
+ 836000p 0.9
+ 836010p -0.3
+ 838000p -0.3
+ 838010p 0.9
+ 840000p 0.9
+ 840010p -0.3
+ 842000p -0.3
+ 842010p 0.9
+ 844000p 0.9
+ 844010p -0.3
+ 846000p -0.3
+ 846010p 0.9
+ 848000p 0.9
+ 848010p -0.3
+ 850000p -0.3
+ 850010p 0.9
+ 852000p 0.9
+ 852010p -0.3
+ 854000p -0.3
+ 854010p 0.9
+ 856000p 0.9
+ 856010p -0.3
+ 858000p -0.3
+ 858010p 0.9
+ 860000p 0.9
+ 860010p -0.3
+ 862000p -0.3
+ 862010p 0.9
+ 864000p 0.9
+ 864010p -0.3
+ 866000p -0.3
+ 866010p 0.9
+ 868000p 0.9
+ 868010p -0.3
+ 870000p -0.3
+ 870010p 0.9
+ 872000p 0.9
+ 872010p -0.3
+ 874000p -0.3
+ 874010p 0.9
+ 876000p 0.9
+ 876010p -0.3
+ 878000p -0.3
+ 878010p 0.9
+ 880000p 0.9
+ 880010p -0.3
+ 882000p -0.3
+ 882010p 0.9
+ 884000p 0.9
+ 884010p -0.3
+ 886000p -0.3
+ 886010p 0.9
+ 888000p 0.9
+ 888010p -0.3
+ 890000p -0.3
+ 890010p 0.9
+ 892000p 0.9
+ 892010p -0.3
+ 894000p -0.3
+ 894010p 0.9
+ 896000p 0.9
+ 896010p -0.3
+ 898000p -0.3
+ 898010p 0.9
+ 900000p 0.9
+ 900010p -0.3
+ 902000p -0.3
+ 902010p 0.9
+ 904000p 0.9
+ 904010p -0.3
+ 906000p -0.3
+ 906010p 0.9
+ 908000p 0.9
+ 908010p -0.3
+ 910000p -0.3
+ 910010p 0.9
+ 912000p 0.9
+ 912010p -0.3
+ 914000p -0.3
+ 914010p 0.9
+ 916000p 0.9
+ 916010p -0.3
+ 918000p -0.3
+ 918010p 0.9
+ 920000p 0.9
+ 920010p -0.3
+ 922000p -0.3
+ 922010p 0.9
+ 924000p 0.9
+ 924010p -0.3
+ 926000p -0.3
+ 926010p 0.9
+ 928000p 0.9
+ 928010p -0.3
+ 930000p -0.3
+ 930010p 0.9
+ 932000p 0.9
+ 932010p -0.3
+ 934000p -0.3
+ 934010p 0.9
+ 936000p 0.9
+ 936010p -0.3
+ 938000p -0.3
+ 938010p 0.9
+ 940000p 0.9
+ 940010p -0.3
+ 942000p -0.3
+ 942010p 0.9
+ 944000p 0.9
+ 944010p -0.3
+ 946000p -0.3
+ 946010p 0.9
+ 948000p 0.9
+ 948010p -0.3
+ 950000p -0.3
+ 950010p 0.9
+ 952000p 0.9
+ 952010p -0.3
+ 954000p -0.3
+ 954010p 0.9
+ 956000p 0.9
+ 956010p -0.3
+ 958000p -0.3
+ 958010p 0.9
+ 960000p 0.9
+ 960010p -0.3
+ 962000p -0.3
+ 962010p 0.9
+ 964000p 0.9
+ 964010p -0.3
+ 966000p -0.3
+ 966010p 0.9
+ 968000p 0.9
+ 968010p -0.3
+ 970000p -0.3
+ 970010p 0.9
+ 972000p 0.9
+ 972010p -0.3
+ 974000p -0.3
+ 974010p 0.9
+ 976000p 0.9
+ 976010p -0.3
+ 978000p -0.3
+ 978010p 0.9
+ 980000p 0.9
+ 980010p -0.3
+ 982000p -0.3
+ 982010p 0.9
+ 984000p 0.9
+ 984010p -0.3
+ 986000p -0.3
+ 986010p 0.9
+ 988000p 0.9
+ 988010p -0.3
+ 990000p -0.3
+ 990010p 0.9
+ 992000p 0.9
+ 992010p -0.3
+ 994000p -0.3
+ 994010p 0.9
+ 996000p 0.9
+ 996010p -0.3
+ 998000p -0.3
+ 998010p 0.9
+ 1000000p 0.9
+ 1000010p -0.3
+ 1002000p -0.3
+ 1002010p 0.9
+ 1004000p 0.9
+ 1004010p -0.3
+ 1006000p -0.3
+ 1006010p 0.9
+ 1008000p 0.9
+ 1008010p -0.3
+ 1010000p -0.3
+ 1010010p 0.9
+ 1012000p 0.9
+ 1012010p -0.3
+ 1014000p -0.3
+ 1014010p 0.9
+ 1016000p 0.9
+ 1016010p -0.3
+ 1018000p -0.3
+ 1018010p 0.9
+ 1020000p 0.9
+ 1020010p -0.3
+ 1022000p -0.3
+ 1022010p 0.9
+ 1024000p 0.9
+ 1024010p -0.3
+ 1026000p -0.3
+ 1026010p 0.9
+ 1028000p 0.9
+ 1028010p -0.3
+ 1030000p -0.3
+ 1030010p 0.9
+ 1032000p 0.9
+ 1032010p -0.3
+ 1034000p -0.3
+ 1034010p 0.9
+ 1036000p 0.9
+ 1036010p -0.3
+ 1038000p -0.3
+ 1038010p 0.9
+ 1040000p 0.9
+ 1040010p -0.3
+ 1042000p -0.3
+ 1042010p 0.9
+ 1044000p 0.9
+ 1044010p -0.3
+ 1046000p -0.3
+ 1046010p 0.9
+ 1048000p 0.9
+ 1048010p -0.3
+ 1050000p -0.3
+ 1050010p 0.9
+ 1052000p 0.9
+ 1052010p -0.3
+ 1054000p -0.3
+ 1054010p 0.9
+ 1056000p 0.9
+ 1056010p -0.3
+ 1058000p -0.3
+ 1058010p 0.9
+ 1060000p 0.9
+ 1060010p -0.3
+ 1062000p -0.3
+ 1062010p 0.9
+ 1064000p 0.9
+ 1064010p -0.3
+ 1066000p -0.3
+ 1066010p 0.9
+ 1068000p 0.9
+ 1068010p -0.3
+ 1070000p -0.3
+ 1070010p 0.9
+ 1072000p 0.9
+ 1072010p -0.3
+ 1074000p -0.3
+ 1074010p 0.9
+ 1076000p 0.9
+ 1076010p -0.3
+ 1078000p -0.3
+ 1078010p 0.9
+ 1080000p 0.9
+ 1080010p -0.3
+ 1082000p -0.3
+ 1082010p 0.9
+ 1084000p 0.9
+ 1084010p -0.3
+ 1086000p -0.3
+ 1086010p 0.9
+ 1088000p 0.9
+ 1088010p -0.3
+ 1090000p -0.3
+ 1090010p 0.9
+ 1092000p 0.9
+ 1092010p -0.3
+ 1094000p -0.3
+ 1094010p 0.9
+ 1096000p 0.9
+ 1096010p -0.3
+ 1098000p -0.3
+ 1098010p 0.9
+ 1100000p 0.9
+ 1100010p -0.3
+ 1102000p -0.3
+ 1102010p 0.9
+ 1104000p 0.9
+ 1104010p -0.3
+ 1106000p -0.3
+ 1106010p 0.9
+ 1108000p 0.9
+ 1108010p -0.3
+ 1110000p -0.3
+ 1110010p 0.9
+ 1112000p 0.9
+ 1112010p -0.3
+ 1114000p -0.3
+ 1114010p 0.9
+ 1116000p 0.9
+ 1116010p -0.3
+ 1118000p -0.3
+ 1118010p 0.9
+ 1120000p 0.9
+ 1120010p -0.3
+ 1122000p -0.3
+ 1122010p 0.9
+ 1124000p 0.9
+ 1124010p -0.3
+ 1126000p -0.3
+ 1126010p 0.9
+ 1128000p 0.9
+ 1128010p -0.3
+ 1130000p -0.3
+ 1130010p 0.9
+ 1132000p 0.9
+ 1132010p -0.3
+ 1134000p -0.3
+ 1134010p 0.9
+ 1136000p 0.9
+ 1136010p -0.3
+ 1138000p -0.3
+ 1138010p 0.9
+ 1140000p 0.9
+ 1140010p -0.3
+ 1142000p -0.3
+ 1142010p 0.9
+ 1144000p 0.9
+ 1144010p -0.3
+ 1146000p -0.3
+ 1146010p 0.9
+ 1148000p 0.9
+ 1148010p -0.3
+ 1150000p -0.3
+ 1150010p 0.9
+ 1152000p 0.9
+ 1152010p -0.3
+ 1154000p -0.3
+ 1154010p 0.9
+ 1156000p 0.9
+ 1156010p -0.3
+ 1158000p -0.3
+ 1158010p 0.9
+ 1160000p 0.9
+ 1160010p -0.3
+ 1162000p -0.3
+ 1162010p 0.9
+ 1164000p 0.9
+ 1164010p -0.3
+ 1166000p -0.3
+ 1166010p 0.9
+ 1168000p 0.9
+ 1168010p -0.3
+ 1170000p -0.3
+ 1170010p 0.9
+ 1172000p 0.9
+ 1172010p -0.3
+ 1174000p -0.3
+ 1174010p 0.9
+ 1176000p 0.9
+ 1176010p -0.3
+ 1178000p -0.3
+ 1178010p 0.9
+ 1180000p 0.9
+ 1180010p -0.3
+ 1182000p -0.3
+ 1182010p 0.9
+ 1184000p 0.9
+ 1184010p -0.3
+ 1186000p -0.3
+ 1186010p 0.9
+ 1188000p 0.9
+ 1188010p -0.3
+ 1190000p -0.3
+ 1190010p 0.9
+ 1192000p 0.9
+ 1192010p -0.3
+ 1194000p -0.3
+ 1194010p 0.9
+ 1196000p 0.9
+ 1196010p -0.3
+ 1198000p -0.3
+ 1198010p 0.9
+ 1200000p 0.9
+ 1200010p -0.3
+ 1202000p -0.3
+ 1202010p 0.9
+ 1204000p 0.9
+ 1204010p -0.3
+ 1206000p -0.3
+ 1206010p 0.9
+ 1208000p 0.9
+ 1208010p -0.3
+ 1210000p -0.3
+ 1210010p 0.9
+ 1212000p 0.9
+ 1212010p -0.3
+ 1214000p -0.3
+ 1214010p 0.9
+ 1216000p 0.9
+ 1216010p -0.3
+ 1218000p -0.3
+ 1218010p 0.9
+ 1220000p 0.9
+ 1220010p -0.3
+ 1222000p -0.3
+ 1222010p 0.9
+ 1224000p 0.9
+ 1224010p -0.3
+ 1226000p -0.3
+ 1226010p 0.9
+ 1228000p 0.9
+ 1228010p -0.3
+ 1230000p -0.3
+ 1230010p 0.9
+ 1232000p 0.9
+ 1232010p -0.3
+ 1234000p -0.3
+ 1234010p 0.9
+ 1236000p 0.9
+ 1236010p -0.3
+ 1238000p -0.3
+ 1238010p 0.9
+ 1240000p 0.9
+ 1240010p -0.3
+ 1242000p -0.3
+ 1242010p 0.9
+ 1244000p 0.9
+ 1244010p -0.3
+ 1246000p -0.3
+ 1246010p 0.9
+ 1248000p 0.9
+ 1248010p -0.3
+ 1250000p -0.3
+ 1250010p 0.9
+ 1252000p 0.9
+ 1252010p -0.3
+ 1254000p -0.3
+ 1254010p 0.9
+ 1256000p 0.9
+ 1256010p -0.3
+ 1258000p -0.3
+ 1258010p 0.9
+ 1260000p 0.9
+ 1260010p -0.3
+ 1262000p -0.3
+ 1262010p 0.9
+ 1264000p 0.9
+ 1264010p -0.3
+ 1266000p -0.3
+ 1266010p 0.9
+ 1268000p 0.9
+ 1268010p -0.3
+ 1270000p -0.3
+ 1270010p 0.9
+ 1272000p 0.9
+ 1272010p -0.3
+ 1274000p -0.3
+ 1274010p 0.9
+ 1276000p 0.9
+ 1276010p -0.3
+ 1278000p -0.3
+ 1278010p 0.9
+ 1280000p 0.9
+ 1280010p -0.3
+ 1282000p -0.3
+ 1282010p 0.9
+ 1284000p 0.9
+ 1284010p -0.3
+ 1286000p -0.3
+ 1286010p 0.9
+ 1288000p 0.9
+ 1288010p -0.3
+ 1290000p -0.3
+ 1290010p 0.9
+ 1292000p 0.9
+ 1292010p -0.3
+ 1294000p -0.3
+ 1294010p 0.9
+ 1296000p 0.9
+ 1296010p -0.3
+ 1298000p -0.3
+ 1298010p 0.9
+ 1300000p 0.9
+ 1300010p -0.3
+ 1302000p -0.3
+ 1302010p 0.9
+ 1304000p 0.9
+ 1304010p -0.3
+ 1306000p -0.3
+ 1306010p 0.9
+ 1308000p 0.9
+ 1308010p -0.3
+ 1310000p -0.3
+ 1310010p 0.9
+ 1312000p 0.9
+ 1312010p -0.3
+ 1314000p -0.3
+ 1314010p 0.9
+ 1316000p 0.9
+ 1316010p -0.3
+ 1318000p -0.3
+ 1318010p 0.9
+ 1320000p 0.9
+ 1320010p -0.3
+ 1322000p -0.3
+ 1322010p 0.9
+ 1324000p 0.9
+ 1324010p -0.3
+ 1326000p -0.3
+ 1326010p 0.9
+ 1328000p 0.9
+ 1328010p -0.3
+ 1330000p -0.3
+ 1330010p 0.9
+ 1332000p 0.9
+ 1332010p -0.3
+ 1334000p -0.3
+ 1334010p 0.9
+ 1336000p 0.9
+ 1336010p -0.3
+ 1338000p -0.3
+ 1338010p 0.9
+ 1340000p 0.9
+ 1340010p -0.3
+ 1342000p -0.3
+ 1342010p 0.9
+ 1344000p 0.9
+ 1344010p -0.3
+ 1346000p -0.3
+ 1346010p 0.9
+ 1348000p 0.9
+ 1348010p -0.3
+ 1350000p -0.3
+ 1350010p 0.9
+ 1352000p 0.9
+ 1352010p -0.3
+ 1354000p -0.3
+ 1354010p 0.9
+ 1356000p 0.9
+ 1356010p -0.3
+ 1358000p -0.3
+ 1358010p 0.9
+ 1360000p 0.9
+ 1360010p -0.3
+ 1362000p -0.3
+ 1362010p 0.9
+ 1364000p 0.9
+ 1364010p -0.3
+ 1366000p -0.3
+ 1366010p 0.9
+ 1368000p 0.9
+ 1368010p -0.3
+ 1370000p -0.3
+ 1370010p 0.9
+ 1372000p 0.9
+ 1372010p -0.3
+ 1374000p -0.3
+ 1374010p 0.9
+ 1376000p 0.9
+ 1376010p -0.3
+ 1378000p -0.3
+ 1378010p 0.9
+ 1380000p 0.9
+ 1380010p -0.3
+ 1382000p -0.3
+ 1382010p 0.9
+ 1384000p 0.9
+ 1384010p -0.3
+ 1386000p -0.3
+ 1386010p 0.9
+ 1388000p 0.9
+ 1388010p -0.3
+ 1390000p -0.3
+ 1390010p 0.9
+ 1392000p 0.9
+ 1392010p -0.3
+ 1394000p -0.3
+ 1394010p 0.9
+ 1396000p 0.9
+ 1396010p -0.3
+ 1398000p -0.3
+ 1398010p 0.9
+ 1400000p 0.9
+ 1400010p -0.3
+ 1402000p -0.3
+ 1402010p 0.9
+ 1404000p 0.9
+ 1404010p -0.3
+ 1406000p -0.3
+ 1406010p 0.9
+ 1408000p 0.9
+ 1408010p -0.3
+ 1410000p -0.3
+ 1410010p 0.9
+ 1412000p 0.9
+ 1412010p -0.3
+ 1414000p -0.3
+ 1414010p 0.9
+ 1416000p 0.9
+ 1416010p -0.3
+ 1418000p -0.3
+ 1418010p 0.9
+ 1420000p 0.9
+ 1420010p -0.3
+ 1422000p -0.3
+ 1422010p 0.9
+ 1424000p 0.9
+ 1424010p -0.3
+ 1426000p -0.3
+ 1426010p 0.9
+ 1428000p 0.9
+ 1428010p -0.3
+ 1430000p -0.3
+ 1430010p 0.9
+ 1432000p 0.9
+ 1432010p -0.3
+ 1434000p -0.3
+ 1434010p 0.9
+ 1436000p 0.9
+ 1436010p -0.3
+ 1438000p -0.3
+ 1438010p 0.9
+ 1440000p 0.9
+ 1440010p -0.3
+ 1442000p -0.3
+ 1442010p 0.9
+ 1444000p 0.9
+ 1444010p -0.3
+ 1446000p -0.3
+ 1446010p 0.9
+ 1448000p 0.9
+ 1448010p -0.3
+ 1450000p -0.3
+ 1450010p 0.9
+ 1452000p 0.9
+ 1452010p -0.3
+ 1454000p -0.3
+ 1454010p 0.9
+ 1456000p 0.9
+ 1456010p -0.3
+ 1458000p -0.3
+ 1458010p 0.9
+ 1460000p 0.9
+ 1460010p -0.3
+ 1462000p -0.3
+ 1462010p 0.9
+ 1464000p 0.9
+ 1464010p -0.3
+ 1466000p -0.3
+ 1466010p 0.9
+ 1468000p 0.9
+ 1468010p -0.3
+ 1470000p -0.3
+ 1470010p 0.9
+ 1472000p 0.9
+ 1472010p -0.3
+ 1474000p -0.3
+ 1474010p 0.9
+ 1476000p 0.9
+ 1476010p -0.3
+ 1478000p -0.3
+ 1478010p 0.9
+ 1480000p 0.9
+ 1480010p -0.3
+ 1482000p -0.3
+ 1482010p 0.9
+ 1484000p 0.9
+ 1484010p -0.3
+ 1486000p -0.3
+ 1486010p 0.9
+ 1488000p 0.9
+ 1488010p -0.3
+ 1490000p -0.3
+ 1490010p 0.9
+ 1492000p 0.9
+ 1492010p -0.3
+ 1494000p -0.3
+ 1494010p 0.9
+ 1496000p 0.9
+ 1496010p -0.3
+ 1498000p -0.3
+ 1498010p 0.9
+ 1500000p 0.9
+ 1500010p -0.3
+ 1502000p -0.3
+ 1502010p 0.9
+ 1504000p 0.9
+ 1504010p -0.3
+ 1506000p -0.3
+ 1506010p 0.9
+ 1508000p 0.9
+ 1508010p -0.3
+ 1510000p -0.3
+ 1510010p 0.9
+ 1512000p 0.9
+ 1512010p -0.3
+ 1514000p -0.3
+ 1514010p 0.9
+ 1516000p 0.9
+ 1516010p -0.3
+ 1518000p -0.3
+ 1518010p 0.9
+ 1520000p 0.9
+ 1520010p -0.3
+ 1522000p -0.3
+ 1522010p 0.9
+ 1524000p 0.9
+ 1524010p -0.3
+ 1526000p -0.3
+ 1526010p 0.9
+ 1528000p 0.9
+ 1528010p -0.3
+ 1530000p -0.3
+ 1530010p 0.9
+ 1532000p 0.9
+ 1532010p -0.3
+ 1534000p -0.3
+ 1534010p 0.9
+ 1536000p 0.9
+ 1536010p -0.3
+ 1538000p -0.3
+ 1538010p 0.9
+ 1540000p 0.9
+ 1540010p -0.3
+ 1542000p -0.3
+ 1542010p 0.9
+ 1544000p 0.9
+ 1544010p -0.3
+ 1546000p -0.3
+ 1546010p 0.9
+ 1548000p 0.9
+ 1548010p -0.3
+ 1550000p -0.3
+ 1550010p 0.9
+ 1552000p 0.9
+ 1552010p -0.3
+ 1554000p -0.3
+ 1554010p 0.9
+ 1556000p 0.9
+ 1556010p -0.3
+ 1558000p -0.3
+ 1558010p 0.9
+ 1560000p 0.9
+ 1560010p -0.3
+ 1562000p -0.3
+ 1562010p 0.9
+ 1564000p 0.9
+ 1564010p -0.3
+ 1566000p -0.3
+ 1566010p 0.9
+ 1568000p 0.9
+ 1568010p -0.3
+ 1570000p -0.3
+ 1570010p 0.9
+ 1572000p 0.9
+ 1572010p -0.3
+ 1574000p -0.3
+ 1574010p 0.9
+ 1576000p 0.9
+ 1576010p -0.3
+ 1578000p -0.3
+ 1578010p 0.9
+ 1580000p 0.9
+ 1580010p -0.3
+ 1582000p -0.3
+ 1582010p 0.9
+ 1584000p 0.9
+ 1584010p -0.3
+ 1586000p -0.3
+ 1586010p 0.9
+ 1588000p 0.9
+ 1588010p -0.3
+ 1590000p -0.3
+ 1590010p 0.9
+ 1592000p 0.9
+ 1592010p -0.3
+ 1594000p -0.3
+ 1594010p 0.9
+ 1596000p 0.9
+ 1596010p -0.3
+ 1598000p -0.3
+ 1598010p 0.9
+ 1600000p 0.9
+ 1600010p -0.3
+ 1602000p -0.3
+ 1602010p 0.9
+ 1604000p 0.9
+ 1604010p -0.3
+ 1606000p -0.3
+ 1606010p 0.9
+ 1608000p 0.9
+ 1608010p -0.3
+ 1610000p -0.3
+ 1610010p 0.9
+ 1612000p 0.9
+ 1612010p -0.3
+ 1614000p -0.3
+ 1614010p 0.9
+ 1616000p 0.9
+ 1616010p -0.3
+ 1618000p -0.3
+ 1618010p 0.9
+ 1620000p 0.9
+ 1620010p -0.3
+ 1622000p -0.3
+ 1622010p 0.9
+ 1624000p 0.9
+ 1624010p -0.3
+ 1626000p -0.3
+ 1626010p 0.9
+ 1628000p 0.9
+ 1628010p -0.3
+ 1630000p -0.3
+ 1630010p 0.9
+ 1632000p 0.9
+ 1632010p -0.3
+ 1634000p -0.3
+ 1634010p 0.9
+ 1636000p 0.9
+ 1636010p -0.3
+ 1638000p -0.3
+ 1638010p 0.9
+ 1640000p 0.9
+ 1640010p -0.3
+ 1642000p -0.3
+ 1642010p 0.9
+ 1644000p 0.9
+ 1644010p -0.3
+ 1646000p -0.3
+ 1646010p 0.9
+ 1648000p 0.9
+ 1648010p -0.3
+ 1650000p -0.3
+ 1650010p 0.9
+ 1652000p 0.9
+ 1652010p -0.3
+ 1654000p -0.3
+ 1654010p 0.9
+ 1656000p 0.9
+ 1656010p -0.3
+ 1658000p -0.3
+ 1658010p 0.9
+ 1660000p 0.9
+ 1660010p -0.3
+ 1662000p -0.3
+ 1662010p 0.9
+ 1664000p 0.9
+ 1664010p -0.3
+ 1666000p -0.3
+ 1666010p 0.9
+ 1668000p 0.9
+ 1668010p -0.3
+ 1670000p -0.3
+ 1670010p 0.9
+ 1672000p 0.9
+ 1672010p -0.3
+ 1674000p -0.3
+ 1674010p 0.9
+ 1676000p 0.9
+ 1676010p -0.3
+ 1678000p -0.3
+ 1678010p 0.9
+ 1680000p 0.9
+ 1680010p -0.3
+ 1682000p -0.3
+ 1682010p 0.9
+ 1684000p 0.9
+ 1684010p -0.3
+ 1686000p -0.3
+ 1686010p 0.9
+ 1688000p 0.9
+ 1688010p -0.3
+ 1690000p -0.3
+ 1690010p 0.9
+ 1692000p 0.9
+ 1692010p -0.3
+ 1694000p -0.3
+ 1694010p 0.9
+ 1696000p 0.9
+ 1696010p -0.3
+ 1698000p -0.3
+ 1698010p 0.9
+ 1700000p 0.9
+ 1700010p -0.3
+ 1702000p -0.3
+ 1702010p 0.9
+ 1704000p 0.9
+ 1704010p -0.3
+ 1706000p -0.3
+ 1706010p 0.9
+ 1708000p 0.9
+ 1708010p -0.3
+ 1710000p -0.3
+ 1710010p 0.9
+ 1712000p 0.9
+ 1712010p -0.3
+ 1714000p -0.3
+ 1714010p 0.9
+ 1716000p 0.9
+ 1716010p -0.3
+ 1718000p -0.3
+ 1718010p 0.9
+ 1720000p 0.9
+ 1720010p -0.3
+ 1722000p -0.3
+ 1722010p 0.9
+ 1724000p 0.9
+ 1724010p -0.3
+ 1726000p -0.3
+ 1726010p 0.9
+ 1728000p 0.9
+ 1728010p -0.3
+ 1730000p -0.3
+ 1730010p 0.9
+ 1732000p 0.9
+ 1732010p -0.3
+ 1734000p -0.3
+ 1734010p 0.9
+ 1736000p 0.9
+ 1736010p -0.3
+ 1738000p -0.3
+ 1738010p 0.9
+ 1740000p 0.9
+ 1740010p -0.3
+ 1742000p -0.3
+ 1742010p 0.9
+ 1744000p 0.9
+ 1744010p -0.3
+ 1746000p -0.3
+ 1746010p 0.9
+ 1748000p 0.9
+ 1748010p -0.3
+ 1750000p -0.3
+ 1750010p 0.9
+ 1752000p 0.9
+ 1752010p -0.3
+ 1754000p -0.3
+ 1754010p 0.9
+ 1756000p 0.9
+ 1756010p -0.3
+ 1758000p -0.3
+ 1758010p 0.9
+ 1760000p 0.9
+ 1760010p -0.3
+ 1762000p -0.3
+ 1762010p 0.9
+ 1764000p 0.9
+ 1764010p -0.3
+ 1766000p -0.3
+ 1766010p 0.9
+ 1768000p 0.9
+ 1768010p -0.3
+ 1770000p -0.3
+ 1770010p 0.9
+ 1772000p 0.9
+ 1772010p -0.3
+ 1774000p -0.3
+ 1774010p 0.9
+ 1776000p 0.9
+ 1776010p -0.3
+ 1778000p -0.3
+ 1778010p 0.9
+ 1780000p 0.9
+ 1780010p -0.3
+ 1782000p -0.3
+ 1782010p 0.9
+ 1784000p 0.9
+ 1784010p -0.3
+ 1786000p -0.3
+ 1786010p 0.9
+ 1788000p 0.9
+ 1788010p -0.3
+ 1790000p -0.3
+ 1790010p 0.9
+ 1792000p 0.9
+ 1792010p -0.3
+ 1794000p -0.3
+ 1794010p 0.9
+ 1796000p 0.9
+ 1796010p -0.3
+ 1798000p -0.3
+ 1798010p 0.9
+ 1800000p 0.9
+ 1800010p -0.3
+ 1802000p -0.3
+ 1802010p 0.9
+ 1804000p 0.9
+ 1804010p -0.3
+ 1806000p -0.3
+ 1806010p 0.9
+ 1808000p 0.9
+ 1808010p -0.3
+ 1810000p -0.3
+ 1810010p 0.9
+ 1812000p 0.9
+ 1812010p -0.3
+ 1814000p -0.3
+ 1814010p 0.9
+ 1816000p 0.9
+ 1816010p -0.3
+ 1818000p -0.3
+ 1818010p 0.9
+ 1820000p 0.9
+ 1820010p -0.3
+ 1822000p -0.3
+ 1822010p 0.9
+ 1824000p 0.9
+ 1824010p -0.3
+ 1826000p -0.3
+ 1826010p 0.9
+ 1828000p 0.9
+ 1828010p -0.3
+ 1830000p -0.3
+ 1830010p 0.9
+ 1832000p 0.9
+ 1832010p -0.3
+ 1834000p -0.3
+ 1834010p 0.9
+ 1836000p 0.9
+ 1836010p -0.3
+ 1838000p -0.3
+ 1838010p 0.9
+ 1840000p 0.9
+ 1840010p -0.3
+ 1842000p -0.3
+ 1842010p 0.9
+ 1844000p 0.9
+ 1844010p -0.3
+ 1846000p -0.3
+ 1846010p 0.9
+ 1848000p 0.9
+ 1848010p -0.3
+ 1850000p -0.3
+ 1850010p 0.9
+ 1852000p 0.9
+ 1852010p -0.3
+ 1854000p -0.3
+ 1854010p 0.9
+ 1856000p 0.9
+ 1856010p -0.3
+ 1858000p -0.3
+ 1858010p 0.9
+ 1860000p 0.9
+ 1860010p -0.3
+ 1862000p -0.3
+ 1862010p 0.9
+ 1864000p 0.9
+ 1864010p -0.3
+ 1866000p -0.3
+ 1866010p 0.9
+ 1868000p 0.9
+ 1868010p -0.3
+ 1870000p -0.3
+ 1870010p 0.9
+ 1872000p 0.9
+ 1872010p -0.3
+ 1874000p -0.3
+ 1874010p 0.9
+ 1876000p 0.9
+ 1876010p -0.3
+ 1878000p -0.3
+ 1878010p 0.9
+ 1880000p 0.9
+ 1880010p -0.3
+ 1882000p -0.3
+ 1882010p 0.9
+ 1884000p 0.9
+ 1884010p -0.3
+ 1886000p -0.3
+ 1886010p 0.9
+ 1888000p 0.9
+ 1888010p -0.3
+ 1890000p -0.3
+ 1890010p 0.9
+ 1892000p 0.9
+ 1892010p -0.3
+ 1894000p -0.3
+ 1894010p 0.9
+ 1896000p 0.9
+ 1896010p -0.3
+ 1898000p -0.3
+ 1898010p 0.9
+ 1900000p 0.9
+ 1900010p -0.3
+ 1902000p -0.3
+ 1902010p 0.9
+ 1904000p 0.9
+ 1904010p -0.3
+ 1906000p -0.3
+ 1906010p 0.9
+ 1908000p 0.9
+ 1908010p -0.3
+ 1910000p -0.3
+ 1910010p 0.9
+ 1912000p 0.9
+ 1912010p -0.3
+ 1914000p -0.3
+ 1914010p 0.9
+ 1916000p 0.9
+ 1916010p -0.3
+ 1918000p -0.3
+ 1918010p 0.9
+ 1920000p 0.9
+ 1920010p -0.3
+ 1922000p -0.3
+ 1922010p 0.9
+ 1924000p 0.9
+ 1924010p -0.3
+ 1926000p -0.3
+ 1926010p 0.9
+ 1928000p 0.9
+ 1928010p -0.3
+ 1930000p -0.3
+ 1930010p 0.9
+ 1932000p 0.9
+ 1932010p -0.3
+ 1934000p -0.3
+ 1934010p 0.9
+ 1936000p 0.9
+ 1936010p -0.3
+ 1938000p -0.3
+ 1938010p 0.9
+ 1940000p 0.9
+ 1940010p -0.3
+ 1942000p -0.3
+ 1942010p 0.9
+ 1944000p 0.9
+ 1944010p -0.3
+ 1946000p -0.3
+ 1946010p 0.9
+ 1948000p 0.9
+ 1948010p -0.3
+ 1950000p -0.3
+ 1950010p 0.9
+ 1952000p 0.9
+ 1952010p -0.3
+ 1954000p -0.3
+ 1954010p 0.9
+ 1956000p 0.9
+ 1956010p -0.3
+ 1958000p -0.3
+ 1958010p 0.9
+ 1960000p 0.9
+ 1960010p -0.3
+ 1962000p -0.3
+ 1962010p 0.9
+ 1964000p 0.9
+ 1964010p -0.3
+ 1966000p -0.3
+ 1966010p 0.9
+ 1968000p 0.9
+ 1968010p -0.3
+ 1970000p -0.3
+ 1970010p 0.9
+ 1972000p 0.9
+ 1972010p -0.3
+ 1974000p -0.3
+ 1974010p 0.9
+ 1976000p 0.9
+ 1976010p -0.3
+ 1978000p -0.3
+ 1978010p 0.9
+ 1980000p 0.9
+ 1980010p -0.3
+ 1982000p -0.3
+ 1982010p 0.9
+ 1984000p 0.9
+ 1984010p -0.3
+ 1986000p -0.3
+ 1986010p 0.9
+ 1988000p 0.9
+ 1988010p -0.3
+ 1990000p -0.3
+ 1990010p 0.9
+ 1992000p 0.9
+ 1992010p -0.3
+ 1994000p -0.3
+ 1994010p 0.9
+ 1996000p 0.9
+ 1996010p -0.3
+ 1998000p -0.3
+ 1998010p 0.9
+ 2000000p 0.9
+ 2000010p -0.3
+ 2002000p -0.3
+ 2002010p 0.9
+ 2004000p 0.9
+ 2004010p -0.3
+ 2006000p -0.3
+ 2006010p 0.9
+ 2008000p 0.9
+ 2008010p -0.3
+ 2010000p -0.3
+ 2010010p 0.9
+ 2012000p 0.9
+ 2012010p -0.3
+ 2014000p -0.3
+ 2014010p 0.9
+ 2016000p 0.9
+ 2016010p -0.3
+ 2018000p -0.3
+ 2018010p 0.9
+ 2020000p 0.9
+ 2020010p -0.3
+ 2022000p -0.3
+ 2022010p 0.9
+ 2024000p 0.9
+ 2024010p -0.3
+ 2026000p -0.3
+ 2026010p 0.9
+ 2028000p 0.9
+ 2028010p -0.3
+ 2030000p -0.3
+ 2030010p 0.9
+ 2032000p 0.9
+ 2032010p -0.3
+ 2034000p -0.3
+ 2034010p 0.9
+ 2036000p 0.9
+ 2036010p -0.3
+ 2038000p -0.3
+ 2038010p 0.9
+ 2040000p 0.9
+ 2040010p -0.3
+ 2042000p -0.3
+ 2042010p 0.9
+ 2044000p 0.9
+ 2044010p -0.3
+ 2046000p -0.3
+ 2046010p 0.9
+ 2048000p 0.9
+ 2048010p -0.3
+ \]
V_data_10 (Data\\<10\\> gnd!) vsource type=pwl wave=\[
+ 0    0.9
+ 2000p 0.9
+ 2010p -0.3
+ 4000p -0.3
+ 4010p 0.9
+ 6000p 0.9
+ 6010p -0.3
+ 8000p -0.3
+ 8010p 0.9
+ 10000p 0.9
+ 10010p -0.3
+ 12000p -0.3
+ 12010p 0.9
+ 14000p 0.9
+ 14010p -0.3
+ 16000p -0.3
+ 16010p 0.9
+ 18000p 0.9
+ 18010p -0.3
+ 20000p -0.3
+ 20010p 0.9
+ 22000p 0.9
+ 22010p -0.3
+ 24000p -0.3
+ 24010p 0.9
+ 26000p 0.9
+ 26010p -0.3
+ 28000p -0.3
+ 28010p 0.9
+ 30000p 0.9
+ 30010p -0.3
+ 32000p -0.3
+ 32010p 0.9
+ 34000p 0.9
+ 34010p -0.3
+ 36000p -0.3
+ 36010p 0.9
+ 38000p 0.9
+ 38010p -0.3
+ 40000p -0.3
+ 40010p 0.9
+ 42000p 0.9
+ 42010p -0.3
+ 44000p -0.3
+ 44010p 0.9
+ 46000p 0.9
+ 46010p -0.3
+ 48000p -0.3
+ 48010p 0.9
+ 50000p 0.9
+ 50010p -0.3
+ 52000p -0.3
+ 52010p 0.9
+ 54000p 0.9
+ 54010p -0.3
+ 56000p -0.3
+ 56010p 0.9
+ 58000p 0.9
+ 58010p -0.3
+ 60000p -0.3
+ 60010p 0.9
+ 62000p 0.9
+ 62010p -0.3
+ 64000p -0.3
+ 64010p 0.9
+ 66000p 0.9
+ 66010p -0.3
+ 68000p -0.3
+ 68010p 0.9
+ 70000p 0.9
+ 70010p -0.3
+ 72000p -0.3
+ 72010p 0.9
+ 74000p 0.9
+ 74010p -0.3
+ 76000p -0.3
+ 76010p 0.9
+ 78000p 0.9
+ 78010p -0.3
+ 80000p -0.3
+ 80010p 0.9
+ 82000p 0.9
+ 82010p -0.3
+ 84000p -0.3
+ 84010p 0.9
+ 86000p 0.9
+ 86010p -0.3
+ 88000p -0.3
+ 88010p 0.9
+ 90000p 0.9
+ 90010p -0.3
+ 92000p -0.3
+ 92010p 0.9
+ 94000p 0.9
+ 94010p -0.3
+ 96000p -0.3
+ 96010p 0.9
+ 98000p 0.9
+ 98010p -0.3
+ 100000p -0.3
+ 100010p 0.9
+ 102000p 0.9
+ 102010p -0.3
+ 104000p -0.3
+ 104010p 0.9
+ 106000p 0.9
+ 106010p -0.3
+ 108000p -0.3
+ 108010p 0.9
+ 110000p 0.9
+ 110010p -0.3
+ 112000p -0.3
+ 112010p 0.9
+ 114000p 0.9
+ 114010p -0.3
+ 116000p -0.3
+ 116010p 0.9
+ 118000p 0.9
+ 118010p -0.3
+ 120000p -0.3
+ 120010p 0.9
+ 122000p 0.9
+ 122010p -0.3
+ 124000p -0.3
+ 124010p 0.9
+ 126000p 0.9
+ 126010p -0.3
+ 128000p -0.3
+ 128010p 0.9
+ 130000p 0.9
+ 130010p -0.3
+ 132000p -0.3
+ 132010p 0.9
+ 134000p 0.9
+ 134010p -0.3
+ 136000p -0.3
+ 136010p 0.9
+ 138000p 0.9
+ 138010p -0.3
+ 140000p -0.3
+ 140010p 0.9
+ 142000p 0.9
+ 142010p -0.3
+ 144000p -0.3
+ 144010p 0.9
+ 146000p 0.9
+ 146010p -0.3
+ 148000p -0.3
+ 148010p 0.9
+ 150000p 0.9
+ 150010p -0.3
+ 152000p -0.3
+ 152010p 0.9
+ 154000p 0.9
+ 154010p -0.3
+ 156000p -0.3
+ 156010p 0.9
+ 158000p 0.9
+ 158010p -0.3
+ 160000p -0.3
+ 160010p 0.9
+ 162000p 0.9
+ 162010p -0.3
+ 164000p -0.3
+ 164010p 0.9
+ 166000p 0.9
+ 166010p -0.3
+ 168000p -0.3
+ 168010p 0.9
+ 170000p 0.9
+ 170010p -0.3
+ 172000p -0.3
+ 172010p 0.9
+ 174000p 0.9
+ 174010p -0.3
+ 176000p -0.3
+ 176010p 0.9
+ 178000p 0.9
+ 178010p -0.3
+ 180000p -0.3
+ 180010p 0.9
+ 182000p 0.9
+ 182010p -0.3
+ 184000p -0.3
+ 184010p 0.9
+ 186000p 0.9
+ 186010p -0.3
+ 188000p -0.3
+ 188010p 0.9
+ 190000p 0.9
+ 190010p -0.3
+ 192000p -0.3
+ 192010p 0.9
+ 194000p 0.9
+ 194010p -0.3
+ 196000p -0.3
+ 196010p 0.9
+ 198000p 0.9
+ 198010p -0.3
+ 200000p -0.3
+ 200010p 0.9
+ 202000p 0.9
+ 202010p -0.3
+ 204000p -0.3
+ 204010p 0.9
+ 206000p 0.9
+ 206010p -0.3
+ 208000p -0.3
+ 208010p 0.9
+ 210000p 0.9
+ 210010p -0.3
+ 212000p -0.3
+ 212010p 0.9
+ 214000p 0.9
+ 214010p -0.3
+ 216000p -0.3
+ 216010p 0.9
+ 218000p 0.9
+ 218010p -0.3
+ 220000p -0.3
+ 220010p 0.9
+ 222000p 0.9
+ 222010p -0.3
+ 224000p -0.3
+ 224010p 0.9
+ 226000p 0.9
+ 226010p -0.3
+ 228000p -0.3
+ 228010p 0.9
+ 230000p 0.9
+ 230010p -0.3
+ 232000p -0.3
+ 232010p 0.9
+ 234000p 0.9
+ 234010p -0.3
+ 236000p -0.3
+ 236010p 0.9
+ 238000p 0.9
+ 238010p -0.3
+ 240000p -0.3
+ 240010p 0.9
+ 242000p 0.9
+ 242010p -0.3
+ 244000p -0.3
+ 244010p 0.9
+ 246000p 0.9
+ 246010p -0.3
+ 248000p -0.3
+ 248010p 0.9
+ 250000p 0.9
+ 250010p -0.3
+ 252000p -0.3
+ 252010p 0.9
+ 254000p 0.9
+ 254010p -0.3
+ 256000p -0.3
+ 256010p 0.9
+ 258000p 0.9
+ 258010p -0.3
+ 260000p -0.3
+ 260010p 0.9
+ 262000p 0.9
+ 262010p -0.3
+ 264000p -0.3
+ 264010p 0.9
+ 266000p 0.9
+ 266010p -0.3
+ 268000p -0.3
+ 268010p 0.9
+ 270000p 0.9
+ 270010p -0.3
+ 272000p -0.3
+ 272010p 0.9
+ 274000p 0.9
+ 274010p -0.3
+ 276000p -0.3
+ 276010p 0.9
+ 278000p 0.9
+ 278010p -0.3
+ 280000p -0.3
+ 280010p 0.9
+ 282000p 0.9
+ 282010p -0.3
+ 284000p -0.3
+ 284010p 0.9
+ 286000p 0.9
+ 286010p -0.3
+ 288000p -0.3
+ 288010p 0.9
+ 290000p 0.9
+ 290010p -0.3
+ 292000p -0.3
+ 292010p 0.9
+ 294000p 0.9
+ 294010p -0.3
+ 296000p -0.3
+ 296010p 0.9
+ 298000p 0.9
+ 298010p -0.3
+ 300000p -0.3
+ 300010p 0.9
+ 302000p 0.9
+ 302010p -0.3
+ 304000p -0.3
+ 304010p 0.9
+ 306000p 0.9
+ 306010p -0.3
+ 308000p -0.3
+ 308010p 0.9
+ 310000p 0.9
+ 310010p -0.3
+ 312000p -0.3
+ 312010p 0.9
+ 314000p 0.9
+ 314010p -0.3
+ 316000p -0.3
+ 316010p 0.9
+ 318000p 0.9
+ 318010p -0.3
+ 320000p -0.3
+ 320010p 0.9
+ 322000p 0.9
+ 322010p -0.3
+ 324000p -0.3
+ 324010p 0.9
+ 326000p 0.9
+ 326010p -0.3
+ 328000p -0.3
+ 328010p 0.9
+ 330000p 0.9
+ 330010p -0.3
+ 332000p -0.3
+ 332010p 0.9
+ 334000p 0.9
+ 334010p -0.3
+ 336000p -0.3
+ 336010p 0.9
+ 338000p 0.9
+ 338010p -0.3
+ 340000p -0.3
+ 340010p 0.9
+ 342000p 0.9
+ 342010p -0.3
+ 344000p -0.3
+ 344010p 0.9
+ 346000p 0.9
+ 346010p -0.3
+ 348000p -0.3
+ 348010p 0.9
+ 350000p 0.9
+ 350010p -0.3
+ 352000p -0.3
+ 352010p 0.9
+ 354000p 0.9
+ 354010p -0.3
+ 356000p -0.3
+ 356010p 0.9
+ 358000p 0.9
+ 358010p -0.3
+ 360000p -0.3
+ 360010p 0.9
+ 362000p 0.9
+ 362010p -0.3
+ 364000p -0.3
+ 364010p 0.9
+ 366000p 0.9
+ 366010p -0.3
+ 368000p -0.3
+ 368010p 0.9
+ 370000p 0.9
+ 370010p -0.3
+ 372000p -0.3
+ 372010p 0.9
+ 374000p 0.9
+ 374010p -0.3
+ 376000p -0.3
+ 376010p 0.9
+ 378000p 0.9
+ 378010p -0.3
+ 380000p -0.3
+ 380010p 0.9
+ 382000p 0.9
+ 382010p -0.3
+ 384000p -0.3
+ 384010p 0.9
+ 386000p 0.9
+ 386010p -0.3
+ 388000p -0.3
+ 388010p 0.9
+ 390000p 0.9
+ 390010p -0.3
+ 392000p -0.3
+ 392010p 0.9
+ 394000p 0.9
+ 394010p -0.3
+ 396000p -0.3
+ 396010p 0.9
+ 398000p 0.9
+ 398010p -0.3
+ 400000p -0.3
+ 400010p 0.9
+ 402000p 0.9
+ 402010p -0.3
+ 404000p -0.3
+ 404010p 0.9
+ 406000p 0.9
+ 406010p -0.3
+ 408000p -0.3
+ 408010p 0.9
+ 410000p 0.9
+ 410010p -0.3
+ 412000p -0.3
+ 412010p 0.9
+ 414000p 0.9
+ 414010p -0.3
+ 416000p -0.3
+ 416010p 0.9
+ 418000p 0.9
+ 418010p -0.3
+ 420000p -0.3
+ 420010p 0.9
+ 422000p 0.9
+ 422010p -0.3
+ 424000p -0.3
+ 424010p 0.9
+ 426000p 0.9
+ 426010p -0.3
+ 428000p -0.3
+ 428010p 0.9
+ 430000p 0.9
+ 430010p -0.3
+ 432000p -0.3
+ 432010p 0.9
+ 434000p 0.9
+ 434010p -0.3
+ 436000p -0.3
+ 436010p 0.9
+ 438000p 0.9
+ 438010p -0.3
+ 440000p -0.3
+ 440010p 0.9
+ 442000p 0.9
+ 442010p -0.3
+ 444000p -0.3
+ 444010p 0.9
+ 446000p 0.9
+ 446010p -0.3
+ 448000p -0.3
+ 448010p 0.9
+ 450000p 0.9
+ 450010p -0.3
+ 452000p -0.3
+ 452010p 0.9
+ 454000p 0.9
+ 454010p -0.3
+ 456000p -0.3
+ 456010p 0.9
+ 458000p 0.9
+ 458010p -0.3
+ 460000p -0.3
+ 460010p 0.9
+ 462000p 0.9
+ 462010p -0.3
+ 464000p -0.3
+ 464010p 0.9
+ 466000p 0.9
+ 466010p -0.3
+ 468000p -0.3
+ 468010p 0.9
+ 470000p 0.9
+ 470010p -0.3
+ 472000p -0.3
+ 472010p 0.9
+ 474000p 0.9
+ 474010p -0.3
+ 476000p -0.3
+ 476010p 0.9
+ 478000p 0.9
+ 478010p -0.3
+ 480000p -0.3
+ 480010p 0.9
+ 482000p 0.9
+ 482010p -0.3
+ 484000p -0.3
+ 484010p 0.9
+ 486000p 0.9
+ 486010p -0.3
+ 488000p -0.3
+ 488010p 0.9
+ 490000p 0.9
+ 490010p -0.3
+ 492000p -0.3
+ 492010p 0.9
+ 494000p 0.9
+ 494010p -0.3
+ 496000p -0.3
+ 496010p 0.9
+ 498000p 0.9
+ 498010p -0.3
+ 500000p -0.3
+ 500010p 0.9
+ 502000p 0.9
+ 502010p -0.3
+ 504000p -0.3
+ 504010p 0.9
+ 506000p 0.9
+ 506010p -0.3
+ 508000p -0.3
+ 508010p 0.9
+ 510000p 0.9
+ 510010p -0.3
+ 512000p -0.3
+ 512010p 0.9
+ 514000p 0.9
+ 514010p -0.3
+ 516000p -0.3
+ 516010p 0.9
+ 518000p 0.9
+ 518010p -0.3
+ 520000p -0.3
+ 520010p 0.9
+ 522000p 0.9
+ 522010p -0.3
+ 524000p -0.3
+ 524010p 0.9
+ 526000p 0.9
+ 526010p -0.3
+ 528000p -0.3
+ 528010p 0.9
+ 530000p 0.9
+ 530010p -0.3
+ 532000p -0.3
+ 532010p 0.9
+ 534000p 0.9
+ 534010p -0.3
+ 536000p -0.3
+ 536010p 0.9
+ 538000p 0.9
+ 538010p -0.3
+ 540000p -0.3
+ 540010p 0.9
+ 542000p 0.9
+ 542010p -0.3
+ 544000p -0.3
+ 544010p 0.9
+ 546000p 0.9
+ 546010p -0.3
+ 548000p -0.3
+ 548010p 0.9
+ 550000p 0.9
+ 550010p -0.3
+ 552000p -0.3
+ 552010p 0.9
+ 554000p 0.9
+ 554010p -0.3
+ 556000p -0.3
+ 556010p 0.9
+ 558000p 0.9
+ 558010p -0.3
+ 560000p -0.3
+ 560010p 0.9
+ 562000p 0.9
+ 562010p -0.3
+ 564000p -0.3
+ 564010p 0.9
+ 566000p 0.9
+ 566010p -0.3
+ 568000p -0.3
+ 568010p 0.9
+ 570000p 0.9
+ 570010p -0.3
+ 572000p -0.3
+ 572010p 0.9
+ 574000p 0.9
+ 574010p -0.3
+ 576000p -0.3
+ 576010p 0.9
+ 578000p 0.9
+ 578010p -0.3
+ 580000p -0.3
+ 580010p 0.9
+ 582000p 0.9
+ 582010p -0.3
+ 584000p -0.3
+ 584010p 0.9
+ 586000p 0.9
+ 586010p -0.3
+ 588000p -0.3
+ 588010p 0.9
+ 590000p 0.9
+ 590010p -0.3
+ 592000p -0.3
+ 592010p 0.9
+ 594000p 0.9
+ 594010p -0.3
+ 596000p -0.3
+ 596010p 0.9
+ 598000p 0.9
+ 598010p -0.3
+ 600000p -0.3
+ 600010p 0.9
+ 602000p 0.9
+ 602010p -0.3
+ 604000p -0.3
+ 604010p 0.9
+ 606000p 0.9
+ 606010p -0.3
+ 608000p -0.3
+ 608010p 0.9
+ 610000p 0.9
+ 610010p -0.3
+ 612000p -0.3
+ 612010p 0.9
+ 614000p 0.9
+ 614010p -0.3
+ 616000p -0.3
+ 616010p 0.9
+ 618000p 0.9
+ 618010p -0.3
+ 620000p -0.3
+ 620010p 0.9
+ 622000p 0.9
+ 622010p -0.3
+ 624000p -0.3
+ 624010p 0.9
+ 626000p 0.9
+ 626010p -0.3
+ 628000p -0.3
+ 628010p 0.9
+ 630000p 0.9
+ 630010p -0.3
+ 632000p -0.3
+ 632010p 0.9
+ 634000p 0.9
+ 634010p -0.3
+ 636000p -0.3
+ 636010p 0.9
+ 638000p 0.9
+ 638010p -0.3
+ 640000p -0.3
+ 640010p 0.9
+ 642000p 0.9
+ 642010p -0.3
+ 644000p -0.3
+ 644010p 0.9
+ 646000p 0.9
+ 646010p -0.3
+ 648000p -0.3
+ 648010p 0.9
+ 650000p 0.9
+ 650010p -0.3
+ 652000p -0.3
+ 652010p 0.9
+ 654000p 0.9
+ 654010p -0.3
+ 656000p -0.3
+ 656010p 0.9
+ 658000p 0.9
+ 658010p -0.3
+ 660000p -0.3
+ 660010p 0.9
+ 662000p 0.9
+ 662010p -0.3
+ 664000p -0.3
+ 664010p 0.9
+ 666000p 0.9
+ 666010p -0.3
+ 668000p -0.3
+ 668010p 0.9
+ 670000p 0.9
+ 670010p -0.3
+ 672000p -0.3
+ 672010p 0.9
+ 674000p 0.9
+ 674010p -0.3
+ 676000p -0.3
+ 676010p 0.9
+ 678000p 0.9
+ 678010p -0.3
+ 680000p -0.3
+ 680010p 0.9
+ 682000p 0.9
+ 682010p -0.3
+ 684000p -0.3
+ 684010p 0.9
+ 686000p 0.9
+ 686010p -0.3
+ 688000p -0.3
+ 688010p 0.9
+ 690000p 0.9
+ 690010p -0.3
+ 692000p -0.3
+ 692010p 0.9
+ 694000p 0.9
+ 694010p -0.3
+ 696000p -0.3
+ 696010p 0.9
+ 698000p 0.9
+ 698010p -0.3
+ 700000p -0.3
+ 700010p 0.9
+ 702000p 0.9
+ 702010p -0.3
+ 704000p -0.3
+ 704010p 0.9
+ 706000p 0.9
+ 706010p -0.3
+ 708000p -0.3
+ 708010p 0.9
+ 710000p 0.9
+ 710010p -0.3
+ 712000p -0.3
+ 712010p 0.9
+ 714000p 0.9
+ 714010p -0.3
+ 716000p -0.3
+ 716010p 0.9
+ 718000p 0.9
+ 718010p -0.3
+ 720000p -0.3
+ 720010p 0.9
+ 722000p 0.9
+ 722010p -0.3
+ 724000p -0.3
+ 724010p 0.9
+ 726000p 0.9
+ 726010p -0.3
+ 728000p -0.3
+ 728010p 0.9
+ 730000p 0.9
+ 730010p -0.3
+ 732000p -0.3
+ 732010p 0.9
+ 734000p 0.9
+ 734010p -0.3
+ 736000p -0.3
+ 736010p 0.9
+ 738000p 0.9
+ 738010p -0.3
+ 740000p -0.3
+ 740010p 0.9
+ 742000p 0.9
+ 742010p -0.3
+ 744000p -0.3
+ 744010p 0.9
+ 746000p 0.9
+ 746010p -0.3
+ 748000p -0.3
+ 748010p 0.9
+ 750000p 0.9
+ 750010p -0.3
+ 752000p -0.3
+ 752010p 0.9
+ 754000p 0.9
+ 754010p -0.3
+ 756000p -0.3
+ 756010p 0.9
+ 758000p 0.9
+ 758010p -0.3
+ 760000p -0.3
+ 760010p 0.9
+ 762000p 0.9
+ 762010p -0.3
+ 764000p -0.3
+ 764010p 0.9
+ 766000p 0.9
+ 766010p -0.3
+ 768000p -0.3
+ 768010p 0.9
+ 770000p 0.9
+ 770010p -0.3
+ 772000p -0.3
+ 772010p 0.9
+ 774000p 0.9
+ 774010p -0.3
+ 776000p -0.3
+ 776010p 0.9
+ 778000p 0.9
+ 778010p -0.3
+ 780000p -0.3
+ 780010p 0.9
+ 782000p 0.9
+ 782010p -0.3
+ 784000p -0.3
+ 784010p 0.9
+ 786000p 0.9
+ 786010p -0.3
+ 788000p -0.3
+ 788010p 0.9
+ 790000p 0.9
+ 790010p -0.3
+ 792000p -0.3
+ 792010p 0.9
+ 794000p 0.9
+ 794010p -0.3
+ 796000p -0.3
+ 796010p 0.9
+ 798000p 0.9
+ 798010p -0.3
+ 800000p -0.3
+ 800010p 0.9
+ 802000p 0.9
+ 802010p -0.3
+ 804000p -0.3
+ 804010p 0.9
+ 806000p 0.9
+ 806010p -0.3
+ 808000p -0.3
+ 808010p 0.9
+ 810000p 0.9
+ 810010p -0.3
+ 812000p -0.3
+ 812010p 0.9
+ 814000p 0.9
+ 814010p -0.3
+ 816000p -0.3
+ 816010p 0.9
+ 818000p 0.9
+ 818010p -0.3
+ 820000p -0.3
+ 820010p 0.9
+ 822000p 0.9
+ 822010p -0.3
+ 824000p -0.3
+ 824010p 0.9
+ 826000p 0.9
+ 826010p -0.3
+ 828000p -0.3
+ 828010p 0.9
+ 830000p 0.9
+ 830010p -0.3
+ 832000p -0.3
+ 832010p 0.9
+ 834000p 0.9
+ 834010p -0.3
+ 836000p -0.3
+ 836010p 0.9
+ 838000p 0.9
+ 838010p -0.3
+ 840000p -0.3
+ 840010p 0.9
+ 842000p 0.9
+ 842010p -0.3
+ 844000p -0.3
+ 844010p 0.9
+ 846000p 0.9
+ 846010p -0.3
+ 848000p -0.3
+ 848010p 0.9
+ 850000p 0.9
+ 850010p -0.3
+ 852000p -0.3
+ 852010p 0.9
+ 854000p 0.9
+ 854010p -0.3
+ 856000p -0.3
+ 856010p 0.9
+ 858000p 0.9
+ 858010p -0.3
+ 860000p -0.3
+ 860010p 0.9
+ 862000p 0.9
+ 862010p -0.3
+ 864000p -0.3
+ 864010p 0.9
+ 866000p 0.9
+ 866010p -0.3
+ 868000p -0.3
+ 868010p 0.9
+ 870000p 0.9
+ 870010p -0.3
+ 872000p -0.3
+ 872010p 0.9
+ 874000p 0.9
+ 874010p -0.3
+ 876000p -0.3
+ 876010p 0.9
+ 878000p 0.9
+ 878010p -0.3
+ 880000p -0.3
+ 880010p 0.9
+ 882000p 0.9
+ 882010p -0.3
+ 884000p -0.3
+ 884010p 0.9
+ 886000p 0.9
+ 886010p -0.3
+ 888000p -0.3
+ 888010p 0.9
+ 890000p 0.9
+ 890010p -0.3
+ 892000p -0.3
+ 892010p 0.9
+ 894000p 0.9
+ 894010p -0.3
+ 896000p -0.3
+ 896010p 0.9
+ 898000p 0.9
+ 898010p -0.3
+ 900000p -0.3
+ 900010p 0.9
+ 902000p 0.9
+ 902010p -0.3
+ 904000p -0.3
+ 904010p 0.9
+ 906000p 0.9
+ 906010p -0.3
+ 908000p -0.3
+ 908010p 0.9
+ 910000p 0.9
+ 910010p -0.3
+ 912000p -0.3
+ 912010p 0.9
+ 914000p 0.9
+ 914010p -0.3
+ 916000p -0.3
+ 916010p 0.9
+ 918000p 0.9
+ 918010p -0.3
+ 920000p -0.3
+ 920010p 0.9
+ 922000p 0.9
+ 922010p -0.3
+ 924000p -0.3
+ 924010p 0.9
+ 926000p 0.9
+ 926010p -0.3
+ 928000p -0.3
+ 928010p 0.9
+ 930000p 0.9
+ 930010p -0.3
+ 932000p -0.3
+ 932010p 0.9
+ 934000p 0.9
+ 934010p -0.3
+ 936000p -0.3
+ 936010p 0.9
+ 938000p 0.9
+ 938010p -0.3
+ 940000p -0.3
+ 940010p 0.9
+ 942000p 0.9
+ 942010p -0.3
+ 944000p -0.3
+ 944010p 0.9
+ 946000p 0.9
+ 946010p -0.3
+ 948000p -0.3
+ 948010p 0.9
+ 950000p 0.9
+ 950010p -0.3
+ 952000p -0.3
+ 952010p 0.9
+ 954000p 0.9
+ 954010p -0.3
+ 956000p -0.3
+ 956010p 0.9
+ 958000p 0.9
+ 958010p -0.3
+ 960000p -0.3
+ 960010p 0.9
+ 962000p 0.9
+ 962010p -0.3
+ 964000p -0.3
+ 964010p 0.9
+ 966000p 0.9
+ 966010p -0.3
+ 968000p -0.3
+ 968010p 0.9
+ 970000p 0.9
+ 970010p -0.3
+ 972000p -0.3
+ 972010p 0.9
+ 974000p 0.9
+ 974010p -0.3
+ 976000p -0.3
+ 976010p 0.9
+ 978000p 0.9
+ 978010p -0.3
+ 980000p -0.3
+ 980010p 0.9
+ 982000p 0.9
+ 982010p -0.3
+ 984000p -0.3
+ 984010p 0.9
+ 986000p 0.9
+ 986010p -0.3
+ 988000p -0.3
+ 988010p 0.9
+ 990000p 0.9
+ 990010p -0.3
+ 992000p -0.3
+ 992010p 0.9
+ 994000p 0.9
+ 994010p -0.3
+ 996000p -0.3
+ 996010p 0.9
+ 998000p 0.9
+ 998010p -0.3
+ 1000000p -0.3
+ 1000010p 0.9
+ 1002000p 0.9
+ 1002010p -0.3
+ 1004000p -0.3
+ 1004010p 0.9
+ 1006000p 0.9
+ 1006010p -0.3
+ 1008000p -0.3
+ 1008010p 0.9
+ 1010000p 0.9
+ 1010010p -0.3
+ 1012000p -0.3
+ 1012010p 0.9
+ 1014000p 0.9
+ 1014010p -0.3
+ 1016000p -0.3
+ 1016010p 0.9
+ 1018000p 0.9
+ 1018010p -0.3
+ 1020000p -0.3
+ 1020010p 0.9
+ 1022000p 0.9
+ 1022010p -0.3
+ 1024000p -0.3
+ 1024010p 0.9
+ 1026000p 0.9
+ 1026010p -0.3
+ 1028000p -0.3
+ 1028010p 0.9
+ 1030000p 0.9
+ 1030010p -0.3
+ 1032000p -0.3
+ 1032010p 0.9
+ 1034000p 0.9
+ 1034010p -0.3
+ 1036000p -0.3
+ 1036010p 0.9
+ 1038000p 0.9
+ 1038010p -0.3
+ 1040000p -0.3
+ 1040010p 0.9
+ 1042000p 0.9
+ 1042010p -0.3
+ 1044000p -0.3
+ 1044010p 0.9
+ 1046000p 0.9
+ 1046010p -0.3
+ 1048000p -0.3
+ 1048010p 0.9
+ 1050000p 0.9
+ 1050010p -0.3
+ 1052000p -0.3
+ 1052010p 0.9
+ 1054000p 0.9
+ 1054010p -0.3
+ 1056000p -0.3
+ 1056010p 0.9
+ 1058000p 0.9
+ 1058010p -0.3
+ 1060000p -0.3
+ 1060010p 0.9
+ 1062000p 0.9
+ 1062010p -0.3
+ 1064000p -0.3
+ 1064010p 0.9
+ 1066000p 0.9
+ 1066010p -0.3
+ 1068000p -0.3
+ 1068010p 0.9
+ 1070000p 0.9
+ 1070010p -0.3
+ 1072000p -0.3
+ 1072010p 0.9
+ 1074000p 0.9
+ 1074010p -0.3
+ 1076000p -0.3
+ 1076010p 0.9
+ 1078000p 0.9
+ 1078010p -0.3
+ 1080000p -0.3
+ 1080010p 0.9
+ 1082000p 0.9
+ 1082010p -0.3
+ 1084000p -0.3
+ 1084010p 0.9
+ 1086000p 0.9
+ 1086010p -0.3
+ 1088000p -0.3
+ 1088010p 0.9
+ 1090000p 0.9
+ 1090010p -0.3
+ 1092000p -0.3
+ 1092010p 0.9
+ 1094000p 0.9
+ 1094010p -0.3
+ 1096000p -0.3
+ 1096010p 0.9
+ 1098000p 0.9
+ 1098010p -0.3
+ 1100000p -0.3
+ 1100010p 0.9
+ 1102000p 0.9
+ 1102010p -0.3
+ 1104000p -0.3
+ 1104010p 0.9
+ 1106000p 0.9
+ 1106010p -0.3
+ 1108000p -0.3
+ 1108010p 0.9
+ 1110000p 0.9
+ 1110010p -0.3
+ 1112000p -0.3
+ 1112010p 0.9
+ 1114000p 0.9
+ 1114010p -0.3
+ 1116000p -0.3
+ 1116010p 0.9
+ 1118000p 0.9
+ 1118010p -0.3
+ 1120000p -0.3
+ 1120010p 0.9
+ 1122000p 0.9
+ 1122010p -0.3
+ 1124000p -0.3
+ 1124010p 0.9
+ 1126000p 0.9
+ 1126010p -0.3
+ 1128000p -0.3
+ 1128010p 0.9
+ 1130000p 0.9
+ 1130010p -0.3
+ 1132000p -0.3
+ 1132010p 0.9
+ 1134000p 0.9
+ 1134010p -0.3
+ 1136000p -0.3
+ 1136010p 0.9
+ 1138000p 0.9
+ 1138010p -0.3
+ 1140000p -0.3
+ 1140010p 0.9
+ 1142000p 0.9
+ 1142010p -0.3
+ 1144000p -0.3
+ 1144010p 0.9
+ 1146000p 0.9
+ 1146010p -0.3
+ 1148000p -0.3
+ 1148010p 0.9
+ 1150000p 0.9
+ 1150010p -0.3
+ 1152000p -0.3
+ 1152010p 0.9
+ 1154000p 0.9
+ 1154010p -0.3
+ 1156000p -0.3
+ 1156010p 0.9
+ 1158000p 0.9
+ 1158010p -0.3
+ 1160000p -0.3
+ 1160010p 0.9
+ 1162000p 0.9
+ 1162010p -0.3
+ 1164000p -0.3
+ 1164010p 0.9
+ 1166000p 0.9
+ 1166010p -0.3
+ 1168000p -0.3
+ 1168010p 0.9
+ 1170000p 0.9
+ 1170010p -0.3
+ 1172000p -0.3
+ 1172010p 0.9
+ 1174000p 0.9
+ 1174010p -0.3
+ 1176000p -0.3
+ 1176010p 0.9
+ 1178000p 0.9
+ 1178010p -0.3
+ 1180000p -0.3
+ 1180010p 0.9
+ 1182000p 0.9
+ 1182010p -0.3
+ 1184000p -0.3
+ 1184010p 0.9
+ 1186000p 0.9
+ 1186010p -0.3
+ 1188000p -0.3
+ 1188010p 0.9
+ 1190000p 0.9
+ 1190010p -0.3
+ 1192000p -0.3
+ 1192010p 0.9
+ 1194000p 0.9
+ 1194010p -0.3
+ 1196000p -0.3
+ 1196010p 0.9
+ 1198000p 0.9
+ 1198010p -0.3
+ 1200000p -0.3
+ 1200010p 0.9
+ 1202000p 0.9
+ 1202010p -0.3
+ 1204000p -0.3
+ 1204010p 0.9
+ 1206000p 0.9
+ 1206010p -0.3
+ 1208000p -0.3
+ 1208010p 0.9
+ 1210000p 0.9
+ 1210010p -0.3
+ 1212000p -0.3
+ 1212010p 0.9
+ 1214000p 0.9
+ 1214010p -0.3
+ 1216000p -0.3
+ 1216010p 0.9
+ 1218000p 0.9
+ 1218010p -0.3
+ 1220000p -0.3
+ 1220010p 0.9
+ 1222000p 0.9
+ 1222010p -0.3
+ 1224000p -0.3
+ 1224010p 0.9
+ 1226000p 0.9
+ 1226010p -0.3
+ 1228000p -0.3
+ 1228010p 0.9
+ 1230000p 0.9
+ 1230010p -0.3
+ 1232000p -0.3
+ 1232010p 0.9
+ 1234000p 0.9
+ 1234010p -0.3
+ 1236000p -0.3
+ 1236010p 0.9
+ 1238000p 0.9
+ 1238010p -0.3
+ 1240000p -0.3
+ 1240010p 0.9
+ 1242000p 0.9
+ 1242010p -0.3
+ 1244000p -0.3
+ 1244010p 0.9
+ 1246000p 0.9
+ 1246010p -0.3
+ 1248000p -0.3
+ 1248010p 0.9
+ 1250000p 0.9
+ 1250010p -0.3
+ 1252000p -0.3
+ 1252010p 0.9
+ 1254000p 0.9
+ 1254010p -0.3
+ 1256000p -0.3
+ 1256010p 0.9
+ 1258000p 0.9
+ 1258010p -0.3
+ 1260000p -0.3
+ 1260010p 0.9
+ 1262000p 0.9
+ 1262010p -0.3
+ 1264000p -0.3
+ 1264010p 0.9
+ 1266000p 0.9
+ 1266010p -0.3
+ 1268000p -0.3
+ 1268010p 0.9
+ 1270000p 0.9
+ 1270010p -0.3
+ 1272000p -0.3
+ 1272010p 0.9
+ 1274000p 0.9
+ 1274010p -0.3
+ 1276000p -0.3
+ 1276010p 0.9
+ 1278000p 0.9
+ 1278010p -0.3
+ 1280000p -0.3
+ 1280010p 0.9
+ 1282000p 0.9
+ 1282010p -0.3
+ 1284000p -0.3
+ 1284010p 0.9
+ 1286000p 0.9
+ 1286010p -0.3
+ 1288000p -0.3
+ 1288010p 0.9
+ 1290000p 0.9
+ 1290010p -0.3
+ 1292000p -0.3
+ 1292010p 0.9
+ 1294000p 0.9
+ 1294010p -0.3
+ 1296000p -0.3
+ 1296010p 0.9
+ 1298000p 0.9
+ 1298010p -0.3
+ 1300000p -0.3
+ 1300010p 0.9
+ 1302000p 0.9
+ 1302010p -0.3
+ 1304000p -0.3
+ 1304010p 0.9
+ 1306000p 0.9
+ 1306010p -0.3
+ 1308000p -0.3
+ 1308010p 0.9
+ 1310000p 0.9
+ 1310010p -0.3
+ 1312000p -0.3
+ 1312010p 0.9
+ 1314000p 0.9
+ 1314010p -0.3
+ 1316000p -0.3
+ 1316010p 0.9
+ 1318000p 0.9
+ 1318010p -0.3
+ 1320000p -0.3
+ 1320010p 0.9
+ 1322000p 0.9
+ 1322010p -0.3
+ 1324000p -0.3
+ 1324010p 0.9
+ 1326000p 0.9
+ 1326010p -0.3
+ 1328000p -0.3
+ 1328010p 0.9
+ 1330000p 0.9
+ 1330010p -0.3
+ 1332000p -0.3
+ 1332010p 0.9
+ 1334000p 0.9
+ 1334010p -0.3
+ 1336000p -0.3
+ 1336010p 0.9
+ 1338000p 0.9
+ 1338010p -0.3
+ 1340000p -0.3
+ 1340010p 0.9
+ 1342000p 0.9
+ 1342010p -0.3
+ 1344000p -0.3
+ 1344010p 0.9
+ 1346000p 0.9
+ 1346010p -0.3
+ 1348000p -0.3
+ 1348010p 0.9
+ 1350000p 0.9
+ 1350010p -0.3
+ 1352000p -0.3
+ 1352010p 0.9
+ 1354000p 0.9
+ 1354010p -0.3
+ 1356000p -0.3
+ 1356010p 0.9
+ 1358000p 0.9
+ 1358010p -0.3
+ 1360000p -0.3
+ 1360010p 0.9
+ 1362000p 0.9
+ 1362010p -0.3
+ 1364000p -0.3
+ 1364010p 0.9
+ 1366000p 0.9
+ 1366010p -0.3
+ 1368000p -0.3
+ 1368010p 0.9
+ 1370000p 0.9
+ 1370010p -0.3
+ 1372000p -0.3
+ 1372010p 0.9
+ 1374000p 0.9
+ 1374010p -0.3
+ 1376000p -0.3
+ 1376010p 0.9
+ 1378000p 0.9
+ 1378010p -0.3
+ 1380000p -0.3
+ 1380010p 0.9
+ 1382000p 0.9
+ 1382010p -0.3
+ 1384000p -0.3
+ 1384010p 0.9
+ 1386000p 0.9
+ 1386010p -0.3
+ 1388000p -0.3
+ 1388010p 0.9
+ 1390000p 0.9
+ 1390010p -0.3
+ 1392000p -0.3
+ 1392010p 0.9
+ 1394000p 0.9
+ 1394010p -0.3
+ 1396000p -0.3
+ 1396010p 0.9
+ 1398000p 0.9
+ 1398010p -0.3
+ 1400000p -0.3
+ 1400010p 0.9
+ 1402000p 0.9
+ 1402010p -0.3
+ 1404000p -0.3
+ 1404010p 0.9
+ 1406000p 0.9
+ 1406010p -0.3
+ 1408000p -0.3
+ 1408010p 0.9
+ 1410000p 0.9
+ 1410010p -0.3
+ 1412000p -0.3
+ 1412010p 0.9
+ 1414000p 0.9
+ 1414010p -0.3
+ 1416000p -0.3
+ 1416010p 0.9
+ 1418000p 0.9
+ 1418010p -0.3
+ 1420000p -0.3
+ 1420010p 0.9
+ 1422000p 0.9
+ 1422010p -0.3
+ 1424000p -0.3
+ 1424010p 0.9
+ 1426000p 0.9
+ 1426010p -0.3
+ 1428000p -0.3
+ 1428010p 0.9
+ 1430000p 0.9
+ 1430010p -0.3
+ 1432000p -0.3
+ 1432010p 0.9
+ 1434000p 0.9
+ 1434010p -0.3
+ 1436000p -0.3
+ 1436010p 0.9
+ 1438000p 0.9
+ 1438010p -0.3
+ 1440000p -0.3
+ 1440010p 0.9
+ 1442000p 0.9
+ 1442010p -0.3
+ 1444000p -0.3
+ 1444010p 0.9
+ 1446000p 0.9
+ 1446010p -0.3
+ 1448000p -0.3
+ 1448010p 0.9
+ 1450000p 0.9
+ 1450010p -0.3
+ 1452000p -0.3
+ 1452010p 0.9
+ 1454000p 0.9
+ 1454010p -0.3
+ 1456000p -0.3
+ 1456010p 0.9
+ 1458000p 0.9
+ 1458010p -0.3
+ 1460000p -0.3
+ 1460010p 0.9
+ 1462000p 0.9
+ 1462010p -0.3
+ 1464000p -0.3
+ 1464010p 0.9
+ 1466000p 0.9
+ 1466010p -0.3
+ 1468000p -0.3
+ 1468010p 0.9
+ 1470000p 0.9
+ 1470010p -0.3
+ 1472000p -0.3
+ 1472010p 0.9
+ 1474000p 0.9
+ 1474010p -0.3
+ 1476000p -0.3
+ 1476010p 0.9
+ 1478000p 0.9
+ 1478010p -0.3
+ 1480000p -0.3
+ 1480010p 0.9
+ 1482000p 0.9
+ 1482010p -0.3
+ 1484000p -0.3
+ 1484010p 0.9
+ 1486000p 0.9
+ 1486010p -0.3
+ 1488000p -0.3
+ 1488010p 0.9
+ 1490000p 0.9
+ 1490010p -0.3
+ 1492000p -0.3
+ 1492010p 0.9
+ 1494000p 0.9
+ 1494010p -0.3
+ 1496000p -0.3
+ 1496010p 0.9
+ 1498000p 0.9
+ 1498010p -0.3
+ 1500000p -0.3
+ 1500010p 0.9
+ 1502000p 0.9
+ 1502010p -0.3
+ 1504000p -0.3
+ 1504010p 0.9
+ 1506000p 0.9
+ 1506010p -0.3
+ 1508000p -0.3
+ 1508010p 0.9
+ 1510000p 0.9
+ 1510010p -0.3
+ 1512000p -0.3
+ 1512010p 0.9
+ 1514000p 0.9
+ 1514010p -0.3
+ 1516000p -0.3
+ 1516010p 0.9
+ 1518000p 0.9
+ 1518010p -0.3
+ 1520000p -0.3
+ 1520010p 0.9
+ 1522000p 0.9
+ 1522010p -0.3
+ 1524000p -0.3
+ 1524010p 0.9
+ 1526000p 0.9
+ 1526010p -0.3
+ 1528000p -0.3
+ 1528010p 0.9
+ 1530000p 0.9
+ 1530010p -0.3
+ 1532000p -0.3
+ 1532010p 0.9
+ 1534000p 0.9
+ 1534010p -0.3
+ 1536000p -0.3
+ 1536010p 0.9
+ 1538000p 0.9
+ 1538010p -0.3
+ 1540000p -0.3
+ 1540010p 0.9
+ 1542000p 0.9
+ 1542010p -0.3
+ 1544000p -0.3
+ 1544010p 0.9
+ 1546000p 0.9
+ 1546010p -0.3
+ 1548000p -0.3
+ 1548010p 0.9
+ 1550000p 0.9
+ 1550010p -0.3
+ 1552000p -0.3
+ 1552010p 0.9
+ 1554000p 0.9
+ 1554010p -0.3
+ 1556000p -0.3
+ 1556010p 0.9
+ 1558000p 0.9
+ 1558010p -0.3
+ 1560000p -0.3
+ 1560010p 0.9
+ 1562000p 0.9
+ 1562010p -0.3
+ 1564000p -0.3
+ 1564010p 0.9
+ 1566000p 0.9
+ 1566010p -0.3
+ 1568000p -0.3
+ 1568010p 0.9
+ 1570000p 0.9
+ 1570010p -0.3
+ 1572000p -0.3
+ 1572010p 0.9
+ 1574000p 0.9
+ 1574010p -0.3
+ 1576000p -0.3
+ 1576010p 0.9
+ 1578000p 0.9
+ 1578010p -0.3
+ 1580000p -0.3
+ 1580010p 0.9
+ 1582000p 0.9
+ 1582010p -0.3
+ 1584000p -0.3
+ 1584010p 0.9
+ 1586000p 0.9
+ 1586010p -0.3
+ 1588000p -0.3
+ 1588010p 0.9
+ 1590000p 0.9
+ 1590010p -0.3
+ 1592000p -0.3
+ 1592010p 0.9
+ 1594000p 0.9
+ 1594010p -0.3
+ 1596000p -0.3
+ 1596010p 0.9
+ 1598000p 0.9
+ 1598010p -0.3
+ 1600000p -0.3
+ 1600010p 0.9
+ 1602000p 0.9
+ 1602010p -0.3
+ 1604000p -0.3
+ 1604010p 0.9
+ 1606000p 0.9
+ 1606010p -0.3
+ 1608000p -0.3
+ 1608010p 0.9
+ 1610000p 0.9
+ 1610010p -0.3
+ 1612000p -0.3
+ 1612010p 0.9
+ 1614000p 0.9
+ 1614010p -0.3
+ 1616000p -0.3
+ 1616010p 0.9
+ 1618000p 0.9
+ 1618010p -0.3
+ 1620000p -0.3
+ 1620010p 0.9
+ 1622000p 0.9
+ 1622010p -0.3
+ 1624000p -0.3
+ 1624010p 0.9
+ 1626000p 0.9
+ 1626010p -0.3
+ 1628000p -0.3
+ 1628010p 0.9
+ 1630000p 0.9
+ 1630010p -0.3
+ 1632000p -0.3
+ 1632010p 0.9
+ 1634000p 0.9
+ 1634010p -0.3
+ 1636000p -0.3
+ 1636010p 0.9
+ 1638000p 0.9
+ 1638010p -0.3
+ 1640000p -0.3
+ 1640010p 0.9
+ 1642000p 0.9
+ 1642010p -0.3
+ 1644000p -0.3
+ 1644010p 0.9
+ 1646000p 0.9
+ 1646010p -0.3
+ 1648000p -0.3
+ 1648010p 0.9
+ 1650000p 0.9
+ 1650010p -0.3
+ 1652000p -0.3
+ 1652010p 0.9
+ 1654000p 0.9
+ 1654010p -0.3
+ 1656000p -0.3
+ 1656010p 0.9
+ 1658000p 0.9
+ 1658010p -0.3
+ 1660000p -0.3
+ 1660010p 0.9
+ 1662000p 0.9
+ 1662010p -0.3
+ 1664000p -0.3
+ 1664010p 0.9
+ 1666000p 0.9
+ 1666010p -0.3
+ 1668000p -0.3
+ 1668010p 0.9
+ 1670000p 0.9
+ 1670010p -0.3
+ 1672000p -0.3
+ 1672010p 0.9
+ 1674000p 0.9
+ 1674010p -0.3
+ 1676000p -0.3
+ 1676010p 0.9
+ 1678000p 0.9
+ 1678010p -0.3
+ 1680000p -0.3
+ 1680010p 0.9
+ 1682000p 0.9
+ 1682010p -0.3
+ 1684000p -0.3
+ 1684010p 0.9
+ 1686000p 0.9
+ 1686010p -0.3
+ 1688000p -0.3
+ 1688010p 0.9
+ 1690000p 0.9
+ 1690010p -0.3
+ 1692000p -0.3
+ 1692010p 0.9
+ 1694000p 0.9
+ 1694010p -0.3
+ 1696000p -0.3
+ 1696010p 0.9
+ 1698000p 0.9
+ 1698010p -0.3
+ 1700000p -0.3
+ 1700010p 0.9
+ 1702000p 0.9
+ 1702010p -0.3
+ 1704000p -0.3
+ 1704010p 0.9
+ 1706000p 0.9
+ 1706010p -0.3
+ 1708000p -0.3
+ 1708010p 0.9
+ 1710000p 0.9
+ 1710010p -0.3
+ 1712000p -0.3
+ 1712010p 0.9
+ 1714000p 0.9
+ 1714010p -0.3
+ 1716000p -0.3
+ 1716010p 0.9
+ 1718000p 0.9
+ 1718010p -0.3
+ 1720000p -0.3
+ 1720010p 0.9
+ 1722000p 0.9
+ 1722010p -0.3
+ 1724000p -0.3
+ 1724010p 0.9
+ 1726000p 0.9
+ 1726010p -0.3
+ 1728000p -0.3
+ 1728010p 0.9
+ 1730000p 0.9
+ 1730010p -0.3
+ 1732000p -0.3
+ 1732010p 0.9
+ 1734000p 0.9
+ 1734010p -0.3
+ 1736000p -0.3
+ 1736010p 0.9
+ 1738000p 0.9
+ 1738010p -0.3
+ 1740000p -0.3
+ 1740010p 0.9
+ 1742000p 0.9
+ 1742010p -0.3
+ 1744000p -0.3
+ 1744010p 0.9
+ 1746000p 0.9
+ 1746010p -0.3
+ 1748000p -0.3
+ 1748010p 0.9
+ 1750000p 0.9
+ 1750010p -0.3
+ 1752000p -0.3
+ 1752010p 0.9
+ 1754000p 0.9
+ 1754010p -0.3
+ 1756000p -0.3
+ 1756010p 0.9
+ 1758000p 0.9
+ 1758010p -0.3
+ 1760000p -0.3
+ 1760010p 0.9
+ 1762000p 0.9
+ 1762010p -0.3
+ 1764000p -0.3
+ 1764010p 0.9
+ 1766000p 0.9
+ 1766010p -0.3
+ 1768000p -0.3
+ 1768010p 0.9
+ 1770000p 0.9
+ 1770010p -0.3
+ 1772000p -0.3
+ 1772010p 0.9
+ 1774000p 0.9
+ 1774010p -0.3
+ 1776000p -0.3
+ 1776010p 0.9
+ 1778000p 0.9
+ 1778010p -0.3
+ 1780000p -0.3
+ 1780010p 0.9
+ 1782000p 0.9
+ 1782010p -0.3
+ 1784000p -0.3
+ 1784010p 0.9
+ 1786000p 0.9
+ 1786010p -0.3
+ 1788000p -0.3
+ 1788010p 0.9
+ 1790000p 0.9
+ 1790010p -0.3
+ 1792000p -0.3
+ 1792010p 0.9
+ 1794000p 0.9
+ 1794010p -0.3
+ 1796000p -0.3
+ 1796010p 0.9
+ 1798000p 0.9
+ 1798010p -0.3
+ 1800000p -0.3
+ 1800010p 0.9
+ 1802000p 0.9
+ 1802010p -0.3
+ 1804000p -0.3
+ 1804010p 0.9
+ 1806000p 0.9
+ 1806010p -0.3
+ 1808000p -0.3
+ 1808010p 0.9
+ 1810000p 0.9
+ 1810010p -0.3
+ 1812000p -0.3
+ 1812010p 0.9
+ 1814000p 0.9
+ 1814010p -0.3
+ 1816000p -0.3
+ 1816010p 0.9
+ 1818000p 0.9
+ 1818010p -0.3
+ 1820000p -0.3
+ 1820010p 0.9
+ 1822000p 0.9
+ 1822010p -0.3
+ 1824000p -0.3
+ 1824010p 0.9
+ 1826000p 0.9
+ 1826010p -0.3
+ 1828000p -0.3
+ 1828010p 0.9
+ 1830000p 0.9
+ 1830010p -0.3
+ 1832000p -0.3
+ 1832010p 0.9
+ 1834000p 0.9
+ 1834010p -0.3
+ 1836000p -0.3
+ 1836010p 0.9
+ 1838000p 0.9
+ 1838010p -0.3
+ 1840000p -0.3
+ 1840010p 0.9
+ 1842000p 0.9
+ 1842010p -0.3
+ 1844000p -0.3
+ 1844010p 0.9
+ 1846000p 0.9
+ 1846010p -0.3
+ 1848000p -0.3
+ 1848010p 0.9
+ 1850000p 0.9
+ 1850010p -0.3
+ 1852000p -0.3
+ 1852010p 0.9
+ 1854000p 0.9
+ 1854010p -0.3
+ 1856000p -0.3
+ 1856010p 0.9
+ 1858000p 0.9
+ 1858010p -0.3
+ 1860000p -0.3
+ 1860010p 0.9
+ 1862000p 0.9
+ 1862010p -0.3
+ 1864000p -0.3
+ 1864010p 0.9
+ 1866000p 0.9
+ 1866010p -0.3
+ 1868000p -0.3
+ 1868010p 0.9
+ 1870000p 0.9
+ 1870010p -0.3
+ 1872000p -0.3
+ 1872010p 0.9
+ 1874000p 0.9
+ 1874010p -0.3
+ 1876000p -0.3
+ 1876010p 0.9
+ 1878000p 0.9
+ 1878010p -0.3
+ 1880000p -0.3
+ 1880010p 0.9
+ 1882000p 0.9
+ 1882010p -0.3
+ 1884000p -0.3
+ 1884010p 0.9
+ 1886000p 0.9
+ 1886010p -0.3
+ 1888000p -0.3
+ 1888010p 0.9
+ 1890000p 0.9
+ 1890010p -0.3
+ 1892000p -0.3
+ 1892010p 0.9
+ 1894000p 0.9
+ 1894010p -0.3
+ 1896000p -0.3
+ 1896010p 0.9
+ 1898000p 0.9
+ 1898010p -0.3
+ 1900000p -0.3
+ 1900010p 0.9
+ 1902000p 0.9
+ 1902010p -0.3
+ 1904000p -0.3
+ 1904010p 0.9
+ 1906000p 0.9
+ 1906010p -0.3
+ 1908000p -0.3
+ 1908010p 0.9
+ 1910000p 0.9
+ 1910010p -0.3
+ 1912000p -0.3
+ 1912010p 0.9
+ 1914000p 0.9
+ 1914010p -0.3
+ 1916000p -0.3
+ 1916010p 0.9
+ 1918000p 0.9
+ 1918010p -0.3
+ 1920000p -0.3
+ 1920010p 0.9
+ 1922000p 0.9
+ 1922010p -0.3
+ 1924000p -0.3
+ 1924010p 0.9
+ 1926000p 0.9
+ 1926010p -0.3
+ 1928000p -0.3
+ 1928010p 0.9
+ 1930000p 0.9
+ 1930010p -0.3
+ 1932000p -0.3
+ 1932010p 0.9
+ 1934000p 0.9
+ 1934010p -0.3
+ 1936000p -0.3
+ 1936010p 0.9
+ 1938000p 0.9
+ 1938010p -0.3
+ 1940000p -0.3
+ 1940010p 0.9
+ 1942000p 0.9
+ 1942010p -0.3
+ 1944000p -0.3
+ 1944010p 0.9
+ 1946000p 0.9
+ 1946010p -0.3
+ 1948000p -0.3
+ 1948010p 0.9
+ 1950000p 0.9
+ 1950010p -0.3
+ 1952000p -0.3
+ 1952010p 0.9
+ 1954000p 0.9
+ 1954010p -0.3
+ 1956000p -0.3
+ 1956010p 0.9
+ 1958000p 0.9
+ 1958010p -0.3
+ 1960000p -0.3
+ 1960010p 0.9
+ 1962000p 0.9
+ 1962010p -0.3
+ 1964000p -0.3
+ 1964010p 0.9
+ 1966000p 0.9
+ 1966010p -0.3
+ 1968000p -0.3
+ 1968010p 0.9
+ 1970000p 0.9
+ 1970010p -0.3
+ 1972000p -0.3
+ 1972010p 0.9
+ 1974000p 0.9
+ 1974010p -0.3
+ 1976000p -0.3
+ 1976010p 0.9
+ 1978000p 0.9
+ 1978010p -0.3
+ 1980000p -0.3
+ 1980010p 0.9
+ 1982000p 0.9
+ 1982010p -0.3
+ 1984000p -0.3
+ 1984010p 0.9
+ 1986000p 0.9
+ 1986010p -0.3
+ 1988000p -0.3
+ 1988010p 0.9
+ 1990000p 0.9
+ 1990010p -0.3
+ 1992000p -0.3
+ 1992010p 0.9
+ 1994000p 0.9
+ 1994010p -0.3
+ 1996000p -0.3
+ 1996010p 0.9
+ 1998000p 0.9
+ 1998010p -0.3
+ 2000000p -0.3
+ 2000010p 0.9
+ 2002000p 0.9
+ 2002010p -0.3
+ 2004000p -0.3
+ 2004010p 0.9
+ 2006000p 0.9
+ 2006010p -0.3
+ 2008000p -0.3
+ 2008010p 0.9
+ 2010000p 0.9
+ 2010010p -0.3
+ 2012000p -0.3
+ 2012010p 0.9
+ 2014000p 0.9
+ 2014010p -0.3
+ 2016000p -0.3
+ 2016010p 0.9
+ 2018000p 0.9
+ 2018010p -0.3
+ 2020000p -0.3
+ 2020010p 0.9
+ 2022000p 0.9
+ 2022010p -0.3
+ 2024000p -0.3
+ 2024010p 0.9
+ 2026000p 0.9
+ 2026010p -0.3
+ 2028000p -0.3
+ 2028010p 0.9
+ 2030000p 0.9
+ 2030010p -0.3
+ 2032000p -0.3
+ 2032010p 0.9
+ 2034000p 0.9
+ 2034010p -0.3
+ 2036000p -0.3
+ 2036010p 0.9
+ 2038000p 0.9
+ 2038010p -0.3
+ 2040000p -0.3
+ 2040010p 0.9
+ 2042000p 0.9
+ 2042010p -0.3
+ 2044000p -0.3
+ 2044010p 0.9
+ 2046000p 0.9
+ 2046010p -0.3
+ 2048000p -0.3
+ 2048010p 0.9
+ \]
V_data_bar_10 (Data_bar\\<10\\> gnd!) vsource type=pwl wave=\[
+ 0    -0.3
+ 2000p -0.3
+ 2010p 0.9
+ 4000p 0.9
+ 4010p -0.3
+ 6000p -0.3
+ 6010p 0.9
+ 8000p 0.9
+ 8010p -0.3
+ 10000p -0.3
+ 10010p 0.9
+ 12000p 0.9
+ 12010p -0.3
+ 14000p -0.3
+ 14010p 0.9
+ 16000p 0.9
+ 16010p -0.3
+ 18000p -0.3
+ 18010p 0.9
+ 20000p 0.9
+ 20010p -0.3
+ 22000p -0.3
+ 22010p 0.9
+ 24000p 0.9
+ 24010p -0.3
+ 26000p -0.3
+ 26010p 0.9
+ 28000p 0.9
+ 28010p -0.3
+ 30000p -0.3
+ 30010p 0.9
+ 32000p 0.9
+ 32010p -0.3
+ 34000p -0.3
+ 34010p 0.9
+ 36000p 0.9
+ 36010p -0.3
+ 38000p -0.3
+ 38010p 0.9
+ 40000p 0.9
+ 40010p -0.3
+ 42000p -0.3
+ 42010p 0.9
+ 44000p 0.9
+ 44010p -0.3
+ 46000p -0.3
+ 46010p 0.9
+ 48000p 0.9
+ 48010p -0.3
+ 50000p -0.3
+ 50010p 0.9
+ 52000p 0.9
+ 52010p -0.3
+ 54000p -0.3
+ 54010p 0.9
+ 56000p 0.9
+ 56010p -0.3
+ 58000p -0.3
+ 58010p 0.9
+ 60000p 0.9
+ 60010p -0.3
+ 62000p -0.3
+ 62010p 0.9
+ 64000p 0.9
+ 64010p -0.3
+ 66000p -0.3
+ 66010p 0.9
+ 68000p 0.9
+ 68010p -0.3
+ 70000p -0.3
+ 70010p 0.9
+ 72000p 0.9
+ 72010p -0.3
+ 74000p -0.3
+ 74010p 0.9
+ 76000p 0.9
+ 76010p -0.3
+ 78000p -0.3
+ 78010p 0.9
+ 80000p 0.9
+ 80010p -0.3
+ 82000p -0.3
+ 82010p 0.9
+ 84000p 0.9
+ 84010p -0.3
+ 86000p -0.3
+ 86010p 0.9
+ 88000p 0.9
+ 88010p -0.3
+ 90000p -0.3
+ 90010p 0.9
+ 92000p 0.9
+ 92010p -0.3
+ 94000p -0.3
+ 94010p 0.9
+ 96000p 0.9
+ 96010p -0.3
+ 98000p -0.3
+ 98010p 0.9
+ 100000p 0.9
+ 100010p -0.3
+ 102000p -0.3
+ 102010p 0.9
+ 104000p 0.9
+ 104010p -0.3
+ 106000p -0.3
+ 106010p 0.9
+ 108000p 0.9
+ 108010p -0.3
+ 110000p -0.3
+ 110010p 0.9
+ 112000p 0.9
+ 112010p -0.3
+ 114000p -0.3
+ 114010p 0.9
+ 116000p 0.9
+ 116010p -0.3
+ 118000p -0.3
+ 118010p 0.9
+ 120000p 0.9
+ 120010p -0.3
+ 122000p -0.3
+ 122010p 0.9
+ 124000p 0.9
+ 124010p -0.3
+ 126000p -0.3
+ 126010p 0.9
+ 128000p 0.9
+ 128010p -0.3
+ 130000p -0.3
+ 130010p 0.9
+ 132000p 0.9
+ 132010p -0.3
+ 134000p -0.3
+ 134010p 0.9
+ 136000p 0.9
+ 136010p -0.3
+ 138000p -0.3
+ 138010p 0.9
+ 140000p 0.9
+ 140010p -0.3
+ 142000p -0.3
+ 142010p 0.9
+ 144000p 0.9
+ 144010p -0.3
+ 146000p -0.3
+ 146010p 0.9
+ 148000p 0.9
+ 148010p -0.3
+ 150000p -0.3
+ 150010p 0.9
+ 152000p 0.9
+ 152010p -0.3
+ 154000p -0.3
+ 154010p 0.9
+ 156000p 0.9
+ 156010p -0.3
+ 158000p -0.3
+ 158010p 0.9
+ 160000p 0.9
+ 160010p -0.3
+ 162000p -0.3
+ 162010p 0.9
+ 164000p 0.9
+ 164010p -0.3
+ 166000p -0.3
+ 166010p 0.9
+ 168000p 0.9
+ 168010p -0.3
+ 170000p -0.3
+ 170010p 0.9
+ 172000p 0.9
+ 172010p -0.3
+ 174000p -0.3
+ 174010p 0.9
+ 176000p 0.9
+ 176010p -0.3
+ 178000p -0.3
+ 178010p 0.9
+ 180000p 0.9
+ 180010p -0.3
+ 182000p -0.3
+ 182010p 0.9
+ 184000p 0.9
+ 184010p -0.3
+ 186000p -0.3
+ 186010p 0.9
+ 188000p 0.9
+ 188010p -0.3
+ 190000p -0.3
+ 190010p 0.9
+ 192000p 0.9
+ 192010p -0.3
+ 194000p -0.3
+ 194010p 0.9
+ 196000p 0.9
+ 196010p -0.3
+ 198000p -0.3
+ 198010p 0.9
+ 200000p 0.9
+ 200010p -0.3
+ 202000p -0.3
+ 202010p 0.9
+ 204000p 0.9
+ 204010p -0.3
+ 206000p -0.3
+ 206010p 0.9
+ 208000p 0.9
+ 208010p -0.3
+ 210000p -0.3
+ 210010p 0.9
+ 212000p 0.9
+ 212010p -0.3
+ 214000p -0.3
+ 214010p 0.9
+ 216000p 0.9
+ 216010p -0.3
+ 218000p -0.3
+ 218010p 0.9
+ 220000p 0.9
+ 220010p -0.3
+ 222000p -0.3
+ 222010p 0.9
+ 224000p 0.9
+ 224010p -0.3
+ 226000p -0.3
+ 226010p 0.9
+ 228000p 0.9
+ 228010p -0.3
+ 230000p -0.3
+ 230010p 0.9
+ 232000p 0.9
+ 232010p -0.3
+ 234000p -0.3
+ 234010p 0.9
+ 236000p 0.9
+ 236010p -0.3
+ 238000p -0.3
+ 238010p 0.9
+ 240000p 0.9
+ 240010p -0.3
+ 242000p -0.3
+ 242010p 0.9
+ 244000p 0.9
+ 244010p -0.3
+ 246000p -0.3
+ 246010p 0.9
+ 248000p 0.9
+ 248010p -0.3
+ 250000p -0.3
+ 250010p 0.9
+ 252000p 0.9
+ 252010p -0.3
+ 254000p -0.3
+ 254010p 0.9
+ 256000p 0.9
+ 256010p -0.3
+ 258000p -0.3
+ 258010p 0.9
+ 260000p 0.9
+ 260010p -0.3
+ 262000p -0.3
+ 262010p 0.9
+ 264000p 0.9
+ 264010p -0.3
+ 266000p -0.3
+ 266010p 0.9
+ 268000p 0.9
+ 268010p -0.3
+ 270000p -0.3
+ 270010p 0.9
+ 272000p 0.9
+ 272010p -0.3
+ 274000p -0.3
+ 274010p 0.9
+ 276000p 0.9
+ 276010p -0.3
+ 278000p -0.3
+ 278010p 0.9
+ 280000p 0.9
+ 280010p -0.3
+ 282000p -0.3
+ 282010p 0.9
+ 284000p 0.9
+ 284010p -0.3
+ 286000p -0.3
+ 286010p 0.9
+ 288000p 0.9
+ 288010p -0.3
+ 290000p -0.3
+ 290010p 0.9
+ 292000p 0.9
+ 292010p -0.3
+ 294000p -0.3
+ 294010p 0.9
+ 296000p 0.9
+ 296010p -0.3
+ 298000p -0.3
+ 298010p 0.9
+ 300000p 0.9
+ 300010p -0.3
+ 302000p -0.3
+ 302010p 0.9
+ 304000p 0.9
+ 304010p -0.3
+ 306000p -0.3
+ 306010p 0.9
+ 308000p 0.9
+ 308010p -0.3
+ 310000p -0.3
+ 310010p 0.9
+ 312000p 0.9
+ 312010p -0.3
+ 314000p -0.3
+ 314010p 0.9
+ 316000p 0.9
+ 316010p -0.3
+ 318000p -0.3
+ 318010p 0.9
+ 320000p 0.9
+ 320010p -0.3
+ 322000p -0.3
+ 322010p 0.9
+ 324000p 0.9
+ 324010p -0.3
+ 326000p -0.3
+ 326010p 0.9
+ 328000p 0.9
+ 328010p -0.3
+ 330000p -0.3
+ 330010p 0.9
+ 332000p 0.9
+ 332010p -0.3
+ 334000p -0.3
+ 334010p 0.9
+ 336000p 0.9
+ 336010p -0.3
+ 338000p -0.3
+ 338010p 0.9
+ 340000p 0.9
+ 340010p -0.3
+ 342000p -0.3
+ 342010p 0.9
+ 344000p 0.9
+ 344010p -0.3
+ 346000p -0.3
+ 346010p 0.9
+ 348000p 0.9
+ 348010p -0.3
+ 350000p -0.3
+ 350010p 0.9
+ 352000p 0.9
+ 352010p -0.3
+ 354000p -0.3
+ 354010p 0.9
+ 356000p 0.9
+ 356010p -0.3
+ 358000p -0.3
+ 358010p 0.9
+ 360000p 0.9
+ 360010p -0.3
+ 362000p -0.3
+ 362010p 0.9
+ 364000p 0.9
+ 364010p -0.3
+ 366000p -0.3
+ 366010p 0.9
+ 368000p 0.9
+ 368010p -0.3
+ 370000p -0.3
+ 370010p 0.9
+ 372000p 0.9
+ 372010p -0.3
+ 374000p -0.3
+ 374010p 0.9
+ 376000p 0.9
+ 376010p -0.3
+ 378000p -0.3
+ 378010p 0.9
+ 380000p 0.9
+ 380010p -0.3
+ 382000p -0.3
+ 382010p 0.9
+ 384000p 0.9
+ 384010p -0.3
+ 386000p -0.3
+ 386010p 0.9
+ 388000p 0.9
+ 388010p -0.3
+ 390000p -0.3
+ 390010p 0.9
+ 392000p 0.9
+ 392010p -0.3
+ 394000p -0.3
+ 394010p 0.9
+ 396000p 0.9
+ 396010p -0.3
+ 398000p -0.3
+ 398010p 0.9
+ 400000p 0.9
+ 400010p -0.3
+ 402000p -0.3
+ 402010p 0.9
+ 404000p 0.9
+ 404010p -0.3
+ 406000p -0.3
+ 406010p 0.9
+ 408000p 0.9
+ 408010p -0.3
+ 410000p -0.3
+ 410010p 0.9
+ 412000p 0.9
+ 412010p -0.3
+ 414000p -0.3
+ 414010p 0.9
+ 416000p 0.9
+ 416010p -0.3
+ 418000p -0.3
+ 418010p 0.9
+ 420000p 0.9
+ 420010p -0.3
+ 422000p -0.3
+ 422010p 0.9
+ 424000p 0.9
+ 424010p -0.3
+ 426000p -0.3
+ 426010p 0.9
+ 428000p 0.9
+ 428010p -0.3
+ 430000p -0.3
+ 430010p 0.9
+ 432000p 0.9
+ 432010p -0.3
+ 434000p -0.3
+ 434010p 0.9
+ 436000p 0.9
+ 436010p -0.3
+ 438000p -0.3
+ 438010p 0.9
+ 440000p 0.9
+ 440010p -0.3
+ 442000p -0.3
+ 442010p 0.9
+ 444000p 0.9
+ 444010p -0.3
+ 446000p -0.3
+ 446010p 0.9
+ 448000p 0.9
+ 448010p -0.3
+ 450000p -0.3
+ 450010p 0.9
+ 452000p 0.9
+ 452010p -0.3
+ 454000p -0.3
+ 454010p 0.9
+ 456000p 0.9
+ 456010p -0.3
+ 458000p -0.3
+ 458010p 0.9
+ 460000p 0.9
+ 460010p -0.3
+ 462000p -0.3
+ 462010p 0.9
+ 464000p 0.9
+ 464010p -0.3
+ 466000p -0.3
+ 466010p 0.9
+ 468000p 0.9
+ 468010p -0.3
+ 470000p -0.3
+ 470010p 0.9
+ 472000p 0.9
+ 472010p -0.3
+ 474000p -0.3
+ 474010p 0.9
+ 476000p 0.9
+ 476010p -0.3
+ 478000p -0.3
+ 478010p 0.9
+ 480000p 0.9
+ 480010p -0.3
+ 482000p -0.3
+ 482010p 0.9
+ 484000p 0.9
+ 484010p -0.3
+ 486000p -0.3
+ 486010p 0.9
+ 488000p 0.9
+ 488010p -0.3
+ 490000p -0.3
+ 490010p 0.9
+ 492000p 0.9
+ 492010p -0.3
+ 494000p -0.3
+ 494010p 0.9
+ 496000p 0.9
+ 496010p -0.3
+ 498000p -0.3
+ 498010p 0.9
+ 500000p 0.9
+ 500010p -0.3
+ 502000p -0.3
+ 502010p 0.9
+ 504000p 0.9
+ 504010p -0.3
+ 506000p -0.3
+ 506010p 0.9
+ 508000p 0.9
+ 508010p -0.3
+ 510000p -0.3
+ 510010p 0.9
+ 512000p 0.9
+ 512010p -0.3
+ 514000p -0.3
+ 514010p 0.9
+ 516000p 0.9
+ 516010p -0.3
+ 518000p -0.3
+ 518010p 0.9
+ 520000p 0.9
+ 520010p -0.3
+ 522000p -0.3
+ 522010p 0.9
+ 524000p 0.9
+ 524010p -0.3
+ 526000p -0.3
+ 526010p 0.9
+ 528000p 0.9
+ 528010p -0.3
+ 530000p -0.3
+ 530010p 0.9
+ 532000p 0.9
+ 532010p -0.3
+ 534000p -0.3
+ 534010p 0.9
+ 536000p 0.9
+ 536010p -0.3
+ 538000p -0.3
+ 538010p 0.9
+ 540000p 0.9
+ 540010p -0.3
+ 542000p -0.3
+ 542010p 0.9
+ 544000p 0.9
+ 544010p -0.3
+ 546000p -0.3
+ 546010p 0.9
+ 548000p 0.9
+ 548010p -0.3
+ 550000p -0.3
+ 550010p 0.9
+ 552000p 0.9
+ 552010p -0.3
+ 554000p -0.3
+ 554010p 0.9
+ 556000p 0.9
+ 556010p -0.3
+ 558000p -0.3
+ 558010p 0.9
+ 560000p 0.9
+ 560010p -0.3
+ 562000p -0.3
+ 562010p 0.9
+ 564000p 0.9
+ 564010p -0.3
+ 566000p -0.3
+ 566010p 0.9
+ 568000p 0.9
+ 568010p -0.3
+ 570000p -0.3
+ 570010p 0.9
+ 572000p 0.9
+ 572010p -0.3
+ 574000p -0.3
+ 574010p 0.9
+ 576000p 0.9
+ 576010p -0.3
+ 578000p -0.3
+ 578010p 0.9
+ 580000p 0.9
+ 580010p -0.3
+ 582000p -0.3
+ 582010p 0.9
+ 584000p 0.9
+ 584010p -0.3
+ 586000p -0.3
+ 586010p 0.9
+ 588000p 0.9
+ 588010p -0.3
+ 590000p -0.3
+ 590010p 0.9
+ 592000p 0.9
+ 592010p -0.3
+ 594000p -0.3
+ 594010p 0.9
+ 596000p 0.9
+ 596010p -0.3
+ 598000p -0.3
+ 598010p 0.9
+ 600000p 0.9
+ 600010p -0.3
+ 602000p -0.3
+ 602010p 0.9
+ 604000p 0.9
+ 604010p -0.3
+ 606000p -0.3
+ 606010p 0.9
+ 608000p 0.9
+ 608010p -0.3
+ 610000p -0.3
+ 610010p 0.9
+ 612000p 0.9
+ 612010p -0.3
+ 614000p -0.3
+ 614010p 0.9
+ 616000p 0.9
+ 616010p -0.3
+ 618000p -0.3
+ 618010p 0.9
+ 620000p 0.9
+ 620010p -0.3
+ 622000p -0.3
+ 622010p 0.9
+ 624000p 0.9
+ 624010p -0.3
+ 626000p -0.3
+ 626010p 0.9
+ 628000p 0.9
+ 628010p -0.3
+ 630000p -0.3
+ 630010p 0.9
+ 632000p 0.9
+ 632010p -0.3
+ 634000p -0.3
+ 634010p 0.9
+ 636000p 0.9
+ 636010p -0.3
+ 638000p -0.3
+ 638010p 0.9
+ 640000p 0.9
+ 640010p -0.3
+ 642000p -0.3
+ 642010p 0.9
+ 644000p 0.9
+ 644010p -0.3
+ 646000p -0.3
+ 646010p 0.9
+ 648000p 0.9
+ 648010p -0.3
+ 650000p -0.3
+ 650010p 0.9
+ 652000p 0.9
+ 652010p -0.3
+ 654000p -0.3
+ 654010p 0.9
+ 656000p 0.9
+ 656010p -0.3
+ 658000p -0.3
+ 658010p 0.9
+ 660000p 0.9
+ 660010p -0.3
+ 662000p -0.3
+ 662010p 0.9
+ 664000p 0.9
+ 664010p -0.3
+ 666000p -0.3
+ 666010p 0.9
+ 668000p 0.9
+ 668010p -0.3
+ 670000p -0.3
+ 670010p 0.9
+ 672000p 0.9
+ 672010p -0.3
+ 674000p -0.3
+ 674010p 0.9
+ 676000p 0.9
+ 676010p -0.3
+ 678000p -0.3
+ 678010p 0.9
+ 680000p 0.9
+ 680010p -0.3
+ 682000p -0.3
+ 682010p 0.9
+ 684000p 0.9
+ 684010p -0.3
+ 686000p -0.3
+ 686010p 0.9
+ 688000p 0.9
+ 688010p -0.3
+ 690000p -0.3
+ 690010p 0.9
+ 692000p 0.9
+ 692010p -0.3
+ 694000p -0.3
+ 694010p 0.9
+ 696000p 0.9
+ 696010p -0.3
+ 698000p -0.3
+ 698010p 0.9
+ 700000p 0.9
+ 700010p -0.3
+ 702000p -0.3
+ 702010p 0.9
+ 704000p 0.9
+ 704010p -0.3
+ 706000p -0.3
+ 706010p 0.9
+ 708000p 0.9
+ 708010p -0.3
+ 710000p -0.3
+ 710010p 0.9
+ 712000p 0.9
+ 712010p -0.3
+ 714000p -0.3
+ 714010p 0.9
+ 716000p 0.9
+ 716010p -0.3
+ 718000p -0.3
+ 718010p 0.9
+ 720000p 0.9
+ 720010p -0.3
+ 722000p -0.3
+ 722010p 0.9
+ 724000p 0.9
+ 724010p -0.3
+ 726000p -0.3
+ 726010p 0.9
+ 728000p 0.9
+ 728010p -0.3
+ 730000p -0.3
+ 730010p 0.9
+ 732000p 0.9
+ 732010p -0.3
+ 734000p -0.3
+ 734010p 0.9
+ 736000p 0.9
+ 736010p -0.3
+ 738000p -0.3
+ 738010p 0.9
+ 740000p 0.9
+ 740010p -0.3
+ 742000p -0.3
+ 742010p 0.9
+ 744000p 0.9
+ 744010p -0.3
+ 746000p -0.3
+ 746010p 0.9
+ 748000p 0.9
+ 748010p -0.3
+ 750000p -0.3
+ 750010p 0.9
+ 752000p 0.9
+ 752010p -0.3
+ 754000p -0.3
+ 754010p 0.9
+ 756000p 0.9
+ 756010p -0.3
+ 758000p -0.3
+ 758010p 0.9
+ 760000p 0.9
+ 760010p -0.3
+ 762000p -0.3
+ 762010p 0.9
+ 764000p 0.9
+ 764010p -0.3
+ 766000p -0.3
+ 766010p 0.9
+ 768000p 0.9
+ 768010p -0.3
+ 770000p -0.3
+ 770010p 0.9
+ 772000p 0.9
+ 772010p -0.3
+ 774000p -0.3
+ 774010p 0.9
+ 776000p 0.9
+ 776010p -0.3
+ 778000p -0.3
+ 778010p 0.9
+ 780000p 0.9
+ 780010p -0.3
+ 782000p -0.3
+ 782010p 0.9
+ 784000p 0.9
+ 784010p -0.3
+ 786000p -0.3
+ 786010p 0.9
+ 788000p 0.9
+ 788010p -0.3
+ 790000p -0.3
+ 790010p 0.9
+ 792000p 0.9
+ 792010p -0.3
+ 794000p -0.3
+ 794010p 0.9
+ 796000p 0.9
+ 796010p -0.3
+ 798000p -0.3
+ 798010p 0.9
+ 800000p 0.9
+ 800010p -0.3
+ 802000p -0.3
+ 802010p 0.9
+ 804000p 0.9
+ 804010p -0.3
+ 806000p -0.3
+ 806010p 0.9
+ 808000p 0.9
+ 808010p -0.3
+ 810000p -0.3
+ 810010p 0.9
+ 812000p 0.9
+ 812010p -0.3
+ 814000p -0.3
+ 814010p 0.9
+ 816000p 0.9
+ 816010p -0.3
+ 818000p -0.3
+ 818010p 0.9
+ 820000p 0.9
+ 820010p -0.3
+ 822000p -0.3
+ 822010p 0.9
+ 824000p 0.9
+ 824010p -0.3
+ 826000p -0.3
+ 826010p 0.9
+ 828000p 0.9
+ 828010p -0.3
+ 830000p -0.3
+ 830010p 0.9
+ 832000p 0.9
+ 832010p -0.3
+ 834000p -0.3
+ 834010p 0.9
+ 836000p 0.9
+ 836010p -0.3
+ 838000p -0.3
+ 838010p 0.9
+ 840000p 0.9
+ 840010p -0.3
+ 842000p -0.3
+ 842010p 0.9
+ 844000p 0.9
+ 844010p -0.3
+ 846000p -0.3
+ 846010p 0.9
+ 848000p 0.9
+ 848010p -0.3
+ 850000p -0.3
+ 850010p 0.9
+ 852000p 0.9
+ 852010p -0.3
+ 854000p -0.3
+ 854010p 0.9
+ 856000p 0.9
+ 856010p -0.3
+ 858000p -0.3
+ 858010p 0.9
+ 860000p 0.9
+ 860010p -0.3
+ 862000p -0.3
+ 862010p 0.9
+ 864000p 0.9
+ 864010p -0.3
+ 866000p -0.3
+ 866010p 0.9
+ 868000p 0.9
+ 868010p -0.3
+ 870000p -0.3
+ 870010p 0.9
+ 872000p 0.9
+ 872010p -0.3
+ 874000p -0.3
+ 874010p 0.9
+ 876000p 0.9
+ 876010p -0.3
+ 878000p -0.3
+ 878010p 0.9
+ 880000p 0.9
+ 880010p -0.3
+ 882000p -0.3
+ 882010p 0.9
+ 884000p 0.9
+ 884010p -0.3
+ 886000p -0.3
+ 886010p 0.9
+ 888000p 0.9
+ 888010p -0.3
+ 890000p -0.3
+ 890010p 0.9
+ 892000p 0.9
+ 892010p -0.3
+ 894000p -0.3
+ 894010p 0.9
+ 896000p 0.9
+ 896010p -0.3
+ 898000p -0.3
+ 898010p 0.9
+ 900000p 0.9
+ 900010p -0.3
+ 902000p -0.3
+ 902010p 0.9
+ 904000p 0.9
+ 904010p -0.3
+ 906000p -0.3
+ 906010p 0.9
+ 908000p 0.9
+ 908010p -0.3
+ 910000p -0.3
+ 910010p 0.9
+ 912000p 0.9
+ 912010p -0.3
+ 914000p -0.3
+ 914010p 0.9
+ 916000p 0.9
+ 916010p -0.3
+ 918000p -0.3
+ 918010p 0.9
+ 920000p 0.9
+ 920010p -0.3
+ 922000p -0.3
+ 922010p 0.9
+ 924000p 0.9
+ 924010p -0.3
+ 926000p -0.3
+ 926010p 0.9
+ 928000p 0.9
+ 928010p -0.3
+ 930000p -0.3
+ 930010p 0.9
+ 932000p 0.9
+ 932010p -0.3
+ 934000p -0.3
+ 934010p 0.9
+ 936000p 0.9
+ 936010p -0.3
+ 938000p -0.3
+ 938010p 0.9
+ 940000p 0.9
+ 940010p -0.3
+ 942000p -0.3
+ 942010p 0.9
+ 944000p 0.9
+ 944010p -0.3
+ 946000p -0.3
+ 946010p 0.9
+ 948000p 0.9
+ 948010p -0.3
+ 950000p -0.3
+ 950010p 0.9
+ 952000p 0.9
+ 952010p -0.3
+ 954000p -0.3
+ 954010p 0.9
+ 956000p 0.9
+ 956010p -0.3
+ 958000p -0.3
+ 958010p 0.9
+ 960000p 0.9
+ 960010p -0.3
+ 962000p -0.3
+ 962010p 0.9
+ 964000p 0.9
+ 964010p -0.3
+ 966000p -0.3
+ 966010p 0.9
+ 968000p 0.9
+ 968010p -0.3
+ 970000p -0.3
+ 970010p 0.9
+ 972000p 0.9
+ 972010p -0.3
+ 974000p -0.3
+ 974010p 0.9
+ 976000p 0.9
+ 976010p -0.3
+ 978000p -0.3
+ 978010p 0.9
+ 980000p 0.9
+ 980010p -0.3
+ 982000p -0.3
+ 982010p 0.9
+ 984000p 0.9
+ 984010p -0.3
+ 986000p -0.3
+ 986010p 0.9
+ 988000p 0.9
+ 988010p -0.3
+ 990000p -0.3
+ 990010p 0.9
+ 992000p 0.9
+ 992010p -0.3
+ 994000p -0.3
+ 994010p 0.9
+ 996000p 0.9
+ 996010p -0.3
+ 998000p -0.3
+ 998010p 0.9
+ 1000000p 0.9
+ 1000010p -0.3
+ 1002000p -0.3
+ 1002010p 0.9
+ 1004000p 0.9
+ 1004010p -0.3
+ 1006000p -0.3
+ 1006010p 0.9
+ 1008000p 0.9
+ 1008010p -0.3
+ 1010000p -0.3
+ 1010010p 0.9
+ 1012000p 0.9
+ 1012010p -0.3
+ 1014000p -0.3
+ 1014010p 0.9
+ 1016000p 0.9
+ 1016010p -0.3
+ 1018000p -0.3
+ 1018010p 0.9
+ 1020000p 0.9
+ 1020010p -0.3
+ 1022000p -0.3
+ 1022010p 0.9
+ 1024000p 0.9
+ 1024010p -0.3
+ 1026000p -0.3
+ 1026010p 0.9
+ 1028000p 0.9
+ 1028010p -0.3
+ 1030000p -0.3
+ 1030010p 0.9
+ 1032000p 0.9
+ 1032010p -0.3
+ 1034000p -0.3
+ 1034010p 0.9
+ 1036000p 0.9
+ 1036010p -0.3
+ 1038000p -0.3
+ 1038010p 0.9
+ 1040000p 0.9
+ 1040010p -0.3
+ 1042000p -0.3
+ 1042010p 0.9
+ 1044000p 0.9
+ 1044010p -0.3
+ 1046000p -0.3
+ 1046010p 0.9
+ 1048000p 0.9
+ 1048010p -0.3
+ 1050000p -0.3
+ 1050010p 0.9
+ 1052000p 0.9
+ 1052010p -0.3
+ 1054000p -0.3
+ 1054010p 0.9
+ 1056000p 0.9
+ 1056010p -0.3
+ 1058000p -0.3
+ 1058010p 0.9
+ 1060000p 0.9
+ 1060010p -0.3
+ 1062000p -0.3
+ 1062010p 0.9
+ 1064000p 0.9
+ 1064010p -0.3
+ 1066000p -0.3
+ 1066010p 0.9
+ 1068000p 0.9
+ 1068010p -0.3
+ 1070000p -0.3
+ 1070010p 0.9
+ 1072000p 0.9
+ 1072010p -0.3
+ 1074000p -0.3
+ 1074010p 0.9
+ 1076000p 0.9
+ 1076010p -0.3
+ 1078000p -0.3
+ 1078010p 0.9
+ 1080000p 0.9
+ 1080010p -0.3
+ 1082000p -0.3
+ 1082010p 0.9
+ 1084000p 0.9
+ 1084010p -0.3
+ 1086000p -0.3
+ 1086010p 0.9
+ 1088000p 0.9
+ 1088010p -0.3
+ 1090000p -0.3
+ 1090010p 0.9
+ 1092000p 0.9
+ 1092010p -0.3
+ 1094000p -0.3
+ 1094010p 0.9
+ 1096000p 0.9
+ 1096010p -0.3
+ 1098000p -0.3
+ 1098010p 0.9
+ 1100000p 0.9
+ 1100010p -0.3
+ 1102000p -0.3
+ 1102010p 0.9
+ 1104000p 0.9
+ 1104010p -0.3
+ 1106000p -0.3
+ 1106010p 0.9
+ 1108000p 0.9
+ 1108010p -0.3
+ 1110000p -0.3
+ 1110010p 0.9
+ 1112000p 0.9
+ 1112010p -0.3
+ 1114000p -0.3
+ 1114010p 0.9
+ 1116000p 0.9
+ 1116010p -0.3
+ 1118000p -0.3
+ 1118010p 0.9
+ 1120000p 0.9
+ 1120010p -0.3
+ 1122000p -0.3
+ 1122010p 0.9
+ 1124000p 0.9
+ 1124010p -0.3
+ 1126000p -0.3
+ 1126010p 0.9
+ 1128000p 0.9
+ 1128010p -0.3
+ 1130000p -0.3
+ 1130010p 0.9
+ 1132000p 0.9
+ 1132010p -0.3
+ 1134000p -0.3
+ 1134010p 0.9
+ 1136000p 0.9
+ 1136010p -0.3
+ 1138000p -0.3
+ 1138010p 0.9
+ 1140000p 0.9
+ 1140010p -0.3
+ 1142000p -0.3
+ 1142010p 0.9
+ 1144000p 0.9
+ 1144010p -0.3
+ 1146000p -0.3
+ 1146010p 0.9
+ 1148000p 0.9
+ 1148010p -0.3
+ 1150000p -0.3
+ 1150010p 0.9
+ 1152000p 0.9
+ 1152010p -0.3
+ 1154000p -0.3
+ 1154010p 0.9
+ 1156000p 0.9
+ 1156010p -0.3
+ 1158000p -0.3
+ 1158010p 0.9
+ 1160000p 0.9
+ 1160010p -0.3
+ 1162000p -0.3
+ 1162010p 0.9
+ 1164000p 0.9
+ 1164010p -0.3
+ 1166000p -0.3
+ 1166010p 0.9
+ 1168000p 0.9
+ 1168010p -0.3
+ 1170000p -0.3
+ 1170010p 0.9
+ 1172000p 0.9
+ 1172010p -0.3
+ 1174000p -0.3
+ 1174010p 0.9
+ 1176000p 0.9
+ 1176010p -0.3
+ 1178000p -0.3
+ 1178010p 0.9
+ 1180000p 0.9
+ 1180010p -0.3
+ 1182000p -0.3
+ 1182010p 0.9
+ 1184000p 0.9
+ 1184010p -0.3
+ 1186000p -0.3
+ 1186010p 0.9
+ 1188000p 0.9
+ 1188010p -0.3
+ 1190000p -0.3
+ 1190010p 0.9
+ 1192000p 0.9
+ 1192010p -0.3
+ 1194000p -0.3
+ 1194010p 0.9
+ 1196000p 0.9
+ 1196010p -0.3
+ 1198000p -0.3
+ 1198010p 0.9
+ 1200000p 0.9
+ 1200010p -0.3
+ 1202000p -0.3
+ 1202010p 0.9
+ 1204000p 0.9
+ 1204010p -0.3
+ 1206000p -0.3
+ 1206010p 0.9
+ 1208000p 0.9
+ 1208010p -0.3
+ 1210000p -0.3
+ 1210010p 0.9
+ 1212000p 0.9
+ 1212010p -0.3
+ 1214000p -0.3
+ 1214010p 0.9
+ 1216000p 0.9
+ 1216010p -0.3
+ 1218000p -0.3
+ 1218010p 0.9
+ 1220000p 0.9
+ 1220010p -0.3
+ 1222000p -0.3
+ 1222010p 0.9
+ 1224000p 0.9
+ 1224010p -0.3
+ 1226000p -0.3
+ 1226010p 0.9
+ 1228000p 0.9
+ 1228010p -0.3
+ 1230000p -0.3
+ 1230010p 0.9
+ 1232000p 0.9
+ 1232010p -0.3
+ 1234000p -0.3
+ 1234010p 0.9
+ 1236000p 0.9
+ 1236010p -0.3
+ 1238000p -0.3
+ 1238010p 0.9
+ 1240000p 0.9
+ 1240010p -0.3
+ 1242000p -0.3
+ 1242010p 0.9
+ 1244000p 0.9
+ 1244010p -0.3
+ 1246000p -0.3
+ 1246010p 0.9
+ 1248000p 0.9
+ 1248010p -0.3
+ 1250000p -0.3
+ 1250010p 0.9
+ 1252000p 0.9
+ 1252010p -0.3
+ 1254000p -0.3
+ 1254010p 0.9
+ 1256000p 0.9
+ 1256010p -0.3
+ 1258000p -0.3
+ 1258010p 0.9
+ 1260000p 0.9
+ 1260010p -0.3
+ 1262000p -0.3
+ 1262010p 0.9
+ 1264000p 0.9
+ 1264010p -0.3
+ 1266000p -0.3
+ 1266010p 0.9
+ 1268000p 0.9
+ 1268010p -0.3
+ 1270000p -0.3
+ 1270010p 0.9
+ 1272000p 0.9
+ 1272010p -0.3
+ 1274000p -0.3
+ 1274010p 0.9
+ 1276000p 0.9
+ 1276010p -0.3
+ 1278000p -0.3
+ 1278010p 0.9
+ 1280000p 0.9
+ 1280010p -0.3
+ 1282000p -0.3
+ 1282010p 0.9
+ 1284000p 0.9
+ 1284010p -0.3
+ 1286000p -0.3
+ 1286010p 0.9
+ 1288000p 0.9
+ 1288010p -0.3
+ 1290000p -0.3
+ 1290010p 0.9
+ 1292000p 0.9
+ 1292010p -0.3
+ 1294000p -0.3
+ 1294010p 0.9
+ 1296000p 0.9
+ 1296010p -0.3
+ 1298000p -0.3
+ 1298010p 0.9
+ 1300000p 0.9
+ 1300010p -0.3
+ 1302000p -0.3
+ 1302010p 0.9
+ 1304000p 0.9
+ 1304010p -0.3
+ 1306000p -0.3
+ 1306010p 0.9
+ 1308000p 0.9
+ 1308010p -0.3
+ 1310000p -0.3
+ 1310010p 0.9
+ 1312000p 0.9
+ 1312010p -0.3
+ 1314000p -0.3
+ 1314010p 0.9
+ 1316000p 0.9
+ 1316010p -0.3
+ 1318000p -0.3
+ 1318010p 0.9
+ 1320000p 0.9
+ 1320010p -0.3
+ 1322000p -0.3
+ 1322010p 0.9
+ 1324000p 0.9
+ 1324010p -0.3
+ 1326000p -0.3
+ 1326010p 0.9
+ 1328000p 0.9
+ 1328010p -0.3
+ 1330000p -0.3
+ 1330010p 0.9
+ 1332000p 0.9
+ 1332010p -0.3
+ 1334000p -0.3
+ 1334010p 0.9
+ 1336000p 0.9
+ 1336010p -0.3
+ 1338000p -0.3
+ 1338010p 0.9
+ 1340000p 0.9
+ 1340010p -0.3
+ 1342000p -0.3
+ 1342010p 0.9
+ 1344000p 0.9
+ 1344010p -0.3
+ 1346000p -0.3
+ 1346010p 0.9
+ 1348000p 0.9
+ 1348010p -0.3
+ 1350000p -0.3
+ 1350010p 0.9
+ 1352000p 0.9
+ 1352010p -0.3
+ 1354000p -0.3
+ 1354010p 0.9
+ 1356000p 0.9
+ 1356010p -0.3
+ 1358000p -0.3
+ 1358010p 0.9
+ 1360000p 0.9
+ 1360010p -0.3
+ 1362000p -0.3
+ 1362010p 0.9
+ 1364000p 0.9
+ 1364010p -0.3
+ 1366000p -0.3
+ 1366010p 0.9
+ 1368000p 0.9
+ 1368010p -0.3
+ 1370000p -0.3
+ 1370010p 0.9
+ 1372000p 0.9
+ 1372010p -0.3
+ 1374000p -0.3
+ 1374010p 0.9
+ 1376000p 0.9
+ 1376010p -0.3
+ 1378000p -0.3
+ 1378010p 0.9
+ 1380000p 0.9
+ 1380010p -0.3
+ 1382000p -0.3
+ 1382010p 0.9
+ 1384000p 0.9
+ 1384010p -0.3
+ 1386000p -0.3
+ 1386010p 0.9
+ 1388000p 0.9
+ 1388010p -0.3
+ 1390000p -0.3
+ 1390010p 0.9
+ 1392000p 0.9
+ 1392010p -0.3
+ 1394000p -0.3
+ 1394010p 0.9
+ 1396000p 0.9
+ 1396010p -0.3
+ 1398000p -0.3
+ 1398010p 0.9
+ 1400000p 0.9
+ 1400010p -0.3
+ 1402000p -0.3
+ 1402010p 0.9
+ 1404000p 0.9
+ 1404010p -0.3
+ 1406000p -0.3
+ 1406010p 0.9
+ 1408000p 0.9
+ 1408010p -0.3
+ 1410000p -0.3
+ 1410010p 0.9
+ 1412000p 0.9
+ 1412010p -0.3
+ 1414000p -0.3
+ 1414010p 0.9
+ 1416000p 0.9
+ 1416010p -0.3
+ 1418000p -0.3
+ 1418010p 0.9
+ 1420000p 0.9
+ 1420010p -0.3
+ 1422000p -0.3
+ 1422010p 0.9
+ 1424000p 0.9
+ 1424010p -0.3
+ 1426000p -0.3
+ 1426010p 0.9
+ 1428000p 0.9
+ 1428010p -0.3
+ 1430000p -0.3
+ 1430010p 0.9
+ 1432000p 0.9
+ 1432010p -0.3
+ 1434000p -0.3
+ 1434010p 0.9
+ 1436000p 0.9
+ 1436010p -0.3
+ 1438000p -0.3
+ 1438010p 0.9
+ 1440000p 0.9
+ 1440010p -0.3
+ 1442000p -0.3
+ 1442010p 0.9
+ 1444000p 0.9
+ 1444010p -0.3
+ 1446000p -0.3
+ 1446010p 0.9
+ 1448000p 0.9
+ 1448010p -0.3
+ 1450000p -0.3
+ 1450010p 0.9
+ 1452000p 0.9
+ 1452010p -0.3
+ 1454000p -0.3
+ 1454010p 0.9
+ 1456000p 0.9
+ 1456010p -0.3
+ 1458000p -0.3
+ 1458010p 0.9
+ 1460000p 0.9
+ 1460010p -0.3
+ 1462000p -0.3
+ 1462010p 0.9
+ 1464000p 0.9
+ 1464010p -0.3
+ 1466000p -0.3
+ 1466010p 0.9
+ 1468000p 0.9
+ 1468010p -0.3
+ 1470000p -0.3
+ 1470010p 0.9
+ 1472000p 0.9
+ 1472010p -0.3
+ 1474000p -0.3
+ 1474010p 0.9
+ 1476000p 0.9
+ 1476010p -0.3
+ 1478000p -0.3
+ 1478010p 0.9
+ 1480000p 0.9
+ 1480010p -0.3
+ 1482000p -0.3
+ 1482010p 0.9
+ 1484000p 0.9
+ 1484010p -0.3
+ 1486000p -0.3
+ 1486010p 0.9
+ 1488000p 0.9
+ 1488010p -0.3
+ 1490000p -0.3
+ 1490010p 0.9
+ 1492000p 0.9
+ 1492010p -0.3
+ 1494000p -0.3
+ 1494010p 0.9
+ 1496000p 0.9
+ 1496010p -0.3
+ 1498000p -0.3
+ 1498010p 0.9
+ 1500000p 0.9
+ 1500010p -0.3
+ 1502000p -0.3
+ 1502010p 0.9
+ 1504000p 0.9
+ 1504010p -0.3
+ 1506000p -0.3
+ 1506010p 0.9
+ 1508000p 0.9
+ 1508010p -0.3
+ 1510000p -0.3
+ 1510010p 0.9
+ 1512000p 0.9
+ 1512010p -0.3
+ 1514000p -0.3
+ 1514010p 0.9
+ 1516000p 0.9
+ 1516010p -0.3
+ 1518000p -0.3
+ 1518010p 0.9
+ 1520000p 0.9
+ 1520010p -0.3
+ 1522000p -0.3
+ 1522010p 0.9
+ 1524000p 0.9
+ 1524010p -0.3
+ 1526000p -0.3
+ 1526010p 0.9
+ 1528000p 0.9
+ 1528010p -0.3
+ 1530000p -0.3
+ 1530010p 0.9
+ 1532000p 0.9
+ 1532010p -0.3
+ 1534000p -0.3
+ 1534010p 0.9
+ 1536000p 0.9
+ 1536010p -0.3
+ 1538000p -0.3
+ 1538010p 0.9
+ 1540000p 0.9
+ 1540010p -0.3
+ 1542000p -0.3
+ 1542010p 0.9
+ 1544000p 0.9
+ 1544010p -0.3
+ 1546000p -0.3
+ 1546010p 0.9
+ 1548000p 0.9
+ 1548010p -0.3
+ 1550000p -0.3
+ 1550010p 0.9
+ 1552000p 0.9
+ 1552010p -0.3
+ 1554000p -0.3
+ 1554010p 0.9
+ 1556000p 0.9
+ 1556010p -0.3
+ 1558000p -0.3
+ 1558010p 0.9
+ 1560000p 0.9
+ 1560010p -0.3
+ 1562000p -0.3
+ 1562010p 0.9
+ 1564000p 0.9
+ 1564010p -0.3
+ 1566000p -0.3
+ 1566010p 0.9
+ 1568000p 0.9
+ 1568010p -0.3
+ 1570000p -0.3
+ 1570010p 0.9
+ 1572000p 0.9
+ 1572010p -0.3
+ 1574000p -0.3
+ 1574010p 0.9
+ 1576000p 0.9
+ 1576010p -0.3
+ 1578000p -0.3
+ 1578010p 0.9
+ 1580000p 0.9
+ 1580010p -0.3
+ 1582000p -0.3
+ 1582010p 0.9
+ 1584000p 0.9
+ 1584010p -0.3
+ 1586000p -0.3
+ 1586010p 0.9
+ 1588000p 0.9
+ 1588010p -0.3
+ 1590000p -0.3
+ 1590010p 0.9
+ 1592000p 0.9
+ 1592010p -0.3
+ 1594000p -0.3
+ 1594010p 0.9
+ 1596000p 0.9
+ 1596010p -0.3
+ 1598000p -0.3
+ 1598010p 0.9
+ 1600000p 0.9
+ 1600010p -0.3
+ 1602000p -0.3
+ 1602010p 0.9
+ 1604000p 0.9
+ 1604010p -0.3
+ 1606000p -0.3
+ 1606010p 0.9
+ 1608000p 0.9
+ 1608010p -0.3
+ 1610000p -0.3
+ 1610010p 0.9
+ 1612000p 0.9
+ 1612010p -0.3
+ 1614000p -0.3
+ 1614010p 0.9
+ 1616000p 0.9
+ 1616010p -0.3
+ 1618000p -0.3
+ 1618010p 0.9
+ 1620000p 0.9
+ 1620010p -0.3
+ 1622000p -0.3
+ 1622010p 0.9
+ 1624000p 0.9
+ 1624010p -0.3
+ 1626000p -0.3
+ 1626010p 0.9
+ 1628000p 0.9
+ 1628010p -0.3
+ 1630000p -0.3
+ 1630010p 0.9
+ 1632000p 0.9
+ 1632010p -0.3
+ 1634000p -0.3
+ 1634010p 0.9
+ 1636000p 0.9
+ 1636010p -0.3
+ 1638000p -0.3
+ 1638010p 0.9
+ 1640000p 0.9
+ 1640010p -0.3
+ 1642000p -0.3
+ 1642010p 0.9
+ 1644000p 0.9
+ 1644010p -0.3
+ 1646000p -0.3
+ 1646010p 0.9
+ 1648000p 0.9
+ 1648010p -0.3
+ 1650000p -0.3
+ 1650010p 0.9
+ 1652000p 0.9
+ 1652010p -0.3
+ 1654000p -0.3
+ 1654010p 0.9
+ 1656000p 0.9
+ 1656010p -0.3
+ 1658000p -0.3
+ 1658010p 0.9
+ 1660000p 0.9
+ 1660010p -0.3
+ 1662000p -0.3
+ 1662010p 0.9
+ 1664000p 0.9
+ 1664010p -0.3
+ 1666000p -0.3
+ 1666010p 0.9
+ 1668000p 0.9
+ 1668010p -0.3
+ 1670000p -0.3
+ 1670010p 0.9
+ 1672000p 0.9
+ 1672010p -0.3
+ 1674000p -0.3
+ 1674010p 0.9
+ 1676000p 0.9
+ 1676010p -0.3
+ 1678000p -0.3
+ 1678010p 0.9
+ 1680000p 0.9
+ 1680010p -0.3
+ 1682000p -0.3
+ 1682010p 0.9
+ 1684000p 0.9
+ 1684010p -0.3
+ 1686000p -0.3
+ 1686010p 0.9
+ 1688000p 0.9
+ 1688010p -0.3
+ 1690000p -0.3
+ 1690010p 0.9
+ 1692000p 0.9
+ 1692010p -0.3
+ 1694000p -0.3
+ 1694010p 0.9
+ 1696000p 0.9
+ 1696010p -0.3
+ 1698000p -0.3
+ 1698010p 0.9
+ 1700000p 0.9
+ 1700010p -0.3
+ 1702000p -0.3
+ 1702010p 0.9
+ 1704000p 0.9
+ 1704010p -0.3
+ 1706000p -0.3
+ 1706010p 0.9
+ 1708000p 0.9
+ 1708010p -0.3
+ 1710000p -0.3
+ 1710010p 0.9
+ 1712000p 0.9
+ 1712010p -0.3
+ 1714000p -0.3
+ 1714010p 0.9
+ 1716000p 0.9
+ 1716010p -0.3
+ 1718000p -0.3
+ 1718010p 0.9
+ 1720000p 0.9
+ 1720010p -0.3
+ 1722000p -0.3
+ 1722010p 0.9
+ 1724000p 0.9
+ 1724010p -0.3
+ 1726000p -0.3
+ 1726010p 0.9
+ 1728000p 0.9
+ 1728010p -0.3
+ 1730000p -0.3
+ 1730010p 0.9
+ 1732000p 0.9
+ 1732010p -0.3
+ 1734000p -0.3
+ 1734010p 0.9
+ 1736000p 0.9
+ 1736010p -0.3
+ 1738000p -0.3
+ 1738010p 0.9
+ 1740000p 0.9
+ 1740010p -0.3
+ 1742000p -0.3
+ 1742010p 0.9
+ 1744000p 0.9
+ 1744010p -0.3
+ 1746000p -0.3
+ 1746010p 0.9
+ 1748000p 0.9
+ 1748010p -0.3
+ 1750000p -0.3
+ 1750010p 0.9
+ 1752000p 0.9
+ 1752010p -0.3
+ 1754000p -0.3
+ 1754010p 0.9
+ 1756000p 0.9
+ 1756010p -0.3
+ 1758000p -0.3
+ 1758010p 0.9
+ 1760000p 0.9
+ 1760010p -0.3
+ 1762000p -0.3
+ 1762010p 0.9
+ 1764000p 0.9
+ 1764010p -0.3
+ 1766000p -0.3
+ 1766010p 0.9
+ 1768000p 0.9
+ 1768010p -0.3
+ 1770000p -0.3
+ 1770010p 0.9
+ 1772000p 0.9
+ 1772010p -0.3
+ 1774000p -0.3
+ 1774010p 0.9
+ 1776000p 0.9
+ 1776010p -0.3
+ 1778000p -0.3
+ 1778010p 0.9
+ 1780000p 0.9
+ 1780010p -0.3
+ 1782000p -0.3
+ 1782010p 0.9
+ 1784000p 0.9
+ 1784010p -0.3
+ 1786000p -0.3
+ 1786010p 0.9
+ 1788000p 0.9
+ 1788010p -0.3
+ 1790000p -0.3
+ 1790010p 0.9
+ 1792000p 0.9
+ 1792010p -0.3
+ 1794000p -0.3
+ 1794010p 0.9
+ 1796000p 0.9
+ 1796010p -0.3
+ 1798000p -0.3
+ 1798010p 0.9
+ 1800000p 0.9
+ 1800010p -0.3
+ 1802000p -0.3
+ 1802010p 0.9
+ 1804000p 0.9
+ 1804010p -0.3
+ 1806000p -0.3
+ 1806010p 0.9
+ 1808000p 0.9
+ 1808010p -0.3
+ 1810000p -0.3
+ 1810010p 0.9
+ 1812000p 0.9
+ 1812010p -0.3
+ 1814000p -0.3
+ 1814010p 0.9
+ 1816000p 0.9
+ 1816010p -0.3
+ 1818000p -0.3
+ 1818010p 0.9
+ 1820000p 0.9
+ 1820010p -0.3
+ 1822000p -0.3
+ 1822010p 0.9
+ 1824000p 0.9
+ 1824010p -0.3
+ 1826000p -0.3
+ 1826010p 0.9
+ 1828000p 0.9
+ 1828010p -0.3
+ 1830000p -0.3
+ 1830010p 0.9
+ 1832000p 0.9
+ 1832010p -0.3
+ 1834000p -0.3
+ 1834010p 0.9
+ 1836000p 0.9
+ 1836010p -0.3
+ 1838000p -0.3
+ 1838010p 0.9
+ 1840000p 0.9
+ 1840010p -0.3
+ 1842000p -0.3
+ 1842010p 0.9
+ 1844000p 0.9
+ 1844010p -0.3
+ 1846000p -0.3
+ 1846010p 0.9
+ 1848000p 0.9
+ 1848010p -0.3
+ 1850000p -0.3
+ 1850010p 0.9
+ 1852000p 0.9
+ 1852010p -0.3
+ 1854000p -0.3
+ 1854010p 0.9
+ 1856000p 0.9
+ 1856010p -0.3
+ 1858000p -0.3
+ 1858010p 0.9
+ 1860000p 0.9
+ 1860010p -0.3
+ 1862000p -0.3
+ 1862010p 0.9
+ 1864000p 0.9
+ 1864010p -0.3
+ 1866000p -0.3
+ 1866010p 0.9
+ 1868000p 0.9
+ 1868010p -0.3
+ 1870000p -0.3
+ 1870010p 0.9
+ 1872000p 0.9
+ 1872010p -0.3
+ 1874000p -0.3
+ 1874010p 0.9
+ 1876000p 0.9
+ 1876010p -0.3
+ 1878000p -0.3
+ 1878010p 0.9
+ 1880000p 0.9
+ 1880010p -0.3
+ 1882000p -0.3
+ 1882010p 0.9
+ 1884000p 0.9
+ 1884010p -0.3
+ 1886000p -0.3
+ 1886010p 0.9
+ 1888000p 0.9
+ 1888010p -0.3
+ 1890000p -0.3
+ 1890010p 0.9
+ 1892000p 0.9
+ 1892010p -0.3
+ 1894000p -0.3
+ 1894010p 0.9
+ 1896000p 0.9
+ 1896010p -0.3
+ 1898000p -0.3
+ 1898010p 0.9
+ 1900000p 0.9
+ 1900010p -0.3
+ 1902000p -0.3
+ 1902010p 0.9
+ 1904000p 0.9
+ 1904010p -0.3
+ 1906000p -0.3
+ 1906010p 0.9
+ 1908000p 0.9
+ 1908010p -0.3
+ 1910000p -0.3
+ 1910010p 0.9
+ 1912000p 0.9
+ 1912010p -0.3
+ 1914000p -0.3
+ 1914010p 0.9
+ 1916000p 0.9
+ 1916010p -0.3
+ 1918000p -0.3
+ 1918010p 0.9
+ 1920000p 0.9
+ 1920010p -0.3
+ 1922000p -0.3
+ 1922010p 0.9
+ 1924000p 0.9
+ 1924010p -0.3
+ 1926000p -0.3
+ 1926010p 0.9
+ 1928000p 0.9
+ 1928010p -0.3
+ 1930000p -0.3
+ 1930010p 0.9
+ 1932000p 0.9
+ 1932010p -0.3
+ 1934000p -0.3
+ 1934010p 0.9
+ 1936000p 0.9
+ 1936010p -0.3
+ 1938000p -0.3
+ 1938010p 0.9
+ 1940000p 0.9
+ 1940010p -0.3
+ 1942000p -0.3
+ 1942010p 0.9
+ 1944000p 0.9
+ 1944010p -0.3
+ 1946000p -0.3
+ 1946010p 0.9
+ 1948000p 0.9
+ 1948010p -0.3
+ 1950000p -0.3
+ 1950010p 0.9
+ 1952000p 0.9
+ 1952010p -0.3
+ 1954000p -0.3
+ 1954010p 0.9
+ 1956000p 0.9
+ 1956010p -0.3
+ 1958000p -0.3
+ 1958010p 0.9
+ 1960000p 0.9
+ 1960010p -0.3
+ 1962000p -0.3
+ 1962010p 0.9
+ 1964000p 0.9
+ 1964010p -0.3
+ 1966000p -0.3
+ 1966010p 0.9
+ 1968000p 0.9
+ 1968010p -0.3
+ 1970000p -0.3
+ 1970010p 0.9
+ 1972000p 0.9
+ 1972010p -0.3
+ 1974000p -0.3
+ 1974010p 0.9
+ 1976000p 0.9
+ 1976010p -0.3
+ 1978000p -0.3
+ 1978010p 0.9
+ 1980000p 0.9
+ 1980010p -0.3
+ 1982000p -0.3
+ 1982010p 0.9
+ 1984000p 0.9
+ 1984010p -0.3
+ 1986000p -0.3
+ 1986010p 0.9
+ 1988000p 0.9
+ 1988010p -0.3
+ 1990000p -0.3
+ 1990010p 0.9
+ 1992000p 0.9
+ 1992010p -0.3
+ 1994000p -0.3
+ 1994010p 0.9
+ 1996000p 0.9
+ 1996010p -0.3
+ 1998000p -0.3
+ 1998010p 0.9
+ 2000000p 0.9
+ 2000010p -0.3
+ 2002000p -0.3
+ 2002010p 0.9
+ 2004000p 0.9
+ 2004010p -0.3
+ 2006000p -0.3
+ 2006010p 0.9
+ 2008000p 0.9
+ 2008010p -0.3
+ 2010000p -0.3
+ 2010010p 0.9
+ 2012000p 0.9
+ 2012010p -0.3
+ 2014000p -0.3
+ 2014010p 0.9
+ 2016000p 0.9
+ 2016010p -0.3
+ 2018000p -0.3
+ 2018010p 0.9
+ 2020000p 0.9
+ 2020010p -0.3
+ 2022000p -0.3
+ 2022010p 0.9
+ 2024000p 0.9
+ 2024010p -0.3
+ 2026000p -0.3
+ 2026010p 0.9
+ 2028000p 0.9
+ 2028010p -0.3
+ 2030000p -0.3
+ 2030010p 0.9
+ 2032000p 0.9
+ 2032010p -0.3
+ 2034000p -0.3
+ 2034010p 0.9
+ 2036000p 0.9
+ 2036010p -0.3
+ 2038000p -0.3
+ 2038010p 0.9
+ 2040000p 0.9
+ 2040010p -0.3
+ 2042000p -0.3
+ 2042010p 0.9
+ 2044000p 0.9
+ 2044010p -0.3
+ 2046000p -0.3
+ 2046010p 0.9
+ 2048000p 0.9
+ 2048010p -0.3
+ \]
V_data_11 (Data\\<11\\> gnd!) vsource type=pwl wave=\[
+ 0    0.9
+ 2000p 0.9
+ 2010p -0.3
+ 4000p -0.3
+ 4010p 0.9
+ 6000p 0.9
+ 6010p -0.3
+ 8000p -0.3
+ 8010p 0.9
+ 10000p 0.9
+ 10010p -0.3
+ 12000p -0.3
+ 12010p 0.9
+ 14000p 0.9
+ 14010p -0.3
+ 16000p -0.3
+ 16010p 0.9
+ 18000p 0.9
+ 18010p -0.3
+ 20000p -0.3
+ 20010p 0.9
+ 22000p 0.9
+ 22010p -0.3
+ 24000p -0.3
+ 24010p 0.9
+ 26000p 0.9
+ 26010p -0.3
+ 28000p -0.3
+ 28010p 0.9
+ 30000p 0.9
+ 30010p -0.3
+ 32000p -0.3
+ 32010p 0.9
+ 34000p 0.9
+ 34010p -0.3
+ 36000p -0.3
+ 36010p 0.9
+ 38000p 0.9
+ 38010p -0.3
+ 40000p -0.3
+ 40010p 0.9
+ 42000p 0.9
+ 42010p -0.3
+ 44000p -0.3
+ 44010p 0.9
+ 46000p 0.9
+ 46010p -0.3
+ 48000p -0.3
+ 48010p 0.9
+ 50000p 0.9
+ 50010p -0.3
+ 52000p -0.3
+ 52010p 0.9
+ 54000p 0.9
+ 54010p -0.3
+ 56000p -0.3
+ 56010p 0.9
+ 58000p 0.9
+ 58010p -0.3
+ 60000p -0.3
+ 60010p 0.9
+ 62000p 0.9
+ 62010p -0.3
+ 64000p -0.3
+ 64010p 0.9
+ 66000p 0.9
+ 66010p -0.3
+ 68000p -0.3
+ 68010p 0.9
+ 70000p 0.9
+ 70010p -0.3
+ 72000p -0.3
+ 72010p 0.9
+ 74000p 0.9
+ 74010p -0.3
+ 76000p -0.3
+ 76010p 0.9
+ 78000p 0.9
+ 78010p -0.3
+ 80000p -0.3
+ 80010p 0.9
+ 82000p 0.9
+ 82010p -0.3
+ 84000p -0.3
+ 84010p 0.9
+ 86000p 0.9
+ 86010p -0.3
+ 88000p -0.3
+ 88010p 0.9
+ 90000p 0.9
+ 90010p -0.3
+ 92000p -0.3
+ 92010p 0.9
+ 94000p 0.9
+ 94010p -0.3
+ 96000p -0.3
+ 96010p 0.9
+ 98000p 0.9
+ 98010p -0.3
+ 100000p -0.3
+ 100010p 0.9
+ 102000p 0.9
+ 102010p -0.3
+ 104000p -0.3
+ 104010p 0.9
+ 106000p 0.9
+ 106010p -0.3
+ 108000p -0.3
+ 108010p 0.9
+ 110000p 0.9
+ 110010p -0.3
+ 112000p -0.3
+ 112010p 0.9
+ 114000p 0.9
+ 114010p -0.3
+ 116000p -0.3
+ 116010p 0.9
+ 118000p 0.9
+ 118010p -0.3
+ 120000p -0.3
+ 120010p 0.9
+ 122000p 0.9
+ 122010p -0.3
+ 124000p -0.3
+ 124010p 0.9
+ 126000p 0.9
+ 126010p -0.3
+ 128000p -0.3
+ 128010p 0.9
+ 130000p 0.9
+ 130010p -0.3
+ 132000p -0.3
+ 132010p 0.9
+ 134000p 0.9
+ 134010p -0.3
+ 136000p -0.3
+ 136010p 0.9
+ 138000p 0.9
+ 138010p -0.3
+ 140000p -0.3
+ 140010p 0.9
+ 142000p 0.9
+ 142010p -0.3
+ 144000p -0.3
+ 144010p 0.9
+ 146000p 0.9
+ 146010p -0.3
+ 148000p -0.3
+ 148010p 0.9
+ 150000p 0.9
+ 150010p -0.3
+ 152000p -0.3
+ 152010p 0.9
+ 154000p 0.9
+ 154010p -0.3
+ 156000p -0.3
+ 156010p 0.9
+ 158000p 0.9
+ 158010p -0.3
+ 160000p -0.3
+ 160010p 0.9
+ 162000p 0.9
+ 162010p -0.3
+ 164000p -0.3
+ 164010p 0.9
+ 166000p 0.9
+ 166010p -0.3
+ 168000p -0.3
+ 168010p 0.9
+ 170000p 0.9
+ 170010p -0.3
+ 172000p -0.3
+ 172010p 0.9
+ 174000p 0.9
+ 174010p -0.3
+ 176000p -0.3
+ 176010p 0.9
+ 178000p 0.9
+ 178010p -0.3
+ 180000p -0.3
+ 180010p 0.9
+ 182000p 0.9
+ 182010p -0.3
+ 184000p -0.3
+ 184010p 0.9
+ 186000p 0.9
+ 186010p -0.3
+ 188000p -0.3
+ 188010p 0.9
+ 190000p 0.9
+ 190010p -0.3
+ 192000p -0.3
+ 192010p 0.9
+ 194000p 0.9
+ 194010p -0.3
+ 196000p -0.3
+ 196010p 0.9
+ 198000p 0.9
+ 198010p -0.3
+ 200000p -0.3
+ 200010p 0.9
+ 202000p 0.9
+ 202010p -0.3
+ 204000p -0.3
+ 204010p 0.9
+ 206000p 0.9
+ 206010p -0.3
+ 208000p -0.3
+ 208010p 0.9
+ 210000p 0.9
+ 210010p -0.3
+ 212000p -0.3
+ 212010p 0.9
+ 214000p 0.9
+ 214010p -0.3
+ 216000p -0.3
+ 216010p 0.9
+ 218000p 0.9
+ 218010p -0.3
+ 220000p -0.3
+ 220010p 0.9
+ 222000p 0.9
+ 222010p -0.3
+ 224000p -0.3
+ 224010p 0.9
+ 226000p 0.9
+ 226010p -0.3
+ 228000p -0.3
+ 228010p 0.9
+ 230000p 0.9
+ 230010p -0.3
+ 232000p -0.3
+ 232010p 0.9
+ 234000p 0.9
+ 234010p -0.3
+ 236000p -0.3
+ 236010p 0.9
+ 238000p 0.9
+ 238010p -0.3
+ 240000p -0.3
+ 240010p 0.9
+ 242000p 0.9
+ 242010p -0.3
+ 244000p -0.3
+ 244010p 0.9
+ 246000p 0.9
+ 246010p -0.3
+ 248000p -0.3
+ 248010p 0.9
+ 250000p 0.9
+ 250010p -0.3
+ 252000p -0.3
+ 252010p 0.9
+ 254000p 0.9
+ 254010p -0.3
+ 256000p -0.3
+ 256010p 0.9
+ 258000p 0.9
+ 258010p -0.3
+ 260000p -0.3
+ 260010p 0.9
+ 262000p 0.9
+ 262010p -0.3
+ 264000p -0.3
+ 264010p 0.9
+ 266000p 0.9
+ 266010p -0.3
+ 268000p -0.3
+ 268010p 0.9
+ 270000p 0.9
+ 270010p -0.3
+ 272000p -0.3
+ 272010p 0.9
+ 274000p 0.9
+ 274010p -0.3
+ 276000p -0.3
+ 276010p 0.9
+ 278000p 0.9
+ 278010p -0.3
+ 280000p -0.3
+ 280010p 0.9
+ 282000p 0.9
+ 282010p -0.3
+ 284000p -0.3
+ 284010p 0.9
+ 286000p 0.9
+ 286010p -0.3
+ 288000p -0.3
+ 288010p 0.9
+ 290000p 0.9
+ 290010p -0.3
+ 292000p -0.3
+ 292010p 0.9
+ 294000p 0.9
+ 294010p -0.3
+ 296000p -0.3
+ 296010p 0.9
+ 298000p 0.9
+ 298010p -0.3
+ 300000p -0.3
+ 300010p 0.9
+ 302000p 0.9
+ 302010p -0.3
+ 304000p -0.3
+ 304010p 0.9
+ 306000p 0.9
+ 306010p -0.3
+ 308000p -0.3
+ 308010p 0.9
+ 310000p 0.9
+ 310010p -0.3
+ 312000p -0.3
+ 312010p 0.9
+ 314000p 0.9
+ 314010p -0.3
+ 316000p -0.3
+ 316010p 0.9
+ 318000p 0.9
+ 318010p -0.3
+ 320000p -0.3
+ 320010p 0.9
+ 322000p 0.9
+ 322010p -0.3
+ 324000p -0.3
+ 324010p 0.9
+ 326000p 0.9
+ 326010p -0.3
+ 328000p -0.3
+ 328010p 0.9
+ 330000p 0.9
+ 330010p -0.3
+ 332000p -0.3
+ 332010p 0.9
+ 334000p 0.9
+ 334010p -0.3
+ 336000p -0.3
+ 336010p 0.9
+ 338000p 0.9
+ 338010p -0.3
+ 340000p -0.3
+ 340010p 0.9
+ 342000p 0.9
+ 342010p -0.3
+ 344000p -0.3
+ 344010p 0.9
+ 346000p 0.9
+ 346010p -0.3
+ 348000p -0.3
+ 348010p 0.9
+ 350000p 0.9
+ 350010p -0.3
+ 352000p -0.3
+ 352010p 0.9
+ 354000p 0.9
+ 354010p -0.3
+ 356000p -0.3
+ 356010p 0.9
+ 358000p 0.9
+ 358010p -0.3
+ 360000p -0.3
+ 360010p 0.9
+ 362000p 0.9
+ 362010p -0.3
+ 364000p -0.3
+ 364010p 0.9
+ 366000p 0.9
+ 366010p -0.3
+ 368000p -0.3
+ 368010p 0.9
+ 370000p 0.9
+ 370010p -0.3
+ 372000p -0.3
+ 372010p 0.9
+ 374000p 0.9
+ 374010p -0.3
+ 376000p -0.3
+ 376010p 0.9
+ 378000p 0.9
+ 378010p -0.3
+ 380000p -0.3
+ 380010p 0.9
+ 382000p 0.9
+ 382010p -0.3
+ 384000p -0.3
+ 384010p 0.9
+ 386000p 0.9
+ 386010p -0.3
+ 388000p -0.3
+ 388010p 0.9
+ 390000p 0.9
+ 390010p -0.3
+ 392000p -0.3
+ 392010p 0.9
+ 394000p 0.9
+ 394010p -0.3
+ 396000p -0.3
+ 396010p 0.9
+ 398000p 0.9
+ 398010p -0.3
+ 400000p -0.3
+ 400010p 0.9
+ 402000p 0.9
+ 402010p -0.3
+ 404000p -0.3
+ 404010p 0.9
+ 406000p 0.9
+ 406010p -0.3
+ 408000p -0.3
+ 408010p 0.9
+ 410000p 0.9
+ 410010p -0.3
+ 412000p -0.3
+ 412010p 0.9
+ 414000p 0.9
+ 414010p -0.3
+ 416000p -0.3
+ 416010p 0.9
+ 418000p 0.9
+ 418010p -0.3
+ 420000p -0.3
+ 420010p 0.9
+ 422000p 0.9
+ 422010p -0.3
+ 424000p -0.3
+ 424010p 0.9
+ 426000p 0.9
+ 426010p -0.3
+ 428000p -0.3
+ 428010p 0.9
+ 430000p 0.9
+ 430010p -0.3
+ 432000p -0.3
+ 432010p 0.9
+ 434000p 0.9
+ 434010p -0.3
+ 436000p -0.3
+ 436010p 0.9
+ 438000p 0.9
+ 438010p -0.3
+ 440000p -0.3
+ 440010p 0.9
+ 442000p 0.9
+ 442010p -0.3
+ 444000p -0.3
+ 444010p 0.9
+ 446000p 0.9
+ 446010p -0.3
+ 448000p -0.3
+ 448010p 0.9
+ 450000p 0.9
+ 450010p -0.3
+ 452000p -0.3
+ 452010p 0.9
+ 454000p 0.9
+ 454010p -0.3
+ 456000p -0.3
+ 456010p 0.9
+ 458000p 0.9
+ 458010p -0.3
+ 460000p -0.3
+ 460010p 0.9
+ 462000p 0.9
+ 462010p -0.3
+ 464000p -0.3
+ 464010p 0.9
+ 466000p 0.9
+ 466010p -0.3
+ 468000p -0.3
+ 468010p 0.9
+ 470000p 0.9
+ 470010p -0.3
+ 472000p -0.3
+ 472010p 0.9
+ 474000p 0.9
+ 474010p -0.3
+ 476000p -0.3
+ 476010p 0.9
+ 478000p 0.9
+ 478010p -0.3
+ 480000p -0.3
+ 480010p 0.9
+ 482000p 0.9
+ 482010p -0.3
+ 484000p -0.3
+ 484010p 0.9
+ 486000p 0.9
+ 486010p -0.3
+ 488000p -0.3
+ 488010p 0.9
+ 490000p 0.9
+ 490010p -0.3
+ 492000p -0.3
+ 492010p 0.9
+ 494000p 0.9
+ 494010p -0.3
+ 496000p -0.3
+ 496010p 0.9
+ 498000p 0.9
+ 498010p -0.3
+ 500000p -0.3
+ 500010p 0.9
+ 502000p 0.9
+ 502010p -0.3
+ 504000p -0.3
+ 504010p 0.9
+ 506000p 0.9
+ 506010p -0.3
+ 508000p -0.3
+ 508010p 0.9
+ 510000p 0.9
+ 510010p -0.3
+ 512000p -0.3
+ 512010p 0.9
+ 514000p 0.9
+ 514010p -0.3
+ 516000p -0.3
+ 516010p 0.9
+ 518000p 0.9
+ 518010p -0.3
+ 520000p -0.3
+ 520010p 0.9
+ 522000p 0.9
+ 522010p -0.3
+ 524000p -0.3
+ 524010p 0.9
+ 526000p 0.9
+ 526010p -0.3
+ 528000p -0.3
+ 528010p 0.9
+ 530000p 0.9
+ 530010p -0.3
+ 532000p -0.3
+ 532010p 0.9
+ 534000p 0.9
+ 534010p -0.3
+ 536000p -0.3
+ 536010p 0.9
+ 538000p 0.9
+ 538010p -0.3
+ 540000p -0.3
+ 540010p 0.9
+ 542000p 0.9
+ 542010p -0.3
+ 544000p -0.3
+ 544010p 0.9
+ 546000p 0.9
+ 546010p -0.3
+ 548000p -0.3
+ 548010p 0.9
+ 550000p 0.9
+ 550010p -0.3
+ 552000p -0.3
+ 552010p 0.9
+ 554000p 0.9
+ 554010p -0.3
+ 556000p -0.3
+ 556010p 0.9
+ 558000p 0.9
+ 558010p -0.3
+ 560000p -0.3
+ 560010p 0.9
+ 562000p 0.9
+ 562010p -0.3
+ 564000p -0.3
+ 564010p 0.9
+ 566000p 0.9
+ 566010p -0.3
+ 568000p -0.3
+ 568010p 0.9
+ 570000p 0.9
+ 570010p -0.3
+ 572000p -0.3
+ 572010p 0.9
+ 574000p 0.9
+ 574010p -0.3
+ 576000p -0.3
+ 576010p 0.9
+ 578000p 0.9
+ 578010p -0.3
+ 580000p -0.3
+ 580010p 0.9
+ 582000p 0.9
+ 582010p -0.3
+ 584000p -0.3
+ 584010p 0.9
+ 586000p 0.9
+ 586010p -0.3
+ 588000p -0.3
+ 588010p 0.9
+ 590000p 0.9
+ 590010p -0.3
+ 592000p -0.3
+ 592010p 0.9
+ 594000p 0.9
+ 594010p -0.3
+ 596000p -0.3
+ 596010p 0.9
+ 598000p 0.9
+ 598010p -0.3
+ 600000p -0.3
+ 600010p 0.9
+ 602000p 0.9
+ 602010p -0.3
+ 604000p -0.3
+ 604010p 0.9
+ 606000p 0.9
+ 606010p -0.3
+ 608000p -0.3
+ 608010p 0.9
+ 610000p 0.9
+ 610010p -0.3
+ 612000p -0.3
+ 612010p 0.9
+ 614000p 0.9
+ 614010p -0.3
+ 616000p -0.3
+ 616010p 0.9
+ 618000p 0.9
+ 618010p -0.3
+ 620000p -0.3
+ 620010p 0.9
+ 622000p 0.9
+ 622010p -0.3
+ 624000p -0.3
+ 624010p 0.9
+ 626000p 0.9
+ 626010p -0.3
+ 628000p -0.3
+ 628010p 0.9
+ 630000p 0.9
+ 630010p -0.3
+ 632000p -0.3
+ 632010p 0.9
+ 634000p 0.9
+ 634010p -0.3
+ 636000p -0.3
+ 636010p 0.9
+ 638000p 0.9
+ 638010p -0.3
+ 640000p -0.3
+ 640010p 0.9
+ 642000p 0.9
+ 642010p -0.3
+ 644000p -0.3
+ 644010p 0.9
+ 646000p 0.9
+ 646010p -0.3
+ 648000p -0.3
+ 648010p 0.9
+ 650000p 0.9
+ 650010p -0.3
+ 652000p -0.3
+ 652010p 0.9
+ 654000p 0.9
+ 654010p -0.3
+ 656000p -0.3
+ 656010p 0.9
+ 658000p 0.9
+ 658010p -0.3
+ 660000p -0.3
+ 660010p 0.9
+ 662000p 0.9
+ 662010p -0.3
+ 664000p -0.3
+ 664010p 0.9
+ 666000p 0.9
+ 666010p -0.3
+ 668000p -0.3
+ 668010p 0.9
+ 670000p 0.9
+ 670010p -0.3
+ 672000p -0.3
+ 672010p 0.9
+ 674000p 0.9
+ 674010p -0.3
+ 676000p -0.3
+ 676010p 0.9
+ 678000p 0.9
+ 678010p -0.3
+ 680000p -0.3
+ 680010p 0.9
+ 682000p 0.9
+ 682010p -0.3
+ 684000p -0.3
+ 684010p 0.9
+ 686000p 0.9
+ 686010p -0.3
+ 688000p -0.3
+ 688010p 0.9
+ 690000p 0.9
+ 690010p -0.3
+ 692000p -0.3
+ 692010p 0.9
+ 694000p 0.9
+ 694010p -0.3
+ 696000p -0.3
+ 696010p 0.9
+ 698000p 0.9
+ 698010p -0.3
+ 700000p -0.3
+ 700010p 0.9
+ 702000p 0.9
+ 702010p -0.3
+ 704000p -0.3
+ 704010p 0.9
+ 706000p 0.9
+ 706010p -0.3
+ 708000p -0.3
+ 708010p 0.9
+ 710000p 0.9
+ 710010p -0.3
+ 712000p -0.3
+ 712010p 0.9
+ 714000p 0.9
+ 714010p -0.3
+ 716000p -0.3
+ 716010p 0.9
+ 718000p 0.9
+ 718010p -0.3
+ 720000p -0.3
+ 720010p 0.9
+ 722000p 0.9
+ 722010p -0.3
+ 724000p -0.3
+ 724010p 0.9
+ 726000p 0.9
+ 726010p -0.3
+ 728000p -0.3
+ 728010p 0.9
+ 730000p 0.9
+ 730010p -0.3
+ 732000p -0.3
+ 732010p 0.9
+ 734000p 0.9
+ 734010p -0.3
+ 736000p -0.3
+ 736010p 0.9
+ 738000p 0.9
+ 738010p -0.3
+ 740000p -0.3
+ 740010p 0.9
+ 742000p 0.9
+ 742010p -0.3
+ 744000p -0.3
+ 744010p 0.9
+ 746000p 0.9
+ 746010p -0.3
+ 748000p -0.3
+ 748010p 0.9
+ 750000p 0.9
+ 750010p -0.3
+ 752000p -0.3
+ 752010p 0.9
+ 754000p 0.9
+ 754010p -0.3
+ 756000p -0.3
+ 756010p 0.9
+ 758000p 0.9
+ 758010p -0.3
+ 760000p -0.3
+ 760010p 0.9
+ 762000p 0.9
+ 762010p -0.3
+ 764000p -0.3
+ 764010p 0.9
+ 766000p 0.9
+ 766010p -0.3
+ 768000p -0.3
+ 768010p 0.9
+ 770000p 0.9
+ 770010p -0.3
+ 772000p -0.3
+ 772010p 0.9
+ 774000p 0.9
+ 774010p -0.3
+ 776000p -0.3
+ 776010p 0.9
+ 778000p 0.9
+ 778010p -0.3
+ 780000p -0.3
+ 780010p 0.9
+ 782000p 0.9
+ 782010p -0.3
+ 784000p -0.3
+ 784010p 0.9
+ 786000p 0.9
+ 786010p -0.3
+ 788000p -0.3
+ 788010p 0.9
+ 790000p 0.9
+ 790010p -0.3
+ 792000p -0.3
+ 792010p 0.9
+ 794000p 0.9
+ 794010p -0.3
+ 796000p -0.3
+ 796010p 0.9
+ 798000p 0.9
+ 798010p -0.3
+ 800000p -0.3
+ 800010p 0.9
+ 802000p 0.9
+ 802010p -0.3
+ 804000p -0.3
+ 804010p 0.9
+ 806000p 0.9
+ 806010p -0.3
+ 808000p -0.3
+ 808010p 0.9
+ 810000p 0.9
+ 810010p -0.3
+ 812000p -0.3
+ 812010p 0.9
+ 814000p 0.9
+ 814010p -0.3
+ 816000p -0.3
+ 816010p 0.9
+ 818000p 0.9
+ 818010p -0.3
+ 820000p -0.3
+ 820010p 0.9
+ 822000p 0.9
+ 822010p -0.3
+ 824000p -0.3
+ 824010p 0.9
+ 826000p 0.9
+ 826010p -0.3
+ 828000p -0.3
+ 828010p 0.9
+ 830000p 0.9
+ 830010p -0.3
+ 832000p -0.3
+ 832010p 0.9
+ 834000p 0.9
+ 834010p -0.3
+ 836000p -0.3
+ 836010p 0.9
+ 838000p 0.9
+ 838010p -0.3
+ 840000p -0.3
+ 840010p 0.9
+ 842000p 0.9
+ 842010p -0.3
+ 844000p -0.3
+ 844010p 0.9
+ 846000p 0.9
+ 846010p -0.3
+ 848000p -0.3
+ 848010p 0.9
+ 850000p 0.9
+ 850010p -0.3
+ 852000p -0.3
+ 852010p 0.9
+ 854000p 0.9
+ 854010p -0.3
+ 856000p -0.3
+ 856010p 0.9
+ 858000p 0.9
+ 858010p -0.3
+ 860000p -0.3
+ 860010p 0.9
+ 862000p 0.9
+ 862010p -0.3
+ 864000p -0.3
+ 864010p 0.9
+ 866000p 0.9
+ 866010p -0.3
+ 868000p -0.3
+ 868010p 0.9
+ 870000p 0.9
+ 870010p -0.3
+ 872000p -0.3
+ 872010p 0.9
+ 874000p 0.9
+ 874010p -0.3
+ 876000p -0.3
+ 876010p 0.9
+ 878000p 0.9
+ 878010p -0.3
+ 880000p -0.3
+ 880010p 0.9
+ 882000p 0.9
+ 882010p -0.3
+ 884000p -0.3
+ 884010p 0.9
+ 886000p 0.9
+ 886010p -0.3
+ 888000p -0.3
+ 888010p 0.9
+ 890000p 0.9
+ 890010p -0.3
+ 892000p -0.3
+ 892010p 0.9
+ 894000p 0.9
+ 894010p -0.3
+ 896000p -0.3
+ 896010p 0.9
+ 898000p 0.9
+ 898010p -0.3
+ 900000p -0.3
+ 900010p 0.9
+ 902000p 0.9
+ 902010p -0.3
+ 904000p -0.3
+ 904010p 0.9
+ 906000p 0.9
+ 906010p -0.3
+ 908000p -0.3
+ 908010p 0.9
+ 910000p 0.9
+ 910010p -0.3
+ 912000p -0.3
+ 912010p 0.9
+ 914000p 0.9
+ 914010p -0.3
+ 916000p -0.3
+ 916010p 0.9
+ 918000p 0.9
+ 918010p -0.3
+ 920000p -0.3
+ 920010p 0.9
+ 922000p 0.9
+ 922010p -0.3
+ 924000p -0.3
+ 924010p 0.9
+ 926000p 0.9
+ 926010p -0.3
+ 928000p -0.3
+ 928010p 0.9
+ 930000p 0.9
+ 930010p -0.3
+ 932000p -0.3
+ 932010p 0.9
+ 934000p 0.9
+ 934010p -0.3
+ 936000p -0.3
+ 936010p 0.9
+ 938000p 0.9
+ 938010p -0.3
+ 940000p -0.3
+ 940010p 0.9
+ 942000p 0.9
+ 942010p -0.3
+ 944000p -0.3
+ 944010p 0.9
+ 946000p 0.9
+ 946010p -0.3
+ 948000p -0.3
+ 948010p 0.9
+ 950000p 0.9
+ 950010p -0.3
+ 952000p -0.3
+ 952010p 0.9
+ 954000p 0.9
+ 954010p -0.3
+ 956000p -0.3
+ 956010p 0.9
+ 958000p 0.9
+ 958010p -0.3
+ 960000p -0.3
+ 960010p 0.9
+ 962000p 0.9
+ 962010p -0.3
+ 964000p -0.3
+ 964010p 0.9
+ 966000p 0.9
+ 966010p -0.3
+ 968000p -0.3
+ 968010p 0.9
+ 970000p 0.9
+ 970010p -0.3
+ 972000p -0.3
+ 972010p 0.9
+ 974000p 0.9
+ 974010p -0.3
+ 976000p -0.3
+ 976010p 0.9
+ 978000p 0.9
+ 978010p -0.3
+ 980000p -0.3
+ 980010p 0.9
+ 982000p 0.9
+ 982010p -0.3
+ 984000p -0.3
+ 984010p 0.9
+ 986000p 0.9
+ 986010p -0.3
+ 988000p -0.3
+ 988010p 0.9
+ 990000p 0.9
+ 990010p -0.3
+ 992000p -0.3
+ 992010p 0.9
+ 994000p 0.9
+ 994010p -0.3
+ 996000p -0.3
+ 996010p 0.9
+ 998000p 0.9
+ 998010p -0.3
+ 1000000p -0.3
+ 1000010p 0.9
+ 1002000p 0.9
+ 1002010p -0.3
+ 1004000p -0.3
+ 1004010p 0.9
+ 1006000p 0.9
+ 1006010p -0.3
+ 1008000p -0.3
+ 1008010p 0.9
+ 1010000p 0.9
+ 1010010p -0.3
+ 1012000p -0.3
+ 1012010p 0.9
+ 1014000p 0.9
+ 1014010p -0.3
+ 1016000p -0.3
+ 1016010p 0.9
+ 1018000p 0.9
+ 1018010p -0.3
+ 1020000p -0.3
+ 1020010p 0.9
+ 1022000p 0.9
+ 1022010p -0.3
+ 1024000p -0.3
+ 1024010p 0.9
+ 1026000p 0.9
+ 1026010p -0.3
+ 1028000p -0.3
+ 1028010p 0.9
+ 1030000p 0.9
+ 1030010p -0.3
+ 1032000p -0.3
+ 1032010p 0.9
+ 1034000p 0.9
+ 1034010p -0.3
+ 1036000p -0.3
+ 1036010p 0.9
+ 1038000p 0.9
+ 1038010p -0.3
+ 1040000p -0.3
+ 1040010p 0.9
+ 1042000p 0.9
+ 1042010p -0.3
+ 1044000p -0.3
+ 1044010p 0.9
+ 1046000p 0.9
+ 1046010p -0.3
+ 1048000p -0.3
+ 1048010p 0.9
+ 1050000p 0.9
+ 1050010p -0.3
+ 1052000p -0.3
+ 1052010p 0.9
+ 1054000p 0.9
+ 1054010p -0.3
+ 1056000p -0.3
+ 1056010p 0.9
+ 1058000p 0.9
+ 1058010p -0.3
+ 1060000p -0.3
+ 1060010p 0.9
+ 1062000p 0.9
+ 1062010p -0.3
+ 1064000p -0.3
+ 1064010p 0.9
+ 1066000p 0.9
+ 1066010p -0.3
+ 1068000p -0.3
+ 1068010p 0.9
+ 1070000p 0.9
+ 1070010p -0.3
+ 1072000p -0.3
+ 1072010p 0.9
+ 1074000p 0.9
+ 1074010p -0.3
+ 1076000p -0.3
+ 1076010p 0.9
+ 1078000p 0.9
+ 1078010p -0.3
+ 1080000p -0.3
+ 1080010p 0.9
+ 1082000p 0.9
+ 1082010p -0.3
+ 1084000p -0.3
+ 1084010p 0.9
+ 1086000p 0.9
+ 1086010p -0.3
+ 1088000p -0.3
+ 1088010p 0.9
+ 1090000p 0.9
+ 1090010p -0.3
+ 1092000p -0.3
+ 1092010p 0.9
+ 1094000p 0.9
+ 1094010p -0.3
+ 1096000p -0.3
+ 1096010p 0.9
+ 1098000p 0.9
+ 1098010p -0.3
+ 1100000p -0.3
+ 1100010p 0.9
+ 1102000p 0.9
+ 1102010p -0.3
+ 1104000p -0.3
+ 1104010p 0.9
+ 1106000p 0.9
+ 1106010p -0.3
+ 1108000p -0.3
+ 1108010p 0.9
+ 1110000p 0.9
+ 1110010p -0.3
+ 1112000p -0.3
+ 1112010p 0.9
+ 1114000p 0.9
+ 1114010p -0.3
+ 1116000p -0.3
+ 1116010p 0.9
+ 1118000p 0.9
+ 1118010p -0.3
+ 1120000p -0.3
+ 1120010p 0.9
+ 1122000p 0.9
+ 1122010p -0.3
+ 1124000p -0.3
+ 1124010p 0.9
+ 1126000p 0.9
+ 1126010p -0.3
+ 1128000p -0.3
+ 1128010p 0.9
+ 1130000p 0.9
+ 1130010p -0.3
+ 1132000p -0.3
+ 1132010p 0.9
+ 1134000p 0.9
+ 1134010p -0.3
+ 1136000p -0.3
+ 1136010p 0.9
+ 1138000p 0.9
+ 1138010p -0.3
+ 1140000p -0.3
+ 1140010p 0.9
+ 1142000p 0.9
+ 1142010p -0.3
+ 1144000p -0.3
+ 1144010p 0.9
+ 1146000p 0.9
+ 1146010p -0.3
+ 1148000p -0.3
+ 1148010p 0.9
+ 1150000p 0.9
+ 1150010p -0.3
+ 1152000p -0.3
+ 1152010p 0.9
+ 1154000p 0.9
+ 1154010p -0.3
+ 1156000p -0.3
+ 1156010p 0.9
+ 1158000p 0.9
+ 1158010p -0.3
+ 1160000p -0.3
+ 1160010p 0.9
+ 1162000p 0.9
+ 1162010p -0.3
+ 1164000p -0.3
+ 1164010p 0.9
+ 1166000p 0.9
+ 1166010p -0.3
+ 1168000p -0.3
+ 1168010p 0.9
+ 1170000p 0.9
+ 1170010p -0.3
+ 1172000p -0.3
+ 1172010p 0.9
+ 1174000p 0.9
+ 1174010p -0.3
+ 1176000p -0.3
+ 1176010p 0.9
+ 1178000p 0.9
+ 1178010p -0.3
+ 1180000p -0.3
+ 1180010p 0.9
+ 1182000p 0.9
+ 1182010p -0.3
+ 1184000p -0.3
+ 1184010p 0.9
+ 1186000p 0.9
+ 1186010p -0.3
+ 1188000p -0.3
+ 1188010p 0.9
+ 1190000p 0.9
+ 1190010p -0.3
+ 1192000p -0.3
+ 1192010p 0.9
+ 1194000p 0.9
+ 1194010p -0.3
+ 1196000p -0.3
+ 1196010p 0.9
+ 1198000p 0.9
+ 1198010p -0.3
+ 1200000p -0.3
+ 1200010p 0.9
+ 1202000p 0.9
+ 1202010p -0.3
+ 1204000p -0.3
+ 1204010p 0.9
+ 1206000p 0.9
+ 1206010p -0.3
+ 1208000p -0.3
+ 1208010p 0.9
+ 1210000p 0.9
+ 1210010p -0.3
+ 1212000p -0.3
+ 1212010p 0.9
+ 1214000p 0.9
+ 1214010p -0.3
+ 1216000p -0.3
+ 1216010p 0.9
+ 1218000p 0.9
+ 1218010p -0.3
+ 1220000p -0.3
+ 1220010p 0.9
+ 1222000p 0.9
+ 1222010p -0.3
+ 1224000p -0.3
+ 1224010p 0.9
+ 1226000p 0.9
+ 1226010p -0.3
+ 1228000p -0.3
+ 1228010p 0.9
+ 1230000p 0.9
+ 1230010p -0.3
+ 1232000p -0.3
+ 1232010p 0.9
+ 1234000p 0.9
+ 1234010p -0.3
+ 1236000p -0.3
+ 1236010p 0.9
+ 1238000p 0.9
+ 1238010p -0.3
+ 1240000p -0.3
+ 1240010p 0.9
+ 1242000p 0.9
+ 1242010p -0.3
+ 1244000p -0.3
+ 1244010p 0.9
+ 1246000p 0.9
+ 1246010p -0.3
+ 1248000p -0.3
+ 1248010p 0.9
+ 1250000p 0.9
+ 1250010p -0.3
+ 1252000p -0.3
+ 1252010p 0.9
+ 1254000p 0.9
+ 1254010p -0.3
+ 1256000p -0.3
+ 1256010p 0.9
+ 1258000p 0.9
+ 1258010p -0.3
+ 1260000p -0.3
+ 1260010p 0.9
+ 1262000p 0.9
+ 1262010p -0.3
+ 1264000p -0.3
+ 1264010p 0.9
+ 1266000p 0.9
+ 1266010p -0.3
+ 1268000p -0.3
+ 1268010p 0.9
+ 1270000p 0.9
+ 1270010p -0.3
+ 1272000p -0.3
+ 1272010p 0.9
+ 1274000p 0.9
+ 1274010p -0.3
+ 1276000p -0.3
+ 1276010p 0.9
+ 1278000p 0.9
+ 1278010p -0.3
+ 1280000p -0.3
+ 1280010p 0.9
+ 1282000p 0.9
+ 1282010p -0.3
+ 1284000p -0.3
+ 1284010p 0.9
+ 1286000p 0.9
+ 1286010p -0.3
+ 1288000p -0.3
+ 1288010p 0.9
+ 1290000p 0.9
+ 1290010p -0.3
+ 1292000p -0.3
+ 1292010p 0.9
+ 1294000p 0.9
+ 1294010p -0.3
+ 1296000p -0.3
+ 1296010p 0.9
+ 1298000p 0.9
+ 1298010p -0.3
+ 1300000p -0.3
+ 1300010p 0.9
+ 1302000p 0.9
+ 1302010p -0.3
+ 1304000p -0.3
+ 1304010p 0.9
+ 1306000p 0.9
+ 1306010p -0.3
+ 1308000p -0.3
+ 1308010p 0.9
+ 1310000p 0.9
+ 1310010p -0.3
+ 1312000p -0.3
+ 1312010p 0.9
+ 1314000p 0.9
+ 1314010p -0.3
+ 1316000p -0.3
+ 1316010p 0.9
+ 1318000p 0.9
+ 1318010p -0.3
+ 1320000p -0.3
+ 1320010p 0.9
+ 1322000p 0.9
+ 1322010p -0.3
+ 1324000p -0.3
+ 1324010p 0.9
+ 1326000p 0.9
+ 1326010p -0.3
+ 1328000p -0.3
+ 1328010p 0.9
+ 1330000p 0.9
+ 1330010p -0.3
+ 1332000p -0.3
+ 1332010p 0.9
+ 1334000p 0.9
+ 1334010p -0.3
+ 1336000p -0.3
+ 1336010p 0.9
+ 1338000p 0.9
+ 1338010p -0.3
+ 1340000p -0.3
+ 1340010p 0.9
+ 1342000p 0.9
+ 1342010p -0.3
+ 1344000p -0.3
+ 1344010p 0.9
+ 1346000p 0.9
+ 1346010p -0.3
+ 1348000p -0.3
+ 1348010p 0.9
+ 1350000p 0.9
+ 1350010p -0.3
+ 1352000p -0.3
+ 1352010p 0.9
+ 1354000p 0.9
+ 1354010p -0.3
+ 1356000p -0.3
+ 1356010p 0.9
+ 1358000p 0.9
+ 1358010p -0.3
+ 1360000p -0.3
+ 1360010p 0.9
+ 1362000p 0.9
+ 1362010p -0.3
+ 1364000p -0.3
+ 1364010p 0.9
+ 1366000p 0.9
+ 1366010p -0.3
+ 1368000p -0.3
+ 1368010p 0.9
+ 1370000p 0.9
+ 1370010p -0.3
+ 1372000p -0.3
+ 1372010p 0.9
+ 1374000p 0.9
+ 1374010p -0.3
+ 1376000p -0.3
+ 1376010p 0.9
+ 1378000p 0.9
+ 1378010p -0.3
+ 1380000p -0.3
+ 1380010p 0.9
+ 1382000p 0.9
+ 1382010p -0.3
+ 1384000p -0.3
+ 1384010p 0.9
+ 1386000p 0.9
+ 1386010p -0.3
+ 1388000p -0.3
+ 1388010p 0.9
+ 1390000p 0.9
+ 1390010p -0.3
+ 1392000p -0.3
+ 1392010p 0.9
+ 1394000p 0.9
+ 1394010p -0.3
+ 1396000p -0.3
+ 1396010p 0.9
+ 1398000p 0.9
+ 1398010p -0.3
+ 1400000p -0.3
+ 1400010p 0.9
+ 1402000p 0.9
+ 1402010p -0.3
+ 1404000p -0.3
+ 1404010p 0.9
+ 1406000p 0.9
+ 1406010p -0.3
+ 1408000p -0.3
+ 1408010p 0.9
+ 1410000p 0.9
+ 1410010p -0.3
+ 1412000p -0.3
+ 1412010p 0.9
+ 1414000p 0.9
+ 1414010p -0.3
+ 1416000p -0.3
+ 1416010p 0.9
+ 1418000p 0.9
+ 1418010p -0.3
+ 1420000p -0.3
+ 1420010p 0.9
+ 1422000p 0.9
+ 1422010p -0.3
+ 1424000p -0.3
+ 1424010p 0.9
+ 1426000p 0.9
+ 1426010p -0.3
+ 1428000p -0.3
+ 1428010p 0.9
+ 1430000p 0.9
+ 1430010p -0.3
+ 1432000p -0.3
+ 1432010p 0.9
+ 1434000p 0.9
+ 1434010p -0.3
+ 1436000p -0.3
+ 1436010p 0.9
+ 1438000p 0.9
+ 1438010p -0.3
+ 1440000p -0.3
+ 1440010p 0.9
+ 1442000p 0.9
+ 1442010p -0.3
+ 1444000p -0.3
+ 1444010p 0.9
+ 1446000p 0.9
+ 1446010p -0.3
+ 1448000p -0.3
+ 1448010p 0.9
+ 1450000p 0.9
+ 1450010p -0.3
+ 1452000p -0.3
+ 1452010p 0.9
+ 1454000p 0.9
+ 1454010p -0.3
+ 1456000p -0.3
+ 1456010p 0.9
+ 1458000p 0.9
+ 1458010p -0.3
+ 1460000p -0.3
+ 1460010p 0.9
+ 1462000p 0.9
+ 1462010p -0.3
+ 1464000p -0.3
+ 1464010p 0.9
+ 1466000p 0.9
+ 1466010p -0.3
+ 1468000p -0.3
+ 1468010p 0.9
+ 1470000p 0.9
+ 1470010p -0.3
+ 1472000p -0.3
+ 1472010p 0.9
+ 1474000p 0.9
+ 1474010p -0.3
+ 1476000p -0.3
+ 1476010p 0.9
+ 1478000p 0.9
+ 1478010p -0.3
+ 1480000p -0.3
+ 1480010p 0.9
+ 1482000p 0.9
+ 1482010p -0.3
+ 1484000p -0.3
+ 1484010p 0.9
+ 1486000p 0.9
+ 1486010p -0.3
+ 1488000p -0.3
+ 1488010p 0.9
+ 1490000p 0.9
+ 1490010p -0.3
+ 1492000p -0.3
+ 1492010p 0.9
+ 1494000p 0.9
+ 1494010p -0.3
+ 1496000p -0.3
+ 1496010p 0.9
+ 1498000p 0.9
+ 1498010p -0.3
+ 1500000p -0.3
+ 1500010p 0.9
+ 1502000p 0.9
+ 1502010p -0.3
+ 1504000p -0.3
+ 1504010p 0.9
+ 1506000p 0.9
+ 1506010p -0.3
+ 1508000p -0.3
+ 1508010p 0.9
+ 1510000p 0.9
+ 1510010p -0.3
+ 1512000p -0.3
+ 1512010p 0.9
+ 1514000p 0.9
+ 1514010p -0.3
+ 1516000p -0.3
+ 1516010p 0.9
+ 1518000p 0.9
+ 1518010p -0.3
+ 1520000p -0.3
+ 1520010p 0.9
+ 1522000p 0.9
+ 1522010p -0.3
+ 1524000p -0.3
+ 1524010p 0.9
+ 1526000p 0.9
+ 1526010p -0.3
+ 1528000p -0.3
+ 1528010p 0.9
+ 1530000p 0.9
+ 1530010p -0.3
+ 1532000p -0.3
+ 1532010p 0.9
+ 1534000p 0.9
+ 1534010p -0.3
+ 1536000p -0.3
+ 1536010p 0.9
+ 1538000p 0.9
+ 1538010p -0.3
+ 1540000p -0.3
+ 1540010p 0.9
+ 1542000p 0.9
+ 1542010p -0.3
+ 1544000p -0.3
+ 1544010p 0.9
+ 1546000p 0.9
+ 1546010p -0.3
+ 1548000p -0.3
+ 1548010p 0.9
+ 1550000p 0.9
+ 1550010p -0.3
+ 1552000p -0.3
+ 1552010p 0.9
+ 1554000p 0.9
+ 1554010p -0.3
+ 1556000p -0.3
+ 1556010p 0.9
+ 1558000p 0.9
+ 1558010p -0.3
+ 1560000p -0.3
+ 1560010p 0.9
+ 1562000p 0.9
+ 1562010p -0.3
+ 1564000p -0.3
+ 1564010p 0.9
+ 1566000p 0.9
+ 1566010p -0.3
+ 1568000p -0.3
+ 1568010p 0.9
+ 1570000p 0.9
+ 1570010p -0.3
+ 1572000p -0.3
+ 1572010p 0.9
+ 1574000p 0.9
+ 1574010p -0.3
+ 1576000p -0.3
+ 1576010p 0.9
+ 1578000p 0.9
+ 1578010p -0.3
+ 1580000p -0.3
+ 1580010p 0.9
+ 1582000p 0.9
+ 1582010p -0.3
+ 1584000p -0.3
+ 1584010p 0.9
+ 1586000p 0.9
+ 1586010p -0.3
+ 1588000p -0.3
+ 1588010p 0.9
+ 1590000p 0.9
+ 1590010p -0.3
+ 1592000p -0.3
+ 1592010p 0.9
+ 1594000p 0.9
+ 1594010p -0.3
+ 1596000p -0.3
+ 1596010p 0.9
+ 1598000p 0.9
+ 1598010p -0.3
+ 1600000p -0.3
+ 1600010p 0.9
+ 1602000p 0.9
+ 1602010p -0.3
+ 1604000p -0.3
+ 1604010p 0.9
+ 1606000p 0.9
+ 1606010p -0.3
+ 1608000p -0.3
+ 1608010p 0.9
+ 1610000p 0.9
+ 1610010p -0.3
+ 1612000p -0.3
+ 1612010p 0.9
+ 1614000p 0.9
+ 1614010p -0.3
+ 1616000p -0.3
+ 1616010p 0.9
+ 1618000p 0.9
+ 1618010p -0.3
+ 1620000p -0.3
+ 1620010p 0.9
+ 1622000p 0.9
+ 1622010p -0.3
+ 1624000p -0.3
+ 1624010p 0.9
+ 1626000p 0.9
+ 1626010p -0.3
+ 1628000p -0.3
+ 1628010p 0.9
+ 1630000p 0.9
+ 1630010p -0.3
+ 1632000p -0.3
+ 1632010p 0.9
+ 1634000p 0.9
+ 1634010p -0.3
+ 1636000p -0.3
+ 1636010p 0.9
+ 1638000p 0.9
+ 1638010p -0.3
+ 1640000p -0.3
+ 1640010p 0.9
+ 1642000p 0.9
+ 1642010p -0.3
+ 1644000p -0.3
+ 1644010p 0.9
+ 1646000p 0.9
+ 1646010p -0.3
+ 1648000p -0.3
+ 1648010p 0.9
+ 1650000p 0.9
+ 1650010p -0.3
+ 1652000p -0.3
+ 1652010p 0.9
+ 1654000p 0.9
+ 1654010p -0.3
+ 1656000p -0.3
+ 1656010p 0.9
+ 1658000p 0.9
+ 1658010p -0.3
+ 1660000p -0.3
+ 1660010p 0.9
+ 1662000p 0.9
+ 1662010p -0.3
+ 1664000p -0.3
+ 1664010p 0.9
+ 1666000p 0.9
+ 1666010p -0.3
+ 1668000p -0.3
+ 1668010p 0.9
+ 1670000p 0.9
+ 1670010p -0.3
+ 1672000p -0.3
+ 1672010p 0.9
+ 1674000p 0.9
+ 1674010p -0.3
+ 1676000p -0.3
+ 1676010p 0.9
+ 1678000p 0.9
+ 1678010p -0.3
+ 1680000p -0.3
+ 1680010p 0.9
+ 1682000p 0.9
+ 1682010p -0.3
+ 1684000p -0.3
+ 1684010p 0.9
+ 1686000p 0.9
+ 1686010p -0.3
+ 1688000p -0.3
+ 1688010p 0.9
+ 1690000p 0.9
+ 1690010p -0.3
+ 1692000p -0.3
+ 1692010p 0.9
+ 1694000p 0.9
+ 1694010p -0.3
+ 1696000p -0.3
+ 1696010p 0.9
+ 1698000p 0.9
+ 1698010p -0.3
+ 1700000p -0.3
+ 1700010p 0.9
+ 1702000p 0.9
+ 1702010p -0.3
+ 1704000p -0.3
+ 1704010p 0.9
+ 1706000p 0.9
+ 1706010p -0.3
+ 1708000p -0.3
+ 1708010p 0.9
+ 1710000p 0.9
+ 1710010p -0.3
+ 1712000p -0.3
+ 1712010p 0.9
+ 1714000p 0.9
+ 1714010p -0.3
+ 1716000p -0.3
+ 1716010p 0.9
+ 1718000p 0.9
+ 1718010p -0.3
+ 1720000p -0.3
+ 1720010p 0.9
+ 1722000p 0.9
+ 1722010p -0.3
+ 1724000p -0.3
+ 1724010p 0.9
+ 1726000p 0.9
+ 1726010p -0.3
+ 1728000p -0.3
+ 1728010p 0.9
+ 1730000p 0.9
+ 1730010p -0.3
+ 1732000p -0.3
+ 1732010p 0.9
+ 1734000p 0.9
+ 1734010p -0.3
+ 1736000p -0.3
+ 1736010p 0.9
+ 1738000p 0.9
+ 1738010p -0.3
+ 1740000p -0.3
+ 1740010p 0.9
+ 1742000p 0.9
+ 1742010p -0.3
+ 1744000p -0.3
+ 1744010p 0.9
+ 1746000p 0.9
+ 1746010p -0.3
+ 1748000p -0.3
+ 1748010p 0.9
+ 1750000p 0.9
+ 1750010p -0.3
+ 1752000p -0.3
+ 1752010p 0.9
+ 1754000p 0.9
+ 1754010p -0.3
+ 1756000p -0.3
+ 1756010p 0.9
+ 1758000p 0.9
+ 1758010p -0.3
+ 1760000p -0.3
+ 1760010p 0.9
+ 1762000p 0.9
+ 1762010p -0.3
+ 1764000p -0.3
+ 1764010p 0.9
+ 1766000p 0.9
+ 1766010p -0.3
+ 1768000p -0.3
+ 1768010p 0.9
+ 1770000p 0.9
+ 1770010p -0.3
+ 1772000p -0.3
+ 1772010p 0.9
+ 1774000p 0.9
+ 1774010p -0.3
+ 1776000p -0.3
+ 1776010p 0.9
+ 1778000p 0.9
+ 1778010p -0.3
+ 1780000p -0.3
+ 1780010p 0.9
+ 1782000p 0.9
+ 1782010p -0.3
+ 1784000p -0.3
+ 1784010p 0.9
+ 1786000p 0.9
+ 1786010p -0.3
+ 1788000p -0.3
+ 1788010p 0.9
+ 1790000p 0.9
+ 1790010p -0.3
+ 1792000p -0.3
+ 1792010p 0.9
+ 1794000p 0.9
+ 1794010p -0.3
+ 1796000p -0.3
+ 1796010p 0.9
+ 1798000p 0.9
+ 1798010p -0.3
+ 1800000p -0.3
+ 1800010p 0.9
+ 1802000p 0.9
+ 1802010p -0.3
+ 1804000p -0.3
+ 1804010p 0.9
+ 1806000p 0.9
+ 1806010p -0.3
+ 1808000p -0.3
+ 1808010p 0.9
+ 1810000p 0.9
+ 1810010p -0.3
+ 1812000p -0.3
+ 1812010p 0.9
+ 1814000p 0.9
+ 1814010p -0.3
+ 1816000p -0.3
+ 1816010p 0.9
+ 1818000p 0.9
+ 1818010p -0.3
+ 1820000p -0.3
+ 1820010p 0.9
+ 1822000p 0.9
+ 1822010p -0.3
+ 1824000p -0.3
+ 1824010p 0.9
+ 1826000p 0.9
+ 1826010p -0.3
+ 1828000p -0.3
+ 1828010p 0.9
+ 1830000p 0.9
+ 1830010p -0.3
+ 1832000p -0.3
+ 1832010p 0.9
+ 1834000p 0.9
+ 1834010p -0.3
+ 1836000p -0.3
+ 1836010p 0.9
+ 1838000p 0.9
+ 1838010p -0.3
+ 1840000p -0.3
+ 1840010p 0.9
+ 1842000p 0.9
+ 1842010p -0.3
+ 1844000p -0.3
+ 1844010p 0.9
+ 1846000p 0.9
+ 1846010p -0.3
+ 1848000p -0.3
+ 1848010p 0.9
+ 1850000p 0.9
+ 1850010p -0.3
+ 1852000p -0.3
+ 1852010p 0.9
+ 1854000p 0.9
+ 1854010p -0.3
+ 1856000p -0.3
+ 1856010p 0.9
+ 1858000p 0.9
+ 1858010p -0.3
+ 1860000p -0.3
+ 1860010p 0.9
+ 1862000p 0.9
+ 1862010p -0.3
+ 1864000p -0.3
+ 1864010p 0.9
+ 1866000p 0.9
+ 1866010p -0.3
+ 1868000p -0.3
+ 1868010p 0.9
+ 1870000p 0.9
+ 1870010p -0.3
+ 1872000p -0.3
+ 1872010p 0.9
+ 1874000p 0.9
+ 1874010p -0.3
+ 1876000p -0.3
+ 1876010p 0.9
+ 1878000p 0.9
+ 1878010p -0.3
+ 1880000p -0.3
+ 1880010p 0.9
+ 1882000p 0.9
+ 1882010p -0.3
+ 1884000p -0.3
+ 1884010p 0.9
+ 1886000p 0.9
+ 1886010p -0.3
+ 1888000p -0.3
+ 1888010p 0.9
+ 1890000p 0.9
+ 1890010p -0.3
+ 1892000p -0.3
+ 1892010p 0.9
+ 1894000p 0.9
+ 1894010p -0.3
+ 1896000p -0.3
+ 1896010p 0.9
+ 1898000p 0.9
+ 1898010p -0.3
+ 1900000p -0.3
+ 1900010p 0.9
+ 1902000p 0.9
+ 1902010p -0.3
+ 1904000p -0.3
+ 1904010p 0.9
+ 1906000p 0.9
+ 1906010p -0.3
+ 1908000p -0.3
+ 1908010p 0.9
+ 1910000p 0.9
+ 1910010p -0.3
+ 1912000p -0.3
+ 1912010p 0.9
+ 1914000p 0.9
+ 1914010p -0.3
+ 1916000p -0.3
+ 1916010p 0.9
+ 1918000p 0.9
+ 1918010p -0.3
+ 1920000p -0.3
+ 1920010p 0.9
+ 1922000p 0.9
+ 1922010p -0.3
+ 1924000p -0.3
+ 1924010p 0.9
+ 1926000p 0.9
+ 1926010p -0.3
+ 1928000p -0.3
+ 1928010p 0.9
+ 1930000p 0.9
+ 1930010p -0.3
+ 1932000p -0.3
+ 1932010p 0.9
+ 1934000p 0.9
+ 1934010p -0.3
+ 1936000p -0.3
+ 1936010p 0.9
+ 1938000p 0.9
+ 1938010p -0.3
+ 1940000p -0.3
+ 1940010p 0.9
+ 1942000p 0.9
+ 1942010p -0.3
+ 1944000p -0.3
+ 1944010p 0.9
+ 1946000p 0.9
+ 1946010p -0.3
+ 1948000p -0.3
+ 1948010p 0.9
+ 1950000p 0.9
+ 1950010p -0.3
+ 1952000p -0.3
+ 1952010p 0.9
+ 1954000p 0.9
+ 1954010p -0.3
+ 1956000p -0.3
+ 1956010p 0.9
+ 1958000p 0.9
+ 1958010p -0.3
+ 1960000p -0.3
+ 1960010p 0.9
+ 1962000p 0.9
+ 1962010p -0.3
+ 1964000p -0.3
+ 1964010p 0.9
+ 1966000p 0.9
+ 1966010p -0.3
+ 1968000p -0.3
+ 1968010p 0.9
+ 1970000p 0.9
+ 1970010p -0.3
+ 1972000p -0.3
+ 1972010p 0.9
+ 1974000p 0.9
+ 1974010p -0.3
+ 1976000p -0.3
+ 1976010p 0.9
+ 1978000p 0.9
+ 1978010p -0.3
+ 1980000p -0.3
+ 1980010p 0.9
+ 1982000p 0.9
+ 1982010p -0.3
+ 1984000p -0.3
+ 1984010p 0.9
+ 1986000p 0.9
+ 1986010p -0.3
+ 1988000p -0.3
+ 1988010p 0.9
+ 1990000p 0.9
+ 1990010p -0.3
+ 1992000p -0.3
+ 1992010p 0.9
+ 1994000p 0.9
+ 1994010p -0.3
+ 1996000p -0.3
+ 1996010p 0.9
+ 1998000p 0.9
+ 1998010p -0.3
+ 2000000p -0.3
+ 2000010p 0.9
+ 2002000p 0.9
+ 2002010p -0.3
+ 2004000p -0.3
+ 2004010p 0.9
+ 2006000p 0.9
+ 2006010p -0.3
+ 2008000p -0.3
+ 2008010p 0.9
+ 2010000p 0.9
+ 2010010p -0.3
+ 2012000p -0.3
+ 2012010p 0.9
+ 2014000p 0.9
+ 2014010p -0.3
+ 2016000p -0.3
+ 2016010p 0.9
+ 2018000p 0.9
+ 2018010p -0.3
+ 2020000p -0.3
+ 2020010p 0.9
+ 2022000p 0.9
+ 2022010p -0.3
+ 2024000p -0.3
+ 2024010p 0.9
+ 2026000p 0.9
+ 2026010p -0.3
+ 2028000p -0.3
+ 2028010p 0.9
+ 2030000p 0.9
+ 2030010p -0.3
+ 2032000p -0.3
+ 2032010p 0.9
+ 2034000p 0.9
+ 2034010p -0.3
+ 2036000p -0.3
+ 2036010p 0.9
+ 2038000p 0.9
+ 2038010p -0.3
+ 2040000p -0.3
+ 2040010p 0.9
+ 2042000p 0.9
+ 2042010p -0.3
+ 2044000p -0.3
+ 2044010p 0.9
+ 2046000p 0.9
+ 2046010p -0.3
+ 2048000p -0.3
+ 2048010p 0.9
+ \]
V_data_bar_11 (Data_bar\\<11\\> gnd!) vsource type=pwl wave=\[
+ 0    -0.3
+ 2000p -0.3
+ 2010p 0.9
+ 4000p 0.9
+ 4010p -0.3
+ 6000p -0.3
+ 6010p 0.9
+ 8000p 0.9
+ 8010p -0.3
+ 10000p -0.3
+ 10010p 0.9
+ 12000p 0.9
+ 12010p -0.3
+ 14000p -0.3
+ 14010p 0.9
+ 16000p 0.9
+ 16010p -0.3
+ 18000p -0.3
+ 18010p 0.9
+ 20000p 0.9
+ 20010p -0.3
+ 22000p -0.3
+ 22010p 0.9
+ 24000p 0.9
+ 24010p -0.3
+ 26000p -0.3
+ 26010p 0.9
+ 28000p 0.9
+ 28010p -0.3
+ 30000p -0.3
+ 30010p 0.9
+ 32000p 0.9
+ 32010p -0.3
+ 34000p -0.3
+ 34010p 0.9
+ 36000p 0.9
+ 36010p -0.3
+ 38000p -0.3
+ 38010p 0.9
+ 40000p 0.9
+ 40010p -0.3
+ 42000p -0.3
+ 42010p 0.9
+ 44000p 0.9
+ 44010p -0.3
+ 46000p -0.3
+ 46010p 0.9
+ 48000p 0.9
+ 48010p -0.3
+ 50000p -0.3
+ 50010p 0.9
+ 52000p 0.9
+ 52010p -0.3
+ 54000p -0.3
+ 54010p 0.9
+ 56000p 0.9
+ 56010p -0.3
+ 58000p -0.3
+ 58010p 0.9
+ 60000p 0.9
+ 60010p -0.3
+ 62000p -0.3
+ 62010p 0.9
+ 64000p 0.9
+ 64010p -0.3
+ 66000p -0.3
+ 66010p 0.9
+ 68000p 0.9
+ 68010p -0.3
+ 70000p -0.3
+ 70010p 0.9
+ 72000p 0.9
+ 72010p -0.3
+ 74000p -0.3
+ 74010p 0.9
+ 76000p 0.9
+ 76010p -0.3
+ 78000p -0.3
+ 78010p 0.9
+ 80000p 0.9
+ 80010p -0.3
+ 82000p -0.3
+ 82010p 0.9
+ 84000p 0.9
+ 84010p -0.3
+ 86000p -0.3
+ 86010p 0.9
+ 88000p 0.9
+ 88010p -0.3
+ 90000p -0.3
+ 90010p 0.9
+ 92000p 0.9
+ 92010p -0.3
+ 94000p -0.3
+ 94010p 0.9
+ 96000p 0.9
+ 96010p -0.3
+ 98000p -0.3
+ 98010p 0.9
+ 100000p 0.9
+ 100010p -0.3
+ 102000p -0.3
+ 102010p 0.9
+ 104000p 0.9
+ 104010p -0.3
+ 106000p -0.3
+ 106010p 0.9
+ 108000p 0.9
+ 108010p -0.3
+ 110000p -0.3
+ 110010p 0.9
+ 112000p 0.9
+ 112010p -0.3
+ 114000p -0.3
+ 114010p 0.9
+ 116000p 0.9
+ 116010p -0.3
+ 118000p -0.3
+ 118010p 0.9
+ 120000p 0.9
+ 120010p -0.3
+ 122000p -0.3
+ 122010p 0.9
+ 124000p 0.9
+ 124010p -0.3
+ 126000p -0.3
+ 126010p 0.9
+ 128000p 0.9
+ 128010p -0.3
+ 130000p -0.3
+ 130010p 0.9
+ 132000p 0.9
+ 132010p -0.3
+ 134000p -0.3
+ 134010p 0.9
+ 136000p 0.9
+ 136010p -0.3
+ 138000p -0.3
+ 138010p 0.9
+ 140000p 0.9
+ 140010p -0.3
+ 142000p -0.3
+ 142010p 0.9
+ 144000p 0.9
+ 144010p -0.3
+ 146000p -0.3
+ 146010p 0.9
+ 148000p 0.9
+ 148010p -0.3
+ 150000p -0.3
+ 150010p 0.9
+ 152000p 0.9
+ 152010p -0.3
+ 154000p -0.3
+ 154010p 0.9
+ 156000p 0.9
+ 156010p -0.3
+ 158000p -0.3
+ 158010p 0.9
+ 160000p 0.9
+ 160010p -0.3
+ 162000p -0.3
+ 162010p 0.9
+ 164000p 0.9
+ 164010p -0.3
+ 166000p -0.3
+ 166010p 0.9
+ 168000p 0.9
+ 168010p -0.3
+ 170000p -0.3
+ 170010p 0.9
+ 172000p 0.9
+ 172010p -0.3
+ 174000p -0.3
+ 174010p 0.9
+ 176000p 0.9
+ 176010p -0.3
+ 178000p -0.3
+ 178010p 0.9
+ 180000p 0.9
+ 180010p -0.3
+ 182000p -0.3
+ 182010p 0.9
+ 184000p 0.9
+ 184010p -0.3
+ 186000p -0.3
+ 186010p 0.9
+ 188000p 0.9
+ 188010p -0.3
+ 190000p -0.3
+ 190010p 0.9
+ 192000p 0.9
+ 192010p -0.3
+ 194000p -0.3
+ 194010p 0.9
+ 196000p 0.9
+ 196010p -0.3
+ 198000p -0.3
+ 198010p 0.9
+ 200000p 0.9
+ 200010p -0.3
+ 202000p -0.3
+ 202010p 0.9
+ 204000p 0.9
+ 204010p -0.3
+ 206000p -0.3
+ 206010p 0.9
+ 208000p 0.9
+ 208010p -0.3
+ 210000p -0.3
+ 210010p 0.9
+ 212000p 0.9
+ 212010p -0.3
+ 214000p -0.3
+ 214010p 0.9
+ 216000p 0.9
+ 216010p -0.3
+ 218000p -0.3
+ 218010p 0.9
+ 220000p 0.9
+ 220010p -0.3
+ 222000p -0.3
+ 222010p 0.9
+ 224000p 0.9
+ 224010p -0.3
+ 226000p -0.3
+ 226010p 0.9
+ 228000p 0.9
+ 228010p -0.3
+ 230000p -0.3
+ 230010p 0.9
+ 232000p 0.9
+ 232010p -0.3
+ 234000p -0.3
+ 234010p 0.9
+ 236000p 0.9
+ 236010p -0.3
+ 238000p -0.3
+ 238010p 0.9
+ 240000p 0.9
+ 240010p -0.3
+ 242000p -0.3
+ 242010p 0.9
+ 244000p 0.9
+ 244010p -0.3
+ 246000p -0.3
+ 246010p 0.9
+ 248000p 0.9
+ 248010p -0.3
+ 250000p -0.3
+ 250010p 0.9
+ 252000p 0.9
+ 252010p -0.3
+ 254000p -0.3
+ 254010p 0.9
+ 256000p 0.9
+ 256010p -0.3
+ 258000p -0.3
+ 258010p 0.9
+ 260000p 0.9
+ 260010p -0.3
+ 262000p -0.3
+ 262010p 0.9
+ 264000p 0.9
+ 264010p -0.3
+ 266000p -0.3
+ 266010p 0.9
+ 268000p 0.9
+ 268010p -0.3
+ 270000p -0.3
+ 270010p 0.9
+ 272000p 0.9
+ 272010p -0.3
+ 274000p -0.3
+ 274010p 0.9
+ 276000p 0.9
+ 276010p -0.3
+ 278000p -0.3
+ 278010p 0.9
+ 280000p 0.9
+ 280010p -0.3
+ 282000p -0.3
+ 282010p 0.9
+ 284000p 0.9
+ 284010p -0.3
+ 286000p -0.3
+ 286010p 0.9
+ 288000p 0.9
+ 288010p -0.3
+ 290000p -0.3
+ 290010p 0.9
+ 292000p 0.9
+ 292010p -0.3
+ 294000p -0.3
+ 294010p 0.9
+ 296000p 0.9
+ 296010p -0.3
+ 298000p -0.3
+ 298010p 0.9
+ 300000p 0.9
+ 300010p -0.3
+ 302000p -0.3
+ 302010p 0.9
+ 304000p 0.9
+ 304010p -0.3
+ 306000p -0.3
+ 306010p 0.9
+ 308000p 0.9
+ 308010p -0.3
+ 310000p -0.3
+ 310010p 0.9
+ 312000p 0.9
+ 312010p -0.3
+ 314000p -0.3
+ 314010p 0.9
+ 316000p 0.9
+ 316010p -0.3
+ 318000p -0.3
+ 318010p 0.9
+ 320000p 0.9
+ 320010p -0.3
+ 322000p -0.3
+ 322010p 0.9
+ 324000p 0.9
+ 324010p -0.3
+ 326000p -0.3
+ 326010p 0.9
+ 328000p 0.9
+ 328010p -0.3
+ 330000p -0.3
+ 330010p 0.9
+ 332000p 0.9
+ 332010p -0.3
+ 334000p -0.3
+ 334010p 0.9
+ 336000p 0.9
+ 336010p -0.3
+ 338000p -0.3
+ 338010p 0.9
+ 340000p 0.9
+ 340010p -0.3
+ 342000p -0.3
+ 342010p 0.9
+ 344000p 0.9
+ 344010p -0.3
+ 346000p -0.3
+ 346010p 0.9
+ 348000p 0.9
+ 348010p -0.3
+ 350000p -0.3
+ 350010p 0.9
+ 352000p 0.9
+ 352010p -0.3
+ 354000p -0.3
+ 354010p 0.9
+ 356000p 0.9
+ 356010p -0.3
+ 358000p -0.3
+ 358010p 0.9
+ 360000p 0.9
+ 360010p -0.3
+ 362000p -0.3
+ 362010p 0.9
+ 364000p 0.9
+ 364010p -0.3
+ 366000p -0.3
+ 366010p 0.9
+ 368000p 0.9
+ 368010p -0.3
+ 370000p -0.3
+ 370010p 0.9
+ 372000p 0.9
+ 372010p -0.3
+ 374000p -0.3
+ 374010p 0.9
+ 376000p 0.9
+ 376010p -0.3
+ 378000p -0.3
+ 378010p 0.9
+ 380000p 0.9
+ 380010p -0.3
+ 382000p -0.3
+ 382010p 0.9
+ 384000p 0.9
+ 384010p -0.3
+ 386000p -0.3
+ 386010p 0.9
+ 388000p 0.9
+ 388010p -0.3
+ 390000p -0.3
+ 390010p 0.9
+ 392000p 0.9
+ 392010p -0.3
+ 394000p -0.3
+ 394010p 0.9
+ 396000p 0.9
+ 396010p -0.3
+ 398000p -0.3
+ 398010p 0.9
+ 400000p 0.9
+ 400010p -0.3
+ 402000p -0.3
+ 402010p 0.9
+ 404000p 0.9
+ 404010p -0.3
+ 406000p -0.3
+ 406010p 0.9
+ 408000p 0.9
+ 408010p -0.3
+ 410000p -0.3
+ 410010p 0.9
+ 412000p 0.9
+ 412010p -0.3
+ 414000p -0.3
+ 414010p 0.9
+ 416000p 0.9
+ 416010p -0.3
+ 418000p -0.3
+ 418010p 0.9
+ 420000p 0.9
+ 420010p -0.3
+ 422000p -0.3
+ 422010p 0.9
+ 424000p 0.9
+ 424010p -0.3
+ 426000p -0.3
+ 426010p 0.9
+ 428000p 0.9
+ 428010p -0.3
+ 430000p -0.3
+ 430010p 0.9
+ 432000p 0.9
+ 432010p -0.3
+ 434000p -0.3
+ 434010p 0.9
+ 436000p 0.9
+ 436010p -0.3
+ 438000p -0.3
+ 438010p 0.9
+ 440000p 0.9
+ 440010p -0.3
+ 442000p -0.3
+ 442010p 0.9
+ 444000p 0.9
+ 444010p -0.3
+ 446000p -0.3
+ 446010p 0.9
+ 448000p 0.9
+ 448010p -0.3
+ 450000p -0.3
+ 450010p 0.9
+ 452000p 0.9
+ 452010p -0.3
+ 454000p -0.3
+ 454010p 0.9
+ 456000p 0.9
+ 456010p -0.3
+ 458000p -0.3
+ 458010p 0.9
+ 460000p 0.9
+ 460010p -0.3
+ 462000p -0.3
+ 462010p 0.9
+ 464000p 0.9
+ 464010p -0.3
+ 466000p -0.3
+ 466010p 0.9
+ 468000p 0.9
+ 468010p -0.3
+ 470000p -0.3
+ 470010p 0.9
+ 472000p 0.9
+ 472010p -0.3
+ 474000p -0.3
+ 474010p 0.9
+ 476000p 0.9
+ 476010p -0.3
+ 478000p -0.3
+ 478010p 0.9
+ 480000p 0.9
+ 480010p -0.3
+ 482000p -0.3
+ 482010p 0.9
+ 484000p 0.9
+ 484010p -0.3
+ 486000p -0.3
+ 486010p 0.9
+ 488000p 0.9
+ 488010p -0.3
+ 490000p -0.3
+ 490010p 0.9
+ 492000p 0.9
+ 492010p -0.3
+ 494000p -0.3
+ 494010p 0.9
+ 496000p 0.9
+ 496010p -0.3
+ 498000p -0.3
+ 498010p 0.9
+ 500000p 0.9
+ 500010p -0.3
+ 502000p -0.3
+ 502010p 0.9
+ 504000p 0.9
+ 504010p -0.3
+ 506000p -0.3
+ 506010p 0.9
+ 508000p 0.9
+ 508010p -0.3
+ 510000p -0.3
+ 510010p 0.9
+ 512000p 0.9
+ 512010p -0.3
+ 514000p -0.3
+ 514010p 0.9
+ 516000p 0.9
+ 516010p -0.3
+ 518000p -0.3
+ 518010p 0.9
+ 520000p 0.9
+ 520010p -0.3
+ 522000p -0.3
+ 522010p 0.9
+ 524000p 0.9
+ 524010p -0.3
+ 526000p -0.3
+ 526010p 0.9
+ 528000p 0.9
+ 528010p -0.3
+ 530000p -0.3
+ 530010p 0.9
+ 532000p 0.9
+ 532010p -0.3
+ 534000p -0.3
+ 534010p 0.9
+ 536000p 0.9
+ 536010p -0.3
+ 538000p -0.3
+ 538010p 0.9
+ 540000p 0.9
+ 540010p -0.3
+ 542000p -0.3
+ 542010p 0.9
+ 544000p 0.9
+ 544010p -0.3
+ 546000p -0.3
+ 546010p 0.9
+ 548000p 0.9
+ 548010p -0.3
+ 550000p -0.3
+ 550010p 0.9
+ 552000p 0.9
+ 552010p -0.3
+ 554000p -0.3
+ 554010p 0.9
+ 556000p 0.9
+ 556010p -0.3
+ 558000p -0.3
+ 558010p 0.9
+ 560000p 0.9
+ 560010p -0.3
+ 562000p -0.3
+ 562010p 0.9
+ 564000p 0.9
+ 564010p -0.3
+ 566000p -0.3
+ 566010p 0.9
+ 568000p 0.9
+ 568010p -0.3
+ 570000p -0.3
+ 570010p 0.9
+ 572000p 0.9
+ 572010p -0.3
+ 574000p -0.3
+ 574010p 0.9
+ 576000p 0.9
+ 576010p -0.3
+ 578000p -0.3
+ 578010p 0.9
+ 580000p 0.9
+ 580010p -0.3
+ 582000p -0.3
+ 582010p 0.9
+ 584000p 0.9
+ 584010p -0.3
+ 586000p -0.3
+ 586010p 0.9
+ 588000p 0.9
+ 588010p -0.3
+ 590000p -0.3
+ 590010p 0.9
+ 592000p 0.9
+ 592010p -0.3
+ 594000p -0.3
+ 594010p 0.9
+ 596000p 0.9
+ 596010p -0.3
+ 598000p -0.3
+ 598010p 0.9
+ 600000p 0.9
+ 600010p -0.3
+ 602000p -0.3
+ 602010p 0.9
+ 604000p 0.9
+ 604010p -0.3
+ 606000p -0.3
+ 606010p 0.9
+ 608000p 0.9
+ 608010p -0.3
+ 610000p -0.3
+ 610010p 0.9
+ 612000p 0.9
+ 612010p -0.3
+ 614000p -0.3
+ 614010p 0.9
+ 616000p 0.9
+ 616010p -0.3
+ 618000p -0.3
+ 618010p 0.9
+ 620000p 0.9
+ 620010p -0.3
+ 622000p -0.3
+ 622010p 0.9
+ 624000p 0.9
+ 624010p -0.3
+ 626000p -0.3
+ 626010p 0.9
+ 628000p 0.9
+ 628010p -0.3
+ 630000p -0.3
+ 630010p 0.9
+ 632000p 0.9
+ 632010p -0.3
+ 634000p -0.3
+ 634010p 0.9
+ 636000p 0.9
+ 636010p -0.3
+ 638000p -0.3
+ 638010p 0.9
+ 640000p 0.9
+ 640010p -0.3
+ 642000p -0.3
+ 642010p 0.9
+ 644000p 0.9
+ 644010p -0.3
+ 646000p -0.3
+ 646010p 0.9
+ 648000p 0.9
+ 648010p -0.3
+ 650000p -0.3
+ 650010p 0.9
+ 652000p 0.9
+ 652010p -0.3
+ 654000p -0.3
+ 654010p 0.9
+ 656000p 0.9
+ 656010p -0.3
+ 658000p -0.3
+ 658010p 0.9
+ 660000p 0.9
+ 660010p -0.3
+ 662000p -0.3
+ 662010p 0.9
+ 664000p 0.9
+ 664010p -0.3
+ 666000p -0.3
+ 666010p 0.9
+ 668000p 0.9
+ 668010p -0.3
+ 670000p -0.3
+ 670010p 0.9
+ 672000p 0.9
+ 672010p -0.3
+ 674000p -0.3
+ 674010p 0.9
+ 676000p 0.9
+ 676010p -0.3
+ 678000p -0.3
+ 678010p 0.9
+ 680000p 0.9
+ 680010p -0.3
+ 682000p -0.3
+ 682010p 0.9
+ 684000p 0.9
+ 684010p -0.3
+ 686000p -0.3
+ 686010p 0.9
+ 688000p 0.9
+ 688010p -0.3
+ 690000p -0.3
+ 690010p 0.9
+ 692000p 0.9
+ 692010p -0.3
+ 694000p -0.3
+ 694010p 0.9
+ 696000p 0.9
+ 696010p -0.3
+ 698000p -0.3
+ 698010p 0.9
+ 700000p 0.9
+ 700010p -0.3
+ 702000p -0.3
+ 702010p 0.9
+ 704000p 0.9
+ 704010p -0.3
+ 706000p -0.3
+ 706010p 0.9
+ 708000p 0.9
+ 708010p -0.3
+ 710000p -0.3
+ 710010p 0.9
+ 712000p 0.9
+ 712010p -0.3
+ 714000p -0.3
+ 714010p 0.9
+ 716000p 0.9
+ 716010p -0.3
+ 718000p -0.3
+ 718010p 0.9
+ 720000p 0.9
+ 720010p -0.3
+ 722000p -0.3
+ 722010p 0.9
+ 724000p 0.9
+ 724010p -0.3
+ 726000p -0.3
+ 726010p 0.9
+ 728000p 0.9
+ 728010p -0.3
+ 730000p -0.3
+ 730010p 0.9
+ 732000p 0.9
+ 732010p -0.3
+ 734000p -0.3
+ 734010p 0.9
+ 736000p 0.9
+ 736010p -0.3
+ 738000p -0.3
+ 738010p 0.9
+ 740000p 0.9
+ 740010p -0.3
+ 742000p -0.3
+ 742010p 0.9
+ 744000p 0.9
+ 744010p -0.3
+ 746000p -0.3
+ 746010p 0.9
+ 748000p 0.9
+ 748010p -0.3
+ 750000p -0.3
+ 750010p 0.9
+ 752000p 0.9
+ 752010p -0.3
+ 754000p -0.3
+ 754010p 0.9
+ 756000p 0.9
+ 756010p -0.3
+ 758000p -0.3
+ 758010p 0.9
+ 760000p 0.9
+ 760010p -0.3
+ 762000p -0.3
+ 762010p 0.9
+ 764000p 0.9
+ 764010p -0.3
+ 766000p -0.3
+ 766010p 0.9
+ 768000p 0.9
+ 768010p -0.3
+ 770000p -0.3
+ 770010p 0.9
+ 772000p 0.9
+ 772010p -0.3
+ 774000p -0.3
+ 774010p 0.9
+ 776000p 0.9
+ 776010p -0.3
+ 778000p -0.3
+ 778010p 0.9
+ 780000p 0.9
+ 780010p -0.3
+ 782000p -0.3
+ 782010p 0.9
+ 784000p 0.9
+ 784010p -0.3
+ 786000p -0.3
+ 786010p 0.9
+ 788000p 0.9
+ 788010p -0.3
+ 790000p -0.3
+ 790010p 0.9
+ 792000p 0.9
+ 792010p -0.3
+ 794000p -0.3
+ 794010p 0.9
+ 796000p 0.9
+ 796010p -0.3
+ 798000p -0.3
+ 798010p 0.9
+ 800000p 0.9
+ 800010p -0.3
+ 802000p -0.3
+ 802010p 0.9
+ 804000p 0.9
+ 804010p -0.3
+ 806000p -0.3
+ 806010p 0.9
+ 808000p 0.9
+ 808010p -0.3
+ 810000p -0.3
+ 810010p 0.9
+ 812000p 0.9
+ 812010p -0.3
+ 814000p -0.3
+ 814010p 0.9
+ 816000p 0.9
+ 816010p -0.3
+ 818000p -0.3
+ 818010p 0.9
+ 820000p 0.9
+ 820010p -0.3
+ 822000p -0.3
+ 822010p 0.9
+ 824000p 0.9
+ 824010p -0.3
+ 826000p -0.3
+ 826010p 0.9
+ 828000p 0.9
+ 828010p -0.3
+ 830000p -0.3
+ 830010p 0.9
+ 832000p 0.9
+ 832010p -0.3
+ 834000p -0.3
+ 834010p 0.9
+ 836000p 0.9
+ 836010p -0.3
+ 838000p -0.3
+ 838010p 0.9
+ 840000p 0.9
+ 840010p -0.3
+ 842000p -0.3
+ 842010p 0.9
+ 844000p 0.9
+ 844010p -0.3
+ 846000p -0.3
+ 846010p 0.9
+ 848000p 0.9
+ 848010p -0.3
+ 850000p -0.3
+ 850010p 0.9
+ 852000p 0.9
+ 852010p -0.3
+ 854000p -0.3
+ 854010p 0.9
+ 856000p 0.9
+ 856010p -0.3
+ 858000p -0.3
+ 858010p 0.9
+ 860000p 0.9
+ 860010p -0.3
+ 862000p -0.3
+ 862010p 0.9
+ 864000p 0.9
+ 864010p -0.3
+ 866000p -0.3
+ 866010p 0.9
+ 868000p 0.9
+ 868010p -0.3
+ 870000p -0.3
+ 870010p 0.9
+ 872000p 0.9
+ 872010p -0.3
+ 874000p -0.3
+ 874010p 0.9
+ 876000p 0.9
+ 876010p -0.3
+ 878000p -0.3
+ 878010p 0.9
+ 880000p 0.9
+ 880010p -0.3
+ 882000p -0.3
+ 882010p 0.9
+ 884000p 0.9
+ 884010p -0.3
+ 886000p -0.3
+ 886010p 0.9
+ 888000p 0.9
+ 888010p -0.3
+ 890000p -0.3
+ 890010p 0.9
+ 892000p 0.9
+ 892010p -0.3
+ 894000p -0.3
+ 894010p 0.9
+ 896000p 0.9
+ 896010p -0.3
+ 898000p -0.3
+ 898010p 0.9
+ 900000p 0.9
+ 900010p -0.3
+ 902000p -0.3
+ 902010p 0.9
+ 904000p 0.9
+ 904010p -0.3
+ 906000p -0.3
+ 906010p 0.9
+ 908000p 0.9
+ 908010p -0.3
+ 910000p -0.3
+ 910010p 0.9
+ 912000p 0.9
+ 912010p -0.3
+ 914000p -0.3
+ 914010p 0.9
+ 916000p 0.9
+ 916010p -0.3
+ 918000p -0.3
+ 918010p 0.9
+ 920000p 0.9
+ 920010p -0.3
+ 922000p -0.3
+ 922010p 0.9
+ 924000p 0.9
+ 924010p -0.3
+ 926000p -0.3
+ 926010p 0.9
+ 928000p 0.9
+ 928010p -0.3
+ 930000p -0.3
+ 930010p 0.9
+ 932000p 0.9
+ 932010p -0.3
+ 934000p -0.3
+ 934010p 0.9
+ 936000p 0.9
+ 936010p -0.3
+ 938000p -0.3
+ 938010p 0.9
+ 940000p 0.9
+ 940010p -0.3
+ 942000p -0.3
+ 942010p 0.9
+ 944000p 0.9
+ 944010p -0.3
+ 946000p -0.3
+ 946010p 0.9
+ 948000p 0.9
+ 948010p -0.3
+ 950000p -0.3
+ 950010p 0.9
+ 952000p 0.9
+ 952010p -0.3
+ 954000p -0.3
+ 954010p 0.9
+ 956000p 0.9
+ 956010p -0.3
+ 958000p -0.3
+ 958010p 0.9
+ 960000p 0.9
+ 960010p -0.3
+ 962000p -0.3
+ 962010p 0.9
+ 964000p 0.9
+ 964010p -0.3
+ 966000p -0.3
+ 966010p 0.9
+ 968000p 0.9
+ 968010p -0.3
+ 970000p -0.3
+ 970010p 0.9
+ 972000p 0.9
+ 972010p -0.3
+ 974000p -0.3
+ 974010p 0.9
+ 976000p 0.9
+ 976010p -0.3
+ 978000p -0.3
+ 978010p 0.9
+ 980000p 0.9
+ 980010p -0.3
+ 982000p -0.3
+ 982010p 0.9
+ 984000p 0.9
+ 984010p -0.3
+ 986000p -0.3
+ 986010p 0.9
+ 988000p 0.9
+ 988010p -0.3
+ 990000p -0.3
+ 990010p 0.9
+ 992000p 0.9
+ 992010p -0.3
+ 994000p -0.3
+ 994010p 0.9
+ 996000p 0.9
+ 996010p -0.3
+ 998000p -0.3
+ 998010p 0.9
+ 1000000p 0.9
+ 1000010p -0.3
+ 1002000p -0.3
+ 1002010p 0.9
+ 1004000p 0.9
+ 1004010p -0.3
+ 1006000p -0.3
+ 1006010p 0.9
+ 1008000p 0.9
+ 1008010p -0.3
+ 1010000p -0.3
+ 1010010p 0.9
+ 1012000p 0.9
+ 1012010p -0.3
+ 1014000p -0.3
+ 1014010p 0.9
+ 1016000p 0.9
+ 1016010p -0.3
+ 1018000p -0.3
+ 1018010p 0.9
+ 1020000p 0.9
+ 1020010p -0.3
+ 1022000p -0.3
+ 1022010p 0.9
+ 1024000p 0.9
+ 1024010p -0.3
+ 1026000p -0.3
+ 1026010p 0.9
+ 1028000p 0.9
+ 1028010p -0.3
+ 1030000p -0.3
+ 1030010p 0.9
+ 1032000p 0.9
+ 1032010p -0.3
+ 1034000p -0.3
+ 1034010p 0.9
+ 1036000p 0.9
+ 1036010p -0.3
+ 1038000p -0.3
+ 1038010p 0.9
+ 1040000p 0.9
+ 1040010p -0.3
+ 1042000p -0.3
+ 1042010p 0.9
+ 1044000p 0.9
+ 1044010p -0.3
+ 1046000p -0.3
+ 1046010p 0.9
+ 1048000p 0.9
+ 1048010p -0.3
+ 1050000p -0.3
+ 1050010p 0.9
+ 1052000p 0.9
+ 1052010p -0.3
+ 1054000p -0.3
+ 1054010p 0.9
+ 1056000p 0.9
+ 1056010p -0.3
+ 1058000p -0.3
+ 1058010p 0.9
+ 1060000p 0.9
+ 1060010p -0.3
+ 1062000p -0.3
+ 1062010p 0.9
+ 1064000p 0.9
+ 1064010p -0.3
+ 1066000p -0.3
+ 1066010p 0.9
+ 1068000p 0.9
+ 1068010p -0.3
+ 1070000p -0.3
+ 1070010p 0.9
+ 1072000p 0.9
+ 1072010p -0.3
+ 1074000p -0.3
+ 1074010p 0.9
+ 1076000p 0.9
+ 1076010p -0.3
+ 1078000p -0.3
+ 1078010p 0.9
+ 1080000p 0.9
+ 1080010p -0.3
+ 1082000p -0.3
+ 1082010p 0.9
+ 1084000p 0.9
+ 1084010p -0.3
+ 1086000p -0.3
+ 1086010p 0.9
+ 1088000p 0.9
+ 1088010p -0.3
+ 1090000p -0.3
+ 1090010p 0.9
+ 1092000p 0.9
+ 1092010p -0.3
+ 1094000p -0.3
+ 1094010p 0.9
+ 1096000p 0.9
+ 1096010p -0.3
+ 1098000p -0.3
+ 1098010p 0.9
+ 1100000p 0.9
+ 1100010p -0.3
+ 1102000p -0.3
+ 1102010p 0.9
+ 1104000p 0.9
+ 1104010p -0.3
+ 1106000p -0.3
+ 1106010p 0.9
+ 1108000p 0.9
+ 1108010p -0.3
+ 1110000p -0.3
+ 1110010p 0.9
+ 1112000p 0.9
+ 1112010p -0.3
+ 1114000p -0.3
+ 1114010p 0.9
+ 1116000p 0.9
+ 1116010p -0.3
+ 1118000p -0.3
+ 1118010p 0.9
+ 1120000p 0.9
+ 1120010p -0.3
+ 1122000p -0.3
+ 1122010p 0.9
+ 1124000p 0.9
+ 1124010p -0.3
+ 1126000p -0.3
+ 1126010p 0.9
+ 1128000p 0.9
+ 1128010p -0.3
+ 1130000p -0.3
+ 1130010p 0.9
+ 1132000p 0.9
+ 1132010p -0.3
+ 1134000p -0.3
+ 1134010p 0.9
+ 1136000p 0.9
+ 1136010p -0.3
+ 1138000p -0.3
+ 1138010p 0.9
+ 1140000p 0.9
+ 1140010p -0.3
+ 1142000p -0.3
+ 1142010p 0.9
+ 1144000p 0.9
+ 1144010p -0.3
+ 1146000p -0.3
+ 1146010p 0.9
+ 1148000p 0.9
+ 1148010p -0.3
+ 1150000p -0.3
+ 1150010p 0.9
+ 1152000p 0.9
+ 1152010p -0.3
+ 1154000p -0.3
+ 1154010p 0.9
+ 1156000p 0.9
+ 1156010p -0.3
+ 1158000p -0.3
+ 1158010p 0.9
+ 1160000p 0.9
+ 1160010p -0.3
+ 1162000p -0.3
+ 1162010p 0.9
+ 1164000p 0.9
+ 1164010p -0.3
+ 1166000p -0.3
+ 1166010p 0.9
+ 1168000p 0.9
+ 1168010p -0.3
+ 1170000p -0.3
+ 1170010p 0.9
+ 1172000p 0.9
+ 1172010p -0.3
+ 1174000p -0.3
+ 1174010p 0.9
+ 1176000p 0.9
+ 1176010p -0.3
+ 1178000p -0.3
+ 1178010p 0.9
+ 1180000p 0.9
+ 1180010p -0.3
+ 1182000p -0.3
+ 1182010p 0.9
+ 1184000p 0.9
+ 1184010p -0.3
+ 1186000p -0.3
+ 1186010p 0.9
+ 1188000p 0.9
+ 1188010p -0.3
+ 1190000p -0.3
+ 1190010p 0.9
+ 1192000p 0.9
+ 1192010p -0.3
+ 1194000p -0.3
+ 1194010p 0.9
+ 1196000p 0.9
+ 1196010p -0.3
+ 1198000p -0.3
+ 1198010p 0.9
+ 1200000p 0.9
+ 1200010p -0.3
+ 1202000p -0.3
+ 1202010p 0.9
+ 1204000p 0.9
+ 1204010p -0.3
+ 1206000p -0.3
+ 1206010p 0.9
+ 1208000p 0.9
+ 1208010p -0.3
+ 1210000p -0.3
+ 1210010p 0.9
+ 1212000p 0.9
+ 1212010p -0.3
+ 1214000p -0.3
+ 1214010p 0.9
+ 1216000p 0.9
+ 1216010p -0.3
+ 1218000p -0.3
+ 1218010p 0.9
+ 1220000p 0.9
+ 1220010p -0.3
+ 1222000p -0.3
+ 1222010p 0.9
+ 1224000p 0.9
+ 1224010p -0.3
+ 1226000p -0.3
+ 1226010p 0.9
+ 1228000p 0.9
+ 1228010p -0.3
+ 1230000p -0.3
+ 1230010p 0.9
+ 1232000p 0.9
+ 1232010p -0.3
+ 1234000p -0.3
+ 1234010p 0.9
+ 1236000p 0.9
+ 1236010p -0.3
+ 1238000p -0.3
+ 1238010p 0.9
+ 1240000p 0.9
+ 1240010p -0.3
+ 1242000p -0.3
+ 1242010p 0.9
+ 1244000p 0.9
+ 1244010p -0.3
+ 1246000p -0.3
+ 1246010p 0.9
+ 1248000p 0.9
+ 1248010p -0.3
+ 1250000p -0.3
+ 1250010p 0.9
+ 1252000p 0.9
+ 1252010p -0.3
+ 1254000p -0.3
+ 1254010p 0.9
+ 1256000p 0.9
+ 1256010p -0.3
+ 1258000p -0.3
+ 1258010p 0.9
+ 1260000p 0.9
+ 1260010p -0.3
+ 1262000p -0.3
+ 1262010p 0.9
+ 1264000p 0.9
+ 1264010p -0.3
+ 1266000p -0.3
+ 1266010p 0.9
+ 1268000p 0.9
+ 1268010p -0.3
+ 1270000p -0.3
+ 1270010p 0.9
+ 1272000p 0.9
+ 1272010p -0.3
+ 1274000p -0.3
+ 1274010p 0.9
+ 1276000p 0.9
+ 1276010p -0.3
+ 1278000p -0.3
+ 1278010p 0.9
+ 1280000p 0.9
+ 1280010p -0.3
+ 1282000p -0.3
+ 1282010p 0.9
+ 1284000p 0.9
+ 1284010p -0.3
+ 1286000p -0.3
+ 1286010p 0.9
+ 1288000p 0.9
+ 1288010p -0.3
+ 1290000p -0.3
+ 1290010p 0.9
+ 1292000p 0.9
+ 1292010p -0.3
+ 1294000p -0.3
+ 1294010p 0.9
+ 1296000p 0.9
+ 1296010p -0.3
+ 1298000p -0.3
+ 1298010p 0.9
+ 1300000p 0.9
+ 1300010p -0.3
+ 1302000p -0.3
+ 1302010p 0.9
+ 1304000p 0.9
+ 1304010p -0.3
+ 1306000p -0.3
+ 1306010p 0.9
+ 1308000p 0.9
+ 1308010p -0.3
+ 1310000p -0.3
+ 1310010p 0.9
+ 1312000p 0.9
+ 1312010p -0.3
+ 1314000p -0.3
+ 1314010p 0.9
+ 1316000p 0.9
+ 1316010p -0.3
+ 1318000p -0.3
+ 1318010p 0.9
+ 1320000p 0.9
+ 1320010p -0.3
+ 1322000p -0.3
+ 1322010p 0.9
+ 1324000p 0.9
+ 1324010p -0.3
+ 1326000p -0.3
+ 1326010p 0.9
+ 1328000p 0.9
+ 1328010p -0.3
+ 1330000p -0.3
+ 1330010p 0.9
+ 1332000p 0.9
+ 1332010p -0.3
+ 1334000p -0.3
+ 1334010p 0.9
+ 1336000p 0.9
+ 1336010p -0.3
+ 1338000p -0.3
+ 1338010p 0.9
+ 1340000p 0.9
+ 1340010p -0.3
+ 1342000p -0.3
+ 1342010p 0.9
+ 1344000p 0.9
+ 1344010p -0.3
+ 1346000p -0.3
+ 1346010p 0.9
+ 1348000p 0.9
+ 1348010p -0.3
+ 1350000p -0.3
+ 1350010p 0.9
+ 1352000p 0.9
+ 1352010p -0.3
+ 1354000p -0.3
+ 1354010p 0.9
+ 1356000p 0.9
+ 1356010p -0.3
+ 1358000p -0.3
+ 1358010p 0.9
+ 1360000p 0.9
+ 1360010p -0.3
+ 1362000p -0.3
+ 1362010p 0.9
+ 1364000p 0.9
+ 1364010p -0.3
+ 1366000p -0.3
+ 1366010p 0.9
+ 1368000p 0.9
+ 1368010p -0.3
+ 1370000p -0.3
+ 1370010p 0.9
+ 1372000p 0.9
+ 1372010p -0.3
+ 1374000p -0.3
+ 1374010p 0.9
+ 1376000p 0.9
+ 1376010p -0.3
+ 1378000p -0.3
+ 1378010p 0.9
+ 1380000p 0.9
+ 1380010p -0.3
+ 1382000p -0.3
+ 1382010p 0.9
+ 1384000p 0.9
+ 1384010p -0.3
+ 1386000p -0.3
+ 1386010p 0.9
+ 1388000p 0.9
+ 1388010p -0.3
+ 1390000p -0.3
+ 1390010p 0.9
+ 1392000p 0.9
+ 1392010p -0.3
+ 1394000p -0.3
+ 1394010p 0.9
+ 1396000p 0.9
+ 1396010p -0.3
+ 1398000p -0.3
+ 1398010p 0.9
+ 1400000p 0.9
+ 1400010p -0.3
+ 1402000p -0.3
+ 1402010p 0.9
+ 1404000p 0.9
+ 1404010p -0.3
+ 1406000p -0.3
+ 1406010p 0.9
+ 1408000p 0.9
+ 1408010p -0.3
+ 1410000p -0.3
+ 1410010p 0.9
+ 1412000p 0.9
+ 1412010p -0.3
+ 1414000p -0.3
+ 1414010p 0.9
+ 1416000p 0.9
+ 1416010p -0.3
+ 1418000p -0.3
+ 1418010p 0.9
+ 1420000p 0.9
+ 1420010p -0.3
+ 1422000p -0.3
+ 1422010p 0.9
+ 1424000p 0.9
+ 1424010p -0.3
+ 1426000p -0.3
+ 1426010p 0.9
+ 1428000p 0.9
+ 1428010p -0.3
+ 1430000p -0.3
+ 1430010p 0.9
+ 1432000p 0.9
+ 1432010p -0.3
+ 1434000p -0.3
+ 1434010p 0.9
+ 1436000p 0.9
+ 1436010p -0.3
+ 1438000p -0.3
+ 1438010p 0.9
+ 1440000p 0.9
+ 1440010p -0.3
+ 1442000p -0.3
+ 1442010p 0.9
+ 1444000p 0.9
+ 1444010p -0.3
+ 1446000p -0.3
+ 1446010p 0.9
+ 1448000p 0.9
+ 1448010p -0.3
+ 1450000p -0.3
+ 1450010p 0.9
+ 1452000p 0.9
+ 1452010p -0.3
+ 1454000p -0.3
+ 1454010p 0.9
+ 1456000p 0.9
+ 1456010p -0.3
+ 1458000p -0.3
+ 1458010p 0.9
+ 1460000p 0.9
+ 1460010p -0.3
+ 1462000p -0.3
+ 1462010p 0.9
+ 1464000p 0.9
+ 1464010p -0.3
+ 1466000p -0.3
+ 1466010p 0.9
+ 1468000p 0.9
+ 1468010p -0.3
+ 1470000p -0.3
+ 1470010p 0.9
+ 1472000p 0.9
+ 1472010p -0.3
+ 1474000p -0.3
+ 1474010p 0.9
+ 1476000p 0.9
+ 1476010p -0.3
+ 1478000p -0.3
+ 1478010p 0.9
+ 1480000p 0.9
+ 1480010p -0.3
+ 1482000p -0.3
+ 1482010p 0.9
+ 1484000p 0.9
+ 1484010p -0.3
+ 1486000p -0.3
+ 1486010p 0.9
+ 1488000p 0.9
+ 1488010p -0.3
+ 1490000p -0.3
+ 1490010p 0.9
+ 1492000p 0.9
+ 1492010p -0.3
+ 1494000p -0.3
+ 1494010p 0.9
+ 1496000p 0.9
+ 1496010p -0.3
+ 1498000p -0.3
+ 1498010p 0.9
+ 1500000p 0.9
+ 1500010p -0.3
+ 1502000p -0.3
+ 1502010p 0.9
+ 1504000p 0.9
+ 1504010p -0.3
+ 1506000p -0.3
+ 1506010p 0.9
+ 1508000p 0.9
+ 1508010p -0.3
+ 1510000p -0.3
+ 1510010p 0.9
+ 1512000p 0.9
+ 1512010p -0.3
+ 1514000p -0.3
+ 1514010p 0.9
+ 1516000p 0.9
+ 1516010p -0.3
+ 1518000p -0.3
+ 1518010p 0.9
+ 1520000p 0.9
+ 1520010p -0.3
+ 1522000p -0.3
+ 1522010p 0.9
+ 1524000p 0.9
+ 1524010p -0.3
+ 1526000p -0.3
+ 1526010p 0.9
+ 1528000p 0.9
+ 1528010p -0.3
+ 1530000p -0.3
+ 1530010p 0.9
+ 1532000p 0.9
+ 1532010p -0.3
+ 1534000p -0.3
+ 1534010p 0.9
+ 1536000p 0.9
+ 1536010p -0.3
+ 1538000p -0.3
+ 1538010p 0.9
+ 1540000p 0.9
+ 1540010p -0.3
+ 1542000p -0.3
+ 1542010p 0.9
+ 1544000p 0.9
+ 1544010p -0.3
+ 1546000p -0.3
+ 1546010p 0.9
+ 1548000p 0.9
+ 1548010p -0.3
+ 1550000p -0.3
+ 1550010p 0.9
+ 1552000p 0.9
+ 1552010p -0.3
+ 1554000p -0.3
+ 1554010p 0.9
+ 1556000p 0.9
+ 1556010p -0.3
+ 1558000p -0.3
+ 1558010p 0.9
+ 1560000p 0.9
+ 1560010p -0.3
+ 1562000p -0.3
+ 1562010p 0.9
+ 1564000p 0.9
+ 1564010p -0.3
+ 1566000p -0.3
+ 1566010p 0.9
+ 1568000p 0.9
+ 1568010p -0.3
+ 1570000p -0.3
+ 1570010p 0.9
+ 1572000p 0.9
+ 1572010p -0.3
+ 1574000p -0.3
+ 1574010p 0.9
+ 1576000p 0.9
+ 1576010p -0.3
+ 1578000p -0.3
+ 1578010p 0.9
+ 1580000p 0.9
+ 1580010p -0.3
+ 1582000p -0.3
+ 1582010p 0.9
+ 1584000p 0.9
+ 1584010p -0.3
+ 1586000p -0.3
+ 1586010p 0.9
+ 1588000p 0.9
+ 1588010p -0.3
+ 1590000p -0.3
+ 1590010p 0.9
+ 1592000p 0.9
+ 1592010p -0.3
+ 1594000p -0.3
+ 1594010p 0.9
+ 1596000p 0.9
+ 1596010p -0.3
+ 1598000p -0.3
+ 1598010p 0.9
+ 1600000p 0.9
+ 1600010p -0.3
+ 1602000p -0.3
+ 1602010p 0.9
+ 1604000p 0.9
+ 1604010p -0.3
+ 1606000p -0.3
+ 1606010p 0.9
+ 1608000p 0.9
+ 1608010p -0.3
+ 1610000p -0.3
+ 1610010p 0.9
+ 1612000p 0.9
+ 1612010p -0.3
+ 1614000p -0.3
+ 1614010p 0.9
+ 1616000p 0.9
+ 1616010p -0.3
+ 1618000p -0.3
+ 1618010p 0.9
+ 1620000p 0.9
+ 1620010p -0.3
+ 1622000p -0.3
+ 1622010p 0.9
+ 1624000p 0.9
+ 1624010p -0.3
+ 1626000p -0.3
+ 1626010p 0.9
+ 1628000p 0.9
+ 1628010p -0.3
+ 1630000p -0.3
+ 1630010p 0.9
+ 1632000p 0.9
+ 1632010p -0.3
+ 1634000p -0.3
+ 1634010p 0.9
+ 1636000p 0.9
+ 1636010p -0.3
+ 1638000p -0.3
+ 1638010p 0.9
+ 1640000p 0.9
+ 1640010p -0.3
+ 1642000p -0.3
+ 1642010p 0.9
+ 1644000p 0.9
+ 1644010p -0.3
+ 1646000p -0.3
+ 1646010p 0.9
+ 1648000p 0.9
+ 1648010p -0.3
+ 1650000p -0.3
+ 1650010p 0.9
+ 1652000p 0.9
+ 1652010p -0.3
+ 1654000p -0.3
+ 1654010p 0.9
+ 1656000p 0.9
+ 1656010p -0.3
+ 1658000p -0.3
+ 1658010p 0.9
+ 1660000p 0.9
+ 1660010p -0.3
+ 1662000p -0.3
+ 1662010p 0.9
+ 1664000p 0.9
+ 1664010p -0.3
+ 1666000p -0.3
+ 1666010p 0.9
+ 1668000p 0.9
+ 1668010p -0.3
+ 1670000p -0.3
+ 1670010p 0.9
+ 1672000p 0.9
+ 1672010p -0.3
+ 1674000p -0.3
+ 1674010p 0.9
+ 1676000p 0.9
+ 1676010p -0.3
+ 1678000p -0.3
+ 1678010p 0.9
+ 1680000p 0.9
+ 1680010p -0.3
+ 1682000p -0.3
+ 1682010p 0.9
+ 1684000p 0.9
+ 1684010p -0.3
+ 1686000p -0.3
+ 1686010p 0.9
+ 1688000p 0.9
+ 1688010p -0.3
+ 1690000p -0.3
+ 1690010p 0.9
+ 1692000p 0.9
+ 1692010p -0.3
+ 1694000p -0.3
+ 1694010p 0.9
+ 1696000p 0.9
+ 1696010p -0.3
+ 1698000p -0.3
+ 1698010p 0.9
+ 1700000p 0.9
+ 1700010p -0.3
+ 1702000p -0.3
+ 1702010p 0.9
+ 1704000p 0.9
+ 1704010p -0.3
+ 1706000p -0.3
+ 1706010p 0.9
+ 1708000p 0.9
+ 1708010p -0.3
+ 1710000p -0.3
+ 1710010p 0.9
+ 1712000p 0.9
+ 1712010p -0.3
+ 1714000p -0.3
+ 1714010p 0.9
+ 1716000p 0.9
+ 1716010p -0.3
+ 1718000p -0.3
+ 1718010p 0.9
+ 1720000p 0.9
+ 1720010p -0.3
+ 1722000p -0.3
+ 1722010p 0.9
+ 1724000p 0.9
+ 1724010p -0.3
+ 1726000p -0.3
+ 1726010p 0.9
+ 1728000p 0.9
+ 1728010p -0.3
+ 1730000p -0.3
+ 1730010p 0.9
+ 1732000p 0.9
+ 1732010p -0.3
+ 1734000p -0.3
+ 1734010p 0.9
+ 1736000p 0.9
+ 1736010p -0.3
+ 1738000p -0.3
+ 1738010p 0.9
+ 1740000p 0.9
+ 1740010p -0.3
+ 1742000p -0.3
+ 1742010p 0.9
+ 1744000p 0.9
+ 1744010p -0.3
+ 1746000p -0.3
+ 1746010p 0.9
+ 1748000p 0.9
+ 1748010p -0.3
+ 1750000p -0.3
+ 1750010p 0.9
+ 1752000p 0.9
+ 1752010p -0.3
+ 1754000p -0.3
+ 1754010p 0.9
+ 1756000p 0.9
+ 1756010p -0.3
+ 1758000p -0.3
+ 1758010p 0.9
+ 1760000p 0.9
+ 1760010p -0.3
+ 1762000p -0.3
+ 1762010p 0.9
+ 1764000p 0.9
+ 1764010p -0.3
+ 1766000p -0.3
+ 1766010p 0.9
+ 1768000p 0.9
+ 1768010p -0.3
+ 1770000p -0.3
+ 1770010p 0.9
+ 1772000p 0.9
+ 1772010p -0.3
+ 1774000p -0.3
+ 1774010p 0.9
+ 1776000p 0.9
+ 1776010p -0.3
+ 1778000p -0.3
+ 1778010p 0.9
+ 1780000p 0.9
+ 1780010p -0.3
+ 1782000p -0.3
+ 1782010p 0.9
+ 1784000p 0.9
+ 1784010p -0.3
+ 1786000p -0.3
+ 1786010p 0.9
+ 1788000p 0.9
+ 1788010p -0.3
+ 1790000p -0.3
+ 1790010p 0.9
+ 1792000p 0.9
+ 1792010p -0.3
+ 1794000p -0.3
+ 1794010p 0.9
+ 1796000p 0.9
+ 1796010p -0.3
+ 1798000p -0.3
+ 1798010p 0.9
+ 1800000p 0.9
+ 1800010p -0.3
+ 1802000p -0.3
+ 1802010p 0.9
+ 1804000p 0.9
+ 1804010p -0.3
+ 1806000p -0.3
+ 1806010p 0.9
+ 1808000p 0.9
+ 1808010p -0.3
+ 1810000p -0.3
+ 1810010p 0.9
+ 1812000p 0.9
+ 1812010p -0.3
+ 1814000p -0.3
+ 1814010p 0.9
+ 1816000p 0.9
+ 1816010p -0.3
+ 1818000p -0.3
+ 1818010p 0.9
+ 1820000p 0.9
+ 1820010p -0.3
+ 1822000p -0.3
+ 1822010p 0.9
+ 1824000p 0.9
+ 1824010p -0.3
+ 1826000p -0.3
+ 1826010p 0.9
+ 1828000p 0.9
+ 1828010p -0.3
+ 1830000p -0.3
+ 1830010p 0.9
+ 1832000p 0.9
+ 1832010p -0.3
+ 1834000p -0.3
+ 1834010p 0.9
+ 1836000p 0.9
+ 1836010p -0.3
+ 1838000p -0.3
+ 1838010p 0.9
+ 1840000p 0.9
+ 1840010p -0.3
+ 1842000p -0.3
+ 1842010p 0.9
+ 1844000p 0.9
+ 1844010p -0.3
+ 1846000p -0.3
+ 1846010p 0.9
+ 1848000p 0.9
+ 1848010p -0.3
+ 1850000p -0.3
+ 1850010p 0.9
+ 1852000p 0.9
+ 1852010p -0.3
+ 1854000p -0.3
+ 1854010p 0.9
+ 1856000p 0.9
+ 1856010p -0.3
+ 1858000p -0.3
+ 1858010p 0.9
+ 1860000p 0.9
+ 1860010p -0.3
+ 1862000p -0.3
+ 1862010p 0.9
+ 1864000p 0.9
+ 1864010p -0.3
+ 1866000p -0.3
+ 1866010p 0.9
+ 1868000p 0.9
+ 1868010p -0.3
+ 1870000p -0.3
+ 1870010p 0.9
+ 1872000p 0.9
+ 1872010p -0.3
+ 1874000p -0.3
+ 1874010p 0.9
+ 1876000p 0.9
+ 1876010p -0.3
+ 1878000p -0.3
+ 1878010p 0.9
+ 1880000p 0.9
+ 1880010p -0.3
+ 1882000p -0.3
+ 1882010p 0.9
+ 1884000p 0.9
+ 1884010p -0.3
+ 1886000p -0.3
+ 1886010p 0.9
+ 1888000p 0.9
+ 1888010p -0.3
+ 1890000p -0.3
+ 1890010p 0.9
+ 1892000p 0.9
+ 1892010p -0.3
+ 1894000p -0.3
+ 1894010p 0.9
+ 1896000p 0.9
+ 1896010p -0.3
+ 1898000p -0.3
+ 1898010p 0.9
+ 1900000p 0.9
+ 1900010p -0.3
+ 1902000p -0.3
+ 1902010p 0.9
+ 1904000p 0.9
+ 1904010p -0.3
+ 1906000p -0.3
+ 1906010p 0.9
+ 1908000p 0.9
+ 1908010p -0.3
+ 1910000p -0.3
+ 1910010p 0.9
+ 1912000p 0.9
+ 1912010p -0.3
+ 1914000p -0.3
+ 1914010p 0.9
+ 1916000p 0.9
+ 1916010p -0.3
+ 1918000p -0.3
+ 1918010p 0.9
+ 1920000p 0.9
+ 1920010p -0.3
+ 1922000p -0.3
+ 1922010p 0.9
+ 1924000p 0.9
+ 1924010p -0.3
+ 1926000p -0.3
+ 1926010p 0.9
+ 1928000p 0.9
+ 1928010p -0.3
+ 1930000p -0.3
+ 1930010p 0.9
+ 1932000p 0.9
+ 1932010p -0.3
+ 1934000p -0.3
+ 1934010p 0.9
+ 1936000p 0.9
+ 1936010p -0.3
+ 1938000p -0.3
+ 1938010p 0.9
+ 1940000p 0.9
+ 1940010p -0.3
+ 1942000p -0.3
+ 1942010p 0.9
+ 1944000p 0.9
+ 1944010p -0.3
+ 1946000p -0.3
+ 1946010p 0.9
+ 1948000p 0.9
+ 1948010p -0.3
+ 1950000p -0.3
+ 1950010p 0.9
+ 1952000p 0.9
+ 1952010p -0.3
+ 1954000p -0.3
+ 1954010p 0.9
+ 1956000p 0.9
+ 1956010p -0.3
+ 1958000p -0.3
+ 1958010p 0.9
+ 1960000p 0.9
+ 1960010p -0.3
+ 1962000p -0.3
+ 1962010p 0.9
+ 1964000p 0.9
+ 1964010p -0.3
+ 1966000p -0.3
+ 1966010p 0.9
+ 1968000p 0.9
+ 1968010p -0.3
+ 1970000p -0.3
+ 1970010p 0.9
+ 1972000p 0.9
+ 1972010p -0.3
+ 1974000p -0.3
+ 1974010p 0.9
+ 1976000p 0.9
+ 1976010p -0.3
+ 1978000p -0.3
+ 1978010p 0.9
+ 1980000p 0.9
+ 1980010p -0.3
+ 1982000p -0.3
+ 1982010p 0.9
+ 1984000p 0.9
+ 1984010p -0.3
+ 1986000p -0.3
+ 1986010p 0.9
+ 1988000p 0.9
+ 1988010p -0.3
+ 1990000p -0.3
+ 1990010p 0.9
+ 1992000p 0.9
+ 1992010p -0.3
+ 1994000p -0.3
+ 1994010p 0.9
+ 1996000p 0.9
+ 1996010p -0.3
+ 1998000p -0.3
+ 1998010p 0.9
+ 2000000p 0.9
+ 2000010p -0.3
+ 2002000p -0.3
+ 2002010p 0.9
+ 2004000p 0.9
+ 2004010p -0.3
+ 2006000p -0.3
+ 2006010p 0.9
+ 2008000p 0.9
+ 2008010p -0.3
+ 2010000p -0.3
+ 2010010p 0.9
+ 2012000p 0.9
+ 2012010p -0.3
+ 2014000p -0.3
+ 2014010p 0.9
+ 2016000p 0.9
+ 2016010p -0.3
+ 2018000p -0.3
+ 2018010p 0.9
+ 2020000p 0.9
+ 2020010p -0.3
+ 2022000p -0.3
+ 2022010p 0.9
+ 2024000p 0.9
+ 2024010p -0.3
+ 2026000p -0.3
+ 2026010p 0.9
+ 2028000p 0.9
+ 2028010p -0.3
+ 2030000p -0.3
+ 2030010p 0.9
+ 2032000p 0.9
+ 2032010p -0.3
+ 2034000p -0.3
+ 2034010p 0.9
+ 2036000p 0.9
+ 2036010p -0.3
+ 2038000p -0.3
+ 2038010p 0.9
+ 2040000p 0.9
+ 2040010p -0.3
+ 2042000p -0.3
+ 2042010p 0.9
+ 2044000p 0.9
+ 2044010p -0.3
+ 2046000p -0.3
+ 2046010p 0.9
+ 2048000p 0.9
+ 2048010p -0.3
+ \]
V_data_12 (Data\\<12\\> gnd!) vsource type=pwl wave=\[
+ 0    0.9
+ 2000p 0.9
+ 2010p -0.3
+ 4000p -0.3
+ 4010p 0.9
+ 6000p 0.9
+ 6010p -0.3
+ 8000p -0.3
+ 8010p 0.9
+ 10000p 0.9
+ 10010p -0.3
+ 12000p -0.3
+ 12010p 0.9
+ 14000p 0.9
+ 14010p -0.3
+ 16000p -0.3
+ 16010p 0.9
+ 18000p 0.9
+ 18010p -0.3
+ 20000p -0.3
+ 20010p 0.9
+ 22000p 0.9
+ 22010p -0.3
+ 24000p -0.3
+ 24010p 0.9
+ 26000p 0.9
+ 26010p -0.3
+ 28000p -0.3
+ 28010p 0.9
+ 30000p 0.9
+ 30010p -0.3
+ 32000p -0.3
+ 32010p 0.9
+ 34000p 0.9
+ 34010p -0.3
+ 36000p -0.3
+ 36010p 0.9
+ 38000p 0.9
+ 38010p -0.3
+ 40000p -0.3
+ 40010p 0.9
+ 42000p 0.9
+ 42010p -0.3
+ 44000p -0.3
+ 44010p 0.9
+ 46000p 0.9
+ 46010p -0.3
+ 48000p -0.3
+ 48010p 0.9
+ 50000p 0.9
+ 50010p -0.3
+ 52000p -0.3
+ 52010p 0.9
+ 54000p 0.9
+ 54010p -0.3
+ 56000p -0.3
+ 56010p 0.9
+ 58000p 0.9
+ 58010p -0.3
+ 60000p -0.3
+ 60010p 0.9
+ 62000p 0.9
+ 62010p -0.3
+ 64000p -0.3
+ 64010p 0.9
+ 66000p 0.9
+ 66010p -0.3
+ 68000p -0.3
+ 68010p 0.9
+ 70000p 0.9
+ 70010p -0.3
+ 72000p -0.3
+ 72010p 0.9
+ 74000p 0.9
+ 74010p -0.3
+ 76000p -0.3
+ 76010p 0.9
+ 78000p 0.9
+ 78010p -0.3
+ 80000p -0.3
+ 80010p 0.9
+ 82000p 0.9
+ 82010p -0.3
+ 84000p -0.3
+ 84010p 0.9
+ 86000p 0.9
+ 86010p -0.3
+ 88000p -0.3
+ 88010p 0.9
+ 90000p 0.9
+ 90010p -0.3
+ 92000p -0.3
+ 92010p 0.9
+ 94000p 0.9
+ 94010p -0.3
+ 96000p -0.3
+ 96010p 0.9
+ 98000p 0.9
+ 98010p -0.3
+ 100000p -0.3
+ 100010p 0.9
+ 102000p 0.9
+ 102010p -0.3
+ 104000p -0.3
+ 104010p 0.9
+ 106000p 0.9
+ 106010p -0.3
+ 108000p -0.3
+ 108010p 0.9
+ 110000p 0.9
+ 110010p -0.3
+ 112000p -0.3
+ 112010p 0.9
+ 114000p 0.9
+ 114010p -0.3
+ 116000p -0.3
+ 116010p 0.9
+ 118000p 0.9
+ 118010p -0.3
+ 120000p -0.3
+ 120010p 0.9
+ 122000p 0.9
+ 122010p -0.3
+ 124000p -0.3
+ 124010p 0.9
+ 126000p 0.9
+ 126010p -0.3
+ 128000p -0.3
+ 128010p 0.9
+ 130000p 0.9
+ 130010p -0.3
+ 132000p -0.3
+ 132010p 0.9
+ 134000p 0.9
+ 134010p -0.3
+ 136000p -0.3
+ 136010p 0.9
+ 138000p 0.9
+ 138010p -0.3
+ 140000p -0.3
+ 140010p 0.9
+ 142000p 0.9
+ 142010p -0.3
+ 144000p -0.3
+ 144010p 0.9
+ 146000p 0.9
+ 146010p -0.3
+ 148000p -0.3
+ 148010p 0.9
+ 150000p 0.9
+ 150010p -0.3
+ 152000p -0.3
+ 152010p 0.9
+ 154000p 0.9
+ 154010p -0.3
+ 156000p -0.3
+ 156010p 0.9
+ 158000p 0.9
+ 158010p -0.3
+ 160000p -0.3
+ 160010p 0.9
+ 162000p 0.9
+ 162010p -0.3
+ 164000p -0.3
+ 164010p 0.9
+ 166000p 0.9
+ 166010p -0.3
+ 168000p -0.3
+ 168010p 0.9
+ 170000p 0.9
+ 170010p -0.3
+ 172000p -0.3
+ 172010p 0.9
+ 174000p 0.9
+ 174010p -0.3
+ 176000p -0.3
+ 176010p 0.9
+ 178000p 0.9
+ 178010p -0.3
+ 180000p -0.3
+ 180010p 0.9
+ 182000p 0.9
+ 182010p -0.3
+ 184000p -0.3
+ 184010p 0.9
+ 186000p 0.9
+ 186010p -0.3
+ 188000p -0.3
+ 188010p 0.9
+ 190000p 0.9
+ 190010p -0.3
+ 192000p -0.3
+ 192010p 0.9
+ 194000p 0.9
+ 194010p -0.3
+ 196000p -0.3
+ 196010p 0.9
+ 198000p 0.9
+ 198010p -0.3
+ 200000p -0.3
+ 200010p 0.9
+ 202000p 0.9
+ 202010p -0.3
+ 204000p -0.3
+ 204010p 0.9
+ 206000p 0.9
+ 206010p -0.3
+ 208000p -0.3
+ 208010p 0.9
+ 210000p 0.9
+ 210010p -0.3
+ 212000p -0.3
+ 212010p 0.9
+ 214000p 0.9
+ 214010p -0.3
+ 216000p -0.3
+ 216010p 0.9
+ 218000p 0.9
+ 218010p -0.3
+ 220000p -0.3
+ 220010p 0.9
+ 222000p 0.9
+ 222010p -0.3
+ 224000p -0.3
+ 224010p 0.9
+ 226000p 0.9
+ 226010p -0.3
+ 228000p -0.3
+ 228010p 0.9
+ 230000p 0.9
+ 230010p -0.3
+ 232000p -0.3
+ 232010p 0.9
+ 234000p 0.9
+ 234010p -0.3
+ 236000p -0.3
+ 236010p 0.9
+ 238000p 0.9
+ 238010p -0.3
+ 240000p -0.3
+ 240010p 0.9
+ 242000p 0.9
+ 242010p -0.3
+ 244000p -0.3
+ 244010p 0.9
+ 246000p 0.9
+ 246010p -0.3
+ 248000p -0.3
+ 248010p 0.9
+ 250000p 0.9
+ 250010p -0.3
+ 252000p -0.3
+ 252010p 0.9
+ 254000p 0.9
+ 254010p -0.3
+ 256000p -0.3
+ 256010p 0.9
+ 258000p 0.9
+ 258010p -0.3
+ 260000p -0.3
+ 260010p 0.9
+ 262000p 0.9
+ 262010p -0.3
+ 264000p -0.3
+ 264010p 0.9
+ 266000p 0.9
+ 266010p -0.3
+ 268000p -0.3
+ 268010p 0.9
+ 270000p 0.9
+ 270010p -0.3
+ 272000p -0.3
+ 272010p 0.9
+ 274000p 0.9
+ 274010p -0.3
+ 276000p -0.3
+ 276010p 0.9
+ 278000p 0.9
+ 278010p -0.3
+ 280000p -0.3
+ 280010p 0.9
+ 282000p 0.9
+ 282010p -0.3
+ 284000p -0.3
+ 284010p 0.9
+ 286000p 0.9
+ 286010p -0.3
+ 288000p -0.3
+ 288010p 0.9
+ 290000p 0.9
+ 290010p -0.3
+ 292000p -0.3
+ 292010p 0.9
+ 294000p 0.9
+ 294010p -0.3
+ 296000p -0.3
+ 296010p 0.9
+ 298000p 0.9
+ 298010p -0.3
+ 300000p -0.3
+ 300010p 0.9
+ 302000p 0.9
+ 302010p -0.3
+ 304000p -0.3
+ 304010p 0.9
+ 306000p 0.9
+ 306010p -0.3
+ 308000p -0.3
+ 308010p 0.9
+ 310000p 0.9
+ 310010p -0.3
+ 312000p -0.3
+ 312010p 0.9
+ 314000p 0.9
+ 314010p -0.3
+ 316000p -0.3
+ 316010p 0.9
+ 318000p 0.9
+ 318010p -0.3
+ 320000p -0.3
+ 320010p 0.9
+ 322000p 0.9
+ 322010p -0.3
+ 324000p -0.3
+ 324010p 0.9
+ 326000p 0.9
+ 326010p -0.3
+ 328000p -0.3
+ 328010p 0.9
+ 330000p 0.9
+ 330010p -0.3
+ 332000p -0.3
+ 332010p 0.9
+ 334000p 0.9
+ 334010p -0.3
+ 336000p -0.3
+ 336010p 0.9
+ 338000p 0.9
+ 338010p -0.3
+ 340000p -0.3
+ 340010p 0.9
+ 342000p 0.9
+ 342010p -0.3
+ 344000p -0.3
+ 344010p 0.9
+ 346000p 0.9
+ 346010p -0.3
+ 348000p -0.3
+ 348010p 0.9
+ 350000p 0.9
+ 350010p -0.3
+ 352000p -0.3
+ 352010p 0.9
+ 354000p 0.9
+ 354010p -0.3
+ 356000p -0.3
+ 356010p 0.9
+ 358000p 0.9
+ 358010p -0.3
+ 360000p -0.3
+ 360010p 0.9
+ 362000p 0.9
+ 362010p -0.3
+ 364000p -0.3
+ 364010p 0.9
+ 366000p 0.9
+ 366010p -0.3
+ 368000p -0.3
+ 368010p 0.9
+ 370000p 0.9
+ 370010p -0.3
+ 372000p -0.3
+ 372010p 0.9
+ 374000p 0.9
+ 374010p -0.3
+ 376000p -0.3
+ 376010p 0.9
+ 378000p 0.9
+ 378010p -0.3
+ 380000p -0.3
+ 380010p 0.9
+ 382000p 0.9
+ 382010p -0.3
+ 384000p -0.3
+ 384010p 0.9
+ 386000p 0.9
+ 386010p -0.3
+ 388000p -0.3
+ 388010p 0.9
+ 390000p 0.9
+ 390010p -0.3
+ 392000p -0.3
+ 392010p 0.9
+ 394000p 0.9
+ 394010p -0.3
+ 396000p -0.3
+ 396010p 0.9
+ 398000p 0.9
+ 398010p -0.3
+ 400000p -0.3
+ 400010p 0.9
+ 402000p 0.9
+ 402010p -0.3
+ 404000p -0.3
+ 404010p 0.9
+ 406000p 0.9
+ 406010p -0.3
+ 408000p -0.3
+ 408010p 0.9
+ 410000p 0.9
+ 410010p -0.3
+ 412000p -0.3
+ 412010p 0.9
+ 414000p 0.9
+ 414010p -0.3
+ 416000p -0.3
+ 416010p 0.9
+ 418000p 0.9
+ 418010p -0.3
+ 420000p -0.3
+ 420010p 0.9
+ 422000p 0.9
+ 422010p -0.3
+ 424000p -0.3
+ 424010p 0.9
+ 426000p 0.9
+ 426010p -0.3
+ 428000p -0.3
+ 428010p 0.9
+ 430000p 0.9
+ 430010p -0.3
+ 432000p -0.3
+ 432010p 0.9
+ 434000p 0.9
+ 434010p -0.3
+ 436000p -0.3
+ 436010p 0.9
+ 438000p 0.9
+ 438010p -0.3
+ 440000p -0.3
+ 440010p 0.9
+ 442000p 0.9
+ 442010p -0.3
+ 444000p -0.3
+ 444010p 0.9
+ 446000p 0.9
+ 446010p -0.3
+ 448000p -0.3
+ 448010p 0.9
+ 450000p 0.9
+ 450010p -0.3
+ 452000p -0.3
+ 452010p 0.9
+ 454000p 0.9
+ 454010p -0.3
+ 456000p -0.3
+ 456010p 0.9
+ 458000p 0.9
+ 458010p -0.3
+ 460000p -0.3
+ 460010p 0.9
+ 462000p 0.9
+ 462010p -0.3
+ 464000p -0.3
+ 464010p 0.9
+ 466000p 0.9
+ 466010p -0.3
+ 468000p -0.3
+ 468010p 0.9
+ 470000p 0.9
+ 470010p -0.3
+ 472000p -0.3
+ 472010p 0.9
+ 474000p 0.9
+ 474010p -0.3
+ 476000p -0.3
+ 476010p 0.9
+ 478000p 0.9
+ 478010p -0.3
+ 480000p -0.3
+ 480010p 0.9
+ 482000p 0.9
+ 482010p -0.3
+ 484000p -0.3
+ 484010p 0.9
+ 486000p 0.9
+ 486010p -0.3
+ 488000p -0.3
+ 488010p 0.9
+ 490000p 0.9
+ 490010p -0.3
+ 492000p -0.3
+ 492010p 0.9
+ 494000p 0.9
+ 494010p -0.3
+ 496000p -0.3
+ 496010p 0.9
+ 498000p 0.9
+ 498010p -0.3
+ 500000p -0.3
+ 500010p 0.9
+ 502000p 0.9
+ 502010p -0.3
+ 504000p -0.3
+ 504010p 0.9
+ 506000p 0.9
+ 506010p -0.3
+ 508000p -0.3
+ 508010p 0.9
+ 510000p 0.9
+ 510010p -0.3
+ 512000p -0.3
+ 512010p 0.9
+ 514000p 0.9
+ 514010p -0.3
+ 516000p -0.3
+ 516010p 0.9
+ 518000p 0.9
+ 518010p -0.3
+ 520000p -0.3
+ 520010p 0.9
+ 522000p 0.9
+ 522010p -0.3
+ 524000p -0.3
+ 524010p 0.9
+ 526000p 0.9
+ 526010p -0.3
+ 528000p -0.3
+ 528010p 0.9
+ 530000p 0.9
+ 530010p -0.3
+ 532000p -0.3
+ 532010p 0.9
+ 534000p 0.9
+ 534010p -0.3
+ 536000p -0.3
+ 536010p 0.9
+ 538000p 0.9
+ 538010p -0.3
+ 540000p -0.3
+ 540010p 0.9
+ 542000p 0.9
+ 542010p -0.3
+ 544000p -0.3
+ 544010p 0.9
+ 546000p 0.9
+ 546010p -0.3
+ 548000p -0.3
+ 548010p 0.9
+ 550000p 0.9
+ 550010p -0.3
+ 552000p -0.3
+ 552010p 0.9
+ 554000p 0.9
+ 554010p -0.3
+ 556000p -0.3
+ 556010p 0.9
+ 558000p 0.9
+ 558010p -0.3
+ 560000p -0.3
+ 560010p 0.9
+ 562000p 0.9
+ 562010p -0.3
+ 564000p -0.3
+ 564010p 0.9
+ 566000p 0.9
+ 566010p -0.3
+ 568000p -0.3
+ 568010p 0.9
+ 570000p 0.9
+ 570010p -0.3
+ 572000p -0.3
+ 572010p 0.9
+ 574000p 0.9
+ 574010p -0.3
+ 576000p -0.3
+ 576010p 0.9
+ 578000p 0.9
+ 578010p -0.3
+ 580000p -0.3
+ 580010p 0.9
+ 582000p 0.9
+ 582010p -0.3
+ 584000p -0.3
+ 584010p 0.9
+ 586000p 0.9
+ 586010p -0.3
+ 588000p -0.3
+ 588010p 0.9
+ 590000p 0.9
+ 590010p -0.3
+ 592000p -0.3
+ 592010p 0.9
+ 594000p 0.9
+ 594010p -0.3
+ 596000p -0.3
+ 596010p 0.9
+ 598000p 0.9
+ 598010p -0.3
+ 600000p -0.3
+ 600010p 0.9
+ 602000p 0.9
+ 602010p -0.3
+ 604000p -0.3
+ 604010p 0.9
+ 606000p 0.9
+ 606010p -0.3
+ 608000p -0.3
+ 608010p 0.9
+ 610000p 0.9
+ 610010p -0.3
+ 612000p -0.3
+ 612010p 0.9
+ 614000p 0.9
+ 614010p -0.3
+ 616000p -0.3
+ 616010p 0.9
+ 618000p 0.9
+ 618010p -0.3
+ 620000p -0.3
+ 620010p 0.9
+ 622000p 0.9
+ 622010p -0.3
+ 624000p -0.3
+ 624010p 0.9
+ 626000p 0.9
+ 626010p -0.3
+ 628000p -0.3
+ 628010p 0.9
+ 630000p 0.9
+ 630010p -0.3
+ 632000p -0.3
+ 632010p 0.9
+ 634000p 0.9
+ 634010p -0.3
+ 636000p -0.3
+ 636010p 0.9
+ 638000p 0.9
+ 638010p -0.3
+ 640000p -0.3
+ 640010p 0.9
+ 642000p 0.9
+ 642010p -0.3
+ 644000p -0.3
+ 644010p 0.9
+ 646000p 0.9
+ 646010p -0.3
+ 648000p -0.3
+ 648010p 0.9
+ 650000p 0.9
+ 650010p -0.3
+ 652000p -0.3
+ 652010p 0.9
+ 654000p 0.9
+ 654010p -0.3
+ 656000p -0.3
+ 656010p 0.9
+ 658000p 0.9
+ 658010p -0.3
+ 660000p -0.3
+ 660010p 0.9
+ 662000p 0.9
+ 662010p -0.3
+ 664000p -0.3
+ 664010p 0.9
+ 666000p 0.9
+ 666010p -0.3
+ 668000p -0.3
+ 668010p 0.9
+ 670000p 0.9
+ 670010p -0.3
+ 672000p -0.3
+ 672010p 0.9
+ 674000p 0.9
+ 674010p -0.3
+ 676000p -0.3
+ 676010p 0.9
+ 678000p 0.9
+ 678010p -0.3
+ 680000p -0.3
+ 680010p 0.9
+ 682000p 0.9
+ 682010p -0.3
+ 684000p -0.3
+ 684010p 0.9
+ 686000p 0.9
+ 686010p -0.3
+ 688000p -0.3
+ 688010p 0.9
+ 690000p 0.9
+ 690010p -0.3
+ 692000p -0.3
+ 692010p 0.9
+ 694000p 0.9
+ 694010p -0.3
+ 696000p -0.3
+ 696010p 0.9
+ 698000p 0.9
+ 698010p -0.3
+ 700000p -0.3
+ 700010p 0.9
+ 702000p 0.9
+ 702010p -0.3
+ 704000p -0.3
+ 704010p 0.9
+ 706000p 0.9
+ 706010p -0.3
+ 708000p -0.3
+ 708010p 0.9
+ 710000p 0.9
+ 710010p -0.3
+ 712000p -0.3
+ 712010p 0.9
+ 714000p 0.9
+ 714010p -0.3
+ 716000p -0.3
+ 716010p 0.9
+ 718000p 0.9
+ 718010p -0.3
+ 720000p -0.3
+ 720010p 0.9
+ 722000p 0.9
+ 722010p -0.3
+ 724000p -0.3
+ 724010p 0.9
+ 726000p 0.9
+ 726010p -0.3
+ 728000p -0.3
+ 728010p 0.9
+ 730000p 0.9
+ 730010p -0.3
+ 732000p -0.3
+ 732010p 0.9
+ 734000p 0.9
+ 734010p -0.3
+ 736000p -0.3
+ 736010p 0.9
+ 738000p 0.9
+ 738010p -0.3
+ 740000p -0.3
+ 740010p 0.9
+ 742000p 0.9
+ 742010p -0.3
+ 744000p -0.3
+ 744010p 0.9
+ 746000p 0.9
+ 746010p -0.3
+ 748000p -0.3
+ 748010p 0.9
+ 750000p 0.9
+ 750010p -0.3
+ 752000p -0.3
+ 752010p 0.9
+ 754000p 0.9
+ 754010p -0.3
+ 756000p -0.3
+ 756010p 0.9
+ 758000p 0.9
+ 758010p -0.3
+ 760000p -0.3
+ 760010p 0.9
+ 762000p 0.9
+ 762010p -0.3
+ 764000p -0.3
+ 764010p 0.9
+ 766000p 0.9
+ 766010p -0.3
+ 768000p -0.3
+ 768010p 0.9
+ 770000p 0.9
+ 770010p -0.3
+ 772000p -0.3
+ 772010p 0.9
+ 774000p 0.9
+ 774010p -0.3
+ 776000p -0.3
+ 776010p 0.9
+ 778000p 0.9
+ 778010p -0.3
+ 780000p -0.3
+ 780010p 0.9
+ 782000p 0.9
+ 782010p -0.3
+ 784000p -0.3
+ 784010p 0.9
+ 786000p 0.9
+ 786010p -0.3
+ 788000p -0.3
+ 788010p 0.9
+ 790000p 0.9
+ 790010p -0.3
+ 792000p -0.3
+ 792010p 0.9
+ 794000p 0.9
+ 794010p -0.3
+ 796000p -0.3
+ 796010p 0.9
+ 798000p 0.9
+ 798010p -0.3
+ 800000p -0.3
+ 800010p 0.9
+ 802000p 0.9
+ 802010p -0.3
+ 804000p -0.3
+ 804010p 0.9
+ 806000p 0.9
+ 806010p -0.3
+ 808000p -0.3
+ 808010p 0.9
+ 810000p 0.9
+ 810010p -0.3
+ 812000p -0.3
+ 812010p 0.9
+ 814000p 0.9
+ 814010p -0.3
+ 816000p -0.3
+ 816010p 0.9
+ 818000p 0.9
+ 818010p -0.3
+ 820000p -0.3
+ 820010p 0.9
+ 822000p 0.9
+ 822010p -0.3
+ 824000p -0.3
+ 824010p 0.9
+ 826000p 0.9
+ 826010p -0.3
+ 828000p -0.3
+ 828010p 0.9
+ 830000p 0.9
+ 830010p -0.3
+ 832000p -0.3
+ 832010p 0.9
+ 834000p 0.9
+ 834010p -0.3
+ 836000p -0.3
+ 836010p 0.9
+ 838000p 0.9
+ 838010p -0.3
+ 840000p -0.3
+ 840010p 0.9
+ 842000p 0.9
+ 842010p -0.3
+ 844000p -0.3
+ 844010p 0.9
+ 846000p 0.9
+ 846010p -0.3
+ 848000p -0.3
+ 848010p 0.9
+ 850000p 0.9
+ 850010p -0.3
+ 852000p -0.3
+ 852010p 0.9
+ 854000p 0.9
+ 854010p -0.3
+ 856000p -0.3
+ 856010p 0.9
+ 858000p 0.9
+ 858010p -0.3
+ 860000p -0.3
+ 860010p 0.9
+ 862000p 0.9
+ 862010p -0.3
+ 864000p -0.3
+ 864010p 0.9
+ 866000p 0.9
+ 866010p -0.3
+ 868000p -0.3
+ 868010p 0.9
+ 870000p 0.9
+ 870010p -0.3
+ 872000p -0.3
+ 872010p 0.9
+ 874000p 0.9
+ 874010p -0.3
+ 876000p -0.3
+ 876010p 0.9
+ 878000p 0.9
+ 878010p -0.3
+ 880000p -0.3
+ 880010p 0.9
+ 882000p 0.9
+ 882010p -0.3
+ 884000p -0.3
+ 884010p 0.9
+ 886000p 0.9
+ 886010p -0.3
+ 888000p -0.3
+ 888010p 0.9
+ 890000p 0.9
+ 890010p -0.3
+ 892000p -0.3
+ 892010p 0.9
+ 894000p 0.9
+ 894010p -0.3
+ 896000p -0.3
+ 896010p 0.9
+ 898000p 0.9
+ 898010p -0.3
+ 900000p -0.3
+ 900010p 0.9
+ 902000p 0.9
+ 902010p -0.3
+ 904000p -0.3
+ 904010p 0.9
+ 906000p 0.9
+ 906010p -0.3
+ 908000p -0.3
+ 908010p 0.9
+ 910000p 0.9
+ 910010p -0.3
+ 912000p -0.3
+ 912010p 0.9
+ 914000p 0.9
+ 914010p -0.3
+ 916000p -0.3
+ 916010p 0.9
+ 918000p 0.9
+ 918010p -0.3
+ 920000p -0.3
+ 920010p 0.9
+ 922000p 0.9
+ 922010p -0.3
+ 924000p -0.3
+ 924010p 0.9
+ 926000p 0.9
+ 926010p -0.3
+ 928000p -0.3
+ 928010p 0.9
+ 930000p 0.9
+ 930010p -0.3
+ 932000p -0.3
+ 932010p 0.9
+ 934000p 0.9
+ 934010p -0.3
+ 936000p -0.3
+ 936010p 0.9
+ 938000p 0.9
+ 938010p -0.3
+ 940000p -0.3
+ 940010p 0.9
+ 942000p 0.9
+ 942010p -0.3
+ 944000p -0.3
+ 944010p 0.9
+ 946000p 0.9
+ 946010p -0.3
+ 948000p -0.3
+ 948010p 0.9
+ 950000p 0.9
+ 950010p -0.3
+ 952000p -0.3
+ 952010p 0.9
+ 954000p 0.9
+ 954010p -0.3
+ 956000p -0.3
+ 956010p 0.9
+ 958000p 0.9
+ 958010p -0.3
+ 960000p -0.3
+ 960010p 0.9
+ 962000p 0.9
+ 962010p -0.3
+ 964000p -0.3
+ 964010p 0.9
+ 966000p 0.9
+ 966010p -0.3
+ 968000p -0.3
+ 968010p 0.9
+ 970000p 0.9
+ 970010p -0.3
+ 972000p -0.3
+ 972010p 0.9
+ 974000p 0.9
+ 974010p -0.3
+ 976000p -0.3
+ 976010p 0.9
+ 978000p 0.9
+ 978010p -0.3
+ 980000p -0.3
+ 980010p 0.9
+ 982000p 0.9
+ 982010p -0.3
+ 984000p -0.3
+ 984010p 0.9
+ 986000p 0.9
+ 986010p -0.3
+ 988000p -0.3
+ 988010p 0.9
+ 990000p 0.9
+ 990010p -0.3
+ 992000p -0.3
+ 992010p 0.9
+ 994000p 0.9
+ 994010p -0.3
+ 996000p -0.3
+ 996010p 0.9
+ 998000p 0.9
+ 998010p -0.3
+ 1000000p -0.3
+ 1000010p 0.9
+ 1002000p 0.9
+ 1002010p -0.3
+ 1004000p -0.3
+ 1004010p 0.9
+ 1006000p 0.9
+ 1006010p -0.3
+ 1008000p -0.3
+ 1008010p 0.9
+ 1010000p 0.9
+ 1010010p -0.3
+ 1012000p -0.3
+ 1012010p 0.9
+ 1014000p 0.9
+ 1014010p -0.3
+ 1016000p -0.3
+ 1016010p 0.9
+ 1018000p 0.9
+ 1018010p -0.3
+ 1020000p -0.3
+ 1020010p 0.9
+ 1022000p 0.9
+ 1022010p -0.3
+ 1024000p -0.3
+ 1024010p 0.9
+ 1026000p 0.9
+ 1026010p -0.3
+ 1028000p -0.3
+ 1028010p 0.9
+ 1030000p 0.9
+ 1030010p -0.3
+ 1032000p -0.3
+ 1032010p 0.9
+ 1034000p 0.9
+ 1034010p -0.3
+ 1036000p -0.3
+ 1036010p 0.9
+ 1038000p 0.9
+ 1038010p -0.3
+ 1040000p -0.3
+ 1040010p 0.9
+ 1042000p 0.9
+ 1042010p -0.3
+ 1044000p -0.3
+ 1044010p 0.9
+ 1046000p 0.9
+ 1046010p -0.3
+ 1048000p -0.3
+ 1048010p 0.9
+ 1050000p 0.9
+ 1050010p -0.3
+ 1052000p -0.3
+ 1052010p 0.9
+ 1054000p 0.9
+ 1054010p -0.3
+ 1056000p -0.3
+ 1056010p 0.9
+ 1058000p 0.9
+ 1058010p -0.3
+ 1060000p -0.3
+ 1060010p 0.9
+ 1062000p 0.9
+ 1062010p -0.3
+ 1064000p -0.3
+ 1064010p 0.9
+ 1066000p 0.9
+ 1066010p -0.3
+ 1068000p -0.3
+ 1068010p 0.9
+ 1070000p 0.9
+ 1070010p -0.3
+ 1072000p -0.3
+ 1072010p 0.9
+ 1074000p 0.9
+ 1074010p -0.3
+ 1076000p -0.3
+ 1076010p 0.9
+ 1078000p 0.9
+ 1078010p -0.3
+ 1080000p -0.3
+ 1080010p 0.9
+ 1082000p 0.9
+ 1082010p -0.3
+ 1084000p -0.3
+ 1084010p 0.9
+ 1086000p 0.9
+ 1086010p -0.3
+ 1088000p -0.3
+ 1088010p 0.9
+ 1090000p 0.9
+ 1090010p -0.3
+ 1092000p -0.3
+ 1092010p 0.9
+ 1094000p 0.9
+ 1094010p -0.3
+ 1096000p -0.3
+ 1096010p 0.9
+ 1098000p 0.9
+ 1098010p -0.3
+ 1100000p -0.3
+ 1100010p 0.9
+ 1102000p 0.9
+ 1102010p -0.3
+ 1104000p -0.3
+ 1104010p 0.9
+ 1106000p 0.9
+ 1106010p -0.3
+ 1108000p -0.3
+ 1108010p 0.9
+ 1110000p 0.9
+ 1110010p -0.3
+ 1112000p -0.3
+ 1112010p 0.9
+ 1114000p 0.9
+ 1114010p -0.3
+ 1116000p -0.3
+ 1116010p 0.9
+ 1118000p 0.9
+ 1118010p -0.3
+ 1120000p -0.3
+ 1120010p 0.9
+ 1122000p 0.9
+ 1122010p -0.3
+ 1124000p -0.3
+ 1124010p 0.9
+ 1126000p 0.9
+ 1126010p -0.3
+ 1128000p -0.3
+ 1128010p 0.9
+ 1130000p 0.9
+ 1130010p -0.3
+ 1132000p -0.3
+ 1132010p 0.9
+ 1134000p 0.9
+ 1134010p -0.3
+ 1136000p -0.3
+ 1136010p 0.9
+ 1138000p 0.9
+ 1138010p -0.3
+ 1140000p -0.3
+ 1140010p 0.9
+ 1142000p 0.9
+ 1142010p -0.3
+ 1144000p -0.3
+ 1144010p 0.9
+ 1146000p 0.9
+ 1146010p -0.3
+ 1148000p -0.3
+ 1148010p 0.9
+ 1150000p 0.9
+ 1150010p -0.3
+ 1152000p -0.3
+ 1152010p 0.9
+ 1154000p 0.9
+ 1154010p -0.3
+ 1156000p -0.3
+ 1156010p 0.9
+ 1158000p 0.9
+ 1158010p -0.3
+ 1160000p -0.3
+ 1160010p 0.9
+ 1162000p 0.9
+ 1162010p -0.3
+ 1164000p -0.3
+ 1164010p 0.9
+ 1166000p 0.9
+ 1166010p -0.3
+ 1168000p -0.3
+ 1168010p 0.9
+ 1170000p 0.9
+ 1170010p -0.3
+ 1172000p -0.3
+ 1172010p 0.9
+ 1174000p 0.9
+ 1174010p -0.3
+ 1176000p -0.3
+ 1176010p 0.9
+ 1178000p 0.9
+ 1178010p -0.3
+ 1180000p -0.3
+ 1180010p 0.9
+ 1182000p 0.9
+ 1182010p -0.3
+ 1184000p -0.3
+ 1184010p 0.9
+ 1186000p 0.9
+ 1186010p -0.3
+ 1188000p -0.3
+ 1188010p 0.9
+ 1190000p 0.9
+ 1190010p -0.3
+ 1192000p -0.3
+ 1192010p 0.9
+ 1194000p 0.9
+ 1194010p -0.3
+ 1196000p -0.3
+ 1196010p 0.9
+ 1198000p 0.9
+ 1198010p -0.3
+ 1200000p -0.3
+ 1200010p 0.9
+ 1202000p 0.9
+ 1202010p -0.3
+ 1204000p -0.3
+ 1204010p 0.9
+ 1206000p 0.9
+ 1206010p -0.3
+ 1208000p -0.3
+ 1208010p 0.9
+ 1210000p 0.9
+ 1210010p -0.3
+ 1212000p -0.3
+ 1212010p 0.9
+ 1214000p 0.9
+ 1214010p -0.3
+ 1216000p -0.3
+ 1216010p 0.9
+ 1218000p 0.9
+ 1218010p -0.3
+ 1220000p -0.3
+ 1220010p 0.9
+ 1222000p 0.9
+ 1222010p -0.3
+ 1224000p -0.3
+ 1224010p 0.9
+ 1226000p 0.9
+ 1226010p -0.3
+ 1228000p -0.3
+ 1228010p 0.9
+ 1230000p 0.9
+ 1230010p -0.3
+ 1232000p -0.3
+ 1232010p 0.9
+ 1234000p 0.9
+ 1234010p -0.3
+ 1236000p -0.3
+ 1236010p 0.9
+ 1238000p 0.9
+ 1238010p -0.3
+ 1240000p -0.3
+ 1240010p 0.9
+ 1242000p 0.9
+ 1242010p -0.3
+ 1244000p -0.3
+ 1244010p 0.9
+ 1246000p 0.9
+ 1246010p -0.3
+ 1248000p -0.3
+ 1248010p 0.9
+ 1250000p 0.9
+ 1250010p -0.3
+ 1252000p -0.3
+ 1252010p 0.9
+ 1254000p 0.9
+ 1254010p -0.3
+ 1256000p -0.3
+ 1256010p 0.9
+ 1258000p 0.9
+ 1258010p -0.3
+ 1260000p -0.3
+ 1260010p 0.9
+ 1262000p 0.9
+ 1262010p -0.3
+ 1264000p -0.3
+ 1264010p 0.9
+ 1266000p 0.9
+ 1266010p -0.3
+ 1268000p -0.3
+ 1268010p 0.9
+ 1270000p 0.9
+ 1270010p -0.3
+ 1272000p -0.3
+ 1272010p 0.9
+ 1274000p 0.9
+ 1274010p -0.3
+ 1276000p -0.3
+ 1276010p 0.9
+ 1278000p 0.9
+ 1278010p -0.3
+ 1280000p -0.3
+ 1280010p 0.9
+ 1282000p 0.9
+ 1282010p -0.3
+ 1284000p -0.3
+ 1284010p 0.9
+ 1286000p 0.9
+ 1286010p -0.3
+ 1288000p -0.3
+ 1288010p 0.9
+ 1290000p 0.9
+ 1290010p -0.3
+ 1292000p -0.3
+ 1292010p 0.9
+ 1294000p 0.9
+ 1294010p -0.3
+ 1296000p -0.3
+ 1296010p 0.9
+ 1298000p 0.9
+ 1298010p -0.3
+ 1300000p -0.3
+ 1300010p 0.9
+ 1302000p 0.9
+ 1302010p -0.3
+ 1304000p -0.3
+ 1304010p 0.9
+ 1306000p 0.9
+ 1306010p -0.3
+ 1308000p -0.3
+ 1308010p 0.9
+ 1310000p 0.9
+ 1310010p -0.3
+ 1312000p -0.3
+ 1312010p 0.9
+ 1314000p 0.9
+ 1314010p -0.3
+ 1316000p -0.3
+ 1316010p 0.9
+ 1318000p 0.9
+ 1318010p -0.3
+ 1320000p -0.3
+ 1320010p 0.9
+ 1322000p 0.9
+ 1322010p -0.3
+ 1324000p -0.3
+ 1324010p 0.9
+ 1326000p 0.9
+ 1326010p -0.3
+ 1328000p -0.3
+ 1328010p 0.9
+ 1330000p 0.9
+ 1330010p -0.3
+ 1332000p -0.3
+ 1332010p 0.9
+ 1334000p 0.9
+ 1334010p -0.3
+ 1336000p -0.3
+ 1336010p 0.9
+ 1338000p 0.9
+ 1338010p -0.3
+ 1340000p -0.3
+ 1340010p 0.9
+ 1342000p 0.9
+ 1342010p -0.3
+ 1344000p -0.3
+ 1344010p 0.9
+ 1346000p 0.9
+ 1346010p -0.3
+ 1348000p -0.3
+ 1348010p 0.9
+ 1350000p 0.9
+ 1350010p -0.3
+ 1352000p -0.3
+ 1352010p 0.9
+ 1354000p 0.9
+ 1354010p -0.3
+ 1356000p -0.3
+ 1356010p 0.9
+ 1358000p 0.9
+ 1358010p -0.3
+ 1360000p -0.3
+ 1360010p 0.9
+ 1362000p 0.9
+ 1362010p -0.3
+ 1364000p -0.3
+ 1364010p 0.9
+ 1366000p 0.9
+ 1366010p -0.3
+ 1368000p -0.3
+ 1368010p 0.9
+ 1370000p 0.9
+ 1370010p -0.3
+ 1372000p -0.3
+ 1372010p 0.9
+ 1374000p 0.9
+ 1374010p -0.3
+ 1376000p -0.3
+ 1376010p 0.9
+ 1378000p 0.9
+ 1378010p -0.3
+ 1380000p -0.3
+ 1380010p 0.9
+ 1382000p 0.9
+ 1382010p -0.3
+ 1384000p -0.3
+ 1384010p 0.9
+ 1386000p 0.9
+ 1386010p -0.3
+ 1388000p -0.3
+ 1388010p 0.9
+ 1390000p 0.9
+ 1390010p -0.3
+ 1392000p -0.3
+ 1392010p 0.9
+ 1394000p 0.9
+ 1394010p -0.3
+ 1396000p -0.3
+ 1396010p 0.9
+ 1398000p 0.9
+ 1398010p -0.3
+ 1400000p -0.3
+ 1400010p 0.9
+ 1402000p 0.9
+ 1402010p -0.3
+ 1404000p -0.3
+ 1404010p 0.9
+ 1406000p 0.9
+ 1406010p -0.3
+ 1408000p -0.3
+ 1408010p 0.9
+ 1410000p 0.9
+ 1410010p -0.3
+ 1412000p -0.3
+ 1412010p 0.9
+ 1414000p 0.9
+ 1414010p -0.3
+ 1416000p -0.3
+ 1416010p 0.9
+ 1418000p 0.9
+ 1418010p -0.3
+ 1420000p -0.3
+ 1420010p 0.9
+ 1422000p 0.9
+ 1422010p -0.3
+ 1424000p -0.3
+ 1424010p 0.9
+ 1426000p 0.9
+ 1426010p -0.3
+ 1428000p -0.3
+ 1428010p 0.9
+ 1430000p 0.9
+ 1430010p -0.3
+ 1432000p -0.3
+ 1432010p 0.9
+ 1434000p 0.9
+ 1434010p -0.3
+ 1436000p -0.3
+ 1436010p 0.9
+ 1438000p 0.9
+ 1438010p -0.3
+ 1440000p -0.3
+ 1440010p 0.9
+ 1442000p 0.9
+ 1442010p -0.3
+ 1444000p -0.3
+ 1444010p 0.9
+ 1446000p 0.9
+ 1446010p -0.3
+ 1448000p -0.3
+ 1448010p 0.9
+ 1450000p 0.9
+ 1450010p -0.3
+ 1452000p -0.3
+ 1452010p 0.9
+ 1454000p 0.9
+ 1454010p -0.3
+ 1456000p -0.3
+ 1456010p 0.9
+ 1458000p 0.9
+ 1458010p -0.3
+ 1460000p -0.3
+ 1460010p 0.9
+ 1462000p 0.9
+ 1462010p -0.3
+ 1464000p -0.3
+ 1464010p 0.9
+ 1466000p 0.9
+ 1466010p -0.3
+ 1468000p -0.3
+ 1468010p 0.9
+ 1470000p 0.9
+ 1470010p -0.3
+ 1472000p -0.3
+ 1472010p 0.9
+ 1474000p 0.9
+ 1474010p -0.3
+ 1476000p -0.3
+ 1476010p 0.9
+ 1478000p 0.9
+ 1478010p -0.3
+ 1480000p -0.3
+ 1480010p 0.9
+ 1482000p 0.9
+ 1482010p -0.3
+ 1484000p -0.3
+ 1484010p 0.9
+ 1486000p 0.9
+ 1486010p -0.3
+ 1488000p -0.3
+ 1488010p 0.9
+ 1490000p 0.9
+ 1490010p -0.3
+ 1492000p -0.3
+ 1492010p 0.9
+ 1494000p 0.9
+ 1494010p -0.3
+ 1496000p -0.3
+ 1496010p 0.9
+ 1498000p 0.9
+ 1498010p -0.3
+ 1500000p -0.3
+ 1500010p 0.9
+ 1502000p 0.9
+ 1502010p -0.3
+ 1504000p -0.3
+ 1504010p 0.9
+ 1506000p 0.9
+ 1506010p -0.3
+ 1508000p -0.3
+ 1508010p 0.9
+ 1510000p 0.9
+ 1510010p -0.3
+ 1512000p -0.3
+ 1512010p 0.9
+ 1514000p 0.9
+ 1514010p -0.3
+ 1516000p -0.3
+ 1516010p 0.9
+ 1518000p 0.9
+ 1518010p -0.3
+ 1520000p -0.3
+ 1520010p 0.9
+ 1522000p 0.9
+ 1522010p -0.3
+ 1524000p -0.3
+ 1524010p 0.9
+ 1526000p 0.9
+ 1526010p -0.3
+ 1528000p -0.3
+ 1528010p 0.9
+ 1530000p 0.9
+ 1530010p -0.3
+ 1532000p -0.3
+ 1532010p 0.9
+ 1534000p 0.9
+ 1534010p -0.3
+ 1536000p -0.3
+ 1536010p 0.9
+ 1538000p 0.9
+ 1538010p -0.3
+ 1540000p -0.3
+ 1540010p 0.9
+ 1542000p 0.9
+ 1542010p -0.3
+ 1544000p -0.3
+ 1544010p 0.9
+ 1546000p 0.9
+ 1546010p -0.3
+ 1548000p -0.3
+ 1548010p 0.9
+ 1550000p 0.9
+ 1550010p -0.3
+ 1552000p -0.3
+ 1552010p 0.9
+ 1554000p 0.9
+ 1554010p -0.3
+ 1556000p -0.3
+ 1556010p 0.9
+ 1558000p 0.9
+ 1558010p -0.3
+ 1560000p -0.3
+ 1560010p 0.9
+ 1562000p 0.9
+ 1562010p -0.3
+ 1564000p -0.3
+ 1564010p 0.9
+ 1566000p 0.9
+ 1566010p -0.3
+ 1568000p -0.3
+ 1568010p 0.9
+ 1570000p 0.9
+ 1570010p -0.3
+ 1572000p -0.3
+ 1572010p 0.9
+ 1574000p 0.9
+ 1574010p -0.3
+ 1576000p -0.3
+ 1576010p 0.9
+ 1578000p 0.9
+ 1578010p -0.3
+ 1580000p -0.3
+ 1580010p 0.9
+ 1582000p 0.9
+ 1582010p -0.3
+ 1584000p -0.3
+ 1584010p 0.9
+ 1586000p 0.9
+ 1586010p -0.3
+ 1588000p -0.3
+ 1588010p 0.9
+ 1590000p 0.9
+ 1590010p -0.3
+ 1592000p -0.3
+ 1592010p 0.9
+ 1594000p 0.9
+ 1594010p -0.3
+ 1596000p -0.3
+ 1596010p 0.9
+ 1598000p 0.9
+ 1598010p -0.3
+ 1600000p -0.3
+ 1600010p 0.9
+ 1602000p 0.9
+ 1602010p -0.3
+ 1604000p -0.3
+ 1604010p 0.9
+ 1606000p 0.9
+ 1606010p -0.3
+ 1608000p -0.3
+ 1608010p 0.9
+ 1610000p 0.9
+ 1610010p -0.3
+ 1612000p -0.3
+ 1612010p 0.9
+ 1614000p 0.9
+ 1614010p -0.3
+ 1616000p -0.3
+ 1616010p 0.9
+ 1618000p 0.9
+ 1618010p -0.3
+ 1620000p -0.3
+ 1620010p 0.9
+ 1622000p 0.9
+ 1622010p -0.3
+ 1624000p -0.3
+ 1624010p 0.9
+ 1626000p 0.9
+ 1626010p -0.3
+ 1628000p -0.3
+ 1628010p 0.9
+ 1630000p 0.9
+ 1630010p -0.3
+ 1632000p -0.3
+ 1632010p 0.9
+ 1634000p 0.9
+ 1634010p -0.3
+ 1636000p -0.3
+ 1636010p 0.9
+ 1638000p 0.9
+ 1638010p -0.3
+ 1640000p -0.3
+ 1640010p 0.9
+ 1642000p 0.9
+ 1642010p -0.3
+ 1644000p -0.3
+ 1644010p 0.9
+ 1646000p 0.9
+ 1646010p -0.3
+ 1648000p -0.3
+ 1648010p 0.9
+ 1650000p 0.9
+ 1650010p -0.3
+ 1652000p -0.3
+ 1652010p 0.9
+ 1654000p 0.9
+ 1654010p -0.3
+ 1656000p -0.3
+ 1656010p 0.9
+ 1658000p 0.9
+ 1658010p -0.3
+ 1660000p -0.3
+ 1660010p 0.9
+ 1662000p 0.9
+ 1662010p -0.3
+ 1664000p -0.3
+ 1664010p 0.9
+ 1666000p 0.9
+ 1666010p -0.3
+ 1668000p -0.3
+ 1668010p 0.9
+ 1670000p 0.9
+ 1670010p -0.3
+ 1672000p -0.3
+ 1672010p 0.9
+ 1674000p 0.9
+ 1674010p -0.3
+ 1676000p -0.3
+ 1676010p 0.9
+ 1678000p 0.9
+ 1678010p -0.3
+ 1680000p -0.3
+ 1680010p 0.9
+ 1682000p 0.9
+ 1682010p -0.3
+ 1684000p -0.3
+ 1684010p 0.9
+ 1686000p 0.9
+ 1686010p -0.3
+ 1688000p -0.3
+ 1688010p 0.9
+ 1690000p 0.9
+ 1690010p -0.3
+ 1692000p -0.3
+ 1692010p 0.9
+ 1694000p 0.9
+ 1694010p -0.3
+ 1696000p -0.3
+ 1696010p 0.9
+ 1698000p 0.9
+ 1698010p -0.3
+ 1700000p -0.3
+ 1700010p 0.9
+ 1702000p 0.9
+ 1702010p -0.3
+ 1704000p -0.3
+ 1704010p 0.9
+ 1706000p 0.9
+ 1706010p -0.3
+ 1708000p -0.3
+ 1708010p 0.9
+ 1710000p 0.9
+ 1710010p -0.3
+ 1712000p -0.3
+ 1712010p 0.9
+ 1714000p 0.9
+ 1714010p -0.3
+ 1716000p -0.3
+ 1716010p 0.9
+ 1718000p 0.9
+ 1718010p -0.3
+ 1720000p -0.3
+ 1720010p 0.9
+ 1722000p 0.9
+ 1722010p -0.3
+ 1724000p -0.3
+ 1724010p 0.9
+ 1726000p 0.9
+ 1726010p -0.3
+ 1728000p -0.3
+ 1728010p 0.9
+ 1730000p 0.9
+ 1730010p -0.3
+ 1732000p -0.3
+ 1732010p 0.9
+ 1734000p 0.9
+ 1734010p -0.3
+ 1736000p -0.3
+ 1736010p 0.9
+ 1738000p 0.9
+ 1738010p -0.3
+ 1740000p -0.3
+ 1740010p 0.9
+ 1742000p 0.9
+ 1742010p -0.3
+ 1744000p -0.3
+ 1744010p 0.9
+ 1746000p 0.9
+ 1746010p -0.3
+ 1748000p -0.3
+ 1748010p 0.9
+ 1750000p 0.9
+ 1750010p -0.3
+ 1752000p -0.3
+ 1752010p 0.9
+ 1754000p 0.9
+ 1754010p -0.3
+ 1756000p -0.3
+ 1756010p 0.9
+ 1758000p 0.9
+ 1758010p -0.3
+ 1760000p -0.3
+ 1760010p 0.9
+ 1762000p 0.9
+ 1762010p -0.3
+ 1764000p -0.3
+ 1764010p 0.9
+ 1766000p 0.9
+ 1766010p -0.3
+ 1768000p -0.3
+ 1768010p 0.9
+ 1770000p 0.9
+ 1770010p -0.3
+ 1772000p -0.3
+ 1772010p 0.9
+ 1774000p 0.9
+ 1774010p -0.3
+ 1776000p -0.3
+ 1776010p 0.9
+ 1778000p 0.9
+ 1778010p -0.3
+ 1780000p -0.3
+ 1780010p 0.9
+ 1782000p 0.9
+ 1782010p -0.3
+ 1784000p -0.3
+ 1784010p 0.9
+ 1786000p 0.9
+ 1786010p -0.3
+ 1788000p -0.3
+ 1788010p 0.9
+ 1790000p 0.9
+ 1790010p -0.3
+ 1792000p -0.3
+ 1792010p 0.9
+ 1794000p 0.9
+ 1794010p -0.3
+ 1796000p -0.3
+ 1796010p 0.9
+ 1798000p 0.9
+ 1798010p -0.3
+ 1800000p -0.3
+ 1800010p 0.9
+ 1802000p 0.9
+ 1802010p -0.3
+ 1804000p -0.3
+ 1804010p 0.9
+ 1806000p 0.9
+ 1806010p -0.3
+ 1808000p -0.3
+ 1808010p 0.9
+ 1810000p 0.9
+ 1810010p -0.3
+ 1812000p -0.3
+ 1812010p 0.9
+ 1814000p 0.9
+ 1814010p -0.3
+ 1816000p -0.3
+ 1816010p 0.9
+ 1818000p 0.9
+ 1818010p -0.3
+ 1820000p -0.3
+ 1820010p 0.9
+ 1822000p 0.9
+ 1822010p -0.3
+ 1824000p -0.3
+ 1824010p 0.9
+ 1826000p 0.9
+ 1826010p -0.3
+ 1828000p -0.3
+ 1828010p 0.9
+ 1830000p 0.9
+ 1830010p -0.3
+ 1832000p -0.3
+ 1832010p 0.9
+ 1834000p 0.9
+ 1834010p -0.3
+ 1836000p -0.3
+ 1836010p 0.9
+ 1838000p 0.9
+ 1838010p -0.3
+ 1840000p -0.3
+ 1840010p 0.9
+ 1842000p 0.9
+ 1842010p -0.3
+ 1844000p -0.3
+ 1844010p 0.9
+ 1846000p 0.9
+ 1846010p -0.3
+ 1848000p -0.3
+ 1848010p 0.9
+ 1850000p 0.9
+ 1850010p -0.3
+ 1852000p -0.3
+ 1852010p 0.9
+ 1854000p 0.9
+ 1854010p -0.3
+ 1856000p -0.3
+ 1856010p 0.9
+ 1858000p 0.9
+ 1858010p -0.3
+ 1860000p -0.3
+ 1860010p 0.9
+ 1862000p 0.9
+ 1862010p -0.3
+ 1864000p -0.3
+ 1864010p 0.9
+ 1866000p 0.9
+ 1866010p -0.3
+ 1868000p -0.3
+ 1868010p 0.9
+ 1870000p 0.9
+ 1870010p -0.3
+ 1872000p -0.3
+ 1872010p 0.9
+ 1874000p 0.9
+ 1874010p -0.3
+ 1876000p -0.3
+ 1876010p 0.9
+ 1878000p 0.9
+ 1878010p -0.3
+ 1880000p -0.3
+ 1880010p 0.9
+ 1882000p 0.9
+ 1882010p -0.3
+ 1884000p -0.3
+ 1884010p 0.9
+ 1886000p 0.9
+ 1886010p -0.3
+ 1888000p -0.3
+ 1888010p 0.9
+ 1890000p 0.9
+ 1890010p -0.3
+ 1892000p -0.3
+ 1892010p 0.9
+ 1894000p 0.9
+ 1894010p -0.3
+ 1896000p -0.3
+ 1896010p 0.9
+ 1898000p 0.9
+ 1898010p -0.3
+ 1900000p -0.3
+ 1900010p 0.9
+ 1902000p 0.9
+ 1902010p -0.3
+ 1904000p -0.3
+ 1904010p 0.9
+ 1906000p 0.9
+ 1906010p -0.3
+ 1908000p -0.3
+ 1908010p 0.9
+ 1910000p 0.9
+ 1910010p -0.3
+ 1912000p -0.3
+ 1912010p 0.9
+ 1914000p 0.9
+ 1914010p -0.3
+ 1916000p -0.3
+ 1916010p 0.9
+ 1918000p 0.9
+ 1918010p -0.3
+ 1920000p -0.3
+ 1920010p 0.9
+ 1922000p 0.9
+ 1922010p -0.3
+ 1924000p -0.3
+ 1924010p 0.9
+ 1926000p 0.9
+ 1926010p -0.3
+ 1928000p -0.3
+ 1928010p 0.9
+ 1930000p 0.9
+ 1930010p -0.3
+ 1932000p -0.3
+ 1932010p 0.9
+ 1934000p 0.9
+ 1934010p -0.3
+ 1936000p -0.3
+ 1936010p 0.9
+ 1938000p 0.9
+ 1938010p -0.3
+ 1940000p -0.3
+ 1940010p 0.9
+ 1942000p 0.9
+ 1942010p -0.3
+ 1944000p -0.3
+ 1944010p 0.9
+ 1946000p 0.9
+ 1946010p -0.3
+ 1948000p -0.3
+ 1948010p 0.9
+ 1950000p 0.9
+ 1950010p -0.3
+ 1952000p -0.3
+ 1952010p 0.9
+ 1954000p 0.9
+ 1954010p -0.3
+ 1956000p -0.3
+ 1956010p 0.9
+ 1958000p 0.9
+ 1958010p -0.3
+ 1960000p -0.3
+ 1960010p 0.9
+ 1962000p 0.9
+ 1962010p -0.3
+ 1964000p -0.3
+ 1964010p 0.9
+ 1966000p 0.9
+ 1966010p -0.3
+ 1968000p -0.3
+ 1968010p 0.9
+ 1970000p 0.9
+ 1970010p -0.3
+ 1972000p -0.3
+ 1972010p 0.9
+ 1974000p 0.9
+ 1974010p -0.3
+ 1976000p -0.3
+ 1976010p 0.9
+ 1978000p 0.9
+ 1978010p -0.3
+ 1980000p -0.3
+ 1980010p 0.9
+ 1982000p 0.9
+ 1982010p -0.3
+ 1984000p -0.3
+ 1984010p 0.9
+ 1986000p 0.9
+ 1986010p -0.3
+ 1988000p -0.3
+ 1988010p 0.9
+ 1990000p 0.9
+ 1990010p -0.3
+ 1992000p -0.3
+ 1992010p 0.9
+ 1994000p 0.9
+ 1994010p -0.3
+ 1996000p -0.3
+ 1996010p 0.9
+ 1998000p 0.9
+ 1998010p -0.3
+ 2000000p -0.3
+ 2000010p 0.9
+ 2002000p 0.9
+ 2002010p -0.3
+ 2004000p -0.3
+ 2004010p 0.9
+ 2006000p 0.9
+ 2006010p -0.3
+ 2008000p -0.3
+ 2008010p 0.9
+ 2010000p 0.9
+ 2010010p -0.3
+ 2012000p -0.3
+ 2012010p 0.9
+ 2014000p 0.9
+ 2014010p -0.3
+ 2016000p -0.3
+ 2016010p 0.9
+ 2018000p 0.9
+ 2018010p -0.3
+ 2020000p -0.3
+ 2020010p 0.9
+ 2022000p 0.9
+ 2022010p -0.3
+ 2024000p -0.3
+ 2024010p 0.9
+ 2026000p 0.9
+ 2026010p -0.3
+ 2028000p -0.3
+ 2028010p 0.9
+ 2030000p 0.9
+ 2030010p -0.3
+ 2032000p -0.3
+ 2032010p 0.9
+ 2034000p 0.9
+ 2034010p -0.3
+ 2036000p -0.3
+ 2036010p 0.9
+ 2038000p 0.9
+ 2038010p -0.3
+ 2040000p -0.3
+ 2040010p 0.9
+ 2042000p 0.9
+ 2042010p -0.3
+ 2044000p -0.3
+ 2044010p 0.9
+ 2046000p 0.9
+ 2046010p -0.3
+ 2048000p -0.3
+ 2048010p 0.9
+ \]
V_data_bar_12 (Data_bar\\<12\\> gnd!) vsource type=pwl wave=\[
+ 0    -0.3
+ 2000p -0.3
+ 2010p 0.9
+ 4000p 0.9
+ 4010p -0.3
+ 6000p -0.3
+ 6010p 0.9
+ 8000p 0.9
+ 8010p -0.3
+ 10000p -0.3
+ 10010p 0.9
+ 12000p 0.9
+ 12010p -0.3
+ 14000p -0.3
+ 14010p 0.9
+ 16000p 0.9
+ 16010p -0.3
+ 18000p -0.3
+ 18010p 0.9
+ 20000p 0.9
+ 20010p -0.3
+ 22000p -0.3
+ 22010p 0.9
+ 24000p 0.9
+ 24010p -0.3
+ 26000p -0.3
+ 26010p 0.9
+ 28000p 0.9
+ 28010p -0.3
+ 30000p -0.3
+ 30010p 0.9
+ 32000p 0.9
+ 32010p -0.3
+ 34000p -0.3
+ 34010p 0.9
+ 36000p 0.9
+ 36010p -0.3
+ 38000p -0.3
+ 38010p 0.9
+ 40000p 0.9
+ 40010p -0.3
+ 42000p -0.3
+ 42010p 0.9
+ 44000p 0.9
+ 44010p -0.3
+ 46000p -0.3
+ 46010p 0.9
+ 48000p 0.9
+ 48010p -0.3
+ 50000p -0.3
+ 50010p 0.9
+ 52000p 0.9
+ 52010p -0.3
+ 54000p -0.3
+ 54010p 0.9
+ 56000p 0.9
+ 56010p -0.3
+ 58000p -0.3
+ 58010p 0.9
+ 60000p 0.9
+ 60010p -0.3
+ 62000p -0.3
+ 62010p 0.9
+ 64000p 0.9
+ 64010p -0.3
+ 66000p -0.3
+ 66010p 0.9
+ 68000p 0.9
+ 68010p -0.3
+ 70000p -0.3
+ 70010p 0.9
+ 72000p 0.9
+ 72010p -0.3
+ 74000p -0.3
+ 74010p 0.9
+ 76000p 0.9
+ 76010p -0.3
+ 78000p -0.3
+ 78010p 0.9
+ 80000p 0.9
+ 80010p -0.3
+ 82000p -0.3
+ 82010p 0.9
+ 84000p 0.9
+ 84010p -0.3
+ 86000p -0.3
+ 86010p 0.9
+ 88000p 0.9
+ 88010p -0.3
+ 90000p -0.3
+ 90010p 0.9
+ 92000p 0.9
+ 92010p -0.3
+ 94000p -0.3
+ 94010p 0.9
+ 96000p 0.9
+ 96010p -0.3
+ 98000p -0.3
+ 98010p 0.9
+ 100000p 0.9
+ 100010p -0.3
+ 102000p -0.3
+ 102010p 0.9
+ 104000p 0.9
+ 104010p -0.3
+ 106000p -0.3
+ 106010p 0.9
+ 108000p 0.9
+ 108010p -0.3
+ 110000p -0.3
+ 110010p 0.9
+ 112000p 0.9
+ 112010p -0.3
+ 114000p -0.3
+ 114010p 0.9
+ 116000p 0.9
+ 116010p -0.3
+ 118000p -0.3
+ 118010p 0.9
+ 120000p 0.9
+ 120010p -0.3
+ 122000p -0.3
+ 122010p 0.9
+ 124000p 0.9
+ 124010p -0.3
+ 126000p -0.3
+ 126010p 0.9
+ 128000p 0.9
+ 128010p -0.3
+ 130000p -0.3
+ 130010p 0.9
+ 132000p 0.9
+ 132010p -0.3
+ 134000p -0.3
+ 134010p 0.9
+ 136000p 0.9
+ 136010p -0.3
+ 138000p -0.3
+ 138010p 0.9
+ 140000p 0.9
+ 140010p -0.3
+ 142000p -0.3
+ 142010p 0.9
+ 144000p 0.9
+ 144010p -0.3
+ 146000p -0.3
+ 146010p 0.9
+ 148000p 0.9
+ 148010p -0.3
+ 150000p -0.3
+ 150010p 0.9
+ 152000p 0.9
+ 152010p -0.3
+ 154000p -0.3
+ 154010p 0.9
+ 156000p 0.9
+ 156010p -0.3
+ 158000p -0.3
+ 158010p 0.9
+ 160000p 0.9
+ 160010p -0.3
+ 162000p -0.3
+ 162010p 0.9
+ 164000p 0.9
+ 164010p -0.3
+ 166000p -0.3
+ 166010p 0.9
+ 168000p 0.9
+ 168010p -0.3
+ 170000p -0.3
+ 170010p 0.9
+ 172000p 0.9
+ 172010p -0.3
+ 174000p -0.3
+ 174010p 0.9
+ 176000p 0.9
+ 176010p -0.3
+ 178000p -0.3
+ 178010p 0.9
+ 180000p 0.9
+ 180010p -0.3
+ 182000p -0.3
+ 182010p 0.9
+ 184000p 0.9
+ 184010p -0.3
+ 186000p -0.3
+ 186010p 0.9
+ 188000p 0.9
+ 188010p -0.3
+ 190000p -0.3
+ 190010p 0.9
+ 192000p 0.9
+ 192010p -0.3
+ 194000p -0.3
+ 194010p 0.9
+ 196000p 0.9
+ 196010p -0.3
+ 198000p -0.3
+ 198010p 0.9
+ 200000p 0.9
+ 200010p -0.3
+ 202000p -0.3
+ 202010p 0.9
+ 204000p 0.9
+ 204010p -0.3
+ 206000p -0.3
+ 206010p 0.9
+ 208000p 0.9
+ 208010p -0.3
+ 210000p -0.3
+ 210010p 0.9
+ 212000p 0.9
+ 212010p -0.3
+ 214000p -0.3
+ 214010p 0.9
+ 216000p 0.9
+ 216010p -0.3
+ 218000p -0.3
+ 218010p 0.9
+ 220000p 0.9
+ 220010p -0.3
+ 222000p -0.3
+ 222010p 0.9
+ 224000p 0.9
+ 224010p -0.3
+ 226000p -0.3
+ 226010p 0.9
+ 228000p 0.9
+ 228010p -0.3
+ 230000p -0.3
+ 230010p 0.9
+ 232000p 0.9
+ 232010p -0.3
+ 234000p -0.3
+ 234010p 0.9
+ 236000p 0.9
+ 236010p -0.3
+ 238000p -0.3
+ 238010p 0.9
+ 240000p 0.9
+ 240010p -0.3
+ 242000p -0.3
+ 242010p 0.9
+ 244000p 0.9
+ 244010p -0.3
+ 246000p -0.3
+ 246010p 0.9
+ 248000p 0.9
+ 248010p -0.3
+ 250000p -0.3
+ 250010p 0.9
+ 252000p 0.9
+ 252010p -0.3
+ 254000p -0.3
+ 254010p 0.9
+ 256000p 0.9
+ 256010p -0.3
+ 258000p -0.3
+ 258010p 0.9
+ 260000p 0.9
+ 260010p -0.3
+ 262000p -0.3
+ 262010p 0.9
+ 264000p 0.9
+ 264010p -0.3
+ 266000p -0.3
+ 266010p 0.9
+ 268000p 0.9
+ 268010p -0.3
+ 270000p -0.3
+ 270010p 0.9
+ 272000p 0.9
+ 272010p -0.3
+ 274000p -0.3
+ 274010p 0.9
+ 276000p 0.9
+ 276010p -0.3
+ 278000p -0.3
+ 278010p 0.9
+ 280000p 0.9
+ 280010p -0.3
+ 282000p -0.3
+ 282010p 0.9
+ 284000p 0.9
+ 284010p -0.3
+ 286000p -0.3
+ 286010p 0.9
+ 288000p 0.9
+ 288010p -0.3
+ 290000p -0.3
+ 290010p 0.9
+ 292000p 0.9
+ 292010p -0.3
+ 294000p -0.3
+ 294010p 0.9
+ 296000p 0.9
+ 296010p -0.3
+ 298000p -0.3
+ 298010p 0.9
+ 300000p 0.9
+ 300010p -0.3
+ 302000p -0.3
+ 302010p 0.9
+ 304000p 0.9
+ 304010p -0.3
+ 306000p -0.3
+ 306010p 0.9
+ 308000p 0.9
+ 308010p -0.3
+ 310000p -0.3
+ 310010p 0.9
+ 312000p 0.9
+ 312010p -0.3
+ 314000p -0.3
+ 314010p 0.9
+ 316000p 0.9
+ 316010p -0.3
+ 318000p -0.3
+ 318010p 0.9
+ 320000p 0.9
+ 320010p -0.3
+ 322000p -0.3
+ 322010p 0.9
+ 324000p 0.9
+ 324010p -0.3
+ 326000p -0.3
+ 326010p 0.9
+ 328000p 0.9
+ 328010p -0.3
+ 330000p -0.3
+ 330010p 0.9
+ 332000p 0.9
+ 332010p -0.3
+ 334000p -0.3
+ 334010p 0.9
+ 336000p 0.9
+ 336010p -0.3
+ 338000p -0.3
+ 338010p 0.9
+ 340000p 0.9
+ 340010p -0.3
+ 342000p -0.3
+ 342010p 0.9
+ 344000p 0.9
+ 344010p -0.3
+ 346000p -0.3
+ 346010p 0.9
+ 348000p 0.9
+ 348010p -0.3
+ 350000p -0.3
+ 350010p 0.9
+ 352000p 0.9
+ 352010p -0.3
+ 354000p -0.3
+ 354010p 0.9
+ 356000p 0.9
+ 356010p -0.3
+ 358000p -0.3
+ 358010p 0.9
+ 360000p 0.9
+ 360010p -0.3
+ 362000p -0.3
+ 362010p 0.9
+ 364000p 0.9
+ 364010p -0.3
+ 366000p -0.3
+ 366010p 0.9
+ 368000p 0.9
+ 368010p -0.3
+ 370000p -0.3
+ 370010p 0.9
+ 372000p 0.9
+ 372010p -0.3
+ 374000p -0.3
+ 374010p 0.9
+ 376000p 0.9
+ 376010p -0.3
+ 378000p -0.3
+ 378010p 0.9
+ 380000p 0.9
+ 380010p -0.3
+ 382000p -0.3
+ 382010p 0.9
+ 384000p 0.9
+ 384010p -0.3
+ 386000p -0.3
+ 386010p 0.9
+ 388000p 0.9
+ 388010p -0.3
+ 390000p -0.3
+ 390010p 0.9
+ 392000p 0.9
+ 392010p -0.3
+ 394000p -0.3
+ 394010p 0.9
+ 396000p 0.9
+ 396010p -0.3
+ 398000p -0.3
+ 398010p 0.9
+ 400000p 0.9
+ 400010p -0.3
+ 402000p -0.3
+ 402010p 0.9
+ 404000p 0.9
+ 404010p -0.3
+ 406000p -0.3
+ 406010p 0.9
+ 408000p 0.9
+ 408010p -0.3
+ 410000p -0.3
+ 410010p 0.9
+ 412000p 0.9
+ 412010p -0.3
+ 414000p -0.3
+ 414010p 0.9
+ 416000p 0.9
+ 416010p -0.3
+ 418000p -0.3
+ 418010p 0.9
+ 420000p 0.9
+ 420010p -0.3
+ 422000p -0.3
+ 422010p 0.9
+ 424000p 0.9
+ 424010p -0.3
+ 426000p -0.3
+ 426010p 0.9
+ 428000p 0.9
+ 428010p -0.3
+ 430000p -0.3
+ 430010p 0.9
+ 432000p 0.9
+ 432010p -0.3
+ 434000p -0.3
+ 434010p 0.9
+ 436000p 0.9
+ 436010p -0.3
+ 438000p -0.3
+ 438010p 0.9
+ 440000p 0.9
+ 440010p -0.3
+ 442000p -0.3
+ 442010p 0.9
+ 444000p 0.9
+ 444010p -0.3
+ 446000p -0.3
+ 446010p 0.9
+ 448000p 0.9
+ 448010p -0.3
+ 450000p -0.3
+ 450010p 0.9
+ 452000p 0.9
+ 452010p -0.3
+ 454000p -0.3
+ 454010p 0.9
+ 456000p 0.9
+ 456010p -0.3
+ 458000p -0.3
+ 458010p 0.9
+ 460000p 0.9
+ 460010p -0.3
+ 462000p -0.3
+ 462010p 0.9
+ 464000p 0.9
+ 464010p -0.3
+ 466000p -0.3
+ 466010p 0.9
+ 468000p 0.9
+ 468010p -0.3
+ 470000p -0.3
+ 470010p 0.9
+ 472000p 0.9
+ 472010p -0.3
+ 474000p -0.3
+ 474010p 0.9
+ 476000p 0.9
+ 476010p -0.3
+ 478000p -0.3
+ 478010p 0.9
+ 480000p 0.9
+ 480010p -0.3
+ 482000p -0.3
+ 482010p 0.9
+ 484000p 0.9
+ 484010p -0.3
+ 486000p -0.3
+ 486010p 0.9
+ 488000p 0.9
+ 488010p -0.3
+ 490000p -0.3
+ 490010p 0.9
+ 492000p 0.9
+ 492010p -0.3
+ 494000p -0.3
+ 494010p 0.9
+ 496000p 0.9
+ 496010p -0.3
+ 498000p -0.3
+ 498010p 0.9
+ 500000p 0.9
+ 500010p -0.3
+ 502000p -0.3
+ 502010p 0.9
+ 504000p 0.9
+ 504010p -0.3
+ 506000p -0.3
+ 506010p 0.9
+ 508000p 0.9
+ 508010p -0.3
+ 510000p -0.3
+ 510010p 0.9
+ 512000p 0.9
+ 512010p -0.3
+ 514000p -0.3
+ 514010p 0.9
+ 516000p 0.9
+ 516010p -0.3
+ 518000p -0.3
+ 518010p 0.9
+ 520000p 0.9
+ 520010p -0.3
+ 522000p -0.3
+ 522010p 0.9
+ 524000p 0.9
+ 524010p -0.3
+ 526000p -0.3
+ 526010p 0.9
+ 528000p 0.9
+ 528010p -0.3
+ 530000p -0.3
+ 530010p 0.9
+ 532000p 0.9
+ 532010p -0.3
+ 534000p -0.3
+ 534010p 0.9
+ 536000p 0.9
+ 536010p -0.3
+ 538000p -0.3
+ 538010p 0.9
+ 540000p 0.9
+ 540010p -0.3
+ 542000p -0.3
+ 542010p 0.9
+ 544000p 0.9
+ 544010p -0.3
+ 546000p -0.3
+ 546010p 0.9
+ 548000p 0.9
+ 548010p -0.3
+ 550000p -0.3
+ 550010p 0.9
+ 552000p 0.9
+ 552010p -0.3
+ 554000p -0.3
+ 554010p 0.9
+ 556000p 0.9
+ 556010p -0.3
+ 558000p -0.3
+ 558010p 0.9
+ 560000p 0.9
+ 560010p -0.3
+ 562000p -0.3
+ 562010p 0.9
+ 564000p 0.9
+ 564010p -0.3
+ 566000p -0.3
+ 566010p 0.9
+ 568000p 0.9
+ 568010p -0.3
+ 570000p -0.3
+ 570010p 0.9
+ 572000p 0.9
+ 572010p -0.3
+ 574000p -0.3
+ 574010p 0.9
+ 576000p 0.9
+ 576010p -0.3
+ 578000p -0.3
+ 578010p 0.9
+ 580000p 0.9
+ 580010p -0.3
+ 582000p -0.3
+ 582010p 0.9
+ 584000p 0.9
+ 584010p -0.3
+ 586000p -0.3
+ 586010p 0.9
+ 588000p 0.9
+ 588010p -0.3
+ 590000p -0.3
+ 590010p 0.9
+ 592000p 0.9
+ 592010p -0.3
+ 594000p -0.3
+ 594010p 0.9
+ 596000p 0.9
+ 596010p -0.3
+ 598000p -0.3
+ 598010p 0.9
+ 600000p 0.9
+ 600010p -0.3
+ 602000p -0.3
+ 602010p 0.9
+ 604000p 0.9
+ 604010p -0.3
+ 606000p -0.3
+ 606010p 0.9
+ 608000p 0.9
+ 608010p -0.3
+ 610000p -0.3
+ 610010p 0.9
+ 612000p 0.9
+ 612010p -0.3
+ 614000p -0.3
+ 614010p 0.9
+ 616000p 0.9
+ 616010p -0.3
+ 618000p -0.3
+ 618010p 0.9
+ 620000p 0.9
+ 620010p -0.3
+ 622000p -0.3
+ 622010p 0.9
+ 624000p 0.9
+ 624010p -0.3
+ 626000p -0.3
+ 626010p 0.9
+ 628000p 0.9
+ 628010p -0.3
+ 630000p -0.3
+ 630010p 0.9
+ 632000p 0.9
+ 632010p -0.3
+ 634000p -0.3
+ 634010p 0.9
+ 636000p 0.9
+ 636010p -0.3
+ 638000p -0.3
+ 638010p 0.9
+ 640000p 0.9
+ 640010p -0.3
+ 642000p -0.3
+ 642010p 0.9
+ 644000p 0.9
+ 644010p -0.3
+ 646000p -0.3
+ 646010p 0.9
+ 648000p 0.9
+ 648010p -0.3
+ 650000p -0.3
+ 650010p 0.9
+ 652000p 0.9
+ 652010p -0.3
+ 654000p -0.3
+ 654010p 0.9
+ 656000p 0.9
+ 656010p -0.3
+ 658000p -0.3
+ 658010p 0.9
+ 660000p 0.9
+ 660010p -0.3
+ 662000p -0.3
+ 662010p 0.9
+ 664000p 0.9
+ 664010p -0.3
+ 666000p -0.3
+ 666010p 0.9
+ 668000p 0.9
+ 668010p -0.3
+ 670000p -0.3
+ 670010p 0.9
+ 672000p 0.9
+ 672010p -0.3
+ 674000p -0.3
+ 674010p 0.9
+ 676000p 0.9
+ 676010p -0.3
+ 678000p -0.3
+ 678010p 0.9
+ 680000p 0.9
+ 680010p -0.3
+ 682000p -0.3
+ 682010p 0.9
+ 684000p 0.9
+ 684010p -0.3
+ 686000p -0.3
+ 686010p 0.9
+ 688000p 0.9
+ 688010p -0.3
+ 690000p -0.3
+ 690010p 0.9
+ 692000p 0.9
+ 692010p -0.3
+ 694000p -0.3
+ 694010p 0.9
+ 696000p 0.9
+ 696010p -0.3
+ 698000p -0.3
+ 698010p 0.9
+ 700000p 0.9
+ 700010p -0.3
+ 702000p -0.3
+ 702010p 0.9
+ 704000p 0.9
+ 704010p -0.3
+ 706000p -0.3
+ 706010p 0.9
+ 708000p 0.9
+ 708010p -0.3
+ 710000p -0.3
+ 710010p 0.9
+ 712000p 0.9
+ 712010p -0.3
+ 714000p -0.3
+ 714010p 0.9
+ 716000p 0.9
+ 716010p -0.3
+ 718000p -0.3
+ 718010p 0.9
+ 720000p 0.9
+ 720010p -0.3
+ 722000p -0.3
+ 722010p 0.9
+ 724000p 0.9
+ 724010p -0.3
+ 726000p -0.3
+ 726010p 0.9
+ 728000p 0.9
+ 728010p -0.3
+ 730000p -0.3
+ 730010p 0.9
+ 732000p 0.9
+ 732010p -0.3
+ 734000p -0.3
+ 734010p 0.9
+ 736000p 0.9
+ 736010p -0.3
+ 738000p -0.3
+ 738010p 0.9
+ 740000p 0.9
+ 740010p -0.3
+ 742000p -0.3
+ 742010p 0.9
+ 744000p 0.9
+ 744010p -0.3
+ 746000p -0.3
+ 746010p 0.9
+ 748000p 0.9
+ 748010p -0.3
+ 750000p -0.3
+ 750010p 0.9
+ 752000p 0.9
+ 752010p -0.3
+ 754000p -0.3
+ 754010p 0.9
+ 756000p 0.9
+ 756010p -0.3
+ 758000p -0.3
+ 758010p 0.9
+ 760000p 0.9
+ 760010p -0.3
+ 762000p -0.3
+ 762010p 0.9
+ 764000p 0.9
+ 764010p -0.3
+ 766000p -0.3
+ 766010p 0.9
+ 768000p 0.9
+ 768010p -0.3
+ 770000p -0.3
+ 770010p 0.9
+ 772000p 0.9
+ 772010p -0.3
+ 774000p -0.3
+ 774010p 0.9
+ 776000p 0.9
+ 776010p -0.3
+ 778000p -0.3
+ 778010p 0.9
+ 780000p 0.9
+ 780010p -0.3
+ 782000p -0.3
+ 782010p 0.9
+ 784000p 0.9
+ 784010p -0.3
+ 786000p -0.3
+ 786010p 0.9
+ 788000p 0.9
+ 788010p -0.3
+ 790000p -0.3
+ 790010p 0.9
+ 792000p 0.9
+ 792010p -0.3
+ 794000p -0.3
+ 794010p 0.9
+ 796000p 0.9
+ 796010p -0.3
+ 798000p -0.3
+ 798010p 0.9
+ 800000p 0.9
+ 800010p -0.3
+ 802000p -0.3
+ 802010p 0.9
+ 804000p 0.9
+ 804010p -0.3
+ 806000p -0.3
+ 806010p 0.9
+ 808000p 0.9
+ 808010p -0.3
+ 810000p -0.3
+ 810010p 0.9
+ 812000p 0.9
+ 812010p -0.3
+ 814000p -0.3
+ 814010p 0.9
+ 816000p 0.9
+ 816010p -0.3
+ 818000p -0.3
+ 818010p 0.9
+ 820000p 0.9
+ 820010p -0.3
+ 822000p -0.3
+ 822010p 0.9
+ 824000p 0.9
+ 824010p -0.3
+ 826000p -0.3
+ 826010p 0.9
+ 828000p 0.9
+ 828010p -0.3
+ 830000p -0.3
+ 830010p 0.9
+ 832000p 0.9
+ 832010p -0.3
+ 834000p -0.3
+ 834010p 0.9
+ 836000p 0.9
+ 836010p -0.3
+ 838000p -0.3
+ 838010p 0.9
+ 840000p 0.9
+ 840010p -0.3
+ 842000p -0.3
+ 842010p 0.9
+ 844000p 0.9
+ 844010p -0.3
+ 846000p -0.3
+ 846010p 0.9
+ 848000p 0.9
+ 848010p -0.3
+ 850000p -0.3
+ 850010p 0.9
+ 852000p 0.9
+ 852010p -0.3
+ 854000p -0.3
+ 854010p 0.9
+ 856000p 0.9
+ 856010p -0.3
+ 858000p -0.3
+ 858010p 0.9
+ 860000p 0.9
+ 860010p -0.3
+ 862000p -0.3
+ 862010p 0.9
+ 864000p 0.9
+ 864010p -0.3
+ 866000p -0.3
+ 866010p 0.9
+ 868000p 0.9
+ 868010p -0.3
+ 870000p -0.3
+ 870010p 0.9
+ 872000p 0.9
+ 872010p -0.3
+ 874000p -0.3
+ 874010p 0.9
+ 876000p 0.9
+ 876010p -0.3
+ 878000p -0.3
+ 878010p 0.9
+ 880000p 0.9
+ 880010p -0.3
+ 882000p -0.3
+ 882010p 0.9
+ 884000p 0.9
+ 884010p -0.3
+ 886000p -0.3
+ 886010p 0.9
+ 888000p 0.9
+ 888010p -0.3
+ 890000p -0.3
+ 890010p 0.9
+ 892000p 0.9
+ 892010p -0.3
+ 894000p -0.3
+ 894010p 0.9
+ 896000p 0.9
+ 896010p -0.3
+ 898000p -0.3
+ 898010p 0.9
+ 900000p 0.9
+ 900010p -0.3
+ 902000p -0.3
+ 902010p 0.9
+ 904000p 0.9
+ 904010p -0.3
+ 906000p -0.3
+ 906010p 0.9
+ 908000p 0.9
+ 908010p -0.3
+ 910000p -0.3
+ 910010p 0.9
+ 912000p 0.9
+ 912010p -0.3
+ 914000p -0.3
+ 914010p 0.9
+ 916000p 0.9
+ 916010p -0.3
+ 918000p -0.3
+ 918010p 0.9
+ 920000p 0.9
+ 920010p -0.3
+ 922000p -0.3
+ 922010p 0.9
+ 924000p 0.9
+ 924010p -0.3
+ 926000p -0.3
+ 926010p 0.9
+ 928000p 0.9
+ 928010p -0.3
+ 930000p -0.3
+ 930010p 0.9
+ 932000p 0.9
+ 932010p -0.3
+ 934000p -0.3
+ 934010p 0.9
+ 936000p 0.9
+ 936010p -0.3
+ 938000p -0.3
+ 938010p 0.9
+ 940000p 0.9
+ 940010p -0.3
+ 942000p -0.3
+ 942010p 0.9
+ 944000p 0.9
+ 944010p -0.3
+ 946000p -0.3
+ 946010p 0.9
+ 948000p 0.9
+ 948010p -0.3
+ 950000p -0.3
+ 950010p 0.9
+ 952000p 0.9
+ 952010p -0.3
+ 954000p -0.3
+ 954010p 0.9
+ 956000p 0.9
+ 956010p -0.3
+ 958000p -0.3
+ 958010p 0.9
+ 960000p 0.9
+ 960010p -0.3
+ 962000p -0.3
+ 962010p 0.9
+ 964000p 0.9
+ 964010p -0.3
+ 966000p -0.3
+ 966010p 0.9
+ 968000p 0.9
+ 968010p -0.3
+ 970000p -0.3
+ 970010p 0.9
+ 972000p 0.9
+ 972010p -0.3
+ 974000p -0.3
+ 974010p 0.9
+ 976000p 0.9
+ 976010p -0.3
+ 978000p -0.3
+ 978010p 0.9
+ 980000p 0.9
+ 980010p -0.3
+ 982000p -0.3
+ 982010p 0.9
+ 984000p 0.9
+ 984010p -0.3
+ 986000p -0.3
+ 986010p 0.9
+ 988000p 0.9
+ 988010p -0.3
+ 990000p -0.3
+ 990010p 0.9
+ 992000p 0.9
+ 992010p -0.3
+ 994000p -0.3
+ 994010p 0.9
+ 996000p 0.9
+ 996010p -0.3
+ 998000p -0.3
+ 998010p 0.9
+ 1000000p 0.9
+ 1000010p -0.3
+ 1002000p -0.3
+ 1002010p 0.9
+ 1004000p 0.9
+ 1004010p -0.3
+ 1006000p -0.3
+ 1006010p 0.9
+ 1008000p 0.9
+ 1008010p -0.3
+ 1010000p -0.3
+ 1010010p 0.9
+ 1012000p 0.9
+ 1012010p -0.3
+ 1014000p -0.3
+ 1014010p 0.9
+ 1016000p 0.9
+ 1016010p -0.3
+ 1018000p -0.3
+ 1018010p 0.9
+ 1020000p 0.9
+ 1020010p -0.3
+ 1022000p -0.3
+ 1022010p 0.9
+ 1024000p 0.9
+ 1024010p -0.3
+ 1026000p -0.3
+ 1026010p 0.9
+ 1028000p 0.9
+ 1028010p -0.3
+ 1030000p -0.3
+ 1030010p 0.9
+ 1032000p 0.9
+ 1032010p -0.3
+ 1034000p -0.3
+ 1034010p 0.9
+ 1036000p 0.9
+ 1036010p -0.3
+ 1038000p -0.3
+ 1038010p 0.9
+ 1040000p 0.9
+ 1040010p -0.3
+ 1042000p -0.3
+ 1042010p 0.9
+ 1044000p 0.9
+ 1044010p -0.3
+ 1046000p -0.3
+ 1046010p 0.9
+ 1048000p 0.9
+ 1048010p -0.3
+ 1050000p -0.3
+ 1050010p 0.9
+ 1052000p 0.9
+ 1052010p -0.3
+ 1054000p -0.3
+ 1054010p 0.9
+ 1056000p 0.9
+ 1056010p -0.3
+ 1058000p -0.3
+ 1058010p 0.9
+ 1060000p 0.9
+ 1060010p -0.3
+ 1062000p -0.3
+ 1062010p 0.9
+ 1064000p 0.9
+ 1064010p -0.3
+ 1066000p -0.3
+ 1066010p 0.9
+ 1068000p 0.9
+ 1068010p -0.3
+ 1070000p -0.3
+ 1070010p 0.9
+ 1072000p 0.9
+ 1072010p -0.3
+ 1074000p -0.3
+ 1074010p 0.9
+ 1076000p 0.9
+ 1076010p -0.3
+ 1078000p -0.3
+ 1078010p 0.9
+ 1080000p 0.9
+ 1080010p -0.3
+ 1082000p -0.3
+ 1082010p 0.9
+ 1084000p 0.9
+ 1084010p -0.3
+ 1086000p -0.3
+ 1086010p 0.9
+ 1088000p 0.9
+ 1088010p -0.3
+ 1090000p -0.3
+ 1090010p 0.9
+ 1092000p 0.9
+ 1092010p -0.3
+ 1094000p -0.3
+ 1094010p 0.9
+ 1096000p 0.9
+ 1096010p -0.3
+ 1098000p -0.3
+ 1098010p 0.9
+ 1100000p 0.9
+ 1100010p -0.3
+ 1102000p -0.3
+ 1102010p 0.9
+ 1104000p 0.9
+ 1104010p -0.3
+ 1106000p -0.3
+ 1106010p 0.9
+ 1108000p 0.9
+ 1108010p -0.3
+ 1110000p -0.3
+ 1110010p 0.9
+ 1112000p 0.9
+ 1112010p -0.3
+ 1114000p -0.3
+ 1114010p 0.9
+ 1116000p 0.9
+ 1116010p -0.3
+ 1118000p -0.3
+ 1118010p 0.9
+ 1120000p 0.9
+ 1120010p -0.3
+ 1122000p -0.3
+ 1122010p 0.9
+ 1124000p 0.9
+ 1124010p -0.3
+ 1126000p -0.3
+ 1126010p 0.9
+ 1128000p 0.9
+ 1128010p -0.3
+ 1130000p -0.3
+ 1130010p 0.9
+ 1132000p 0.9
+ 1132010p -0.3
+ 1134000p -0.3
+ 1134010p 0.9
+ 1136000p 0.9
+ 1136010p -0.3
+ 1138000p -0.3
+ 1138010p 0.9
+ 1140000p 0.9
+ 1140010p -0.3
+ 1142000p -0.3
+ 1142010p 0.9
+ 1144000p 0.9
+ 1144010p -0.3
+ 1146000p -0.3
+ 1146010p 0.9
+ 1148000p 0.9
+ 1148010p -0.3
+ 1150000p -0.3
+ 1150010p 0.9
+ 1152000p 0.9
+ 1152010p -0.3
+ 1154000p -0.3
+ 1154010p 0.9
+ 1156000p 0.9
+ 1156010p -0.3
+ 1158000p -0.3
+ 1158010p 0.9
+ 1160000p 0.9
+ 1160010p -0.3
+ 1162000p -0.3
+ 1162010p 0.9
+ 1164000p 0.9
+ 1164010p -0.3
+ 1166000p -0.3
+ 1166010p 0.9
+ 1168000p 0.9
+ 1168010p -0.3
+ 1170000p -0.3
+ 1170010p 0.9
+ 1172000p 0.9
+ 1172010p -0.3
+ 1174000p -0.3
+ 1174010p 0.9
+ 1176000p 0.9
+ 1176010p -0.3
+ 1178000p -0.3
+ 1178010p 0.9
+ 1180000p 0.9
+ 1180010p -0.3
+ 1182000p -0.3
+ 1182010p 0.9
+ 1184000p 0.9
+ 1184010p -0.3
+ 1186000p -0.3
+ 1186010p 0.9
+ 1188000p 0.9
+ 1188010p -0.3
+ 1190000p -0.3
+ 1190010p 0.9
+ 1192000p 0.9
+ 1192010p -0.3
+ 1194000p -0.3
+ 1194010p 0.9
+ 1196000p 0.9
+ 1196010p -0.3
+ 1198000p -0.3
+ 1198010p 0.9
+ 1200000p 0.9
+ 1200010p -0.3
+ 1202000p -0.3
+ 1202010p 0.9
+ 1204000p 0.9
+ 1204010p -0.3
+ 1206000p -0.3
+ 1206010p 0.9
+ 1208000p 0.9
+ 1208010p -0.3
+ 1210000p -0.3
+ 1210010p 0.9
+ 1212000p 0.9
+ 1212010p -0.3
+ 1214000p -0.3
+ 1214010p 0.9
+ 1216000p 0.9
+ 1216010p -0.3
+ 1218000p -0.3
+ 1218010p 0.9
+ 1220000p 0.9
+ 1220010p -0.3
+ 1222000p -0.3
+ 1222010p 0.9
+ 1224000p 0.9
+ 1224010p -0.3
+ 1226000p -0.3
+ 1226010p 0.9
+ 1228000p 0.9
+ 1228010p -0.3
+ 1230000p -0.3
+ 1230010p 0.9
+ 1232000p 0.9
+ 1232010p -0.3
+ 1234000p -0.3
+ 1234010p 0.9
+ 1236000p 0.9
+ 1236010p -0.3
+ 1238000p -0.3
+ 1238010p 0.9
+ 1240000p 0.9
+ 1240010p -0.3
+ 1242000p -0.3
+ 1242010p 0.9
+ 1244000p 0.9
+ 1244010p -0.3
+ 1246000p -0.3
+ 1246010p 0.9
+ 1248000p 0.9
+ 1248010p -0.3
+ 1250000p -0.3
+ 1250010p 0.9
+ 1252000p 0.9
+ 1252010p -0.3
+ 1254000p -0.3
+ 1254010p 0.9
+ 1256000p 0.9
+ 1256010p -0.3
+ 1258000p -0.3
+ 1258010p 0.9
+ 1260000p 0.9
+ 1260010p -0.3
+ 1262000p -0.3
+ 1262010p 0.9
+ 1264000p 0.9
+ 1264010p -0.3
+ 1266000p -0.3
+ 1266010p 0.9
+ 1268000p 0.9
+ 1268010p -0.3
+ 1270000p -0.3
+ 1270010p 0.9
+ 1272000p 0.9
+ 1272010p -0.3
+ 1274000p -0.3
+ 1274010p 0.9
+ 1276000p 0.9
+ 1276010p -0.3
+ 1278000p -0.3
+ 1278010p 0.9
+ 1280000p 0.9
+ 1280010p -0.3
+ 1282000p -0.3
+ 1282010p 0.9
+ 1284000p 0.9
+ 1284010p -0.3
+ 1286000p -0.3
+ 1286010p 0.9
+ 1288000p 0.9
+ 1288010p -0.3
+ 1290000p -0.3
+ 1290010p 0.9
+ 1292000p 0.9
+ 1292010p -0.3
+ 1294000p -0.3
+ 1294010p 0.9
+ 1296000p 0.9
+ 1296010p -0.3
+ 1298000p -0.3
+ 1298010p 0.9
+ 1300000p 0.9
+ 1300010p -0.3
+ 1302000p -0.3
+ 1302010p 0.9
+ 1304000p 0.9
+ 1304010p -0.3
+ 1306000p -0.3
+ 1306010p 0.9
+ 1308000p 0.9
+ 1308010p -0.3
+ 1310000p -0.3
+ 1310010p 0.9
+ 1312000p 0.9
+ 1312010p -0.3
+ 1314000p -0.3
+ 1314010p 0.9
+ 1316000p 0.9
+ 1316010p -0.3
+ 1318000p -0.3
+ 1318010p 0.9
+ 1320000p 0.9
+ 1320010p -0.3
+ 1322000p -0.3
+ 1322010p 0.9
+ 1324000p 0.9
+ 1324010p -0.3
+ 1326000p -0.3
+ 1326010p 0.9
+ 1328000p 0.9
+ 1328010p -0.3
+ 1330000p -0.3
+ 1330010p 0.9
+ 1332000p 0.9
+ 1332010p -0.3
+ 1334000p -0.3
+ 1334010p 0.9
+ 1336000p 0.9
+ 1336010p -0.3
+ 1338000p -0.3
+ 1338010p 0.9
+ 1340000p 0.9
+ 1340010p -0.3
+ 1342000p -0.3
+ 1342010p 0.9
+ 1344000p 0.9
+ 1344010p -0.3
+ 1346000p -0.3
+ 1346010p 0.9
+ 1348000p 0.9
+ 1348010p -0.3
+ 1350000p -0.3
+ 1350010p 0.9
+ 1352000p 0.9
+ 1352010p -0.3
+ 1354000p -0.3
+ 1354010p 0.9
+ 1356000p 0.9
+ 1356010p -0.3
+ 1358000p -0.3
+ 1358010p 0.9
+ 1360000p 0.9
+ 1360010p -0.3
+ 1362000p -0.3
+ 1362010p 0.9
+ 1364000p 0.9
+ 1364010p -0.3
+ 1366000p -0.3
+ 1366010p 0.9
+ 1368000p 0.9
+ 1368010p -0.3
+ 1370000p -0.3
+ 1370010p 0.9
+ 1372000p 0.9
+ 1372010p -0.3
+ 1374000p -0.3
+ 1374010p 0.9
+ 1376000p 0.9
+ 1376010p -0.3
+ 1378000p -0.3
+ 1378010p 0.9
+ 1380000p 0.9
+ 1380010p -0.3
+ 1382000p -0.3
+ 1382010p 0.9
+ 1384000p 0.9
+ 1384010p -0.3
+ 1386000p -0.3
+ 1386010p 0.9
+ 1388000p 0.9
+ 1388010p -0.3
+ 1390000p -0.3
+ 1390010p 0.9
+ 1392000p 0.9
+ 1392010p -0.3
+ 1394000p -0.3
+ 1394010p 0.9
+ 1396000p 0.9
+ 1396010p -0.3
+ 1398000p -0.3
+ 1398010p 0.9
+ 1400000p 0.9
+ 1400010p -0.3
+ 1402000p -0.3
+ 1402010p 0.9
+ 1404000p 0.9
+ 1404010p -0.3
+ 1406000p -0.3
+ 1406010p 0.9
+ 1408000p 0.9
+ 1408010p -0.3
+ 1410000p -0.3
+ 1410010p 0.9
+ 1412000p 0.9
+ 1412010p -0.3
+ 1414000p -0.3
+ 1414010p 0.9
+ 1416000p 0.9
+ 1416010p -0.3
+ 1418000p -0.3
+ 1418010p 0.9
+ 1420000p 0.9
+ 1420010p -0.3
+ 1422000p -0.3
+ 1422010p 0.9
+ 1424000p 0.9
+ 1424010p -0.3
+ 1426000p -0.3
+ 1426010p 0.9
+ 1428000p 0.9
+ 1428010p -0.3
+ 1430000p -0.3
+ 1430010p 0.9
+ 1432000p 0.9
+ 1432010p -0.3
+ 1434000p -0.3
+ 1434010p 0.9
+ 1436000p 0.9
+ 1436010p -0.3
+ 1438000p -0.3
+ 1438010p 0.9
+ 1440000p 0.9
+ 1440010p -0.3
+ 1442000p -0.3
+ 1442010p 0.9
+ 1444000p 0.9
+ 1444010p -0.3
+ 1446000p -0.3
+ 1446010p 0.9
+ 1448000p 0.9
+ 1448010p -0.3
+ 1450000p -0.3
+ 1450010p 0.9
+ 1452000p 0.9
+ 1452010p -0.3
+ 1454000p -0.3
+ 1454010p 0.9
+ 1456000p 0.9
+ 1456010p -0.3
+ 1458000p -0.3
+ 1458010p 0.9
+ 1460000p 0.9
+ 1460010p -0.3
+ 1462000p -0.3
+ 1462010p 0.9
+ 1464000p 0.9
+ 1464010p -0.3
+ 1466000p -0.3
+ 1466010p 0.9
+ 1468000p 0.9
+ 1468010p -0.3
+ 1470000p -0.3
+ 1470010p 0.9
+ 1472000p 0.9
+ 1472010p -0.3
+ 1474000p -0.3
+ 1474010p 0.9
+ 1476000p 0.9
+ 1476010p -0.3
+ 1478000p -0.3
+ 1478010p 0.9
+ 1480000p 0.9
+ 1480010p -0.3
+ 1482000p -0.3
+ 1482010p 0.9
+ 1484000p 0.9
+ 1484010p -0.3
+ 1486000p -0.3
+ 1486010p 0.9
+ 1488000p 0.9
+ 1488010p -0.3
+ 1490000p -0.3
+ 1490010p 0.9
+ 1492000p 0.9
+ 1492010p -0.3
+ 1494000p -0.3
+ 1494010p 0.9
+ 1496000p 0.9
+ 1496010p -0.3
+ 1498000p -0.3
+ 1498010p 0.9
+ 1500000p 0.9
+ 1500010p -0.3
+ 1502000p -0.3
+ 1502010p 0.9
+ 1504000p 0.9
+ 1504010p -0.3
+ 1506000p -0.3
+ 1506010p 0.9
+ 1508000p 0.9
+ 1508010p -0.3
+ 1510000p -0.3
+ 1510010p 0.9
+ 1512000p 0.9
+ 1512010p -0.3
+ 1514000p -0.3
+ 1514010p 0.9
+ 1516000p 0.9
+ 1516010p -0.3
+ 1518000p -0.3
+ 1518010p 0.9
+ 1520000p 0.9
+ 1520010p -0.3
+ 1522000p -0.3
+ 1522010p 0.9
+ 1524000p 0.9
+ 1524010p -0.3
+ 1526000p -0.3
+ 1526010p 0.9
+ 1528000p 0.9
+ 1528010p -0.3
+ 1530000p -0.3
+ 1530010p 0.9
+ 1532000p 0.9
+ 1532010p -0.3
+ 1534000p -0.3
+ 1534010p 0.9
+ 1536000p 0.9
+ 1536010p -0.3
+ 1538000p -0.3
+ 1538010p 0.9
+ 1540000p 0.9
+ 1540010p -0.3
+ 1542000p -0.3
+ 1542010p 0.9
+ 1544000p 0.9
+ 1544010p -0.3
+ 1546000p -0.3
+ 1546010p 0.9
+ 1548000p 0.9
+ 1548010p -0.3
+ 1550000p -0.3
+ 1550010p 0.9
+ 1552000p 0.9
+ 1552010p -0.3
+ 1554000p -0.3
+ 1554010p 0.9
+ 1556000p 0.9
+ 1556010p -0.3
+ 1558000p -0.3
+ 1558010p 0.9
+ 1560000p 0.9
+ 1560010p -0.3
+ 1562000p -0.3
+ 1562010p 0.9
+ 1564000p 0.9
+ 1564010p -0.3
+ 1566000p -0.3
+ 1566010p 0.9
+ 1568000p 0.9
+ 1568010p -0.3
+ 1570000p -0.3
+ 1570010p 0.9
+ 1572000p 0.9
+ 1572010p -0.3
+ 1574000p -0.3
+ 1574010p 0.9
+ 1576000p 0.9
+ 1576010p -0.3
+ 1578000p -0.3
+ 1578010p 0.9
+ 1580000p 0.9
+ 1580010p -0.3
+ 1582000p -0.3
+ 1582010p 0.9
+ 1584000p 0.9
+ 1584010p -0.3
+ 1586000p -0.3
+ 1586010p 0.9
+ 1588000p 0.9
+ 1588010p -0.3
+ 1590000p -0.3
+ 1590010p 0.9
+ 1592000p 0.9
+ 1592010p -0.3
+ 1594000p -0.3
+ 1594010p 0.9
+ 1596000p 0.9
+ 1596010p -0.3
+ 1598000p -0.3
+ 1598010p 0.9
+ 1600000p 0.9
+ 1600010p -0.3
+ 1602000p -0.3
+ 1602010p 0.9
+ 1604000p 0.9
+ 1604010p -0.3
+ 1606000p -0.3
+ 1606010p 0.9
+ 1608000p 0.9
+ 1608010p -0.3
+ 1610000p -0.3
+ 1610010p 0.9
+ 1612000p 0.9
+ 1612010p -0.3
+ 1614000p -0.3
+ 1614010p 0.9
+ 1616000p 0.9
+ 1616010p -0.3
+ 1618000p -0.3
+ 1618010p 0.9
+ 1620000p 0.9
+ 1620010p -0.3
+ 1622000p -0.3
+ 1622010p 0.9
+ 1624000p 0.9
+ 1624010p -0.3
+ 1626000p -0.3
+ 1626010p 0.9
+ 1628000p 0.9
+ 1628010p -0.3
+ 1630000p -0.3
+ 1630010p 0.9
+ 1632000p 0.9
+ 1632010p -0.3
+ 1634000p -0.3
+ 1634010p 0.9
+ 1636000p 0.9
+ 1636010p -0.3
+ 1638000p -0.3
+ 1638010p 0.9
+ 1640000p 0.9
+ 1640010p -0.3
+ 1642000p -0.3
+ 1642010p 0.9
+ 1644000p 0.9
+ 1644010p -0.3
+ 1646000p -0.3
+ 1646010p 0.9
+ 1648000p 0.9
+ 1648010p -0.3
+ 1650000p -0.3
+ 1650010p 0.9
+ 1652000p 0.9
+ 1652010p -0.3
+ 1654000p -0.3
+ 1654010p 0.9
+ 1656000p 0.9
+ 1656010p -0.3
+ 1658000p -0.3
+ 1658010p 0.9
+ 1660000p 0.9
+ 1660010p -0.3
+ 1662000p -0.3
+ 1662010p 0.9
+ 1664000p 0.9
+ 1664010p -0.3
+ 1666000p -0.3
+ 1666010p 0.9
+ 1668000p 0.9
+ 1668010p -0.3
+ 1670000p -0.3
+ 1670010p 0.9
+ 1672000p 0.9
+ 1672010p -0.3
+ 1674000p -0.3
+ 1674010p 0.9
+ 1676000p 0.9
+ 1676010p -0.3
+ 1678000p -0.3
+ 1678010p 0.9
+ 1680000p 0.9
+ 1680010p -0.3
+ 1682000p -0.3
+ 1682010p 0.9
+ 1684000p 0.9
+ 1684010p -0.3
+ 1686000p -0.3
+ 1686010p 0.9
+ 1688000p 0.9
+ 1688010p -0.3
+ 1690000p -0.3
+ 1690010p 0.9
+ 1692000p 0.9
+ 1692010p -0.3
+ 1694000p -0.3
+ 1694010p 0.9
+ 1696000p 0.9
+ 1696010p -0.3
+ 1698000p -0.3
+ 1698010p 0.9
+ 1700000p 0.9
+ 1700010p -0.3
+ 1702000p -0.3
+ 1702010p 0.9
+ 1704000p 0.9
+ 1704010p -0.3
+ 1706000p -0.3
+ 1706010p 0.9
+ 1708000p 0.9
+ 1708010p -0.3
+ 1710000p -0.3
+ 1710010p 0.9
+ 1712000p 0.9
+ 1712010p -0.3
+ 1714000p -0.3
+ 1714010p 0.9
+ 1716000p 0.9
+ 1716010p -0.3
+ 1718000p -0.3
+ 1718010p 0.9
+ 1720000p 0.9
+ 1720010p -0.3
+ 1722000p -0.3
+ 1722010p 0.9
+ 1724000p 0.9
+ 1724010p -0.3
+ 1726000p -0.3
+ 1726010p 0.9
+ 1728000p 0.9
+ 1728010p -0.3
+ 1730000p -0.3
+ 1730010p 0.9
+ 1732000p 0.9
+ 1732010p -0.3
+ 1734000p -0.3
+ 1734010p 0.9
+ 1736000p 0.9
+ 1736010p -0.3
+ 1738000p -0.3
+ 1738010p 0.9
+ 1740000p 0.9
+ 1740010p -0.3
+ 1742000p -0.3
+ 1742010p 0.9
+ 1744000p 0.9
+ 1744010p -0.3
+ 1746000p -0.3
+ 1746010p 0.9
+ 1748000p 0.9
+ 1748010p -0.3
+ 1750000p -0.3
+ 1750010p 0.9
+ 1752000p 0.9
+ 1752010p -0.3
+ 1754000p -0.3
+ 1754010p 0.9
+ 1756000p 0.9
+ 1756010p -0.3
+ 1758000p -0.3
+ 1758010p 0.9
+ 1760000p 0.9
+ 1760010p -0.3
+ 1762000p -0.3
+ 1762010p 0.9
+ 1764000p 0.9
+ 1764010p -0.3
+ 1766000p -0.3
+ 1766010p 0.9
+ 1768000p 0.9
+ 1768010p -0.3
+ 1770000p -0.3
+ 1770010p 0.9
+ 1772000p 0.9
+ 1772010p -0.3
+ 1774000p -0.3
+ 1774010p 0.9
+ 1776000p 0.9
+ 1776010p -0.3
+ 1778000p -0.3
+ 1778010p 0.9
+ 1780000p 0.9
+ 1780010p -0.3
+ 1782000p -0.3
+ 1782010p 0.9
+ 1784000p 0.9
+ 1784010p -0.3
+ 1786000p -0.3
+ 1786010p 0.9
+ 1788000p 0.9
+ 1788010p -0.3
+ 1790000p -0.3
+ 1790010p 0.9
+ 1792000p 0.9
+ 1792010p -0.3
+ 1794000p -0.3
+ 1794010p 0.9
+ 1796000p 0.9
+ 1796010p -0.3
+ 1798000p -0.3
+ 1798010p 0.9
+ 1800000p 0.9
+ 1800010p -0.3
+ 1802000p -0.3
+ 1802010p 0.9
+ 1804000p 0.9
+ 1804010p -0.3
+ 1806000p -0.3
+ 1806010p 0.9
+ 1808000p 0.9
+ 1808010p -0.3
+ 1810000p -0.3
+ 1810010p 0.9
+ 1812000p 0.9
+ 1812010p -0.3
+ 1814000p -0.3
+ 1814010p 0.9
+ 1816000p 0.9
+ 1816010p -0.3
+ 1818000p -0.3
+ 1818010p 0.9
+ 1820000p 0.9
+ 1820010p -0.3
+ 1822000p -0.3
+ 1822010p 0.9
+ 1824000p 0.9
+ 1824010p -0.3
+ 1826000p -0.3
+ 1826010p 0.9
+ 1828000p 0.9
+ 1828010p -0.3
+ 1830000p -0.3
+ 1830010p 0.9
+ 1832000p 0.9
+ 1832010p -0.3
+ 1834000p -0.3
+ 1834010p 0.9
+ 1836000p 0.9
+ 1836010p -0.3
+ 1838000p -0.3
+ 1838010p 0.9
+ 1840000p 0.9
+ 1840010p -0.3
+ 1842000p -0.3
+ 1842010p 0.9
+ 1844000p 0.9
+ 1844010p -0.3
+ 1846000p -0.3
+ 1846010p 0.9
+ 1848000p 0.9
+ 1848010p -0.3
+ 1850000p -0.3
+ 1850010p 0.9
+ 1852000p 0.9
+ 1852010p -0.3
+ 1854000p -0.3
+ 1854010p 0.9
+ 1856000p 0.9
+ 1856010p -0.3
+ 1858000p -0.3
+ 1858010p 0.9
+ 1860000p 0.9
+ 1860010p -0.3
+ 1862000p -0.3
+ 1862010p 0.9
+ 1864000p 0.9
+ 1864010p -0.3
+ 1866000p -0.3
+ 1866010p 0.9
+ 1868000p 0.9
+ 1868010p -0.3
+ 1870000p -0.3
+ 1870010p 0.9
+ 1872000p 0.9
+ 1872010p -0.3
+ 1874000p -0.3
+ 1874010p 0.9
+ 1876000p 0.9
+ 1876010p -0.3
+ 1878000p -0.3
+ 1878010p 0.9
+ 1880000p 0.9
+ 1880010p -0.3
+ 1882000p -0.3
+ 1882010p 0.9
+ 1884000p 0.9
+ 1884010p -0.3
+ 1886000p -0.3
+ 1886010p 0.9
+ 1888000p 0.9
+ 1888010p -0.3
+ 1890000p -0.3
+ 1890010p 0.9
+ 1892000p 0.9
+ 1892010p -0.3
+ 1894000p -0.3
+ 1894010p 0.9
+ 1896000p 0.9
+ 1896010p -0.3
+ 1898000p -0.3
+ 1898010p 0.9
+ 1900000p 0.9
+ 1900010p -0.3
+ 1902000p -0.3
+ 1902010p 0.9
+ 1904000p 0.9
+ 1904010p -0.3
+ 1906000p -0.3
+ 1906010p 0.9
+ 1908000p 0.9
+ 1908010p -0.3
+ 1910000p -0.3
+ 1910010p 0.9
+ 1912000p 0.9
+ 1912010p -0.3
+ 1914000p -0.3
+ 1914010p 0.9
+ 1916000p 0.9
+ 1916010p -0.3
+ 1918000p -0.3
+ 1918010p 0.9
+ 1920000p 0.9
+ 1920010p -0.3
+ 1922000p -0.3
+ 1922010p 0.9
+ 1924000p 0.9
+ 1924010p -0.3
+ 1926000p -0.3
+ 1926010p 0.9
+ 1928000p 0.9
+ 1928010p -0.3
+ 1930000p -0.3
+ 1930010p 0.9
+ 1932000p 0.9
+ 1932010p -0.3
+ 1934000p -0.3
+ 1934010p 0.9
+ 1936000p 0.9
+ 1936010p -0.3
+ 1938000p -0.3
+ 1938010p 0.9
+ 1940000p 0.9
+ 1940010p -0.3
+ 1942000p -0.3
+ 1942010p 0.9
+ 1944000p 0.9
+ 1944010p -0.3
+ 1946000p -0.3
+ 1946010p 0.9
+ 1948000p 0.9
+ 1948010p -0.3
+ 1950000p -0.3
+ 1950010p 0.9
+ 1952000p 0.9
+ 1952010p -0.3
+ 1954000p -0.3
+ 1954010p 0.9
+ 1956000p 0.9
+ 1956010p -0.3
+ 1958000p -0.3
+ 1958010p 0.9
+ 1960000p 0.9
+ 1960010p -0.3
+ 1962000p -0.3
+ 1962010p 0.9
+ 1964000p 0.9
+ 1964010p -0.3
+ 1966000p -0.3
+ 1966010p 0.9
+ 1968000p 0.9
+ 1968010p -0.3
+ 1970000p -0.3
+ 1970010p 0.9
+ 1972000p 0.9
+ 1972010p -0.3
+ 1974000p -0.3
+ 1974010p 0.9
+ 1976000p 0.9
+ 1976010p -0.3
+ 1978000p -0.3
+ 1978010p 0.9
+ 1980000p 0.9
+ 1980010p -0.3
+ 1982000p -0.3
+ 1982010p 0.9
+ 1984000p 0.9
+ 1984010p -0.3
+ 1986000p -0.3
+ 1986010p 0.9
+ 1988000p 0.9
+ 1988010p -0.3
+ 1990000p -0.3
+ 1990010p 0.9
+ 1992000p 0.9
+ 1992010p -0.3
+ 1994000p -0.3
+ 1994010p 0.9
+ 1996000p 0.9
+ 1996010p -0.3
+ 1998000p -0.3
+ 1998010p 0.9
+ 2000000p 0.9
+ 2000010p -0.3
+ 2002000p -0.3
+ 2002010p 0.9
+ 2004000p 0.9
+ 2004010p -0.3
+ 2006000p -0.3
+ 2006010p 0.9
+ 2008000p 0.9
+ 2008010p -0.3
+ 2010000p -0.3
+ 2010010p 0.9
+ 2012000p 0.9
+ 2012010p -0.3
+ 2014000p -0.3
+ 2014010p 0.9
+ 2016000p 0.9
+ 2016010p -0.3
+ 2018000p -0.3
+ 2018010p 0.9
+ 2020000p 0.9
+ 2020010p -0.3
+ 2022000p -0.3
+ 2022010p 0.9
+ 2024000p 0.9
+ 2024010p -0.3
+ 2026000p -0.3
+ 2026010p 0.9
+ 2028000p 0.9
+ 2028010p -0.3
+ 2030000p -0.3
+ 2030010p 0.9
+ 2032000p 0.9
+ 2032010p -0.3
+ 2034000p -0.3
+ 2034010p 0.9
+ 2036000p 0.9
+ 2036010p -0.3
+ 2038000p -0.3
+ 2038010p 0.9
+ 2040000p 0.9
+ 2040010p -0.3
+ 2042000p -0.3
+ 2042010p 0.9
+ 2044000p 0.9
+ 2044010p -0.3
+ 2046000p -0.3
+ 2046010p 0.9
+ 2048000p 0.9
+ 2048010p -0.3
+ \]
V_data_13 (Data\\<13\\> gnd!) vsource type=pwl wave=\[
+ 0    0.9
+ 2000p 0.9
+ 2010p -0.3
+ 4000p -0.3
+ 4010p 0.9
+ 6000p 0.9
+ 6010p -0.3
+ 8000p -0.3
+ 8010p 0.9
+ 10000p 0.9
+ 10010p -0.3
+ 12000p -0.3
+ 12010p 0.9
+ 14000p 0.9
+ 14010p -0.3
+ 16000p -0.3
+ 16010p 0.9
+ 18000p 0.9
+ 18010p -0.3
+ 20000p -0.3
+ 20010p 0.9
+ 22000p 0.9
+ 22010p -0.3
+ 24000p -0.3
+ 24010p 0.9
+ 26000p 0.9
+ 26010p -0.3
+ 28000p -0.3
+ 28010p 0.9
+ 30000p 0.9
+ 30010p -0.3
+ 32000p -0.3
+ 32010p 0.9
+ 34000p 0.9
+ 34010p -0.3
+ 36000p -0.3
+ 36010p 0.9
+ 38000p 0.9
+ 38010p -0.3
+ 40000p -0.3
+ 40010p 0.9
+ 42000p 0.9
+ 42010p -0.3
+ 44000p -0.3
+ 44010p 0.9
+ 46000p 0.9
+ 46010p -0.3
+ 48000p -0.3
+ 48010p 0.9
+ 50000p 0.9
+ 50010p -0.3
+ 52000p -0.3
+ 52010p 0.9
+ 54000p 0.9
+ 54010p -0.3
+ 56000p -0.3
+ 56010p 0.9
+ 58000p 0.9
+ 58010p -0.3
+ 60000p -0.3
+ 60010p 0.9
+ 62000p 0.9
+ 62010p -0.3
+ 64000p -0.3
+ 64010p 0.9
+ 66000p 0.9
+ 66010p -0.3
+ 68000p -0.3
+ 68010p 0.9
+ 70000p 0.9
+ 70010p -0.3
+ 72000p -0.3
+ 72010p 0.9
+ 74000p 0.9
+ 74010p -0.3
+ 76000p -0.3
+ 76010p 0.9
+ 78000p 0.9
+ 78010p -0.3
+ 80000p -0.3
+ 80010p 0.9
+ 82000p 0.9
+ 82010p -0.3
+ 84000p -0.3
+ 84010p 0.9
+ 86000p 0.9
+ 86010p -0.3
+ 88000p -0.3
+ 88010p 0.9
+ 90000p 0.9
+ 90010p -0.3
+ 92000p -0.3
+ 92010p 0.9
+ 94000p 0.9
+ 94010p -0.3
+ 96000p -0.3
+ 96010p 0.9
+ 98000p 0.9
+ 98010p -0.3
+ 100000p -0.3
+ 100010p 0.9
+ 102000p 0.9
+ 102010p -0.3
+ 104000p -0.3
+ 104010p 0.9
+ 106000p 0.9
+ 106010p -0.3
+ 108000p -0.3
+ 108010p 0.9
+ 110000p 0.9
+ 110010p -0.3
+ 112000p -0.3
+ 112010p 0.9
+ 114000p 0.9
+ 114010p -0.3
+ 116000p -0.3
+ 116010p 0.9
+ 118000p 0.9
+ 118010p -0.3
+ 120000p -0.3
+ 120010p 0.9
+ 122000p 0.9
+ 122010p -0.3
+ 124000p -0.3
+ 124010p 0.9
+ 126000p 0.9
+ 126010p -0.3
+ 128000p -0.3
+ 128010p 0.9
+ 130000p 0.9
+ 130010p -0.3
+ 132000p -0.3
+ 132010p 0.9
+ 134000p 0.9
+ 134010p -0.3
+ 136000p -0.3
+ 136010p 0.9
+ 138000p 0.9
+ 138010p -0.3
+ 140000p -0.3
+ 140010p 0.9
+ 142000p 0.9
+ 142010p -0.3
+ 144000p -0.3
+ 144010p 0.9
+ 146000p 0.9
+ 146010p -0.3
+ 148000p -0.3
+ 148010p 0.9
+ 150000p 0.9
+ 150010p -0.3
+ 152000p -0.3
+ 152010p 0.9
+ 154000p 0.9
+ 154010p -0.3
+ 156000p -0.3
+ 156010p 0.9
+ 158000p 0.9
+ 158010p -0.3
+ 160000p -0.3
+ 160010p 0.9
+ 162000p 0.9
+ 162010p -0.3
+ 164000p -0.3
+ 164010p 0.9
+ 166000p 0.9
+ 166010p -0.3
+ 168000p -0.3
+ 168010p 0.9
+ 170000p 0.9
+ 170010p -0.3
+ 172000p -0.3
+ 172010p 0.9
+ 174000p 0.9
+ 174010p -0.3
+ 176000p -0.3
+ 176010p 0.9
+ 178000p 0.9
+ 178010p -0.3
+ 180000p -0.3
+ 180010p 0.9
+ 182000p 0.9
+ 182010p -0.3
+ 184000p -0.3
+ 184010p 0.9
+ 186000p 0.9
+ 186010p -0.3
+ 188000p -0.3
+ 188010p 0.9
+ 190000p 0.9
+ 190010p -0.3
+ 192000p -0.3
+ 192010p 0.9
+ 194000p 0.9
+ 194010p -0.3
+ 196000p -0.3
+ 196010p 0.9
+ 198000p 0.9
+ 198010p -0.3
+ 200000p -0.3
+ 200010p 0.9
+ 202000p 0.9
+ 202010p -0.3
+ 204000p -0.3
+ 204010p 0.9
+ 206000p 0.9
+ 206010p -0.3
+ 208000p -0.3
+ 208010p 0.9
+ 210000p 0.9
+ 210010p -0.3
+ 212000p -0.3
+ 212010p 0.9
+ 214000p 0.9
+ 214010p -0.3
+ 216000p -0.3
+ 216010p 0.9
+ 218000p 0.9
+ 218010p -0.3
+ 220000p -0.3
+ 220010p 0.9
+ 222000p 0.9
+ 222010p -0.3
+ 224000p -0.3
+ 224010p 0.9
+ 226000p 0.9
+ 226010p -0.3
+ 228000p -0.3
+ 228010p 0.9
+ 230000p 0.9
+ 230010p -0.3
+ 232000p -0.3
+ 232010p 0.9
+ 234000p 0.9
+ 234010p -0.3
+ 236000p -0.3
+ 236010p 0.9
+ 238000p 0.9
+ 238010p -0.3
+ 240000p -0.3
+ 240010p 0.9
+ 242000p 0.9
+ 242010p -0.3
+ 244000p -0.3
+ 244010p 0.9
+ 246000p 0.9
+ 246010p -0.3
+ 248000p -0.3
+ 248010p 0.9
+ 250000p 0.9
+ 250010p -0.3
+ 252000p -0.3
+ 252010p 0.9
+ 254000p 0.9
+ 254010p -0.3
+ 256000p -0.3
+ 256010p 0.9
+ 258000p 0.9
+ 258010p -0.3
+ 260000p -0.3
+ 260010p 0.9
+ 262000p 0.9
+ 262010p -0.3
+ 264000p -0.3
+ 264010p 0.9
+ 266000p 0.9
+ 266010p -0.3
+ 268000p -0.3
+ 268010p 0.9
+ 270000p 0.9
+ 270010p -0.3
+ 272000p -0.3
+ 272010p 0.9
+ 274000p 0.9
+ 274010p -0.3
+ 276000p -0.3
+ 276010p 0.9
+ 278000p 0.9
+ 278010p -0.3
+ 280000p -0.3
+ 280010p 0.9
+ 282000p 0.9
+ 282010p -0.3
+ 284000p -0.3
+ 284010p 0.9
+ 286000p 0.9
+ 286010p -0.3
+ 288000p -0.3
+ 288010p 0.9
+ 290000p 0.9
+ 290010p -0.3
+ 292000p -0.3
+ 292010p 0.9
+ 294000p 0.9
+ 294010p -0.3
+ 296000p -0.3
+ 296010p 0.9
+ 298000p 0.9
+ 298010p -0.3
+ 300000p -0.3
+ 300010p 0.9
+ 302000p 0.9
+ 302010p -0.3
+ 304000p -0.3
+ 304010p 0.9
+ 306000p 0.9
+ 306010p -0.3
+ 308000p -0.3
+ 308010p 0.9
+ 310000p 0.9
+ 310010p -0.3
+ 312000p -0.3
+ 312010p 0.9
+ 314000p 0.9
+ 314010p -0.3
+ 316000p -0.3
+ 316010p 0.9
+ 318000p 0.9
+ 318010p -0.3
+ 320000p -0.3
+ 320010p 0.9
+ 322000p 0.9
+ 322010p -0.3
+ 324000p -0.3
+ 324010p 0.9
+ 326000p 0.9
+ 326010p -0.3
+ 328000p -0.3
+ 328010p 0.9
+ 330000p 0.9
+ 330010p -0.3
+ 332000p -0.3
+ 332010p 0.9
+ 334000p 0.9
+ 334010p -0.3
+ 336000p -0.3
+ 336010p 0.9
+ 338000p 0.9
+ 338010p -0.3
+ 340000p -0.3
+ 340010p 0.9
+ 342000p 0.9
+ 342010p -0.3
+ 344000p -0.3
+ 344010p 0.9
+ 346000p 0.9
+ 346010p -0.3
+ 348000p -0.3
+ 348010p 0.9
+ 350000p 0.9
+ 350010p -0.3
+ 352000p -0.3
+ 352010p 0.9
+ 354000p 0.9
+ 354010p -0.3
+ 356000p -0.3
+ 356010p 0.9
+ 358000p 0.9
+ 358010p -0.3
+ 360000p -0.3
+ 360010p 0.9
+ 362000p 0.9
+ 362010p -0.3
+ 364000p -0.3
+ 364010p 0.9
+ 366000p 0.9
+ 366010p -0.3
+ 368000p -0.3
+ 368010p 0.9
+ 370000p 0.9
+ 370010p -0.3
+ 372000p -0.3
+ 372010p 0.9
+ 374000p 0.9
+ 374010p -0.3
+ 376000p -0.3
+ 376010p 0.9
+ 378000p 0.9
+ 378010p -0.3
+ 380000p -0.3
+ 380010p 0.9
+ 382000p 0.9
+ 382010p -0.3
+ 384000p -0.3
+ 384010p 0.9
+ 386000p 0.9
+ 386010p -0.3
+ 388000p -0.3
+ 388010p 0.9
+ 390000p 0.9
+ 390010p -0.3
+ 392000p -0.3
+ 392010p 0.9
+ 394000p 0.9
+ 394010p -0.3
+ 396000p -0.3
+ 396010p 0.9
+ 398000p 0.9
+ 398010p -0.3
+ 400000p -0.3
+ 400010p 0.9
+ 402000p 0.9
+ 402010p -0.3
+ 404000p -0.3
+ 404010p 0.9
+ 406000p 0.9
+ 406010p -0.3
+ 408000p -0.3
+ 408010p 0.9
+ 410000p 0.9
+ 410010p -0.3
+ 412000p -0.3
+ 412010p 0.9
+ 414000p 0.9
+ 414010p -0.3
+ 416000p -0.3
+ 416010p 0.9
+ 418000p 0.9
+ 418010p -0.3
+ 420000p -0.3
+ 420010p 0.9
+ 422000p 0.9
+ 422010p -0.3
+ 424000p -0.3
+ 424010p 0.9
+ 426000p 0.9
+ 426010p -0.3
+ 428000p -0.3
+ 428010p 0.9
+ 430000p 0.9
+ 430010p -0.3
+ 432000p -0.3
+ 432010p 0.9
+ 434000p 0.9
+ 434010p -0.3
+ 436000p -0.3
+ 436010p 0.9
+ 438000p 0.9
+ 438010p -0.3
+ 440000p -0.3
+ 440010p 0.9
+ 442000p 0.9
+ 442010p -0.3
+ 444000p -0.3
+ 444010p 0.9
+ 446000p 0.9
+ 446010p -0.3
+ 448000p -0.3
+ 448010p 0.9
+ 450000p 0.9
+ 450010p -0.3
+ 452000p -0.3
+ 452010p 0.9
+ 454000p 0.9
+ 454010p -0.3
+ 456000p -0.3
+ 456010p 0.9
+ 458000p 0.9
+ 458010p -0.3
+ 460000p -0.3
+ 460010p 0.9
+ 462000p 0.9
+ 462010p -0.3
+ 464000p -0.3
+ 464010p 0.9
+ 466000p 0.9
+ 466010p -0.3
+ 468000p -0.3
+ 468010p 0.9
+ 470000p 0.9
+ 470010p -0.3
+ 472000p -0.3
+ 472010p 0.9
+ 474000p 0.9
+ 474010p -0.3
+ 476000p -0.3
+ 476010p 0.9
+ 478000p 0.9
+ 478010p -0.3
+ 480000p -0.3
+ 480010p 0.9
+ 482000p 0.9
+ 482010p -0.3
+ 484000p -0.3
+ 484010p 0.9
+ 486000p 0.9
+ 486010p -0.3
+ 488000p -0.3
+ 488010p 0.9
+ 490000p 0.9
+ 490010p -0.3
+ 492000p -0.3
+ 492010p 0.9
+ 494000p 0.9
+ 494010p -0.3
+ 496000p -0.3
+ 496010p 0.9
+ 498000p 0.9
+ 498010p -0.3
+ 500000p -0.3
+ 500010p 0.9
+ 502000p 0.9
+ 502010p -0.3
+ 504000p -0.3
+ 504010p 0.9
+ 506000p 0.9
+ 506010p -0.3
+ 508000p -0.3
+ 508010p 0.9
+ 510000p 0.9
+ 510010p -0.3
+ 512000p -0.3
+ 512010p 0.9
+ 514000p 0.9
+ 514010p -0.3
+ 516000p -0.3
+ 516010p 0.9
+ 518000p 0.9
+ 518010p -0.3
+ 520000p -0.3
+ 520010p 0.9
+ 522000p 0.9
+ 522010p -0.3
+ 524000p -0.3
+ 524010p 0.9
+ 526000p 0.9
+ 526010p -0.3
+ 528000p -0.3
+ 528010p 0.9
+ 530000p 0.9
+ 530010p -0.3
+ 532000p -0.3
+ 532010p 0.9
+ 534000p 0.9
+ 534010p -0.3
+ 536000p -0.3
+ 536010p 0.9
+ 538000p 0.9
+ 538010p -0.3
+ 540000p -0.3
+ 540010p 0.9
+ 542000p 0.9
+ 542010p -0.3
+ 544000p -0.3
+ 544010p 0.9
+ 546000p 0.9
+ 546010p -0.3
+ 548000p -0.3
+ 548010p 0.9
+ 550000p 0.9
+ 550010p -0.3
+ 552000p -0.3
+ 552010p 0.9
+ 554000p 0.9
+ 554010p -0.3
+ 556000p -0.3
+ 556010p 0.9
+ 558000p 0.9
+ 558010p -0.3
+ 560000p -0.3
+ 560010p 0.9
+ 562000p 0.9
+ 562010p -0.3
+ 564000p -0.3
+ 564010p 0.9
+ 566000p 0.9
+ 566010p -0.3
+ 568000p -0.3
+ 568010p 0.9
+ 570000p 0.9
+ 570010p -0.3
+ 572000p -0.3
+ 572010p 0.9
+ 574000p 0.9
+ 574010p -0.3
+ 576000p -0.3
+ 576010p 0.9
+ 578000p 0.9
+ 578010p -0.3
+ 580000p -0.3
+ 580010p 0.9
+ 582000p 0.9
+ 582010p -0.3
+ 584000p -0.3
+ 584010p 0.9
+ 586000p 0.9
+ 586010p -0.3
+ 588000p -0.3
+ 588010p 0.9
+ 590000p 0.9
+ 590010p -0.3
+ 592000p -0.3
+ 592010p 0.9
+ 594000p 0.9
+ 594010p -0.3
+ 596000p -0.3
+ 596010p 0.9
+ 598000p 0.9
+ 598010p -0.3
+ 600000p -0.3
+ 600010p 0.9
+ 602000p 0.9
+ 602010p -0.3
+ 604000p -0.3
+ 604010p 0.9
+ 606000p 0.9
+ 606010p -0.3
+ 608000p -0.3
+ 608010p 0.9
+ 610000p 0.9
+ 610010p -0.3
+ 612000p -0.3
+ 612010p 0.9
+ 614000p 0.9
+ 614010p -0.3
+ 616000p -0.3
+ 616010p 0.9
+ 618000p 0.9
+ 618010p -0.3
+ 620000p -0.3
+ 620010p 0.9
+ 622000p 0.9
+ 622010p -0.3
+ 624000p -0.3
+ 624010p 0.9
+ 626000p 0.9
+ 626010p -0.3
+ 628000p -0.3
+ 628010p 0.9
+ 630000p 0.9
+ 630010p -0.3
+ 632000p -0.3
+ 632010p 0.9
+ 634000p 0.9
+ 634010p -0.3
+ 636000p -0.3
+ 636010p 0.9
+ 638000p 0.9
+ 638010p -0.3
+ 640000p -0.3
+ 640010p 0.9
+ 642000p 0.9
+ 642010p -0.3
+ 644000p -0.3
+ 644010p 0.9
+ 646000p 0.9
+ 646010p -0.3
+ 648000p -0.3
+ 648010p 0.9
+ 650000p 0.9
+ 650010p -0.3
+ 652000p -0.3
+ 652010p 0.9
+ 654000p 0.9
+ 654010p -0.3
+ 656000p -0.3
+ 656010p 0.9
+ 658000p 0.9
+ 658010p -0.3
+ 660000p -0.3
+ 660010p 0.9
+ 662000p 0.9
+ 662010p -0.3
+ 664000p -0.3
+ 664010p 0.9
+ 666000p 0.9
+ 666010p -0.3
+ 668000p -0.3
+ 668010p 0.9
+ 670000p 0.9
+ 670010p -0.3
+ 672000p -0.3
+ 672010p 0.9
+ 674000p 0.9
+ 674010p -0.3
+ 676000p -0.3
+ 676010p 0.9
+ 678000p 0.9
+ 678010p -0.3
+ 680000p -0.3
+ 680010p 0.9
+ 682000p 0.9
+ 682010p -0.3
+ 684000p -0.3
+ 684010p 0.9
+ 686000p 0.9
+ 686010p -0.3
+ 688000p -0.3
+ 688010p 0.9
+ 690000p 0.9
+ 690010p -0.3
+ 692000p -0.3
+ 692010p 0.9
+ 694000p 0.9
+ 694010p -0.3
+ 696000p -0.3
+ 696010p 0.9
+ 698000p 0.9
+ 698010p -0.3
+ 700000p -0.3
+ 700010p 0.9
+ 702000p 0.9
+ 702010p -0.3
+ 704000p -0.3
+ 704010p 0.9
+ 706000p 0.9
+ 706010p -0.3
+ 708000p -0.3
+ 708010p 0.9
+ 710000p 0.9
+ 710010p -0.3
+ 712000p -0.3
+ 712010p 0.9
+ 714000p 0.9
+ 714010p -0.3
+ 716000p -0.3
+ 716010p 0.9
+ 718000p 0.9
+ 718010p -0.3
+ 720000p -0.3
+ 720010p 0.9
+ 722000p 0.9
+ 722010p -0.3
+ 724000p -0.3
+ 724010p 0.9
+ 726000p 0.9
+ 726010p -0.3
+ 728000p -0.3
+ 728010p 0.9
+ 730000p 0.9
+ 730010p -0.3
+ 732000p -0.3
+ 732010p 0.9
+ 734000p 0.9
+ 734010p -0.3
+ 736000p -0.3
+ 736010p 0.9
+ 738000p 0.9
+ 738010p -0.3
+ 740000p -0.3
+ 740010p 0.9
+ 742000p 0.9
+ 742010p -0.3
+ 744000p -0.3
+ 744010p 0.9
+ 746000p 0.9
+ 746010p -0.3
+ 748000p -0.3
+ 748010p 0.9
+ 750000p 0.9
+ 750010p -0.3
+ 752000p -0.3
+ 752010p 0.9
+ 754000p 0.9
+ 754010p -0.3
+ 756000p -0.3
+ 756010p 0.9
+ 758000p 0.9
+ 758010p -0.3
+ 760000p -0.3
+ 760010p 0.9
+ 762000p 0.9
+ 762010p -0.3
+ 764000p -0.3
+ 764010p 0.9
+ 766000p 0.9
+ 766010p -0.3
+ 768000p -0.3
+ 768010p 0.9
+ 770000p 0.9
+ 770010p -0.3
+ 772000p -0.3
+ 772010p 0.9
+ 774000p 0.9
+ 774010p -0.3
+ 776000p -0.3
+ 776010p 0.9
+ 778000p 0.9
+ 778010p -0.3
+ 780000p -0.3
+ 780010p 0.9
+ 782000p 0.9
+ 782010p -0.3
+ 784000p -0.3
+ 784010p 0.9
+ 786000p 0.9
+ 786010p -0.3
+ 788000p -0.3
+ 788010p 0.9
+ 790000p 0.9
+ 790010p -0.3
+ 792000p -0.3
+ 792010p 0.9
+ 794000p 0.9
+ 794010p -0.3
+ 796000p -0.3
+ 796010p 0.9
+ 798000p 0.9
+ 798010p -0.3
+ 800000p -0.3
+ 800010p 0.9
+ 802000p 0.9
+ 802010p -0.3
+ 804000p -0.3
+ 804010p 0.9
+ 806000p 0.9
+ 806010p -0.3
+ 808000p -0.3
+ 808010p 0.9
+ 810000p 0.9
+ 810010p -0.3
+ 812000p -0.3
+ 812010p 0.9
+ 814000p 0.9
+ 814010p -0.3
+ 816000p -0.3
+ 816010p 0.9
+ 818000p 0.9
+ 818010p -0.3
+ 820000p -0.3
+ 820010p 0.9
+ 822000p 0.9
+ 822010p -0.3
+ 824000p -0.3
+ 824010p 0.9
+ 826000p 0.9
+ 826010p -0.3
+ 828000p -0.3
+ 828010p 0.9
+ 830000p 0.9
+ 830010p -0.3
+ 832000p -0.3
+ 832010p 0.9
+ 834000p 0.9
+ 834010p -0.3
+ 836000p -0.3
+ 836010p 0.9
+ 838000p 0.9
+ 838010p -0.3
+ 840000p -0.3
+ 840010p 0.9
+ 842000p 0.9
+ 842010p -0.3
+ 844000p -0.3
+ 844010p 0.9
+ 846000p 0.9
+ 846010p -0.3
+ 848000p -0.3
+ 848010p 0.9
+ 850000p 0.9
+ 850010p -0.3
+ 852000p -0.3
+ 852010p 0.9
+ 854000p 0.9
+ 854010p -0.3
+ 856000p -0.3
+ 856010p 0.9
+ 858000p 0.9
+ 858010p -0.3
+ 860000p -0.3
+ 860010p 0.9
+ 862000p 0.9
+ 862010p -0.3
+ 864000p -0.3
+ 864010p 0.9
+ 866000p 0.9
+ 866010p -0.3
+ 868000p -0.3
+ 868010p 0.9
+ 870000p 0.9
+ 870010p -0.3
+ 872000p -0.3
+ 872010p 0.9
+ 874000p 0.9
+ 874010p -0.3
+ 876000p -0.3
+ 876010p 0.9
+ 878000p 0.9
+ 878010p -0.3
+ 880000p -0.3
+ 880010p 0.9
+ 882000p 0.9
+ 882010p -0.3
+ 884000p -0.3
+ 884010p 0.9
+ 886000p 0.9
+ 886010p -0.3
+ 888000p -0.3
+ 888010p 0.9
+ 890000p 0.9
+ 890010p -0.3
+ 892000p -0.3
+ 892010p 0.9
+ 894000p 0.9
+ 894010p -0.3
+ 896000p -0.3
+ 896010p 0.9
+ 898000p 0.9
+ 898010p -0.3
+ 900000p -0.3
+ 900010p 0.9
+ 902000p 0.9
+ 902010p -0.3
+ 904000p -0.3
+ 904010p 0.9
+ 906000p 0.9
+ 906010p -0.3
+ 908000p -0.3
+ 908010p 0.9
+ 910000p 0.9
+ 910010p -0.3
+ 912000p -0.3
+ 912010p 0.9
+ 914000p 0.9
+ 914010p -0.3
+ 916000p -0.3
+ 916010p 0.9
+ 918000p 0.9
+ 918010p -0.3
+ 920000p -0.3
+ 920010p 0.9
+ 922000p 0.9
+ 922010p -0.3
+ 924000p -0.3
+ 924010p 0.9
+ 926000p 0.9
+ 926010p -0.3
+ 928000p -0.3
+ 928010p 0.9
+ 930000p 0.9
+ 930010p -0.3
+ 932000p -0.3
+ 932010p 0.9
+ 934000p 0.9
+ 934010p -0.3
+ 936000p -0.3
+ 936010p 0.9
+ 938000p 0.9
+ 938010p -0.3
+ 940000p -0.3
+ 940010p 0.9
+ 942000p 0.9
+ 942010p -0.3
+ 944000p -0.3
+ 944010p 0.9
+ 946000p 0.9
+ 946010p -0.3
+ 948000p -0.3
+ 948010p 0.9
+ 950000p 0.9
+ 950010p -0.3
+ 952000p -0.3
+ 952010p 0.9
+ 954000p 0.9
+ 954010p -0.3
+ 956000p -0.3
+ 956010p 0.9
+ 958000p 0.9
+ 958010p -0.3
+ 960000p -0.3
+ 960010p 0.9
+ 962000p 0.9
+ 962010p -0.3
+ 964000p -0.3
+ 964010p 0.9
+ 966000p 0.9
+ 966010p -0.3
+ 968000p -0.3
+ 968010p 0.9
+ 970000p 0.9
+ 970010p -0.3
+ 972000p -0.3
+ 972010p 0.9
+ 974000p 0.9
+ 974010p -0.3
+ 976000p -0.3
+ 976010p 0.9
+ 978000p 0.9
+ 978010p -0.3
+ 980000p -0.3
+ 980010p 0.9
+ 982000p 0.9
+ 982010p -0.3
+ 984000p -0.3
+ 984010p 0.9
+ 986000p 0.9
+ 986010p -0.3
+ 988000p -0.3
+ 988010p 0.9
+ 990000p 0.9
+ 990010p -0.3
+ 992000p -0.3
+ 992010p 0.9
+ 994000p 0.9
+ 994010p -0.3
+ 996000p -0.3
+ 996010p 0.9
+ 998000p 0.9
+ 998010p -0.3
+ 1000000p -0.3
+ 1000010p 0.9
+ 1002000p 0.9
+ 1002010p -0.3
+ 1004000p -0.3
+ 1004010p 0.9
+ 1006000p 0.9
+ 1006010p -0.3
+ 1008000p -0.3
+ 1008010p 0.9
+ 1010000p 0.9
+ 1010010p -0.3
+ 1012000p -0.3
+ 1012010p 0.9
+ 1014000p 0.9
+ 1014010p -0.3
+ 1016000p -0.3
+ 1016010p 0.9
+ 1018000p 0.9
+ 1018010p -0.3
+ 1020000p -0.3
+ 1020010p 0.9
+ 1022000p 0.9
+ 1022010p -0.3
+ 1024000p -0.3
+ 1024010p 0.9
+ 1026000p 0.9
+ 1026010p -0.3
+ 1028000p -0.3
+ 1028010p 0.9
+ 1030000p 0.9
+ 1030010p -0.3
+ 1032000p -0.3
+ 1032010p 0.9
+ 1034000p 0.9
+ 1034010p -0.3
+ 1036000p -0.3
+ 1036010p 0.9
+ 1038000p 0.9
+ 1038010p -0.3
+ 1040000p -0.3
+ 1040010p 0.9
+ 1042000p 0.9
+ 1042010p -0.3
+ 1044000p -0.3
+ 1044010p 0.9
+ 1046000p 0.9
+ 1046010p -0.3
+ 1048000p -0.3
+ 1048010p 0.9
+ 1050000p 0.9
+ 1050010p -0.3
+ 1052000p -0.3
+ 1052010p 0.9
+ 1054000p 0.9
+ 1054010p -0.3
+ 1056000p -0.3
+ 1056010p 0.9
+ 1058000p 0.9
+ 1058010p -0.3
+ 1060000p -0.3
+ 1060010p 0.9
+ 1062000p 0.9
+ 1062010p -0.3
+ 1064000p -0.3
+ 1064010p 0.9
+ 1066000p 0.9
+ 1066010p -0.3
+ 1068000p -0.3
+ 1068010p 0.9
+ 1070000p 0.9
+ 1070010p -0.3
+ 1072000p -0.3
+ 1072010p 0.9
+ 1074000p 0.9
+ 1074010p -0.3
+ 1076000p -0.3
+ 1076010p 0.9
+ 1078000p 0.9
+ 1078010p -0.3
+ 1080000p -0.3
+ 1080010p 0.9
+ 1082000p 0.9
+ 1082010p -0.3
+ 1084000p -0.3
+ 1084010p 0.9
+ 1086000p 0.9
+ 1086010p -0.3
+ 1088000p -0.3
+ 1088010p 0.9
+ 1090000p 0.9
+ 1090010p -0.3
+ 1092000p -0.3
+ 1092010p 0.9
+ 1094000p 0.9
+ 1094010p -0.3
+ 1096000p -0.3
+ 1096010p 0.9
+ 1098000p 0.9
+ 1098010p -0.3
+ 1100000p -0.3
+ 1100010p 0.9
+ 1102000p 0.9
+ 1102010p -0.3
+ 1104000p -0.3
+ 1104010p 0.9
+ 1106000p 0.9
+ 1106010p -0.3
+ 1108000p -0.3
+ 1108010p 0.9
+ 1110000p 0.9
+ 1110010p -0.3
+ 1112000p -0.3
+ 1112010p 0.9
+ 1114000p 0.9
+ 1114010p -0.3
+ 1116000p -0.3
+ 1116010p 0.9
+ 1118000p 0.9
+ 1118010p -0.3
+ 1120000p -0.3
+ 1120010p 0.9
+ 1122000p 0.9
+ 1122010p -0.3
+ 1124000p -0.3
+ 1124010p 0.9
+ 1126000p 0.9
+ 1126010p -0.3
+ 1128000p -0.3
+ 1128010p 0.9
+ 1130000p 0.9
+ 1130010p -0.3
+ 1132000p -0.3
+ 1132010p 0.9
+ 1134000p 0.9
+ 1134010p -0.3
+ 1136000p -0.3
+ 1136010p 0.9
+ 1138000p 0.9
+ 1138010p -0.3
+ 1140000p -0.3
+ 1140010p 0.9
+ 1142000p 0.9
+ 1142010p -0.3
+ 1144000p -0.3
+ 1144010p 0.9
+ 1146000p 0.9
+ 1146010p -0.3
+ 1148000p -0.3
+ 1148010p 0.9
+ 1150000p 0.9
+ 1150010p -0.3
+ 1152000p -0.3
+ 1152010p 0.9
+ 1154000p 0.9
+ 1154010p -0.3
+ 1156000p -0.3
+ 1156010p 0.9
+ 1158000p 0.9
+ 1158010p -0.3
+ 1160000p -0.3
+ 1160010p 0.9
+ 1162000p 0.9
+ 1162010p -0.3
+ 1164000p -0.3
+ 1164010p 0.9
+ 1166000p 0.9
+ 1166010p -0.3
+ 1168000p -0.3
+ 1168010p 0.9
+ 1170000p 0.9
+ 1170010p -0.3
+ 1172000p -0.3
+ 1172010p 0.9
+ 1174000p 0.9
+ 1174010p -0.3
+ 1176000p -0.3
+ 1176010p 0.9
+ 1178000p 0.9
+ 1178010p -0.3
+ 1180000p -0.3
+ 1180010p 0.9
+ 1182000p 0.9
+ 1182010p -0.3
+ 1184000p -0.3
+ 1184010p 0.9
+ 1186000p 0.9
+ 1186010p -0.3
+ 1188000p -0.3
+ 1188010p 0.9
+ 1190000p 0.9
+ 1190010p -0.3
+ 1192000p -0.3
+ 1192010p 0.9
+ 1194000p 0.9
+ 1194010p -0.3
+ 1196000p -0.3
+ 1196010p 0.9
+ 1198000p 0.9
+ 1198010p -0.3
+ 1200000p -0.3
+ 1200010p 0.9
+ 1202000p 0.9
+ 1202010p -0.3
+ 1204000p -0.3
+ 1204010p 0.9
+ 1206000p 0.9
+ 1206010p -0.3
+ 1208000p -0.3
+ 1208010p 0.9
+ 1210000p 0.9
+ 1210010p -0.3
+ 1212000p -0.3
+ 1212010p 0.9
+ 1214000p 0.9
+ 1214010p -0.3
+ 1216000p -0.3
+ 1216010p 0.9
+ 1218000p 0.9
+ 1218010p -0.3
+ 1220000p -0.3
+ 1220010p 0.9
+ 1222000p 0.9
+ 1222010p -0.3
+ 1224000p -0.3
+ 1224010p 0.9
+ 1226000p 0.9
+ 1226010p -0.3
+ 1228000p -0.3
+ 1228010p 0.9
+ 1230000p 0.9
+ 1230010p -0.3
+ 1232000p -0.3
+ 1232010p 0.9
+ 1234000p 0.9
+ 1234010p -0.3
+ 1236000p -0.3
+ 1236010p 0.9
+ 1238000p 0.9
+ 1238010p -0.3
+ 1240000p -0.3
+ 1240010p 0.9
+ 1242000p 0.9
+ 1242010p -0.3
+ 1244000p -0.3
+ 1244010p 0.9
+ 1246000p 0.9
+ 1246010p -0.3
+ 1248000p -0.3
+ 1248010p 0.9
+ 1250000p 0.9
+ 1250010p -0.3
+ 1252000p -0.3
+ 1252010p 0.9
+ 1254000p 0.9
+ 1254010p -0.3
+ 1256000p -0.3
+ 1256010p 0.9
+ 1258000p 0.9
+ 1258010p -0.3
+ 1260000p -0.3
+ 1260010p 0.9
+ 1262000p 0.9
+ 1262010p -0.3
+ 1264000p -0.3
+ 1264010p 0.9
+ 1266000p 0.9
+ 1266010p -0.3
+ 1268000p -0.3
+ 1268010p 0.9
+ 1270000p 0.9
+ 1270010p -0.3
+ 1272000p -0.3
+ 1272010p 0.9
+ 1274000p 0.9
+ 1274010p -0.3
+ 1276000p -0.3
+ 1276010p 0.9
+ 1278000p 0.9
+ 1278010p -0.3
+ 1280000p -0.3
+ 1280010p 0.9
+ 1282000p 0.9
+ 1282010p -0.3
+ 1284000p -0.3
+ 1284010p 0.9
+ 1286000p 0.9
+ 1286010p -0.3
+ 1288000p -0.3
+ 1288010p 0.9
+ 1290000p 0.9
+ 1290010p -0.3
+ 1292000p -0.3
+ 1292010p 0.9
+ 1294000p 0.9
+ 1294010p -0.3
+ 1296000p -0.3
+ 1296010p 0.9
+ 1298000p 0.9
+ 1298010p -0.3
+ 1300000p -0.3
+ 1300010p 0.9
+ 1302000p 0.9
+ 1302010p -0.3
+ 1304000p -0.3
+ 1304010p 0.9
+ 1306000p 0.9
+ 1306010p -0.3
+ 1308000p -0.3
+ 1308010p 0.9
+ 1310000p 0.9
+ 1310010p -0.3
+ 1312000p -0.3
+ 1312010p 0.9
+ 1314000p 0.9
+ 1314010p -0.3
+ 1316000p -0.3
+ 1316010p 0.9
+ 1318000p 0.9
+ 1318010p -0.3
+ 1320000p -0.3
+ 1320010p 0.9
+ 1322000p 0.9
+ 1322010p -0.3
+ 1324000p -0.3
+ 1324010p 0.9
+ 1326000p 0.9
+ 1326010p -0.3
+ 1328000p -0.3
+ 1328010p 0.9
+ 1330000p 0.9
+ 1330010p -0.3
+ 1332000p -0.3
+ 1332010p 0.9
+ 1334000p 0.9
+ 1334010p -0.3
+ 1336000p -0.3
+ 1336010p 0.9
+ 1338000p 0.9
+ 1338010p -0.3
+ 1340000p -0.3
+ 1340010p 0.9
+ 1342000p 0.9
+ 1342010p -0.3
+ 1344000p -0.3
+ 1344010p 0.9
+ 1346000p 0.9
+ 1346010p -0.3
+ 1348000p -0.3
+ 1348010p 0.9
+ 1350000p 0.9
+ 1350010p -0.3
+ 1352000p -0.3
+ 1352010p 0.9
+ 1354000p 0.9
+ 1354010p -0.3
+ 1356000p -0.3
+ 1356010p 0.9
+ 1358000p 0.9
+ 1358010p -0.3
+ 1360000p -0.3
+ 1360010p 0.9
+ 1362000p 0.9
+ 1362010p -0.3
+ 1364000p -0.3
+ 1364010p 0.9
+ 1366000p 0.9
+ 1366010p -0.3
+ 1368000p -0.3
+ 1368010p 0.9
+ 1370000p 0.9
+ 1370010p -0.3
+ 1372000p -0.3
+ 1372010p 0.9
+ 1374000p 0.9
+ 1374010p -0.3
+ 1376000p -0.3
+ 1376010p 0.9
+ 1378000p 0.9
+ 1378010p -0.3
+ 1380000p -0.3
+ 1380010p 0.9
+ 1382000p 0.9
+ 1382010p -0.3
+ 1384000p -0.3
+ 1384010p 0.9
+ 1386000p 0.9
+ 1386010p -0.3
+ 1388000p -0.3
+ 1388010p 0.9
+ 1390000p 0.9
+ 1390010p -0.3
+ 1392000p -0.3
+ 1392010p 0.9
+ 1394000p 0.9
+ 1394010p -0.3
+ 1396000p -0.3
+ 1396010p 0.9
+ 1398000p 0.9
+ 1398010p -0.3
+ 1400000p -0.3
+ 1400010p 0.9
+ 1402000p 0.9
+ 1402010p -0.3
+ 1404000p -0.3
+ 1404010p 0.9
+ 1406000p 0.9
+ 1406010p -0.3
+ 1408000p -0.3
+ 1408010p 0.9
+ 1410000p 0.9
+ 1410010p -0.3
+ 1412000p -0.3
+ 1412010p 0.9
+ 1414000p 0.9
+ 1414010p -0.3
+ 1416000p -0.3
+ 1416010p 0.9
+ 1418000p 0.9
+ 1418010p -0.3
+ 1420000p -0.3
+ 1420010p 0.9
+ 1422000p 0.9
+ 1422010p -0.3
+ 1424000p -0.3
+ 1424010p 0.9
+ 1426000p 0.9
+ 1426010p -0.3
+ 1428000p -0.3
+ 1428010p 0.9
+ 1430000p 0.9
+ 1430010p -0.3
+ 1432000p -0.3
+ 1432010p 0.9
+ 1434000p 0.9
+ 1434010p -0.3
+ 1436000p -0.3
+ 1436010p 0.9
+ 1438000p 0.9
+ 1438010p -0.3
+ 1440000p -0.3
+ 1440010p 0.9
+ 1442000p 0.9
+ 1442010p -0.3
+ 1444000p -0.3
+ 1444010p 0.9
+ 1446000p 0.9
+ 1446010p -0.3
+ 1448000p -0.3
+ 1448010p 0.9
+ 1450000p 0.9
+ 1450010p -0.3
+ 1452000p -0.3
+ 1452010p 0.9
+ 1454000p 0.9
+ 1454010p -0.3
+ 1456000p -0.3
+ 1456010p 0.9
+ 1458000p 0.9
+ 1458010p -0.3
+ 1460000p -0.3
+ 1460010p 0.9
+ 1462000p 0.9
+ 1462010p -0.3
+ 1464000p -0.3
+ 1464010p 0.9
+ 1466000p 0.9
+ 1466010p -0.3
+ 1468000p -0.3
+ 1468010p 0.9
+ 1470000p 0.9
+ 1470010p -0.3
+ 1472000p -0.3
+ 1472010p 0.9
+ 1474000p 0.9
+ 1474010p -0.3
+ 1476000p -0.3
+ 1476010p 0.9
+ 1478000p 0.9
+ 1478010p -0.3
+ 1480000p -0.3
+ 1480010p 0.9
+ 1482000p 0.9
+ 1482010p -0.3
+ 1484000p -0.3
+ 1484010p 0.9
+ 1486000p 0.9
+ 1486010p -0.3
+ 1488000p -0.3
+ 1488010p 0.9
+ 1490000p 0.9
+ 1490010p -0.3
+ 1492000p -0.3
+ 1492010p 0.9
+ 1494000p 0.9
+ 1494010p -0.3
+ 1496000p -0.3
+ 1496010p 0.9
+ 1498000p 0.9
+ 1498010p -0.3
+ 1500000p -0.3
+ 1500010p 0.9
+ 1502000p 0.9
+ 1502010p -0.3
+ 1504000p -0.3
+ 1504010p 0.9
+ 1506000p 0.9
+ 1506010p -0.3
+ 1508000p -0.3
+ 1508010p 0.9
+ 1510000p 0.9
+ 1510010p -0.3
+ 1512000p -0.3
+ 1512010p 0.9
+ 1514000p 0.9
+ 1514010p -0.3
+ 1516000p -0.3
+ 1516010p 0.9
+ 1518000p 0.9
+ 1518010p -0.3
+ 1520000p -0.3
+ 1520010p 0.9
+ 1522000p 0.9
+ 1522010p -0.3
+ 1524000p -0.3
+ 1524010p 0.9
+ 1526000p 0.9
+ 1526010p -0.3
+ 1528000p -0.3
+ 1528010p 0.9
+ 1530000p 0.9
+ 1530010p -0.3
+ 1532000p -0.3
+ 1532010p 0.9
+ 1534000p 0.9
+ 1534010p -0.3
+ 1536000p -0.3
+ 1536010p 0.9
+ 1538000p 0.9
+ 1538010p -0.3
+ 1540000p -0.3
+ 1540010p 0.9
+ 1542000p 0.9
+ 1542010p -0.3
+ 1544000p -0.3
+ 1544010p 0.9
+ 1546000p 0.9
+ 1546010p -0.3
+ 1548000p -0.3
+ 1548010p 0.9
+ 1550000p 0.9
+ 1550010p -0.3
+ 1552000p -0.3
+ 1552010p 0.9
+ 1554000p 0.9
+ 1554010p -0.3
+ 1556000p -0.3
+ 1556010p 0.9
+ 1558000p 0.9
+ 1558010p -0.3
+ 1560000p -0.3
+ 1560010p 0.9
+ 1562000p 0.9
+ 1562010p -0.3
+ 1564000p -0.3
+ 1564010p 0.9
+ 1566000p 0.9
+ 1566010p -0.3
+ 1568000p -0.3
+ 1568010p 0.9
+ 1570000p 0.9
+ 1570010p -0.3
+ 1572000p -0.3
+ 1572010p 0.9
+ 1574000p 0.9
+ 1574010p -0.3
+ 1576000p -0.3
+ 1576010p 0.9
+ 1578000p 0.9
+ 1578010p -0.3
+ 1580000p -0.3
+ 1580010p 0.9
+ 1582000p 0.9
+ 1582010p -0.3
+ 1584000p -0.3
+ 1584010p 0.9
+ 1586000p 0.9
+ 1586010p -0.3
+ 1588000p -0.3
+ 1588010p 0.9
+ 1590000p 0.9
+ 1590010p -0.3
+ 1592000p -0.3
+ 1592010p 0.9
+ 1594000p 0.9
+ 1594010p -0.3
+ 1596000p -0.3
+ 1596010p 0.9
+ 1598000p 0.9
+ 1598010p -0.3
+ 1600000p -0.3
+ 1600010p 0.9
+ 1602000p 0.9
+ 1602010p -0.3
+ 1604000p -0.3
+ 1604010p 0.9
+ 1606000p 0.9
+ 1606010p -0.3
+ 1608000p -0.3
+ 1608010p 0.9
+ 1610000p 0.9
+ 1610010p -0.3
+ 1612000p -0.3
+ 1612010p 0.9
+ 1614000p 0.9
+ 1614010p -0.3
+ 1616000p -0.3
+ 1616010p 0.9
+ 1618000p 0.9
+ 1618010p -0.3
+ 1620000p -0.3
+ 1620010p 0.9
+ 1622000p 0.9
+ 1622010p -0.3
+ 1624000p -0.3
+ 1624010p 0.9
+ 1626000p 0.9
+ 1626010p -0.3
+ 1628000p -0.3
+ 1628010p 0.9
+ 1630000p 0.9
+ 1630010p -0.3
+ 1632000p -0.3
+ 1632010p 0.9
+ 1634000p 0.9
+ 1634010p -0.3
+ 1636000p -0.3
+ 1636010p 0.9
+ 1638000p 0.9
+ 1638010p -0.3
+ 1640000p -0.3
+ 1640010p 0.9
+ 1642000p 0.9
+ 1642010p -0.3
+ 1644000p -0.3
+ 1644010p 0.9
+ 1646000p 0.9
+ 1646010p -0.3
+ 1648000p -0.3
+ 1648010p 0.9
+ 1650000p 0.9
+ 1650010p -0.3
+ 1652000p -0.3
+ 1652010p 0.9
+ 1654000p 0.9
+ 1654010p -0.3
+ 1656000p -0.3
+ 1656010p 0.9
+ 1658000p 0.9
+ 1658010p -0.3
+ 1660000p -0.3
+ 1660010p 0.9
+ 1662000p 0.9
+ 1662010p -0.3
+ 1664000p -0.3
+ 1664010p 0.9
+ 1666000p 0.9
+ 1666010p -0.3
+ 1668000p -0.3
+ 1668010p 0.9
+ 1670000p 0.9
+ 1670010p -0.3
+ 1672000p -0.3
+ 1672010p 0.9
+ 1674000p 0.9
+ 1674010p -0.3
+ 1676000p -0.3
+ 1676010p 0.9
+ 1678000p 0.9
+ 1678010p -0.3
+ 1680000p -0.3
+ 1680010p 0.9
+ 1682000p 0.9
+ 1682010p -0.3
+ 1684000p -0.3
+ 1684010p 0.9
+ 1686000p 0.9
+ 1686010p -0.3
+ 1688000p -0.3
+ 1688010p 0.9
+ 1690000p 0.9
+ 1690010p -0.3
+ 1692000p -0.3
+ 1692010p 0.9
+ 1694000p 0.9
+ 1694010p -0.3
+ 1696000p -0.3
+ 1696010p 0.9
+ 1698000p 0.9
+ 1698010p -0.3
+ 1700000p -0.3
+ 1700010p 0.9
+ 1702000p 0.9
+ 1702010p -0.3
+ 1704000p -0.3
+ 1704010p 0.9
+ 1706000p 0.9
+ 1706010p -0.3
+ 1708000p -0.3
+ 1708010p 0.9
+ 1710000p 0.9
+ 1710010p -0.3
+ 1712000p -0.3
+ 1712010p 0.9
+ 1714000p 0.9
+ 1714010p -0.3
+ 1716000p -0.3
+ 1716010p 0.9
+ 1718000p 0.9
+ 1718010p -0.3
+ 1720000p -0.3
+ 1720010p 0.9
+ 1722000p 0.9
+ 1722010p -0.3
+ 1724000p -0.3
+ 1724010p 0.9
+ 1726000p 0.9
+ 1726010p -0.3
+ 1728000p -0.3
+ 1728010p 0.9
+ 1730000p 0.9
+ 1730010p -0.3
+ 1732000p -0.3
+ 1732010p 0.9
+ 1734000p 0.9
+ 1734010p -0.3
+ 1736000p -0.3
+ 1736010p 0.9
+ 1738000p 0.9
+ 1738010p -0.3
+ 1740000p -0.3
+ 1740010p 0.9
+ 1742000p 0.9
+ 1742010p -0.3
+ 1744000p -0.3
+ 1744010p 0.9
+ 1746000p 0.9
+ 1746010p -0.3
+ 1748000p -0.3
+ 1748010p 0.9
+ 1750000p 0.9
+ 1750010p -0.3
+ 1752000p -0.3
+ 1752010p 0.9
+ 1754000p 0.9
+ 1754010p -0.3
+ 1756000p -0.3
+ 1756010p 0.9
+ 1758000p 0.9
+ 1758010p -0.3
+ 1760000p -0.3
+ 1760010p 0.9
+ 1762000p 0.9
+ 1762010p -0.3
+ 1764000p -0.3
+ 1764010p 0.9
+ 1766000p 0.9
+ 1766010p -0.3
+ 1768000p -0.3
+ 1768010p 0.9
+ 1770000p 0.9
+ 1770010p -0.3
+ 1772000p -0.3
+ 1772010p 0.9
+ 1774000p 0.9
+ 1774010p -0.3
+ 1776000p -0.3
+ 1776010p 0.9
+ 1778000p 0.9
+ 1778010p -0.3
+ 1780000p -0.3
+ 1780010p 0.9
+ 1782000p 0.9
+ 1782010p -0.3
+ 1784000p -0.3
+ 1784010p 0.9
+ 1786000p 0.9
+ 1786010p -0.3
+ 1788000p -0.3
+ 1788010p 0.9
+ 1790000p 0.9
+ 1790010p -0.3
+ 1792000p -0.3
+ 1792010p 0.9
+ 1794000p 0.9
+ 1794010p -0.3
+ 1796000p -0.3
+ 1796010p 0.9
+ 1798000p 0.9
+ 1798010p -0.3
+ 1800000p -0.3
+ 1800010p 0.9
+ 1802000p 0.9
+ 1802010p -0.3
+ 1804000p -0.3
+ 1804010p 0.9
+ 1806000p 0.9
+ 1806010p -0.3
+ 1808000p -0.3
+ 1808010p 0.9
+ 1810000p 0.9
+ 1810010p -0.3
+ 1812000p -0.3
+ 1812010p 0.9
+ 1814000p 0.9
+ 1814010p -0.3
+ 1816000p -0.3
+ 1816010p 0.9
+ 1818000p 0.9
+ 1818010p -0.3
+ 1820000p -0.3
+ 1820010p 0.9
+ 1822000p 0.9
+ 1822010p -0.3
+ 1824000p -0.3
+ 1824010p 0.9
+ 1826000p 0.9
+ 1826010p -0.3
+ 1828000p -0.3
+ 1828010p 0.9
+ 1830000p 0.9
+ 1830010p -0.3
+ 1832000p -0.3
+ 1832010p 0.9
+ 1834000p 0.9
+ 1834010p -0.3
+ 1836000p -0.3
+ 1836010p 0.9
+ 1838000p 0.9
+ 1838010p -0.3
+ 1840000p -0.3
+ 1840010p 0.9
+ 1842000p 0.9
+ 1842010p -0.3
+ 1844000p -0.3
+ 1844010p 0.9
+ 1846000p 0.9
+ 1846010p -0.3
+ 1848000p -0.3
+ 1848010p 0.9
+ 1850000p 0.9
+ 1850010p -0.3
+ 1852000p -0.3
+ 1852010p 0.9
+ 1854000p 0.9
+ 1854010p -0.3
+ 1856000p -0.3
+ 1856010p 0.9
+ 1858000p 0.9
+ 1858010p -0.3
+ 1860000p -0.3
+ 1860010p 0.9
+ 1862000p 0.9
+ 1862010p -0.3
+ 1864000p -0.3
+ 1864010p 0.9
+ 1866000p 0.9
+ 1866010p -0.3
+ 1868000p -0.3
+ 1868010p 0.9
+ 1870000p 0.9
+ 1870010p -0.3
+ 1872000p -0.3
+ 1872010p 0.9
+ 1874000p 0.9
+ 1874010p -0.3
+ 1876000p -0.3
+ 1876010p 0.9
+ 1878000p 0.9
+ 1878010p -0.3
+ 1880000p -0.3
+ 1880010p 0.9
+ 1882000p 0.9
+ 1882010p -0.3
+ 1884000p -0.3
+ 1884010p 0.9
+ 1886000p 0.9
+ 1886010p -0.3
+ 1888000p -0.3
+ 1888010p 0.9
+ 1890000p 0.9
+ 1890010p -0.3
+ 1892000p -0.3
+ 1892010p 0.9
+ 1894000p 0.9
+ 1894010p -0.3
+ 1896000p -0.3
+ 1896010p 0.9
+ 1898000p 0.9
+ 1898010p -0.3
+ 1900000p -0.3
+ 1900010p 0.9
+ 1902000p 0.9
+ 1902010p -0.3
+ 1904000p -0.3
+ 1904010p 0.9
+ 1906000p 0.9
+ 1906010p -0.3
+ 1908000p -0.3
+ 1908010p 0.9
+ 1910000p 0.9
+ 1910010p -0.3
+ 1912000p -0.3
+ 1912010p 0.9
+ 1914000p 0.9
+ 1914010p -0.3
+ 1916000p -0.3
+ 1916010p 0.9
+ 1918000p 0.9
+ 1918010p -0.3
+ 1920000p -0.3
+ 1920010p 0.9
+ 1922000p 0.9
+ 1922010p -0.3
+ 1924000p -0.3
+ 1924010p 0.9
+ 1926000p 0.9
+ 1926010p -0.3
+ 1928000p -0.3
+ 1928010p 0.9
+ 1930000p 0.9
+ 1930010p -0.3
+ 1932000p -0.3
+ 1932010p 0.9
+ 1934000p 0.9
+ 1934010p -0.3
+ 1936000p -0.3
+ 1936010p 0.9
+ 1938000p 0.9
+ 1938010p -0.3
+ 1940000p -0.3
+ 1940010p 0.9
+ 1942000p 0.9
+ 1942010p -0.3
+ 1944000p -0.3
+ 1944010p 0.9
+ 1946000p 0.9
+ 1946010p -0.3
+ 1948000p -0.3
+ 1948010p 0.9
+ 1950000p 0.9
+ 1950010p -0.3
+ 1952000p -0.3
+ 1952010p 0.9
+ 1954000p 0.9
+ 1954010p -0.3
+ 1956000p -0.3
+ 1956010p 0.9
+ 1958000p 0.9
+ 1958010p -0.3
+ 1960000p -0.3
+ 1960010p 0.9
+ 1962000p 0.9
+ 1962010p -0.3
+ 1964000p -0.3
+ 1964010p 0.9
+ 1966000p 0.9
+ 1966010p -0.3
+ 1968000p -0.3
+ 1968010p 0.9
+ 1970000p 0.9
+ 1970010p -0.3
+ 1972000p -0.3
+ 1972010p 0.9
+ 1974000p 0.9
+ 1974010p -0.3
+ 1976000p -0.3
+ 1976010p 0.9
+ 1978000p 0.9
+ 1978010p -0.3
+ 1980000p -0.3
+ 1980010p 0.9
+ 1982000p 0.9
+ 1982010p -0.3
+ 1984000p -0.3
+ 1984010p 0.9
+ 1986000p 0.9
+ 1986010p -0.3
+ 1988000p -0.3
+ 1988010p 0.9
+ 1990000p 0.9
+ 1990010p -0.3
+ 1992000p -0.3
+ 1992010p 0.9
+ 1994000p 0.9
+ 1994010p -0.3
+ 1996000p -0.3
+ 1996010p 0.9
+ 1998000p 0.9
+ 1998010p -0.3
+ 2000000p -0.3
+ 2000010p 0.9
+ 2002000p 0.9
+ 2002010p -0.3
+ 2004000p -0.3
+ 2004010p 0.9
+ 2006000p 0.9
+ 2006010p -0.3
+ 2008000p -0.3
+ 2008010p 0.9
+ 2010000p 0.9
+ 2010010p -0.3
+ 2012000p -0.3
+ 2012010p 0.9
+ 2014000p 0.9
+ 2014010p -0.3
+ 2016000p -0.3
+ 2016010p 0.9
+ 2018000p 0.9
+ 2018010p -0.3
+ 2020000p -0.3
+ 2020010p 0.9
+ 2022000p 0.9
+ 2022010p -0.3
+ 2024000p -0.3
+ 2024010p 0.9
+ 2026000p 0.9
+ 2026010p -0.3
+ 2028000p -0.3
+ 2028010p 0.9
+ 2030000p 0.9
+ 2030010p -0.3
+ 2032000p -0.3
+ 2032010p 0.9
+ 2034000p 0.9
+ 2034010p -0.3
+ 2036000p -0.3
+ 2036010p 0.9
+ 2038000p 0.9
+ 2038010p -0.3
+ 2040000p -0.3
+ 2040010p 0.9
+ 2042000p 0.9
+ 2042010p -0.3
+ 2044000p -0.3
+ 2044010p 0.9
+ 2046000p 0.9
+ 2046010p -0.3
+ 2048000p -0.3
+ 2048010p 0.9
+ \]
V_data_bar_13 (Data_bar\\<13\\> gnd!) vsource type=pwl wave=\[
+ 0    -0.3
+ 2000p -0.3
+ 2010p 0.9
+ 4000p 0.9
+ 4010p -0.3
+ 6000p -0.3
+ 6010p 0.9
+ 8000p 0.9
+ 8010p -0.3
+ 10000p -0.3
+ 10010p 0.9
+ 12000p 0.9
+ 12010p -0.3
+ 14000p -0.3
+ 14010p 0.9
+ 16000p 0.9
+ 16010p -0.3
+ 18000p -0.3
+ 18010p 0.9
+ 20000p 0.9
+ 20010p -0.3
+ 22000p -0.3
+ 22010p 0.9
+ 24000p 0.9
+ 24010p -0.3
+ 26000p -0.3
+ 26010p 0.9
+ 28000p 0.9
+ 28010p -0.3
+ 30000p -0.3
+ 30010p 0.9
+ 32000p 0.9
+ 32010p -0.3
+ 34000p -0.3
+ 34010p 0.9
+ 36000p 0.9
+ 36010p -0.3
+ 38000p -0.3
+ 38010p 0.9
+ 40000p 0.9
+ 40010p -0.3
+ 42000p -0.3
+ 42010p 0.9
+ 44000p 0.9
+ 44010p -0.3
+ 46000p -0.3
+ 46010p 0.9
+ 48000p 0.9
+ 48010p -0.3
+ 50000p -0.3
+ 50010p 0.9
+ 52000p 0.9
+ 52010p -0.3
+ 54000p -0.3
+ 54010p 0.9
+ 56000p 0.9
+ 56010p -0.3
+ 58000p -0.3
+ 58010p 0.9
+ 60000p 0.9
+ 60010p -0.3
+ 62000p -0.3
+ 62010p 0.9
+ 64000p 0.9
+ 64010p -0.3
+ 66000p -0.3
+ 66010p 0.9
+ 68000p 0.9
+ 68010p -0.3
+ 70000p -0.3
+ 70010p 0.9
+ 72000p 0.9
+ 72010p -0.3
+ 74000p -0.3
+ 74010p 0.9
+ 76000p 0.9
+ 76010p -0.3
+ 78000p -0.3
+ 78010p 0.9
+ 80000p 0.9
+ 80010p -0.3
+ 82000p -0.3
+ 82010p 0.9
+ 84000p 0.9
+ 84010p -0.3
+ 86000p -0.3
+ 86010p 0.9
+ 88000p 0.9
+ 88010p -0.3
+ 90000p -0.3
+ 90010p 0.9
+ 92000p 0.9
+ 92010p -0.3
+ 94000p -0.3
+ 94010p 0.9
+ 96000p 0.9
+ 96010p -0.3
+ 98000p -0.3
+ 98010p 0.9
+ 100000p 0.9
+ 100010p -0.3
+ 102000p -0.3
+ 102010p 0.9
+ 104000p 0.9
+ 104010p -0.3
+ 106000p -0.3
+ 106010p 0.9
+ 108000p 0.9
+ 108010p -0.3
+ 110000p -0.3
+ 110010p 0.9
+ 112000p 0.9
+ 112010p -0.3
+ 114000p -0.3
+ 114010p 0.9
+ 116000p 0.9
+ 116010p -0.3
+ 118000p -0.3
+ 118010p 0.9
+ 120000p 0.9
+ 120010p -0.3
+ 122000p -0.3
+ 122010p 0.9
+ 124000p 0.9
+ 124010p -0.3
+ 126000p -0.3
+ 126010p 0.9
+ 128000p 0.9
+ 128010p -0.3
+ 130000p -0.3
+ 130010p 0.9
+ 132000p 0.9
+ 132010p -0.3
+ 134000p -0.3
+ 134010p 0.9
+ 136000p 0.9
+ 136010p -0.3
+ 138000p -0.3
+ 138010p 0.9
+ 140000p 0.9
+ 140010p -0.3
+ 142000p -0.3
+ 142010p 0.9
+ 144000p 0.9
+ 144010p -0.3
+ 146000p -0.3
+ 146010p 0.9
+ 148000p 0.9
+ 148010p -0.3
+ 150000p -0.3
+ 150010p 0.9
+ 152000p 0.9
+ 152010p -0.3
+ 154000p -0.3
+ 154010p 0.9
+ 156000p 0.9
+ 156010p -0.3
+ 158000p -0.3
+ 158010p 0.9
+ 160000p 0.9
+ 160010p -0.3
+ 162000p -0.3
+ 162010p 0.9
+ 164000p 0.9
+ 164010p -0.3
+ 166000p -0.3
+ 166010p 0.9
+ 168000p 0.9
+ 168010p -0.3
+ 170000p -0.3
+ 170010p 0.9
+ 172000p 0.9
+ 172010p -0.3
+ 174000p -0.3
+ 174010p 0.9
+ 176000p 0.9
+ 176010p -0.3
+ 178000p -0.3
+ 178010p 0.9
+ 180000p 0.9
+ 180010p -0.3
+ 182000p -0.3
+ 182010p 0.9
+ 184000p 0.9
+ 184010p -0.3
+ 186000p -0.3
+ 186010p 0.9
+ 188000p 0.9
+ 188010p -0.3
+ 190000p -0.3
+ 190010p 0.9
+ 192000p 0.9
+ 192010p -0.3
+ 194000p -0.3
+ 194010p 0.9
+ 196000p 0.9
+ 196010p -0.3
+ 198000p -0.3
+ 198010p 0.9
+ 200000p 0.9
+ 200010p -0.3
+ 202000p -0.3
+ 202010p 0.9
+ 204000p 0.9
+ 204010p -0.3
+ 206000p -0.3
+ 206010p 0.9
+ 208000p 0.9
+ 208010p -0.3
+ 210000p -0.3
+ 210010p 0.9
+ 212000p 0.9
+ 212010p -0.3
+ 214000p -0.3
+ 214010p 0.9
+ 216000p 0.9
+ 216010p -0.3
+ 218000p -0.3
+ 218010p 0.9
+ 220000p 0.9
+ 220010p -0.3
+ 222000p -0.3
+ 222010p 0.9
+ 224000p 0.9
+ 224010p -0.3
+ 226000p -0.3
+ 226010p 0.9
+ 228000p 0.9
+ 228010p -0.3
+ 230000p -0.3
+ 230010p 0.9
+ 232000p 0.9
+ 232010p -0.3
+ 234000p -0.3
+ 234010p 0.9
+ 236000p 0.9
+ 236010p -0.3
+ 238000p -0.3
+ 238010p 0.9
+ 240000p 0.9
+ 240010p -0.3
+ 242000p -0.3
+ 242010p 0.9
+ 244000p 0.9
+ 244010p -0.3
+ 246000p -0.3
+ 246010p 0.9
+ 248000p 0.9
+ 248010p -0.3
+ 250000p -0.3
+ 250010p 0.9
+ 252000p 0.9
+ 252010p -0.3
+ 254000p -0.3
+ 254010p 0.9
+ 256000p 0.9
+ 256010p -0.3
+ 258000p -0.3
+ 258010p 0.9
+ 260000p 0.9
+ 260010p -0.3
+ 262000p -0.3
+ 262010p 0.9
+ 264000p 0.9
+ 264010p -0.3
+ 266000p -0.3
+ 266010p 0.9
+ 268000p 0.9
+ 268010p -0.3
+ 270000p -0.3
+ 270010p 0.9
+ 272000p 0.9
+ 272010p -0.3
+ 274000p -0.3
+ 274010p 0.9
+ 276000p 0.9
+ 276010p -0.3
+ 278000p -0.3
+ 278010p 0.9
+ 280000p 0.9
+ 280010p -0.3
+ 282000p -0.3
+ 282010p 0.9
+ 284000p 0.9
+ 284010p -0.3
+ 286000p -0.3
+ 286010p 0.9
+ 288000p 0.9
+ 288010p -0.3
+ 290000p -0.3
+ 290010p 0.9
+ 292000p 0.9
+ 292010p -0.3
+ 294000p -0.3
+ 294010p 0.9
+ 296000p 0.9
+ 296010p -0.3
+ 298000p -0.3
+ 298010p 0.9
+ 300000p 0.9
+ 300010p -0.3
+ 302000p -0.3
+ 302010p 0.9
+ 304000p 0.9
+ 304010p -0.3
+ 306000p -0.3
+ 306010p 0.9
+ 308000p 0.9
+ 308010p -0.3
+ 310000p -0.3
+ 310010p 0.9
+ 312000p 0.9
+ 312010p -0.3
+ 314000p -0.3
+ 314010p 0.9
+ 316000p 0.9
+ 316010p -0.3
+ 318000p -0.3
+ 318010p 0.9
+ 320000p 0.9
+ 320010p -0.3
+ 322000p -0.3
+ 322010p 0.9
+ 324000p 0.9
+ 324010p -0.3
+ 326000p -0.3
+ 326010p 0.9
+ 328000p 0.9
+ 328010p -0.3
+ 330000p -0.3
+ 330010p 0.9
+ 332000p 0.9
+ 332010p -0.3
+ 334000p -0.3
+ 334010p 0.9
+ 336000p 0.9
+ 336010p -0.3
+ 338000p -0.3
+ 338010p 0.9
+ 340000p 0.9
+ 340010p -0.3
+ 342000p -0.3
+ 342010p 0.9
+ 344000p 0.9
+ 344010p -0.3
+ 346000p -0.3
+ 346010p 0.9
+ 348000p 0.9
+ 348010p -0.3
+ 350000p -0.3
+ 350010p 0.9
+ 352000p 0.9
+ 352010p -0.3
+ 354000p -0.3
+ 354010p 0.9
+ 356000p 0.9
+ 356010p -0.3
+ 358000p -0.3
+ 358010p 0.9
+ 360000p 0.9
+ 360010p -0.3
+ 362000p -0.3
+ 362010p 0.9
+ 364000p 0.9
+ 364010p -0.3
+ 366000p -0.3
+ 366010p 0.9
+ 368000p 0.9
+ 368010p -0.3
+ 370000p -0.3
+ 370010p 0.9
+ 372000p 0.9
+ 372010p -0.3
+ 374000p -0.3
+ 374010p 0.9
+ 376000p 0.9
+ 376010p -0.3
+ 378000p -0.3
+ 378010p 0.9
+ 380000p 0.9
+ 380010p -0.3
+ 382000p -0.3
+ 382010p 0.9
+ 384000p 0.9
+ 384010p -0.3
+ 386000p -0.3
+ 386010p 0.9
+ 388000p 0.9
+ 388010p -0.3
+ 390000p -0.3
+ 390010p 0.9
+ 392000p 0.9
+ 392010p -0.3
+ 394000p -0.3
+ 394010p 0.9
+ 396000p 0.9
+ 396010p -0.3
+ 398000p -0.3
+ 398010p 0.9
+ 400000p 0.9
+ 400010p -0.3
+ 402000p -0.3
+ 402010p 0.9
+ 404000p 0.9
+ 404010p -0.3
+ 406000p -0.3
+ 406010p 0.9
+ 408000p 0.9
+ 408010p -0.3
+ 410000p -0.3
+ 410010p 0.9
+ 412000p 0.9
+ 412010p -0.3
+ 414000p -0.3
+ 414010p 0.9
+ 416000p 0.9
+ 416010p -0.3
+ 418000p -0.3
+ 418010p 0.9
+ 420000p 0.9
+ 420010p -0.3
+ 422000p -0.3
+ 422010p 0.9
+ 424000p 0.9
+ 424010p -0.3
+ 426000p -0.3
+ 426010p 0.9
+ 428000p 0.9
+ 428010p -0.3
+ 430000p -0.3
+ 430010p 0.9
+ 432000p 0.9
+ 432010p -0.3
+ 434000p -0.3
+ 434010p 0.9
+ 436000p 0.9
+ 436010p -0.3
+ 438000p -0.3
+ 438010p 0.9
+ 440000p 0.9
+ 440010p -0.3
+ 442000p -0.3
+ 442010p 0.9
+ 444000p 0.9
+ 444010p -0.3
+ 446000p -0.3
+ 446010p 0.9
+ 448000p 0.9
+ 448010p -0.3
+ 450000p -0.3
+ 450010p 0.9
+ 452000p 0.9
+ 452010p -0.3
+ 454000p -0.3
+ 454010p 0.9
+ 456000p 0.9
+ 456010p -0.3
+ 458000p -0.3
+ 458010p 0.9
+ 460000p 0.9
+ 460010p -0.3
+ 462000p -0.3
+ 462010p 0.9
+ 464000p 0.9
+ 464010p -0.3
+ 466000p -0.3
+ 466010p 0.9
+ 468000p 0.9
+ 468010p -0.3
+ 470000p -0.3
+ 470010p 0.9
+ 472000p 0.9
+ 472010p -0.3
+ 474000p -0.3
+ 474010p 0.9
+ 476000p 0.9
+ 476010p -0.3
+ 478000p -0.3
+ 478010p 0.9
+ 480000p 0.9
+ 480010p -0.3
+ 482000p -0.3
+ 482010p 0.9
+ 484000p 0.9
+ 484010p -0.3
+ 486000p -0.3
+ 486010p 0.9
+ 488000p 0.9
+ 488010p -0.3
+ 490000p -0.3
+ 490010p 0.9
+ 492000p 0.9
+ 492010p -0.3
+ 494000p -0.3
+ 494010p 0.9
+ 496000p 0.9
+ 496010p -0.3
+ 498000p -0.3
+ 498010p 0.9
+ 500000p 0.9
+ 500010p -0.3
+ 502000p -0.3
+ 502010p 0.9
+ 504000p 0.9
+ 504010p -0.3
+ 506000p -0.3
+ 506010p 0.9
+ 508000p 0.9
+ 508010p -0.3
+ 510000p -0.3
+ 510010p 0.9
+ 512000p 0.9
+ 512010p -0.3
+ 514000p -0.3
+ 514010p 0.9
+ 516000p 0.9
+ 516010p -0.3
+ 518000p -0.3
+ 518010p 0.9
+ 520000p 0.9
+ 520010p -0.3
+ 522000p -0.3
+ 522010p 0.9
+ 524000p 0.9
+ 524010p -0.3
+ 526000p -0.3
+ 526010p 0.9
+ 528000p 0.9
+ 528010p -0.3
+ 530000p -0.3
+ 530010p 0.9
+ 532000p 0.9
+ 532010p -0.3
+ 534000p -0.3
+ 534010p 0.9
+ 536000p 0.9
+ 536010p -0.3
+ 538000p -0.3
+ 538010p 0.9
+ 540000p 0.9
+ 540010p -0.3
+ 542000p -0.3
+ 542010p 0.9
+ 544000p 0.9
+ 544010p -0.3
+ 546000p -0.3
+ 546010p 0.9
+ 548000p 0.9
+ 548010p -0.3
+ 550000p -0.3
+ 550010p 0.9
+ 552000p 0.9
+ 552010p -0.3
+ 554000p -0.3
+ 554010p 0.9
+ 556000p 0.9
+ 556010p -0.3
+ 558000p -0.3
+ 558010p 0.9
+ 560000p 0.9
+ 560010p -0.3
+ 562000p -0.3
+ 562010p 0.9
+ 564000p 0.9
+ 564010p -0.3
+ 566000p -0.3
+ 566010p 0.9
+ 568000p 0.9
+ 568010p -0.3
+ 570000p -0.3
+ 570010p 0.9
+ 572000p 0.9
+ 572010p -0.3
+ 574000p -0.3
+ 574010p 0.9
+ 576000p 0.9
+ 576010p -0.3
+ 578000p -0.3
+ 578010p 0.9
+ 580000p 0.9
+ 580010p -0.3
+ 582000p -0.3
+ 582010p 0.9
+ 584000p 0.9
+ 584010p -0.3
+ 586000p -0.3
+ 586010p 0.9
+ 588000p 0.9
+ 588010p -0.3
+ 590000p -0.3
+ 590010p 0.9
+ 592000p 0.9
+ 592010p -0.3
+ 594000p -0.3
+ 594010p 0.9
+ 596000p 0.9
+ 596010p -0.3
+ 598000p -0.3
+ 598010p 0.9
+ 600000p 0.9
+ 600010p -0.3
+ 602000p -0.3
+ 602010p 0.9
+ 604000p 0.9
+ 604010p -0.3
+ 606000p -0.3
+ 606010p 0.9
+ 608000p 0.9
+ 608010p -0.3
+ 610000p -0.3
+ 610010p 0.9
+ 612000p 0.9
+ 612010p -0.3
+ 614000p -0.3
+ 614010p 0.9
+ 616000p 0.9
+ 616010p -0.3
+ 618000p -0.3
+ 618010p 0.9
+ 620000p 0.9
+ 620010p -0.3
+ 622000p -0.3
+ 622010p 0.9
+ 624000p 0.9
+ 624010p -0.3
+ 626000p -0.3
+ 626010p 0.9
+ 628000p 0.9
+ 628010p -0.3
+ 630000p -0.3
+ 630010p 0.9
+ 632000p 0.9
+ 632010p -0.3
+ 634000p -0.3
+ 634010p 0.9
+ 636000p 0.9
+ 636010p -0.3
+ 638000p -0.3
+ 638010p 0.9
+ 640000p 0.9
+ 640010p -0.3
+ 642000p -0.3
+ 642010p 0.9
+ 644000p 0.9
+ 644010p -0.3
+ 646000p -0.3
+ 646010p 0.9
+ 648000p 0.9
+ 648010p -0.3
+ 650000p -0.3
+ 650010p 0.9
+ 652000p 0.9
+ 652010p -0.3
+ 654000p -0.3
+ 654010p 0.9
+ 656000p 0.9
+ 656010p -0.3
+ 658000p -0.3
+ 658010p 0.9
+ 660000p 0.9
+ 660010p -0.3
+ 662000p -0.3
+ 662010p 0.9
+ 664000p 0.9
+ 664010p -0.3
+ 666000p -0.3
+ 666010p 0.9
+ 668000p 0.9
+ 668010p -0.3
+ 670000p -0.3
+ 670010p 0.9
+ 672000p 0.9
+ 672010p -0.3
+ 674000p -0.3
+ 674010p 0.9
+ 676000p 0.9
+ 676010p -0.3
+ 678000p -0.3
+ 678010p 0.9
+ 680000p 0.9
+ 680010p -0.3
+ 682000p -0.3
+ 682010p 0.9
+ 684000p 0.9
+ 684010p -0.3
+ 686000p -0.3
+ 686010p 0.9
+ 688000p 0.9
+ 688010p -0.3
+ 690000p -0.3
+ 690010p 0.9
+ 692000p 0.9
+ 692010p -0.3
+ 694000p -0.3
+ 694010p 0.9
+ 696000p 0.9
+ 696010p -0.3
+ 698000p -0.3
+ 698010p 0.9
+ 700000p 0.9
+ 700010p -0.3
+ 702000p -0.3
+ 702010p 0.9
+ 704000p 0.9
+ 704010p -0.3
+ 706000p -0.3
+ 706010p 0.9
+ 708000p 0.9
+ 708010p -0.3
+ 710000p -0.3
+ 710010p 0.9
+ 712000p 0.9
+ 712010p -0.3
+ 714000p -0.3
+ 714010p 0.9
+ 716000p 0.9
+ 716010p -0.3
+ 718000p -0.3
+ 718010p 0.9
+ 720000p 0.9
+ 720010p -0.3
+ 722000p -0.3
+ 722010p 0.9
+ 724000p 0.9
+ 724010p -0.3
+ 726000p -0.3
+ 726010p 0.9
+ 728000p 0.9
+ 728010p -0.3
+ 730000p -0.3
+ 730010p 0.9
+ 732000p 0.9
+ 732010p -0.3
+ 734000p -0.3
+ 734010p 0.9
+ 736000p 0.9
+ 736010p -0.3
+ 738000p -0.3
+ 738010p 0.9
+ 740000p 0.9
+ 740010p -0.3
+ 742000p -0.3
+ 742010p 0.9
+ 744000p 0.9
+ 744010p -0.3
+ 746000p -0.3
+ 746010p 0.9
+ 748000p 0.9
+ 748010p -0.3
+ 750000p -0.3
+ 750010p 0.9
+ 752000p 0.9
+ 752010p -0.3
+ 754000p -0.3
+ 754010p 0.9
+ 756000p 0.9
+ 756010p -0.3
+ 758000p -0.3
+ 758010p 0.9
+ 760000p 0.9
+ 760010p -0.3
+ 762000p -0.3
+ 762010p 0.9
+ 764000p 0.9
+ 764010p -0.3
+ 766000p -0.3
+ 766010p 0.9
+ 768000p 0.9
+ 768010p -0.3
+ 770000p -0.3
+ 770010p 0.9
+ 772000p 0.9
+ 772010p -0.3
+ 774000p -0.3
+ 774010p 0.9
+ 776000p 0.9
+ 776010p -0.3
+ 778000p -0.3
+ 778010p 0.9
+ 780000p 0.9
+ 780010p -0.3
+ 782000p -0.3
+ 782010p 0.9
+ 784000p 0.9
+ 784010p -0.3
+ 786000p -0.3
+ 786010p 0.9
+ 788000p 0.9
+ 788010p -0.3
+ 790000p -0.3
+ 790010p 0.9
+ 792000p 0.9
+ 792010p -0.3
+ 794000p -0.3
+ 794010p 0.9
+ 796000p 0.9
+ 796010p -0.3
+ 798000p -0.3
+ 798010p 0.9
+ 800000p 0.9
+ 800010p -0.3
+ 802000p -0.3
+ 802010p 0.9
+ 804000p 0.9
+ 804010p -0.3
+ 806000p -0.3
+ 806010p 0.9
+ 808000p 0.9
+ 808010p -0.3
+ 810000p -0.3
+ 810010p 0.9
+ 812000p 0.9
+ 812010p -0.3
+ 814000p -0.3
+ 814010p 0.9
+ 816000p 0.9
+ 816010p -0.3
+ 818000p -0.3
+ 818010p 0.9
+ 820000p 0.9
+ 820010p -0.3
+ 822000p -0.3
+ 822010p 0.9
+ 824000p 0.9
+ 824010p -0.3
+ 826000p -0.3
+ 826010p 0.9
+ 828000p 0.9
+ 828010p -0.3
+ 830000p -0.3
+ 830010p 0.9
+ 832000p 0.9
+ 832010p -0.3
+ 834000p -0.3
+ 834010p 0.9
+ 836000p 0.9
+ 836010p -0.3
+ 838000p -0.3
+ 838010p 0.9
+ 840000p 0.9
+ 840010p -0.3
+ 842000p -0.3
+ 842010p 0.9
+ 844000p 0.9
+ 844010p -0.3
+ 846000p -0.3
+ 846010p 0.9
+ 848000p 0.9
+ 848010p -0.3
+ 850000p -0.3
+ 850010p 0.9
+ 852000p 0.9
+ 852010p -0.3
+ 854000p -0.3
+ 854010p 0.9
+ 856000p 0.9
+ 856010p -0.3
+ 858000p -0.3
+ 858010p 0.9
+ 860000p 0.9
+ 860010p -0.3
+ 862000p -0.3
+ 862010p 0.9
+ 864000p 0.9
+ 864010p -0.3
+ 866000p -0.3
+ 866010p 0.9
+ 868000p 0.9
+ 868010p -0.3
+ 870000p -0.3
+ 870010p 0.9
+ 872000p 0.9
+ 872010p -0.3
+ 874000p -0.3
+ 874010p 0.9
+ 876000p 0.9
+ 876010p -0.3
+ 878000p -0.3
+ 878010p 0.9
+ 880000p 0.9
+ 880010p -0.3
+ 882000p -0.3
+ 882010p 0.9
+ 884000p 0.9
+ 884010p -0.3
+ 886000p -0.3
+ 886010p 0.9
+ 888000p 0.9
+ 888010p -0.3
+ 890000p -0.3
+ 890010p 0.9
+ 892000p 0.9
+ 892010p -0.3
+ 894000p -0.3
+ 894010p 0.9
+ 896000p 0.9
+ 896010p -0.3
+ 898000p -0.3
+ 898010p 0.9
+ 900000p 0.9
+ 900010p -0.3
+ 902000p -0.3
+ 902010p 0.9
+ 904000p 0.9
+ 904010p -0.3
+ 906000p -0.3
+ 906010p 0.9
+ 908000p 0.9
+ 908010p -0.3
+ 910000p -0.3
+ 910010p 0.9
+ 912000p 0.9
+ 912010p -0.3
+ 914000p -0.3
+ 914010p 0.9
+ 916000p 0.9
+ 916010p -0.3
+ 918000p -0.3
+ 918010p 0.9
+ 920000p 0.9
+ 920010p -0.3
+ 922000p -0.3
+ 922010p 0.9
+ 924000p 0.9
+ 924010p -0.3
+ 926000p -0.3
+ 926010p 0.9
+ 928000p 0.9
+ 928010p -0.3
+ 930000p -0.3
+ 930010p 0.9
+ 932000p 0.9
+ 932010p -0.3
+ 934000p -0.3
+ 934010p 0.9
+ 936000p 0.9
+ 936010p -0.3
+ 938000p -0.3
+ 938010p 0.9
+ 940000p 0.9
+ 940010p -0.3
+ 942000p -0.3
+ 942010p 0.9
+ 944000p 0.9
+ 944010p -0.3
+ 946000p -0.3
+ 946010p 0.9
+ 948000p 0.9
+ 948010p -0.3
+ 950000p -0.3
+ 950010p 0.9
+ 952000p 0.9
+ 952010p -0.3
+ 954000p -0.3
+ 954010p 0.9
+ 956000p 0.9
+ 956010p -0.3
+ 958000p -0.3
+ 958010p 0.9
+ 960000p 0.9
+ 960010p -0.3
+ 962000p -0.3
+ 962010p 0.9
+ 964000p 0.9
+ 964010p -0.3
+ 966000p -0.3
+ 966010p 0.9
+ 968000p 0.9
+ 968010p -0.3
+ 970000p -0.3
+ 970010p 0.9
+ 972000p 0.9
+ 972010p -0.3
+ 974000p -0.3
+ 974010p 0.9
+ 976000p 0.9
+ 976010p -0.3
+ 978000p -0.3
+ 978010p 0.9
+ 980000p 0.9
+ 980010p -0.3
+ 982000p -0.3
+ 982010p 0.9
+ 984000p 0.9
+ 984010p -0.3
+ 986000p -0.3
+ 986010p 0.9
+ 988000p 0.9
+ 988010p -0.3
+ 990000p -0.3
+ 990010p 0.9
+ 992000p 0.9
+ 992010p -0.3
+ 994000p -0.3
+ 994010p 0.9
+ 996000p 0.9
+ 996010p -0.3
+ 998000p -0.3
+ 998010p 0.9
+ 1000000p 0.9
+ 1000010p -0.3
+ 1002000p -0.3
+ 1002010p 0.9
+ 1004000p 0.9
+ 1004010p -0.3
+ 1006000p -0.3
+ 1006010p 0.9
+ 1008000p 0.9
+ 1008010p -0.3
+ 1010000p -0.3
+ 1010010p 0.9
+ 1012000p 0.9
+ 1012010p -0.3
+ 1014000p -0.3
+ 1014010p 0.9
+ 1016000p 0.9
+ 1016010p -0.3
+ 1018000p -0.3
+ 1018010p 0.9
+ 1020000p 0.9
+ 1020010p -0.3
+ 1022000p -0.3
+ 1022010p 0.9
+ 1024000p 0.9
+ 1024010p -0.3
+ 1026000p -0.3
+ 1026010p 0.9
+ 1028000p 0.9
+ 1028010p -0.3
+ 1030000p -0.3
+ 1030010p 0.9
+ 1032000p 0.9
+ 1032010p -0.3
+ 1034000p -0.3
+ 1034010p 0.9
+ 1036000p 0.9
+ 1036010p -0.3
+ 1038000p -0.3
+ 1038010p 0.9
+ 1040000p 0.9
+ 1040010p -0.3
+ 1042000p -0.3
+ 1042010p 0.9
+ 1044000p 0.9
+ 1044010p -0.3
+ 1046000p -0.3
+ 1046010p 0.9
+ 1048000p 0.9
+ 1048010p -0.3
+ 1050000p -0.3
+ 1050010p 0.9
+ 1052000p 0.9
+ 1052010p -0.3
+ 1054000p -0.3
+ 1054010p 0.9
+ 1056000p 0.9
+ 1056010p -0.3
+ 1058000p -0.3
+ 1058010p 0.9
+ 1060000p 0.9
+ 1060010p -0.3
+ 1062000p -0.3
+ 1062010p 0.9
+ 1064000p 0.9
+ 1064010p -0.3
+ 1066000p -0.3
+ 1066010p 0.9
+ 1068000p 0.9
+ 1068010p -0.3
+ 1070000p -0.3
+ 1070010p 0.9
+ 1072000p 0.9
+ 1072010p -0.3
+ 1074000p -0.3
+ 1074010p 0.9
+ 1076000p 0.9
+ 1076010p -0.3
+ 1078000p -0.3
+ 1078010p 0.9
+ 1080000p 0.9
+ 1080010p -0.3
+ 1082000p -0.3
+ 1082010p 0.9
+ 1084000p 0.9
+ 1084010p -0.3
+ 1086000p -0.3
+ 1086010p 0.9
+ 1088000p 0.9
+ 1088010p -0.3
+ 1090000p -0.3
+ 1090010p 0.9
+ 1092000p 0.9
+ 1092010p -0.3
+ 1094000p -0.3
+ 1094010p 0.9
+ 1096000p 0.9
+ 1096010p -0.3
+ 1098000p -0.3
+ 1098010p 0.9
+ 1100000p 0.9
+ 1100010p -0.3
+ 1102000p -0.3
+ 1102010p 0.9
+ 1104000p 0.9
+ 1104010p -0.3
+ 1106000p -0.3
+ 1106010p 0.9
+ 1108000p 0.9
+ 1108010p -0.3
+ 1110000p -0.3
+ 1110010p 0.9
+ 1112000p 0.9
+ 1112010p -0.3
+ 1114000p -0.3
+ 1114010p 0.9
+ 1116000p 0.9
+ 1116010p -0.3
+ 1118000p -0.3
+ 1118010p 0.9
+ 1120000p 0.9
+ 1120010p -0.3
+ 1122000p -0.3
+ 1122010p 0.9
+ 1124000p 0.9
+ 1124010p -0.3
+ 1126000p -0.3
+ 1126010p 0.9
+ 1128000p 0.9
+ 1128010p -0.3
+ 1130000p -0.3
+ 1130010p 0.9
+ 1132000p 0.9
+ 1132010p -0.3
+ 1134000p -0.3
+ 1134010p 0.9
+ 1136000p 0.9
+ 1136010p -0.3
+ 1138000p -0.3
+ 1138010p 0.9
+ 1140000p 0.9
+ 1140010p -0.3
+ 1142000p -0.3
+ 1142010p 0.9
+ 1144000p 0.9
+ 1144010p -0.3
+ 1146000p -0.3
+ 1146010p 0.9
+ 1148000p 0.9
+ 1148010p -0.3
+ 1150000p -0.3
+ 1150010p 0.9
+ 1152000p 0.9
+ 1152010p -0.3
+ 1154000p -0.3
+ 1154010p 0.9
+ 1156000p 0.9
+ 1156010p -0.3
+ 1158000p -0.3
+ 1158010p 0.9
+ 1160000p 0.9
+ 1160010p -0.3
+ 1162000p -0.3
+ 1162010p 0.9
+ 1164000p 0.9
+ 1164010p -0.3
+ 1166000p -0.3
+ 1166010p 0.9
+ 1168000p 0.9
+ 1168010p -0.3
+ 1170000p -0.3
+ 1170010p 0.9
+ 1172000p 0.9
+ 1172010p -0.3
+ 1174000p -0.3
+ 1174010p 0.9
+ 1176000p 0.9
+ 1176010p -0.3
+ 1178000p -0.3
+ 1178010p 0.9
+ 1180000p 0.9
+ 1180010p -0.3
+ 1182000p -0.3
+ 1182010p 0.9
+ 1184000p 0.9
+ 1184010p -0.3
+ 1186000p -0.3
+ 1186010p 0.9
+ 1188000p 0.9
+ 1188010p -0.3
+ 1190000p -0.3
+ 1190010p 0.9
+ 1192000p 0.9
+ 1192010p -0.3
+ 1194000p -0.3
+ 1194010p 0.9
+ 1196000p 0.9
+ 1196010p -0.3
+ 1198000p -0.3
+ 1198010p 0.9
+ 1200000p 0.9
+ 1200010p -0.3
+ 1202000p -0.3
+ 1202010p 0.9
+ 1204000p 0.9
+ 1204010p -0.3
+ 1206000p -0.3
+ 1206010p 0.9
+ 1208000p 0.9
+ 1208010p -0.3
+ 1210000p -0.3
+ 1210010p 0.9
+ 1212000p 0.9
+ 1212010p -0.3
+ 1214000p -0.3
+ 1214010p 0.9
+ 1216000p 0.9
+ 1216010p -0.3
+ 1218000p -0.3
+ 1218010p 0.9
+ 1220000p 0.9
+ 1220010p -0.3
+ 1222000p -0.3
+ 1222010p 0.9
+ 1224000p 0.9
+ 1224010p -0.3
+ 1226000p -0.3
+ 1226010p 0.9
+ 1228000p 0.9
+ 1228010p -0.3
+ 1230000p -0.3
+ 1230010p 0.9
+ 1232000p 0.9
+ 1232010p -0.3
+ 1234000p -0.3
+ 1234010p 0.9
+ 1236000p 0.9
+ 1236010p -0.3
+ 1238000p -0.3
+ 1238010p 0.9
+ 1240000p 0.9
+ 1240010p -0.3
+ 1242000p -0.3
+ 1242010p 0.9
+ 1244000p 0.9
+ 1244010p -0.3
+ 1246000p -0.3
+ 1246010p 0.9
+ 1248000p 0.9
+ 1248010p -0.3
+ 1250000p -0.3
+ 1250010p 0.9
+ 1252000p 0.9
+ 1252010p -0.3
+ 1254000p -0.3
+ 1254010p 0.9
+ 1256000p 0.9
+ 1256010p -0.3
+ 1258000p -0.3
+ 1258010p 0.9
+ 1260000p 0.9
+ 1260010p -0.3
+ 1262000p -0.3
+ 1262010p 0.9
+ 1264000p 0.9
+ 1264010p -0.3
+ 1266000p -0.3
+ 1266010p 0.9
+ 1268000p 0.9
+ 1268010p -0.3
+ 1270000p -0.3
+ 1270010p 0.9
+ 1272000p 0.9
+ 1272010p -0.3
+ 1274000p -0.3
+ 1274010p 0.9
+ 1276000p 0.9
+ 1276010p -0.3
+ 1278000p -0.3
+ 1278010p 0.9
+ 1280000p 0.9
+ 1280010p -0.3
+ 1282000p -0.3
+ 1282010p 0.9
+ 1284000p 0.9
+ 1284010p -0.3
+ 1286000p -0.3
+ 1286010p 0.9
+ 1288000p 0.9
+ 1288010p -0.3
+ 1290000p -0.3
+ 1290010p 0.9
+ 1292000p 0.9
+ 1292010p -0.3
+ 1294000p -0.3
+ 1294010p 0.9
+ 1296000p 0.9
+ 1296010p -0.3
+ 1298000p -0.3
+ 1298010p 0.9
+ 1300000p 0.9
+ 1300010p -0.3
+ 1302000p -0.3
+ 1302010p 0.9
+ 1304000p 0.9
+ 1304010p -0.3
+ 1306000p -0.3
+ 1306010p 0.9
+ 1308000p 0.9
+ 1308010p -0.3
+ 1310000p -0.3
+ 1310010p 0.9
+ 1312000p 0.9
+ 1312010p -0.3
+ 1314000p -0.3
+ 1314010p 0.9
+ 1316000p 0.9
+ 1316010p -0.3
+ 1318000p -0.3
+ 1318010p 0.9
+ 1320000p 0.9
+ 1320010p -0.3
+ 1322000p -0.3
+ 1322010p 0.9
+ 1324000p 0.9
+ 1324010p -0.3
+ 1326000p -0.3
+ 1326010p 0.9
+ 1328000p 0.9
+ 1328010p -0.3
+ 1330000p -0.3
+ 1330010p 0.9
+ 1332000p 0.9
+ 1332010p -0.3
+ 1334000p -0.3
+ 1334010p 0.9
+ 1336000p 0.9
+ 1336010p -0.3
+ 1338000p -0.3
+ 1338010p 0.9
+ 1340000p 0.9
+ 1340010p -0.3
+ 1342000p -0.3
+ 1342010p 0.9
+ 1344000p 0.9
+ 1344010p -0.3
+ 1346000p -0.3
+ 1346010p 0.9
+ 1348000p 0.9
+ 1348010p -0.3
+ 1350000p -0.3
+ 1350010p 0.9
+ 1352000p 0.9
+ 1352010p -0.3
+ 1354000p -0.3
+ 1354010p 0.9
+ 1356000p 0.9
+ 1356010p -0.3
+ 1358000p -0.3
+ 1358010p 0.9
+ 1360000p 0.9
+ 1360010p -0.3
+ 1362000p -0.3
+ 1362010p 0.9
+ 1364000p 0.9
+ 1364010p -0.3
+ 1366000p -0.3
+ 1366010p 0.9
+ 1368000p 0.9
+ 1368010p -0.3
+ 1370000p -0.3
+ 1370010p 0.9
+ 1372000p 0.9
+ 1372010p -0.3
+ 1374000p -0.3
+ 1374010p 0.9
+ 1376000p 0.9
+ 1376010p -0.3
+ 1378000p -0.3
+ 1378010p 0.9
+ 1380000p 0.9
+ 1380010p -0.3
+ 1382000p -0.3
+ 1382010p 0.9
+ 1384000p 0.9
+ 1384010p -0.3
+ 1386000p -0.3
+ 1386010p 0.9
+ 1388000p 0.9
+ 1388010p -0.3
+ 1390000p -0.3
+ 1390010p 0.9
+ 1392000p 0.9
+ 1392010p -0.3
+ 1394000p -0.3
+ 1394010p 0.9
+ 1396000p 0.9
+ 1396010p -0.3
+ 1398000p -0.3
+ 1398010p 0.9
+ 1400000p 0.9
+ 1400010p -0.3
+ 1402000p -0.3
+ 1402010p 0.9
+ 1404000p 0.9
+ 1404010p -0.3
+ 1406000p -0.3
+ 1406010p 0.9
+ 1408000p 0.9
+ 1408010p -0.3
+ 1410000p -0.3
+ 1410010p 0.9
+ 1412000p 0.9
+ 1412010p -0.3
+ 1414000p -0.3
+ 1414010p 0.9
+ 1416000p 0.9
+ 1416010p -0.3
+ 1418000p -0.3
+ 1418010p 0.9
+ 1420000p 0.9
+ 1420010p -0.3
+ 1422000p -0.3
+ 1422010p 0.9
+ 1424000p 0.9
+ 1424010p -0.3
+ 1426000p -0.3
+ 1426010p 0.9
+ 1428000p 0.9
+ 1428010p -0.3
+ 1430000p -0.3
+ 1430010p 0.9
+ 1432000p 0.9
+ 1432010p -0.3
+ 1434000p -0.3
+ 1434010p 0.9
+ 1436000p 0.9
+ 1436010p -0.3
+ 1438000p -0.3
+ 1438010p 0.9
+ 1440000p 0.9
+ 1440010p -0.3
+ 1442000p -0.3
+ 1442010p 0.9
+ 1444000p 0.9
+ 1444010p -0.3
+ 1446000p -0.3
+ 1446010p 0.9
+ 1448000p 0.9
+ 1448010p -0.3
+ 1450000p -0.3
+ 1450010p 0.9
+ 1452000p 0.9
+ 1452010p -0.3
+ 1454000p -0.3
+ 1454010p 0.9
+ 1456000p 0.9
+ 1456010p -0.3
+ 1458000p -0.3
+ 1458010p 0.9
+ 1460000p 0.9
+ 1460010p -0.3
+ 1462000p -0.3
+ 1462010p 0.9
+ 1464000p 0.9
+ 1464010p -0.3
+ 1466000p -0.3
+ 1466010p 0.9
+ 1468000p 0.9
+ 1468010p -0.3
+ 1470000p -0.3
+ 1470010p 0.9
+ 1472000p 0.9
+ 1472010p -0.3
+ 1474000p -0.3
+ 1474010p 0.9
+ 1476000p 0.9
+ 1476010p -0.3
+ 1478000p -0.3
+ 1478010p 0.9
+ 1480000p 0.9
+ 1480010p -0.3
+ 1482000p -0.3
+ 1482010p 0.9
+ 1484000p 0.9
+ 1484010p -0.3
+ 1486000p -0.3
+ 1486010p 0.9
+ 1488000p 0.9
+ 1488010p -0.3
+ 1490000p -0.3
+ 1490010p 0.9
+ 1492000p 0.9
+ 1492010p -0.3
+ 1494000p -0.3
+ 1494010p 0.9
+ 1496000p 0.9
+ 1496010p -0.3
+ 1498000p -0.3
+ 1498010p 0.9
+ 1500000p 0.9
+ 1500010p -0.3
+ 1502000p -0.3
+ 1502010p 0.9
+ 1504000p 0.9
+ 1504010p -0.3
+ 1506000p -0.3
+ 1506010p 0.9
+ 1508000p 0.9
+ 1508010p -0.3
+ 1510000p -0.3
+ 1510010p 0.9
+ 1512000p 0.9
+ 1512010p -0.3
+ 1514000p -0.3
+ 1514010p 0.9
+ 1516000p 0.9
+ 1516010p -0.3
+ 1518000p -0.3
+ 1518010p 0.9
+ 1520000p 0.9
+ 1520010p -0.3
+ 1522000p -0.3
+ 1522010p 0.9
+ 1524000p 0.9
+ 1524010p -0.3
+ 1526000p -0.3
+ 1526010p 0.9
+ 1528000p 0.9
+ 1528010p -0.3
+ 1530000p -0.3
+ 1530010p 0.9
+ 1532000p 0.9
+ 1532010p -0.3
+ 1534000p -0.3
+ 1534010p 0.9
+ 1536000p 0.9
+ 1536010p -0.3
+ 1538000p -0.3
+ 1538010p 0.9
+ 1540000p 0.9
+ 1540010p -0.3
+ 1542000p -0.3
+ 1542010p 0.9
+ 1544000p 0.9
+ 1544010p -0.3
+ 1546000p -0.3
+ 1546010p 0.9
+ 1548000p 0.9
+ 1548010p -0.3
+ 1550000p -0.3
+ 1550010p 0.9
+ 1552000p 0.9
+ 1552010p -0.3
+ 1554000p -0.3
+ 1554010p 0.9
+ 1556000p 0.9
+ 1556010p -0.3
+ 1558000p -0.3
+ 1558010p 0.9
+ 1560000p 0.9
+ 1560010p -0.3
+ 1562000p -0.3
+ 1562010p 0.9
+ 1564000p 0.9
+ 1564010p -0.3
+ 1566000p -0.3
+ 1566010p 0.9
+ 1568000p 0.9
+ 1568010p -0.3
+ 1570000p -0.3
+ 1570010p 0.9
+ 1572000p 0.9
+ 1572010p -0.3
+ 1574000p -0.3
+ 1574010p 0.9
+ 1576000p 0.9
+ 1576010p -0.3
+ 1578000p -0.3
+ 1578010p 0.9
+ 1580000p 0.9
+ 1580010p -0.3
+ 1582000p -0.3
+ 1582010p 0.9
+ 1584000p 0.9
+ 1584010p -0.3
+ 1586000p -0.3
+ 1586010p 0.9
+ 1588000p 0.9
+ 1588010p -0.3
+ 1590000p -0.3
+ 1590010p 0.9
+ 1592000p 0.9
+ 1592010p -0.3
+ 1594000p -0.3
+ 1594010p 0.9
+ 1596000p 0.9
+ 1596010p -0.3
+ 1598000p -0.3
+ 1598010p 0.9
+ 1600000p 0.9
+ 1600010p -0.3
+ 1602000p -0.3
+ 1602010p 0.9
+ 1604000p 0.9
+ 1604010p -0.3
+ 1606000p -0.3
+ 1606010p 0.9
+ 1608000p 0.9
+ 1608010p -0.3
+ 1610000p -0.3
+ 1610010p 0.9
+ 1612000p 0.9
+ 1612010p -0.3
+ 1614000p -0.3
+ 1614010p 0.9
+ 1616000p 0.9
+ 1616010p -0.3
+ 1618000p -0.3
+ 1618010p 0.9
+ 1620000p 0.9
+ 1620010p -0.3
+ 1622000p -0.3
+ 1622010p 0.9
+ 1624000p 0.9
+ 1624010p -0.3
+ 1626000p -0.3
+ 1626010p 0.9
+ 1628000p 0.9
+ 1628010p -0.3
+ 1630000p -0.3
+ 1630010p 0.9
+ 1632000p 0.9
+ 1632010p -0.3
+ 1634000p -0.3
+ 1634010p 0.9
+ 1636000p 0.9
+ 1636010p -0.3
+ 1638000p -0.3
+ 1638010p 0.9
+ 1640000p 0.9
+ 1640010p -0.3
+ 1642000p -0.3
+ 1642010p 0.9
+ 1644000p 0.9
+ 1644010p -0.3
+ 1646000p -0.3
+ 1646010p 0.9
+ 1648000p 0.9
+ 1648010p -0.3
+ 1650000p -0.3
+ 1650010p 0.9
+ 1652000p 0.9
+ 1652010p -0.3
+ 1654000p -0.3
+ 1654010p 0.9
+ 1656000p 0.9
+ 1656010p -0.3
+ 1658000p -0.3
+ 1658010p 0.9
+ 1660000p 0.9
+ 1660010p -0.3
+ 1662000p -0.3
+ 1662010p 0.9
+ 1664000p 0.9
+ 1664010p -0.3
+ 1666000p -0.3
+ 1666010p 0.9
+ 1668000p 0.9
+ 1668010p -0.3
+ 1670000p -0.3
+ 1670010p 0.9
+ 1672000p 0.9
+ 1672010p -0.3
+ 1674000p -0.3
+ 1674010p 0.9
+ 1676000p 0.9
+ 1676010p -0.3
+ 1678000p -0.3
+ 1678010p 0.9
+ 1680000p 0.9
+ 1680010p -0.3
+ 1682000p -0.3
+ 1682010p 0.9
+ 1684000p 0.9
+ 1684010p -0.3
+ 1686000p -0.3
+ 1686010p 0.9
+ 1688000p 0.9
+ 1688010p -0.3
+ 1690000p -0.3
+ 1690010p 0.9
+ 1692000p 0.9
+ 1692010p -0.3
+ 1694000p -0.3
+ 1694010p 0.9
+ 1696000p 0.9
+ 1696010p -0.3
+ 1698000p -0.3
+ 1698010p 0.9
+ 1700000p 0.9
+ 1700010p -0.3
+ 1702000p -0.3
+ 1702010p 0.9
+ 1704000p 0.9
+ 1704010p -0.3
+ 1706000p -0.3
+ 1706010p 0.9
+ 1708000p 0.9
+ 1708010p -0.3
+ 1710000p -0.3
+ 1710010p 0.9
+ 1712000p 0.9
+ 1712010p -0.3
+ 1714000p -0.3
+ 1714010p 0.9
+ 1716000p 0.9
+ 1716010p -0.3
+ 1718000p -0.3
+ 1718010p 0.9
+ 1720000p 0.9
+ 1720010p -0.3
+ 1722000p -0.3
+ 1722010p 0.9
+ 1724000p 0.9
+ 1724010p -0.3
+ 1726000p -0.3
+ 1726010p 0.9
+ 1728000p 0.9
+ 1728010p -0.3
+ 1730000p -0.3
+ 1730010p 0.9
+ 1732000p 0.9
+ 1732010p -0.3
+ 1734000p -0.3
+ 1734010p 0.9
+ 1736000p 0.9
+ 1736010p -0.3
+ 1738000p -0.3
+ 1738010p 0.9
+ 1740000p 0.9
+ 1740010p -0.3
+ 1742000p -0.3
+ 1742010p 0.9
+ 1744000p 0.9
+ 1744010p -0.3
+ 1746000p -0.3
+ 1746010p 0.9
+ 1748000p 0.9
+ 1748010p -0.3
+ 1750000p -0.3
+ 1750010p 0.9
+ 1752000p 0.9
+ 1752010p -0.3
+ 1754000p -0.3
+ 1754010p 0.9
+ 1756000p 0.9
+ 1756010p -0.3
+ 1758000p -0.3
+ 1758010p 0.9
+ 1760000p 0.9
+ 1760010p -0.3
+ 1762000p -0.3
+ 1762010p 0.9
+ 1764000p 0.9
+ 1764010p -0.3
+ 1766000p -0.3
+ 1766010p 0.9
+ 1768000p 0.9
+ 1768010p -0.3
+ 1770000p -0.3
+ 1770010p 0.9
+ 1772000p 0.9
+ 1772010p -0.3
+ 1774000p -0.3
+ 1774010p 0.9
+ 1776000p 0.9
+ 1776010p -0.3
+ 1778000p -0.3
+ 1778010p 0.9
+ 1780000p 0.9
+ 1780010p -0.3
+ 1782000p -0.3
+ 1782010p 0.9
+ 1784000p 0.9
+ 1784010p -0.3
+ 1786000p -0.3
+ 1786010p 0.9
+ 1788000p 0.9
+ 1788010p -0.3
+ 1790000p -0.3
+ 1790010p 0.9
+ 1792000p 0.9
+ 1792010p -0.3
+ 1794000p -0.3
+ 1794010p 0.9
+ 1796000p 0.9
+ 1796010p -0.3
+ 1798000p -0.3
+ 1798010p 0.9
+ 1800000p 0.9
+ 1800010p -0.3
+ 1802000p -0.3
+ 1802010p 0.9
+ 1804000p 0.9
+ 1804010p -0.3
+ 1806000p -0.3
+ 1806010p 0.9
+ 1808000p 0.9
+ 1808010p -0.3
+ 1810000p -0.3
+ 1810010p 0.9
+ 1812000p 0.9
+ 1812010p -0.3
+ 1814000p -0.3
+ 1814010p 0.9
+ 1816000p 0.9
+ 1816010p -0.3
+ 1818000p -0.3
+ 1818010p 0.9
+ 1820000p 0.9
+ 1820010p -0.3
+ 1822000p -0.3
+ 1822010p 0.9
+ 1824000p 0.9
+ 1824010p -0.3
+ 1826000p -0.3
+ 1826010p 0.9
+ 1828000p 0.9
+ 1828010p -0.3
+ 1830000p -0.3
+ 1830010p 0.9
+ 1832000p 0.9
+ 1832010p -0.3
+ 1834000p -0.3
+ 1834010p 0.9
+ 1836000p 0.9
+ 1836010p -0.3
+ 1838000p -0.3
+ 1838010p 0.9
+ 1840000p 0.9
+ 1840010p -0.3
+ 1842000p -0.3
+ 1842010p 0.9
+ 1844000p 0.9
+ 1844010p -0.3
+ 1846000p -0.3
+ 1846010p 0.9
+ 1848000p 0.9
+ 1848010p -0.3
+ 1850000p -0.3
+ 1850010p 0.9
+ 1852000p 0.9
+ 1852010p -0.3
+ 1854000p -0.3
+ 1854010p 0.9
+ 1856000p 0.9
+ 1856010p -0.3
+ 1858000p -0.3
+ 1858010p 0.9
+ 1860000p 0.9
+ 1860010p -0.3
+ 1862000p -0.3
+ 1862010p 0.9
+ 1864000p 0.9
+ 1864010p -0.3
+ 1866000p -0.3
+ 1866010p 0.9
+ 1868000p 0.9
+ 1868010p -0.3
+ 1870000p -0.3
+ 1870010p 0.9
+ 1872000p 0.9
+ 1872010p -0.3
+ 1874000p -0.3
+ 1874010p 0.9
+ 1876000p 0.9
+ 1876010p -0.3
+ 1878000p -0.3
+ 1878010p 0.9
+ 1880000p 0.9
+ 1880010p -0.3
+ 1882000p -0.3
+ 1882010p 0.9
+ 1884000p 0.9
+ 1884010p -0.3
+ 1886000p -0.3
+ 1886010p 0.9
+ 1888000p 0.9
+ 1888010p -0.3
+ 1890000p -0.3
+ 1890010p 0.9
+ 1892000p 0.9
+ 1892010p -0.3
+ 1894000p -0.3
+ 1894010p 0.9
+ 1896000p 0.9
+ 1896010p -0.3
+ 1898000p -0.3
+ 1898010p 0.9
+ 1900000p 0.9
+ 1900010p -0.3
+ 1902000p -0.3
+ 1902010p 0.9
+ 1904000p 0.9
+ 1904010p -0.3
+ 1906000p -0.3
+ 1906010p 0.9
+ 1908000p 0.9
+ 1908010p -0.3
+ 1910000p -0.3
+ 1910010p 0.9
+ 1912000p 0.9
+ 1912010p -0.3
+ 1914000p -0.3
+ 1914010p 0.9
+ 1916000p 0.9
+ 1916010p -0.3
+ 1918000p -0.3
+ 1918010p 0.9
+ 1920000p 0.9
+ 1920010p -0.3
+ 1922000p -0.3
+ 1922010p 0.9
+ 1924000p 0.9
+ 1924010p -0.3
+ 1926000p -0.3
+ 1926010p 0.9
+ 1928000p 0.9
+ 1928010p -0.3
+ 1930000p -0.3
+ 1930010p 0.9
+ 1932000p 0.9
+ 1932010p -0.3
+ 1934000p -0.3
+ 1934010p 0.9
+ 1936000p 0.9
+ 1936010p -0.3
+ 1938000p -0.3
+ 1938010p 0.9
+ 1940000p 0.9
+ 1940010p -0.3
+ 1942000p -0.3
+ 1942010p 0.9
+ 1944000p 0.9
+ 1944010p -0.3
+ 1946000p -0.3
+ 1946010p 0.9
+ 1948000p 0.9
+ 1948010p -0.3
+ 1950000p -0.3
+ 1950010p 0.9
+ 1952000p 0.9
+ 1952010p -0.3
+ 1954000p -0.3
+ 1954010p 0.9
+ 1956000p 0.9
+ 1956010p -0.3
+ 1958000p -0.3
+ 1958010p 0.9
+ 1960000p 0.9
+ 1960010p -0.3
+ 1962000p -0.3
+ 1962010p 0.9
+ 1964000p 0.9
+ 1964010p -0.3
+ 1966000p -0.3
+ 1966010p 0.9
+ 1968000p 0.9
+ 1968010p -0.3
+ 1970000p -0.3
+ 1970010p 0.9
+ 1972000p 0.9
+ 1972010p -0.3
+ 1974000p -0.3
+ 1974010p 0.9
+ 1976000p 0.9
+ 1976010p -0.3
+ 1978000p -0.3
+ 1978010p 0.9
+ 1980000p 0.9
+ 1980010p -0.3
+ 1982000p -0.3
+ 1982010p 0.9
+ 1984000p 0.9
+ 1984010p -0.3
+ 1986000p -0.3
+ 1986010p 0.9
+ 1988000p 0.9
+ 1988010p -0.3
+ 1990000p -0.3
+ 1990010p 0.9
+ 1992000p 0.9
+ 1992010p -0.3
+ 1994000p -0.3
+ 1994010p 0.9
+ 1996000p 0.9
+ 1996010p -0.3
+ 1998000p -0.3
+ 1998010p 0.9
+ 2000000p 0.9
+ 2000010p -0.3
+ 2002000p -0.3
+ 2002010p 0.9
+ 2004000p 0.9
+ 2004010p -0.3
+ 2006000p -0.3
+ 2006010p 0.9
+ 2008000p 0.9
+ 2008010p -0.3
+ 2010000p -0.3
+ 2010010p 0.9
+ 2012000p 0.9
+ 2012010p -0.3
+ 2014000p -0.3
+ 2014010p 0.9
+ 2016000p 0.9
+ 2016010p -0.3
+ 2018000p -0.3
+ 2018010p 0.9
+ 2020000p 0.9
+ 2020010p -0.3
+ 2022000p -0.3
+ 2022010p 0.9
+ 2024000p 0.9
+ 2024010p -0.3
+ 2026000p -0.3
+ 2026010p 0.9
+ 2028000p 0.9
+ 2028010p -0.3
+ 2030000p -0.3
+ 2030010p 0.9
+ 2032000p 0.9
+ 2032010p -0.3
+ 2034000p -0.3
+ 2034010p 0.9
+ 2036000p 0.9
+ 2036010p -0.3
+ 2038000p -0.3
+ 2038010p 0.9
+ 2040000p 0.9
+ 2040010p -0.3
+ 2042000p -0.3
+ 2042010p 0.9
+ 2044000p 0.9
+ 2044010p -0.3
+ 2046000p -0.3
+ 2046010p 0.9
+ 2048000p 0.9
+ 2048010p -0.3
+ \]
V_data_14 (Data\\<14\\> gnd!) vsource type=pwl wave=\[
+ 0    0.9
+ 2000p 0.9
+ 2010p -0.3
+ 4000p -0.3
+ 4010p 0.9
+ 6000p 0.9
+ 6010p -0.3
+ 8000p -0.3
+ 8010p 0.9
+ 10000p 0.9
+ 10010p -0.3
+ 12000p -0.3
+ 12010p 0.9
+ 14000p 0.9
+ 14010p -0.3
+ 16000p -0.3
+ 16010p 0.9
+ 18000p 0.9
+ 18010p -0.3
+ 20000p -0.3
+ 20010p 0.9
+ 22000p 0.9
+ 22010p -0.3
+ 24000p -0.3
+ 24010p 0.9
+ 26000p 0.9
+ 26010p -0.3
+ 28000p -0.3
+ 28010p 0.9
+ 30000p 0.9
+ 30010p -0.3
+ 32000p -0.3
+ 32010p 0.9
+ 34000p 0.9
+ 34010p -0.3
+ 36000p -0.3
+ 36010p 0.9
+ 38000p 0.9
+ 38010p -0.3
+ 40000p -0.3
+ 40010p 0.9
+ 42000p 0.9
+ 42010p -0.3
+ 44000p -0.3
+ 44010p 0.9
+ 46000p 0.9
+ 46010p -0.3
+ 48000p -0.3
+ 48010p 0.9
+ 50000p 0.9
+ 50010p -0.3
+ 52000p -0.3
+ 52010p 0.9
+ 54000p 0.9
+ 54010p -0.3
+ 56000p -0.3
+ 56010p 0.9
+ 58000p 0.9
+ 58010p -0.3
+ 60000p -0.3
+ 60010p 0.9
+ 62000p 0.9
+ 62010p -0.3
+ 64000p -0.3
+ 64010p 0.9
+ 66000p 0.9
+ 66010p -0.3
+ 68000p -0.3
+ 68010p 0.9
+ 70000p 0.9
+ 70010p -0.3
+ 72000p -0.3
+ 72010p 0.9
+ 74000p 0.9
+ 74010p -0.3
+ 76000p -0.3
+ 76010p 0.9
+ 78000p 0.9
+ 78010p -0.3
+ 80000p -0.3
+ 80010p 0.9
+ 82000p 0.9
+ 82010p -0.3
+ 84000p -0.3
+ 84010p 0.9
+ 86000p 0.9
+ 86010p -0.3
+ 88000p -0.3
+ 88010p 0.9
+ 90000p 0.9
+ 90010p -0.3
+ 92000p -0.3
+ 92010p 0.9
+ 94000p 0.9
+ 94010p -0.3
+ 96000p -0.3
+ 96010p 0.9
+ 98000p 0.9
+ 98010p -0.3
+ 100000p -0.3
+ 100010p 0.9
+ 102000p 0.9
+ 102010p -0.3
+ 104000p -0.3
+ 104010p 0.9
+ 106000p 0.9
+ 106010p -0.3
+ 108000p -0.3
+ 108010p 0.9
+ 110000p 0.9
+ 110010p -0.3
+ 112000p -0.3
+ 112010p 0.9
+ 114000p 0.9
+ 114010p -0.3
+ 116000p -0.3
+ 116010p 0.9
+ 118000p 0.9
+ 118010p -0.3
+ 120000p -0.3
+ 120010p 0.9
+ 122000p 0.9
+ 122010p -0.3
+ 124000p -0.3
+ 124010p 0.9
+ 126000p 0.9
+ 126010p -0.3
+ 128000p -0.3
+ 128010p 0.9
+ 130000p 0.9
+ 130010p -0.3
+ 132000p -0.3
+ 132010p 0.9
+ 134000p 0.9
+ 134010p -0.3
+ 136000p -0.3
+ 136010p 0.9
+ 138000p 0.9
+ 138010p -0.3
+ 140000p -0.3
+ 140010p 0.9
+ 142000p 0.9
+ 142010p -0.3
+ 144000p -0.3
+ 144010p 0.9
+ 146000p 0.9
+ 146010p -0.3
+ 148000p -0.3
+ 148010p 0.9
+ 150000p 0.9
+ 150010p -0.3
+ 152000p -0.3
+ 152010p 0.9
+ 154000p 0.9
+ 154010p -0.3
+ 156000p -0.3
+ 156010p 0.9
+ 158000p 0.9
+ 158010p -0.3
+ 160000p -0.3
+ 160010p 0.9
+ 162000p 0.9
+ 162010p -0.3
+ 164000p -0.3
+ 164010p 0.9
+ 166000p 0.9
+ 166010p -0.3
+ 168000p -0.3
+ 168010p 0.9
+ 170000p 0.9
+ 170010p -0.3
+ 172000p -0.3
+ 172010p 0.9
+ 174000p 0.9
+ 174010p -0.3
+ 176000p -0.3
+ 176010p 0.9
+ 178000p 0.9
+ 178010p -0.3
+ 180000p -0.3
+ 180010p 0.9
+ 182000p 0.9
+ 182010p -0.3
+ 184000p -0.3
+ 184010p 0.9
+ 186000p 0.9
+ 186010p -0.3
+ 188000p -0.3
+ 188010p 0.9
+ 190000p 0.9
+ 190010p -0.3
+ 192000p -0.3
+ 192010p 0.9
+ 194000p 0.9
+ 194010p -0.3
+ 196000p -0.3
+ 196010p 0.9
+ 198000p 0.9
+ 198010p -0.3
+ 200000p -0.3
+ 200010p 0.9
+ 202000p 0.9
+ 202010p -0.3
+ 204000p -0.3
+ 204010p 0.9
+ 206000p 0.9
+ 206010p -0.3
+ 208000p -0.3
+ 208010p 0.9
+ 210000p 0.9
+ 210010p -0.3
+ 212000p -0.3
+ 212010p 0.9
+ 214000p 0.9
+ 214010p -0.3
+ 216000p -0.3
+ 216010p 0.9
+ 218000p 0.9
+ 218010p -0.3
+ 220000p -0.3
+ 220010p 0.9
+ 222000p 0.9
+ 222010p -0.3
+ 224000p -0.3
+ 224010p 0.9
+ 226000p 0.9
+ 226010p -0.3
+ 228000p -0.3
+ 228010p 0.9
+ 230000p 0.9
+ 230010p -0.3
+ 232000p -0.3
+ 232010p 0.9
+ 234000p 0.9
+ 234010p -0.3
+ 236000p -0.3
+ 236010p 0.9
+ 238000p 0.9
+ 238010p -0.3
+ 240000p -0.3
+ 240010p 0.9
+ 242000p 0.9
+ 242010p -0.3
+ 244000p -0.3
+ 244010p 0.9
+ 246000p 0.9
+ 246010p -0.3
+ 248000p -0.3
+ 248010p 0.9
+ 250000p 0.9
+ 250010p -0.3
+ 252000p -0.3
+ 252010p 0.9
+ 254000p 0.9
+ 254010p -0.3
+ 256000p -0.3
+ 256010p 0.9
+ 258000p 0.9
+ 258010p -0.3
+ 260000p -0.3
+ 260010p 0.9
+ 262000p 0.9
+ 262010p -0.3
+ 264000p -0.3
+ 264010p 0.9
+ 266000p 0.9
+ 266010p -0.3
+ 268000p -0.3
+ 268010p 0.9
+ 270000p 0.9
+ 270010p -0.3
+ 272000p -0.3
+ 272010p 0.9
+ 274000p 0.9
+ 274010p -0.3
+ 276000p -0.3
+ 276010p 0.9
+ 278000p 0.9
+ 278010p -0.3
+ 280000p -0.3
+ 280010p 0.9
+ 282000p 0.9
+ 282010p -0.3
+ 284000p -0.3
+ 284010p 0.9
+ 286000p 0.9
+ 286010p -0.3
+ 288000p -0.3
+ 288010p 0.9
+ 290000p 0.9
+ 290010p -0.3
+ 292000p -0.3
+ 292010p 0.9
+ 294000p 0.9
+ 294010p -0.3
+ 296000p -0.3
+ 296010p 0.9
+ 298000p 0.9
+ 298010p -0.3
+ 300000p -0.3
+ 300010p 0.9
+ 302000p 0.9
+ 302010p -0.3
+ 304000p -0.3
+ 304010p 0.9
+ 306000p 0.9
+ 306010p -0.3
+ 308000p -0.3
+ 308010p 0.9
+ 310000p 0.9
+ 310010p -0.3
+ 312000p -0.3
+ 312010p 0.9
+ 314000p 0.9
+ 314010p -0.3
+ 316000p -0.3
+ 316010p 0.9
+ 318000p 0.9
+ 318010p -0.3
+ 320000p -0.3
+ 320010p 0.9
+ 322000p 0.9
+ 322010p -0.3
+ 324000p -0.3
+ 324010p 0.9
+ 326000p 0.9
+ 326010p -0.3
+ 328000p -0.3
+ 328010p 0.9
+ 330000p 0.9
+ 330010p -0.3
+ 332000p -0.3
+ 332010p 0.9
+ 334000p 0.9
+ 334010p -0.3
+ 336000p -0.3
+ 336010p 0.9
+ 338000p 0.9
+ 338010p -0.3
+ 340000p -0.3
+ 340010p 0.9
+ 342000p 0.9
+ 342010p -0.3
+ 344000p -0.3
+ 344010p 0.9
+ 346000p 0.9
+ 346010p -0.3
+ 348000p -0.3
+ 348010p 0.9
+ 350000p 0.9
+ 350010p -0.3
+ 352000p -0.3
+ 352010p 0.9
+ 354000p 0.9
+ 354010p -0.3
+ 356000p -0.3
+ 356010p 0.9
+ 358000p 0.9
+ 358010p -0.3
+ 360000p -0.3
+ 360010p 0.9
+ 362000p 0.9
+ 362010p -0.3
+ 364000p -0.3
+ 364010p 0.9
+ 366000p 0.9
+ 366010p -0.3
+ 368000p -0.3
+ 368010p 0.9
+ 370000p 0.9
+ 370010p -0.3
+ 372000p -0.3
+ 372010p 0.9
+ 374000p 0.9
+ 374010p -0.3
+ 376000p -0.3
+ 376010p 0.9
+ 378000p 0.9
+ 378010p -0.3
+ 380000p -0.3
+ 380010p 0.9
+ 382000p 0.9
+ 382010p -0.3
+ 384000p -0.3
+ 384010p 0.9
+ 386000p 0.9
+ 386010p -0.3
+ 388000p -0.3
+ 388010p 0.9
+ 390000p 0.9
+ 390010p -0.3
+ 392000p -0.3
+ 392010p 0.9
+ 394000p 0.9
+ 394010p -0.3
+ 396000p -0.3
+ 396010p 0.9
+ 398000p 0.9
+ 398010p -0.3
+ 400000p -0.3
+ 400010p 0.9
+ 402000p 0.9
+ 402010p -0.3
+ 404000p -0.3
+ 404010p 0.9
+ 406000p 0.9
+ 406010p -0.3
+ 408000p -0.3
+ 408010p 0.9
+ 410000p 0.9
+ 410010p -0.3
+ 412000p -0.3
+ 412010p 0.9
+ 414000p 0.9
+ 414010p -0.3
+ 416000p -0.3
+ 416010p 0.9
+ 418000p 0.9
+ 418010p -0.3
+ 420000p -0.3
+ 420010p 0.9
+ 422000p 0.9
+ 422010p -0.3
+ 424000p -0.3
+ 424010p 0.9
+ 426000p 0.9
+ 426010p -0.3
+ 428000p -0.3
+ 428010p 0.9
+ 430000p 0.9
+ 430010p -0.3
+ 432000p -0.3
+ 432010p 0.9
+ 434000p 0.9
+ 434010p -0.3
+ 436000p -0.3
+ 436010p 0.9
+ 438000p 0.9
+ 438010p -0.3
+ 440000p -0.3
+ 440010p 0.9
+ 442000p 0.9
+ 442010p -0.3
+ 444000p -0.3
+ 444010p 0.9
+ 446000p 0.9
+ 446010p -0.3
+ 448000p -0.3
+ 448010p 0.9
+ 450000p 0.9
+ 450010p -0.3
+ 452000p -0.3
+ 452010p 0.9
+ 454000p 0.9
+ 454010p -0.3
+ 456000p -0.3
+ 456010p 0.9
+ 458000p 0.9
+ 458010p -0.3
+ 460000p -0.3
+ 460010p 0.9
+ 462000p 0.9
+ 462010p -0.3
+ 464000p -0.3
+ 464010p 0.9
+ 466000p 0.9
+ 466010p -0.3
+ 468000p -0.3
+ 468010p 0.9
+ 470000p 0.9
+ 470010p -0.3
+ 472000p -0.3
+ 472010p 0.9
+ 474000p 0.9
+ 474010p -0.3
+ 476000p -0.3
+ 476010p 0.9
+ 478000p 0.9
+ 478010p -0.3
+ 480000p -0.3
+ 480010p 0.9
+ 482000p 0.9
+ 482010p -0.3
+ 484000p -0.3
+ 484010p 0.9
+ 486000p 0.9
+ 486010p -0.3
+ 488000p -0.3
+ 488010p 0.9
+ 490000p 0.9
+ 490010p -0.3
+ 492000p -0.3
+ 492010p 0.9
+ 494000p 0.9
+ 494010p -0.3
+ 496000p -0.3
+ 496010p 0.9
+ 498000p 0.9
+ 498010p -0.3
+ 500000p -0.3
+ 500010p 0.9
+ 502000p 0.9
+ 502010p -0.3
+ 504000p -0.3
+ 504010p 0.9
+ 506000p 0.9
+ 506010p -0.3
+ 508000p -0.3
+ 508010p 0.9
+ 510000p 0.9
+ 510010p -0.3
+ 512000p -0.3
+ 512010p 0.9
+ 514000p 0.9
+ 514010p -0.3
+ 516000p -0.3
+ 516010p 0.9
+ 518000p 0.9
+ 518010p -0.3
+ 520000p -0.3
+ 520010p 0.9
+ 522000p 0.9
+ 522010p -0.3
+ 524000p -0.3
+ 524010p 0.9
+ 526000p 0.9
+ 526010p -0.3
+ 528000p -0.3
+ 528010p 0.9
+ 530000p 0.9
+ 530010p -0.3
+ 532000p -0.3
+ 532010p 0.9
+ 534000p 0.9
+ 534010p -0.3
+ 536000p -0.3
+ 536010p 0.9
+ 538000p 0.9
+ 538010p -0.3
+ 540000p -0.3
+ 540010p 0.9
+ 542000p 0.9
+ 542010p -0.3
+ 544000p -0.3
+ 544010p 0.9
+ 546000p 0.9
+ 546010p -0.3
+ 548000p -0.3
+ 548010p 0.9
+ 550000p 0.9
+ 550010p -0.3
+ 552000p -0.3
+ 552010p 0.9
+ 554000p 0.9
+ 554010p -0.3
+ 556000p -0.3
+ 556010p 0.9
+ 558000p 0.9
+ 558010p -0.3
+ 560000p -0.3
+ 560010p 0.9
+ 562000p 0.9
+ 562010p -0.3
+ 564000p -0.3
+ 564010p 0.9
+ 566000p 0.9
+ 566010p -0.3
+ 568000p -0.3
+ 568010p 0.9
+ 570000p 0.9
+ 570010p -0.3
+ 572000p -0.3
+ 572010p 0.9
+ 574000p 0.9
+ 574010p -0.3
+ 576000p -0.3
+ 576010p 0.9
+ 578000p 0.9
+ 578010p -0.3
+ 580000p -0.3
+ 580010p 0.9
+ 582000p 0.9
+ 582010p -0.3
+ 584000p -0.3
+ 584010p 0.9
+ 586000p 0.9
+ 586010p -0.3
+ 588000p -0.3
+ 588010p 0.9
+ 590000p 0.9
+ 590010p -0.3
+ 592000p -0.3
+ 592010p 0.9
+ 594000p 0.9
+ 594010p -0.3
+ 596000p -0.3
+ 596010p 0.9
+ 598000p 0.9
+ 598010p -0.3
+ 600000p -0.3
+ 600010p 0.9
+ 602000p 0.9
+ 602010p -0.3
+ 604000p -0.3
+ 604010p 0.9
+ 606000p 0.9
+ 606010p -0.3
+ 608000p -0.3
+ 608010p 0.9
+ 610000p 0.9
+ 610010p -0.3
+ 612000p -0.3
+ 612010p 0.9
+ 614000p 0.9
+ 614010p -0.3
+ 616000p -0.3
+ 616010p 0.9
+ 618000p 0.9
+ 618010p -0.3
+ 620000p -0.3
+ 620010p 0.9
+ 622000p 0.9
+ 622010p -0.3
+ 624000p -0.3
+ 624010p 0.9
+ 626000p 0.9
+ 626010p -0.3
+ 628000p -0.3
+ 628010p 0.9
+ 630000p 0.9
+ 630010p -0.3
+ 632000p -0.3
+ 632010p 0.9
+ 634000p 0.9
+ 634010p -0.3
+ 636000p -0.3
+ 636010p 0.9
+ 638000p 0.9
+ 638010p -0.3
+ 640000p -0.3
+ 640010p 0.9
+ 642000p 0.9
+ 642010p -0.3
+ 644000p -0.3
+ 644010p 0.9
+ 646000p 0.9
+ 646010p -0.3
+ 648000p -0.3
+ 648010p 0.9
+ 650000p 0.9
+ 650010p -0.3
+ 652000p -0.3
+ 652010p 0.9
+ 654000p 0.9
+ 654010p -0.3
+ 656000p -0.3
+ 656010p 0.9
+ 658000p 0.9
+ 658010p -0.3
+ 660000p -0.3
+ 660010p 0.9
+ 662000p 0.9
+ 662010p -0.3
+ 664000p -0.3
+ 664010p 0.9
+ 666000p 0.9
+ 666010p -0.3
+ 668000p -0.3
+ 668010p 0.9
+ 670000p 0.9
+ 670010p -0.3
+ 672000p -0.3
+ 672010p 0.9
+ 674000p 0.9
+ 674010p -0.3
+ 676000p -0.3
+ 676010p 0.9
+ 678000p 0.9
+ 678010p -0.3
+ 680000p -0.3
+ 680010p 0.9
+ 682000p 0.9
+ 682010p -0.3
+ 684000p -0.3
+ 684010p 0.9
+ 686000p 0.9
+ 686010p -0.3
+ 688000p -0.3
+ 688010p 0.9
+ 690000p 0.9
+ 690010p -0.3
+ 692000p -0.3
+ 692010p 0.9
+ 694000p 0.9
+ 694010p -0.3
+ 696000p -0.3
+ 696010p 0.9
+ 698000p 0.9
+ 698010p -0.3
+ 700000p -0.3
+ 700010p 0.9
+ 702000p 0.9
+ 702010p -0.3
+ 704000p -0.3
+ 704010p 0.9
+ 706000p 0.9
+ 706010p -0.3
+ 708000p -0.3
+ 708010p 0.9
+ 710000p 0.9
+ 710010p -0.3
+ 712000p -0.3
+ 712010p 0.9
+ 714000p 0.9
+ 714010p -0.3
+ 716000p -0.3
+ 716010p 0.9
+ 718000p 0.9
+ 718010p -0.3
+ 720000p -0.3
+ 720010p 0.9
+ 722000p 0.9
+ 722010p -0.3
+ 724000p -0.3
+ 724010p 0.9
+ 726000p 0.9
+ 726010p -0.3
+ 728000p -0.3
+ 728010p 0.9
+ 730000p 0.9
+ 730010p -0.3
+ 732000p -0.3
+ 732010p 0.9
+ 734000p 0.9
+ 734010p -0.3
+ 736000p -0.3
+ 736010p 0.9
+ 738000p 0.9
+ 738010p -0.3
+ 740000p -0.3
+ 740010p 0.9
+ 742000p 0.9
+ 742010p -0.3
+ 744000p -0.3
+ 744010p 0.9
+ 746000p 0.9
+ 746010p -0.3
+ 748000p -0.3
+ 748010p 0.9
+ 750000p 0.9
+ 750010p -0.3
+ 752000p -0.3
+ 752010p 0.9
+ 754000p 0.9
+ 754010p -0.3
+ 756000p -0.3
+ 756010p 0.9
+ 758000p 0.9
+ 758010p -0.3
+ 760000p -0.3
+ 760010p 0.9
+ 762000p 0.9
+ 762010p -0.3
+ 764000p -0.3
+ 764010p 0.9
+ 766000p 0.9
+ 766010p -0.3
+ 768000p -0.3
+ 768010p 0.9
+ 770000p 0.9
+ 770010p -0.3
+ 772000p -0.3
+ 772010p 0.9
+ 774000p 0.9
+ 774010p -0.3
+ 776000p -0.3
+ 776010p 0.9
+ 778000p 0.9
+ 778010p -0.3
+ 780000p -0.3
+ 780010p 0.9
+ 782000p 0.9
+ 782010p -0.3
+ 784000p -0.3
+ 784010p 0.9
+ 786000p 0.9
+ 786010p -0.3
+ 788000p -0.3
+ 788010p 0.9
+ 790000p 0.9
+ 790010p -0.3
+ 792000p -0.3
+ 792010p 0.9
+ 794000p 0.9
+ 794010p -0.3
+ 796000p -0.3
+ 796010p 0.9
+ 798000p 0.9
+ 798010p -0.3
+ 800000p -0.3
+ 800010p 0.9
+ 802000p 0.9
+ 802010p -0.3
+ 804000p -0.3
+ 804010p 0.9
+ 806000p 0.9
+ 806010p -0.3
+ 808000p -0.3
+ 808010p 0.9
+ 810000p 0.9
+ 810010p -0.3
+ 812000p -0.3
+ 812010p 0.9
+ 814000p 0.9
+ 814010p -0.3
+ 816000p -0.3
+ 816010p 0.9
+ 818000p 0.9
+ 818010p -0.3
+ 820000p -0.3
+ 820010p 0.9
+ 822000p 0.9
+ 822010p -0.3
+ 824000p -0.3
+ 824010p 0.9
+ 826000p 0.9
+ 826010p -0.3
+ 828000p -0.3
+ 828010p 0.9
+ 830000p 0.9
+ 830010p -0.3
+ 832000p -0.3
+ 832010p 0.9
+ 834000p 0.9
+ 834010p -0.3
+ 836000p -0.3
+ 836010p 0.9
+ 838000p 0.9
+ 838010p -0.3
+ 840000p -0.3
+ 840010p 0.9
+ 842000p 0.9
+ 842010p -0.3
+ 844000p -0.3
+ 844010p 0.9
+ 846000p 0.9
+ 846010p -0.3
+ 848000p -0.3
+ 848010p 0.9
+ 850000p 0.9
+ 850010p -0.3
+ 852000p -0.3
+ 852010p 0.9
+ 854000p 0.9
+ 854010p -0.3
+ 856000p -0.3
+ 856010p 0.9
+ 858000p 0.9
+ 858010p -0.3
+ 860000p -0.3
+ 860010p 0.9
+ 862000p 0.9
+ 862010p -0.3
+ 864000p -0.3
+ 864010p 0.9
+ 866000p 0.9
+ 866010p -0.3
+ 868000p -0.3
+ 868010p 0.9
+ 870000p 0.9
+ 870010p -0.3
+ 872000p -0.3
+ 872010p 0.9
+ 874000p 0.9
+ 874010p -0.3
+ 876000p -0.3
+ 876010p 0.9
+ 878000p 0.9
+ 878010p -0.3
+ 880000p -0.3
+ 880010p 0.9
+ 882000p 0.9
+ 882010p -0.3
+ 884000p -0.3
+ 884010p 0.9
+ 886000p 0.9
+ 886010p -0.3
+ 888000p -0.3
+ 888010p 0.9
+ 890000p 0.9
+ 890010p -0.3
+ 892000p -0.3
+ 892010p 0.9
+ 894000p 0.9
+ 894010p -0.3
+ 896000p -0.3
+ 896010p 0.9
+ 898000p 0.9
+ 898010p -0.3
+ 900000p -0.3
+ 900010p 0.9
+ 902000p 0.9
+ 902010p -0.3
+ 904000p -0.3
+ 904010p 0.9
+ 906000p 0.9
+ 906010p -0.3
+ 908000p -0.3
+ 908010p 0.9
+ 910000p 0.9
+ 910010p -0.3
+ 912000p -0.3
+ 912010p 0.9
+ 914000p 0.9
+ 914010p -0.3
+ 916000p -0.3
+ 916010p 0.9
+ 918000p 0.9
+ 918010p -0.3
+ 920000p -0.3
+ 920010p 0.9
+ 922000p 0.9
+ 922010p -0.3
+ 924000p -0.3
+ 924010p 0.9
+ 926000p 0.9
+ 926010p -0.3
+ 928000p -0.3
+ 928010p 0.9
+ 930000p 0.9
+ 930010p -0.3
+ 932000p -0.3
+ 932010p 0.9
+ 934000p 0.9
+ 934010p -0.3
+ 936000p -0.3
+ 936010p 0.9
+ 938000p 0.9
+ 938010p -0.3
+ 940000p -0.3
+ 940010p 0.9
+ 942000p 0.9
+ 942010p -0.3
+ 944000p -0.3
+ 944010p 0.9
+ 946000p 0.9
+ 946010p -0.3
+ 948000p -0.3
+ 948010p 0.9
+ 950000p 0.9
+ 950010p -0.3
+ 952000p -0.3
+ 952010p 0.9
+ 954000p 0.9
+ 954010p -0.3
+ 956000p -0.3
+ 956010p 0.9
+ 958000p 0.9
+ 958010p -0.3
+ 960000p -0.3
+ 960010p 0.9
+ 962000p 0.9
+ 962010p -0.3
+ 964000p -0.3
+ 964010p 0.9
+ 966000p 0.9
+ 966010p -0.3
+ 968000p -0.3
+ 968010p 0.9
+ 970000p 0.9
+ 970010p -0.3
+ 972000p -0.3
+ 972010p 0.9
+ 974000p 0.9
+ 974010p -0.3
+ 976000p -0.3
+ 976010p 0.9
+ 978000p 0.9
+ 978010p -0.3
+ 980000p -0.3
+ 980010p 0.9
+ 982000p 0.9
+ 982010p -0.3
+ 984000p -0.3
+ 984010p 0.9
+ 986000p 0.9
+ 986010p -0.3
+ 988000p -0.3
+ 988010p 0.9
+ 990000p 0.9
+ 990010p -0.3
+ 992000p -0.3
+ 992010p 0.9
+ 994000p 0.9
+ 994010p -0.3
+ 996000p -0.3
+ 996010p 0.9
+ 998000p 0.9
+ 998010p -0.3
+ 1000000p -0.3
+ 1000010p 0.9
+ 1002000p 0.9
+ 1002010p -0.3
+ 1004000p -0.3
+ 1004010p 0.9
+ 1006000p 0.9
+ 1006010p -0.3
+ 1008000p -0.3
+ 1008010p 0.9
+ 1010000p 0.9
+ 1010010p -0.3
+ 1012000p -0.3
+ 1012010p 0.9
+ 1014000p 0.9
+ 1014010p -0.3
+ 1016000p -0.3
+ 1016010p 0.9
+ 1018000p 0.9
+ 1018010p -0.3
+ 1020000p -0.3
+ 1020010p 0.9
+ 1022000p 0.9
+ 1022010p -0.3
+ 1024000p -0.3
+ 1024010p 0.9
+ 1026000p 0.9
+ 1026010p -0.3
+ 1028000p -0.3
+ 1028010p 0.9
+ 1030000p 0.9
+ 1030010p -0.3
+ 1032000p -0.3
+ 1032010p 0.9
+ 1034000p 0.9
+ 1034010p -0.3
+ 1036000p -0.3
+ 1036010p 0.9
+ 1038000p 0.9
+ 1038010p -0.3
+ 1040000p -0.3
+ 1040010p 0.9
+ 1042000p 0.9
+ 1042010p -0.3
+ 1044000p -0.3
+ 1044010p 0.9
+ 1046000p 0.9
+ 1046010p -0.3
+ 1048000p -0.3
+ 1048010p 0.9
+ 1050000p 0.9
+ 1050010p -0.3
+ 1052000p -0.3
+ 1052010p 0.9
+ 1054000p 0.9
+ 1054010p -0.3
+ 1056000p -0.3
+ 1056010p 0.9
+ 1058000p 0.9
+ 1058010p -0.3
+ 1060000p -0.3
+ 1060010p 0.9
+ 1062000p 0.9
+ 1062010p -0.3
+ 1064000p -0.3
+ 1064010p 0.9
+ 1066000p 0.9
+ 1066010p -0.3
+ 1068000p -0.3
+ 1068010p 0.9
+ 1070000p 0.9
+ 1070010p -0.3
+ 1072000p -0.3
+ 1072010p 0.9
+ 1074000p 0.9
+ 1074010p -0.3
+ 1076000p -0.3
+ 1076010p 0.9
+ 1078000p 0.9
+ 1078010p -0.3
+ 1080000p -0.3
+ 1080010p 0.9
+ 1082000p 0.9
+ 1082010p -0.3
+ 1084000p -0.3
+ 1084010p 0.9
+ 1086000p 0.9
+ 1086010p -0.3
+ 1088000p -0.3
+ 1088010p 0.9
+ 1090000p 0.9
+ 1090010p -0.3
+ 1092000p -0.3
+ 1092010p 0.9
+ 1094000p 0.9
+ 1094010p -0.3
+ 1096000p -0.3
+ 1096010p 0.9
+ 1098000p 0.9
+ 1098010p -0.3
+ 1100000p -0.3
+ 1100010p 0.9
+ 1102000p 0.9
+ 1102010p -0.3
+ 1104000p -0.3
+ 1104010p 0.9
+ 1106000p 0.9
+ 1106010p -0.3
+ 1108000p -0.3
+ 1108010p 0.9
+ 1110000p 0.9
+ 1110010p -0.3
+ 1112000p -0.3
+ 1112010p 0.9
+ 1114000p 0.9
+ 1114010p -0.3
+ 1116000p -0.3
+ 1116010p 0.9
+ 1118000p 0.9
+ 1118010p -0.3
+ 1120000p -0.3
+ 1120010p 0.9
+ 1122000p 0.9
+ 1122010p -0.3
+ 1124000p -0.3
+ 1124010p 0.9
+ 1126000p 0.9
+ 1126010p -0.3
+ 1128000p -0.3
+ 1128010p 0.9
+ 1130000p 0.9
+ 1130010p -0.3
+ 1132000p -0.3
+ 1132010p 0.9
+ 1134000p 0.9
+ 1134010p -0.3
+ 1136000p -0.3
+ 1136010p 0.9
+ 1138000p 0.9
+ 1138010p -0.3
+ 1140000p -0.3
+ 1140010p 0.9
+ 1142000p 0.9
+ 1142010p -0.3
+ 1144000p -0.3
+ 1144010p 0.9
+ 1146000p 0.9
+ 1146010p -0.3
+ 1148000p -0.3
+ 1148010p 0.9
+ 1150000p 0.9
+ 1150010p -0.3
+ 1152000p -0.3
+ 1152010p 0.9
+ 1154000p 0.9
+ 1154010p -0.3
+ 1156000p -0.3
+ 1156010p 0.9
+ 1158000p 0.9
+ 1158010p -0.3
+ 1160000p -0.3
+ 1160010p 0.9
+ 1162000p 0.9
+ 1162010p -0.3
+ 1164000p -0.3
+ 1164010p 0.9
+ 1166000p 0.9
+ 1166010p -0.3
+ 1168000p -0.3
+ 1168010p 0.9
+ 1170000p 0.9
+ 1170010p -0.3
+ 1172000p -0.3
+ 1172010p 0.9
+ 1174000p 0.9
+ 1174010p -0.3
+ 1176000p -0.3
+ 1176010p 0.9
+ 1178000p 0.9
+ 1178010p -0.3
+ 1180000p -0.3
+ 1180010p 0.9
+ 1182000p 0.9
+ 1182010p -0.3
+ 1184000p -0.3
+ 1184010p 0.9
+ 1186000p 0.9
+ 1186010p -0.3
+ 1188000p -0.3
+ 1188010p 0.9
+ 1190000p 0.9
+ 1190010p -0.3
+ 1192000p -0.3
+ 1192010p 0.9
+ 1194000p 0.9
+ 1194010p -0.3
+ 1196000p -0.3
+ 1196010p 0.9
+ 1198000p 0.9
+ 1198010p -0.3
+ 1200000p -0.3
+ 1200010p 0.9
+ 1202000p 0.9
+ 1202010p -0.3
+ 1204000p -0.3
+ 1204010p 0.9
+ 1206000p 0.9
+ 1206010p -0.3
+ 1208000p -0.3
+ 1208010p 0.9
+ 1210000p 0.9
+ 1210010p -0.3
+ 1212000p -0.3
+ 1212010p 0.9
+ 1214000p 0.9
+ 1214010p -0.3
+ 1216000p -0.3
+ 1216010p 0.9
+ 1218000p 0.9
+ 1218010p -0.3
+ 1220000p -0.3
+ 1220010p 0.9
+ 1222000p 0.9
+ 1222010p -0.3
+ 1224000p -0.3
+ 1224010p 0.9
+ 1226000p 0.9
+ 1226010p -0.3
+ 1228000p -0.3
+ 1228010p 0.9
+ 1230000p 0.9
+ 1230010p -0.3
+ 1232000p -0.3
+ 1232010p 0.9
+ 1234000p 0.9
+ 1234010p -0.3
+ 1236000p -0.3
+ 1236010p 0.9
+ 1238000p 0.9
+ 1238010p -0.3
+ 1240000p -0.3
+ 1240010p 0.9
+ 1242000p 0.9
+ 1242010p -0.3
+ 1244000p -0.3
+ 1244010p 0.9
+ 1246000p 0.9
+ 1246010p -0.3
+ 1248000p -0.3
+ 1248010p 0.9
+ 1250000p 0.9
+ 1250010p -0.3
+ 1252000p -0.3
+ 1252010p 0.9
+ 1254000p 0.9
+ 1254010p -0.3
+ 1256000p -0.3
+ 1256010p 0.9
+ 1258000p 0.9
+ 1258010p -0.3
+ 1260000p -0.3
+ 1260010p 0.9
+ 1262000p 0.9
+ 1262010p -0.3
+ 1264000p -0.3
+ 1264010p 0.9
+ 1266000p 0.9
+ 1266010p -0.3
+ 1268000p -0.3
+ 1268010p 0.9
+ 1270000p 0.9
+ 1270010p -0.3
+ 1272000p -0.3
+ 1272010p 0.9
+ 1274000p 0.9
+ 1274010p -0.3
+ 1276000p -0.3
+ 1276010p 0.9
+ 1278000p 0.9
+ 1278010p -0.3
+ 1280000p -0.3
+ 1280010p 0.9
+ 1282000p 0.9
+ 1282010p -0.3
+ 1284000p -0.3
+ 1284010p 0.9
+ 1286000p 0.9
+ 1286010p -0.3
+ 1288000p -0.3
+ 1288010p 0.9
+ 1290000p 0.9
+ 1290010p -0.3
+ 1292000p -0.3
+ 1292010p 0.9
+ 1294000p 0.9
+ 1294010p -0.3
+ 1296000p -0.3
+ 1296010p 0.9
+ 1298000p 0.9
+ 1298010p -0.3
+ 1300000p -0.3
+ 1300010p 0.9
+ 1302000p 0.9
+ 1302010p -0.3
+ 1304000p -0.3
+ 1304010p 0.9
+ 1306000p 0.9
+ 1306010p -0.3
+ 1308000p -0.3
+ 1308010p 0.9
+ 1310000p 0.9
+ 1310010p -0.3
+ 1312000p -0.3
+ 1312010p 0.9
+ 1314000p 0.9
+ 1314010p -0.3
+ 1316000p -0.3
+ 1316010p 0.9
+ 1318000p 0.9
+ 1318010p -0.3
+ 1320000p -0.3
+ 1320010p 0.9
+ 1322000p 0.9
+ 1322010p -0.3
+ 1324000p -0.3
+ 1324010p 0.9
+ 1326000p 0.9
+ 1326010p -0.3
+ 1328000p -0.3
+ 1328010p 0.9
+ 1330000p 0.9
+ 1330010p -0.3
+ 1332000p -0.3
+ 1332010p 0.9
+ 1334000p 0.9
+ 1334010p -0.3
+ 1336000p -0.3
+ 1336010p 0.9
+ 1338000p 0.9
+ 1338010p -0.3
+ 1340000p -0.3
+ 1340010p 0.9
+ 1342000p 0.9
+ 1342010p -0.3
+ 1344000p -0.3
+ 1344010p 0.9
+ 1346000p 0.9
+ 1346010p -0.3
+ 1348000p -0.3
+ 1348010p 0.9
+ 1350000p 0.9
+ 1350010p -0.3
+ 1352000p -0.3
+ 1352010p 0.9
+ 1354000p 0.9
+ 1354010p -0.3
+ 1356000p -0.3
+ 1356010p 0.9
+ 1358000p 0.9
+ 1358010p -0.3
+ 1360000p -0.3
+ 1360010p 0.9
+ 1362000p 0.9
+ 1362010p -0.3
+ 1364000p -0.3
+ 1364010p 0.9
+ 1366000p 0.9
+ 1366010p -0.3
+ 1368000p -0.3
+ 1368010p 0.9
+ 1370000p 0.9
+ 1370010p -0.3
+ 1372000p -0.3
+ 1372010p 0.9
+ 1374000p 0.9
+ 1374010p -0.3
+ 1376000p -0.3
+ 1376010p 0.9
+ 1378000p 0.9
+ 1378010p -0.3
+ 1380000p -0.3
+ 1380010p 0.9
+ 1382000p 0.9
+ 1382010p -0.3
+ 1384000p -0.3
+ 1384010p 0.9
+ 1386000p 0.9
+ 1386010p -0.3
+ 1388000p -0.3
+ 1388010p 0.9
+ 1390000p 0.9
+ 1390010p -0.3
+ 1392000p -0.3
+ 1392010p 0.9
+ 1394000p 0.9
+ 1394010p -0.3
+ 1396000p -0.3
+ 1396010p 0.9
+ 1398000p 0.9
+ 1398010p -0.3
+ 1400000p -0.3
+ 1400010p 0.9
+ 1402000p 0.9
+ 1402010p -0.3
+ 1404000p -0.3
+ 1404010p 0.9
+ 1406000p 0.9
+ 1406010p -0.3
+ 1408000p -0.3
+ 1408010p 0.9
+ 1410000p 0.9
+ 1410010p -0.3
+ 1412000p -0.3
+ 1412010p 0.9
+ 1414000p 0.9
+ 1414010p -0.3
+ 1416000p -0.3
+ 1416010p 0.9
+ 1418000p 0.9
+ 1418010p -0.3
+ 1420000p -0.3
+ 1420010p 0.9
+ 1422000p 0.9
+ 1422010p -0.3
+ 1424000p -0.3
+ 1424010p 0.9
+ 1426000p 0.9
+ 1426010p -0.3
+ 1428000p -0.3
+ 1428010p 0.9
+ 1430000p 0.9
+ 1430010p -0.3
+ 1432000p -0.3
+ 1432010p 0.9
+ 1434000p 0.9
+ 1434010p -0.3
+ 1436000p -0.3
+ 1436010p 0.9
+ 1438000p 0.9
+ 1438010p -0.3
+ 1440000p -0.3
+ 1440010p 0.9
+ 1442000p 0.9
+ 1442010p -0.3
+ 1444000p -0.3
+ 1444010p 0.9
+ 1446000p 0.9
+ 1446010p -0.3
+ 1448000p -0.3
+ 1448010p 0.9
+ 1450000p 0.9
+ 1450010p -0.3
+ 1452000p -0.3
+ 1452010p 0.9
+ 1454000p 0.9
+ 1454010p -0.3
+ 1456000p -0.3
+ 1456010p 0.9
+ 1458000p 0.9
+ 1458010p -0.3
+ 1460000p -0.3
+ 1460010p 0.9
+ 1462000p 0.9
+ 1462010p -0.3
+ 1464000p -0.3
+ 1464010p 0.9
+ 1466000p 0.9
+ 1466010p -0.3
+ 1468000p -0.3
+ 1468010p 0.9
+ 1470000p 0.9
+ 1470010p -0.3
+ 1472000p -0.3
+ 1472010p 0.9
+ 1474000p 0.9
+ 1474010p -0.3
+ 1476000p -0.3
+ 1476010p 0.9
+ 1478000p 0.9
+ 1478010p -0.3
+ 1480000p -0.3
+ 1480010p 0.9
+ 1482000p 0.9
+ 1482010p -0.3
+ 1484000p -0.3
+ 1484010p 0.9
+ 1486000p 0.9
+ 1486010p -0.3
+ 1488000p -0.3
+ 1488010p 0.9
+ 1490000p 0.9
+ 1490010p -0.3
+ 1492000p -0.3
+ 1492010p 0.9
+ 1494000p 0.9
+ 1494010p -0.3
+ 1496000p -0.3
+ 1496010p 0.9
+ 1498000p 0.9
+ 1498010p -0.3
+ 1500000p -0.3
+ 1500010p 0.9
+ 1502000p 0.9
+ 1502010p -0.3
+ 1504000p -0.3
+ 1504010p 0.9
+ 1506000p 0.9
+ 1506010p -0.3
+ 1508000p -0.3
+ 1508010p 0.9
+ 1510000p 0.9
+ 1510010p -0.3
+ 1512000p -0.3
+ 1512010p 0.9
+ 1514000p 0.9
+ 1514010p -0.3
+ 1516000p -0.3
+ 1516010p 0.9
+ 1518000p 0.9
+ 1518010p -0.3
+ 1520000p -0.3
+ 1520010p 0.9
+ 1522000p 0.9
+ 1522010p -0.3
+ 1524000p -0.3
+ 1524010p 0.9
+ 1526000p 0.9
+ 1526010p -0.3
+ 1528000p -0.3
+ 1528010p 0.9
+ 1530000p 0.9
+ 1530010p -0.3
+ 1532000p -0.3
+ 1532010p 0.9
+ 1534000p 0.9
+ 1534010p -0.3
+ 1536000p -0.3
+ 1536010p 0.9
+ 1538000p 0.9
+ 1538010p -0.3
+ 1540000p -0.3
+ 1540010p 0.9
+ 1542000p 0.9
+ 1542010p -0.3
+ 1544000p -0.3
+ 1544010p 0.9
+ 1546000p 0.9
+ 1546010p -0.3
+ 1548000p -0.3
+ 1548010p 0.9
+ 1550000p 0.9
+ 1550010p -0.3
+ 1552000p -0.3
+ 1552010p 0.9
+ 1554000p 0.9
+ 1554010p -0.3
+ 1556000p -0.3
+ 1556010p 0.9
+ 1558000p 0.9
+ 1558010p -0.3
+ 1560000p -0.3
+ 1560010p 0.9
+ 1562000p 0.9
+ 1562010p -0.3
+ 1564000p -0.3
+ 1564010p 0.9
+ 1566000p 0.9
+ 1566010p -0.3
+ 1568000p -0.3
+ 1568010p 0.9
+ 1570000p 0.9
+ 1570010p -0.3
+ 1572000p -0.3
+ 1572010p 0.9
+ 1574000p 0.9
+ 1574010p -0.3
+ 1576000p -0.3
+ 1576010p 0.9
+ 1578000p 0.9
+ 1578010p -0.3
+ 1580000p -0.3
+ 1580010p 0.9
+ 1582000p 0.9
+ 1582010p -0.3
+ 1584000p -0.3
+ 1584010p 0.9
+ 1586000p 0.9
+ 1586010p -0.3
+ 1588000p -0.3
+ 1588010p 0.9
+ 1590000p 0.9
+ 1590010p -0.3
+ 1592000p -0.3
+ 1592010p 0.9
+ 1594000p 0.9
+ 1594010p -0.3
+ 1596000p -0.3
+ 1596010p 0.9
+ 1598000p 0.9
+ 1598010p -0.3
+ 1600000p -0.3
+ 1600010p 0.9
+ 1602000p 0.9
+ 1602010p -0.3
+ 1604000p -0.3
+ 1604010p 0.9
+ 1606000p 0.9
+ 1606010p -0.3
+ 1608000p -0.3
+ 1608010p 0.9
+ 1610000p 0.9
+ 1610010p -0.3
+ 1612000p -0.3
+ 1612010p 0.9
+ 1614000p 0.9
+ 1614010p -0.3
+ 1616000p -0.3
+ 1616010p 0.9
+ 1618000p 0.9
+ 1618010p -0.3
+ 1620000p -0.3
+ 1620010p 0.9
+ 1622000p 0.9
+ 1622010p -0.3
+ 1624000p -0.3
+ 1624010p 0.9
+ 1626000p 0.9
+ 1626010p -0.3
+ 1628000p -0.3
+ 1628010p 0.9
+ 1630000p 0.9
+ 1630010p -0.3
+ 1632000p -0.3
+ 1632010p 0.9
+ 1634000p 0.9
+ 1634010p -0.3
+ 1636000p -0.3
+ 1636010p 0.9
+ 1638000p 0.9
+ 1638010p -0.3
+ 1640000p -0.3
+ 1640010p 0.9
+ 1642000p 0.9
+ 1642010p -0.3
+ 1644000p -0.3
+ 1644010p 0.9
+ 1646000p 0.9
+ 1646010p -0.3
+ 1648000p -0.3
+ 1648010p 0.9
+ 1650000p 0.9
+ 1650010p -0.3
+ 1652000p -0.3
+ 1652010p 0.9
+ 1654000p 0.9
+ 1654010p -0.3
+ 1656000p -0.3
+ 1656010p 0.9
+ 1658000p 0.9
+ 1658010p -0.3
+ 1660000p -0.3
+ 1660010p 0.9
+ 1662000p 0.9
+ 1662010p -0.3
+ 1664000p -0.3
+ 1664010p 0.9
+ 1666000p 0.9
+ 1666010p -0.3
+ 1668000p -0.3
+ 1668010p 0.9
+ 1670000p 0.9
+ 1670010p -0.3
+ 1672000p -0.3
+ 1672010p 0.9
+ 1674000p 0.9
+ 1674010p -0.3
+ 1676000p -0.3
+ 1676010p 0.9
+ 1678000p 0.9
+ 1678010p -0.3
+ 1680000p -0.3
+ 1680010p 0.9
+ 1682000p 0.9
+ 1682010p -0.3
+ 1684000p -0.3
+ 1684010p 0.9
+ 1686000p 0.9
+ 1686010p -0.3
+ 1688000p -0.3
+ 1688010p 0.9
+ 1690000p 0.9
+ 1690010p -0.3
+ 1692000p -0.3
+ 1692010p 0.9
+ 1694000p 0.9
+ 1694010p -0.3
+ 1696000p -0.3
+ 1696010p 0.9
+ 1698000p 0.9
+ 1698010p -0.3
+ 1700000p -0.3
+ 1700010p 0.9
+ 1702000p 0.9
+ 1702010p -0.3
+ 1704000p -0.3
+ 1704010p 0.9
+ 1706000p 0.9
+ 1706010p -0.3
+ 1708000p -0.3
+ 1708010p 0.9
+ 1710000p 0.9
+ 1710010p -0.3
+ 1712000p -0.3
+ 1712010p 0.9
+ 1714000p 0.9
+ 1714010p -0.3
+ 1716000p -0.3
+ 1716010p 0.9
+ 1718000p 0.9
+ 1718010p -0.3
+ 1720000p -0.3
+ 1720010p 0.9
+ 1722000p 0.9
+ 1722010p -0.3
+ 1724000p -0.3
+ 1724010p 0.9
+ 1726000p 0.9
+ 1726010p -0.3
+ 1728000p -0.3
+ 1728010p 0.9
+ 1730000p 0.9
+ 1730010p -0.3
+ 1732000p -0.3
+ 1732010p 0.9
+ 1734000p 0.9
+ 1734010p -0.3
+ 1736000p -0.3
+ 1736010p 0.9
+ 1738000p 0.9
+ 1738010p -0.3
+ 1740000p -0.3
+ 1740010p 0.9
+ 1742000p 0.9
+ 1742010p -0.3
+ 1744000p -0.3
+ 1744010p 0.9
+ 1746000p 0.9
+ 1746010p -0.3
+ 1748000p -0.3
+ 1748010p 0.9
+ 1750000p 0.9
+ 1750010p -0.3
+ 1752000p -0.3
+ 1752010p 0.9
+ 1754000p 0.9
+ 1754010p -0.3
+ 1756000p -0.3
+ 1756010p 0.9
+ 1758000p 0.9
+ 1758010p -0.3
+ 1760000p -0.3
+ 1760010p 0.9
+ 1762000p 0.9
+ 1762010p -0.3
+ 1764000p -0.3
+ 1764010p 0.9
+ 1766000p 0.9
+ 1766010p -0.3
+ 1768000p -0.3
+ 1768010p 0.9
+ 1770000p 0.9
+ 1770010p -0.3
+ 1772000p -0.3
+ 1772010p 0.9
+ 1774000p 0.9
+ 1774010p -0.3
+ 1776000p -0.3
+ 1776010p 0.9
+ 1778000p 0.9
+ 1778010p -0.3
+ 1780000p -0.3
+ 1780010p 0.9
+ 1782000p 0.9
+ 1782010p -0.3
+ 1784000p -0.3
+ 1784010p 0.9
+ 1786000p 0.9
+ 1786010p -0.3
+ 1788000p -0.3
+ 1788010p 0.9
+ 1790000p 0.9
+ 1790010p -0.3
+ 1792000p -0.3
+ 1792010p 0.9
+ 1794000p 0.9
+ 1794010p -0.3
+ 1796000p -0.3
+ 1796010p 0.9
+ 1798000p 0.9
+ 1798010p -0.3
+ 1800000p -0.3
+ 1800010p 0.9
+ 1802000p 0.9
+ 1802010p -0.3
+ 1804000p -0.3
+ 1804010p 0.9
+ 1806000p 0.9
+ 1806010p -0.3
+ 1808000p -0.3
+ 1808010p 0.9
+ 1810000p 0.9
+ 1810010p -0.3
+ 1812000p -0.3
+ 1812010p 0.9
+ 1814000p 0.9
+ 1814010p -0.3
+ 1816000p -0.3
+ 1816010p 0.9
+ 1818000p 0.9
+ 1818010p -0.3
+ 1820000p -0.3
+ 1820010p 0.9
+ 1822000p 0.9
+ 1822010p -0.3
+ 1824000p -0.3
+ 1824010p 0.9
+ 1826000p 0.9
+ 1826010p -0.3
+ 1828000p -0.3
+ 1828010p 0.9
+ 1830000p 0.9
+ 1830010p -0.3
+ 1832000p -0.3
+ 1832010p 0.9
+ 1834000p 0.9
+ 1834010p -0.3
+ 1836000p -0.3
+ 1836010p 0.9
+ 1838000p 0.9
+ 1838010p -0.3
+ 1840000p -0.3
+ 1840010p 0.9
+ 1842000p 0.9
+ 1842010p -0.3
+ 1844000p -0.3
+ 1844010p 0.9
+ 1846000p 0.9
+ 1846010p -0.3
+ 1848000p -0.3
+ 1848010p 0.9
+ 1850000p 0.9
+ 1850010p -0.3
+ 1852000p -0.3
+ 1852010p 0.9
+ 1854000p 0.9
+ 1854010p -0.3
+ 1856000p -0.3
+ 1856010p 0.9
+ 1858000p 0.9
+ 1858010p -0.3
+ 1860000p -0.3
+ 1860010p 0.9
+ 1862000p 0.9
+ 1862010p -0.3
+ 1864000p -0.3
+ 1864010p 0.9
+ 1866000p 0.9
+ 1866010p -0.3
+ 1868000p -0.3
+ 1868010p 0.9
+ 1870000p 0.9
+ 1870010p -0.3
+ 1872000p -0.3
+ 1872010p 0.9
+ 1874000p 0.9
+ 1874010p -0.3
+ 1876000p -0.3
+ 1876010p 0.9
+ 1878000p 0.9
+ 1878010p -0.3
+ 1880000p -0.3
+ 1880010p 0.9
+ 1882000p 0.9
+ 1882010p -0.3
+ 1884000p -0.3
+ 1884010p 0.9
+ 1886000p 0.9
+ 1886010p -0.3
+ 1888000p -0.3
+ 1888010p 0.9
+ 1890000p 0.9
+ 1890010p -0.3
+ 1892000p -0.3
+ 1892010p 0.9
+ 1894000p 0.9
+ 1894010p -0.3
+ 1896000p -0.3
+ 1896010p 0.9
+ 1898000p 0.9
+ 1898010p -0.3
+ 1900000p -0.3
+ 1900010p 0.9
+ 1902000p 0.9
+ 1902010p -0.3
+ 1904000p -0.3
+ 1904010p 0.9
+ 1906000p 0.9
+ 1906010p -0.3
+ 1908000p -0.3
+ 1908010p 0.9
+ 1910000p 0.9
+ 1910010p -0.3
+ 1912000p -0.3
+ 1912010p 0.9
+ 1914000p 0.9
+ 1914010p -0.3
+ 1916000p -0.3
+ 1916010p 0.9
+ 1918000p 0.9
+ 1918010p -0.3
+ 1920000p -0.3
+ 1920010p 0.9
+ 1922000p 0.9
+ 1922010p -0.3
+ 1924000p -0.3
+ 1924010p 0.9
+ 1926000p 0.9
+ 1926010p -0.3
+ 1928000p -0.3
+ 1928010p 0.9
+ 1930000p 0.9
+ 1930010p -0.3
+ 1932000p -0.3
+ 1932010p 0.9
+ 1934000p 0.9
+ 1934010p -0.3
+ 1936000p -0.3
+ 1936010p 0.9
+ 1938000p 0.9
+ 1938010p -0.3
+ 1940000p -0.3
+ 1940010p 0.9
+ 1942000p 0.9
+ 1942010p -0.3
+ 1944000p -0.3
+ 1944010p 0.9
+ 1946000p 0.9
+ 1946010p -0.3
+ 1948000p -0.3
+ 1948010p 0.9
+ 1950000p 0.9
+ 1950010p -0.3
+ 1952000p -0.3
+ 1952010p 0.9
+ 1954000p 0.9
+ 1954010p -0.3
+ 1956000p -0.3
+ 1956010p 0.9
+ 1958000p 0.9
+ 1958010p -0.3
+ 1960000p -0.3
+ 1960010p 0.9
+ 1962000p 0.9
+ 1962010p -0.3
+ 1964000p -0.3
+ 1964010p 0.9
+ 1966000p 0.9
+ 1966010p -0.3
+ 1968000p -0.3
+ 1968010p 0.9
+ 1970000p 0.9
+ 1970010p -0.3
+ 1972000p -0.3
+ 1972010p 0.9
+ 1974000p 0.9
+ 1974010p -0.3
+ 1976000p -0.3
+ 1976010p 0.9
+ 1978000p 0.9
+ 1978010p -0.3
+ 1980000p -0.3
+ 1980010p 0.9
+ 1982000p 0.9
+ 1982010p -0.3
+ 1984000p -0.3
+ 1984010p 0.9
+ 1986000p 0.9
+ 1986010p -0.3
+ 1988000p -0.3
+ 1988010p 0.9
+ 1990000p 0.9
+ 1990010p -0.3
+ 1992000p -0.3
+ 1992010p 0.9
+ 1994000p 0.9
+ 1994010p -0.3
+ 1996000p -0.3
+ 1996010p 0.9
+ 1998000p 0.9
+ 1998010p -0.3
+ 2000000p -0.3
+ 2000010p 0.9
+ 2002000p 0.9
+ 2002010p -0.3
+ 2004000p -0.3
+ 2004010p 0.9
+ 2006000p 0.9
+ 2006010p -0.3
+ 2008000p -0.3
+ 2008010p 0.9
+ 2010000p 0.9
+ 2010010p -0.3
+ 2012000p -0.3
+ 2012010p 0.9
+ 2014000p 0.9
+ 2014010p -0.3
+ 2016000p -0.3
+ 2016010p 0.9
+ 2018000p 0.9
+ 2018010p -0.3
+ 2020000p -0.3
+ 2020010p 0.9
+ 2022000p 0.9
+ 2022010p -0.3
+ 2024000p -0.3
+ 2024010p 0.9
+ 2026000p 0.9
+ 2026010p -0.3
+ 2028000p -0.3
+ 2028010p 0.9
+ 2030000p 0.9
+ 2030010p -0.3
+ 2032000p -0.3
+ 2032010p 0.9
+ 2034000p 0.9
+ 2034010p -0.3
+ 2036000p -0.3
+ 2036010p 0.9
+ 2038000p 0.9
+ 2038010p -0.3
+ 2040000p -0.3
+ 2040010p 0.9
+ 2042000p 0.9
+ 2042010p -0.3
+ 2044000p -0.3
+ 2044010p 0.9
+ 2046000p 0.9
+ 2046010p -0.3
+ 2048000p -0.3
+ 2048010p 0.9
+ \]
V_data_bar_14 (Data_bar\\<14\\> gnd!) vsource type=pwl wave=\[
+ 0    -0.3
+ 2000p -0.3
+ 2010p 0.9
+ 4000p 0.9
+ 4010p -0.3
+ 6000p -0.3
+ 6010p 0.9
+ 8000p 0.9
+ 8010p -0.3
+ 10000p -0.3
+ 10010p 0.9
+ 12000p 0.9
+ 12010p -0.3
+ 14000p -0.3
+ 14010p 0.9
+ 16000p 0.9
+ 16010p -0.3
+ 18000p -0.3
+ 18010p 0.9
+ 20000p 0.9
+ 20010p -0.3
+ 22000p -0.3
+ 22010p 0.9
+ 24000p 0.9
+ 24010p -0.3
+ 26000p -0.3
+ 26010p 0.9
+ 28000p 0.9
+ 28010p -0.3
+ 30000p -0.3
+ 30010p 0.9
+ 32000p 0.9
+ 32010p -0.3
+ 34000p -0.3
+ 34010p 0.9
+ 36000p 0.9
+ 36010p -0.3
+ 38000p -0.3
+ 38010p 0.9
+ 40000p 0.9
+ 40010p -0.3
+ 42000p -0.3
+ 42010p 0.9
+ 44000p 0.9
+ 44010p -0.3
+ 46000p -0.3
+ 46010p 0.9
+ 48000p 0.9
+ 48010p -0.3
+ 50000p -0.3
+ 50010p 0.9
+ 52000p 0.9
+ 52010p -0.3
+ 54000p -0.3
+ 54010p 0.9
+ 56000p 0.9
+ 56010p -0.3
+ 58000p -0.3
+ 58010p 0.9
+ 60000p 0.9
+ 60010p -0.3
+ 62000p -0.3
+ 62010p 0.9
+ 64000p 0.9
+ 64010p -0.3
+ 66000p -0.3
+ 66010p 0.9
+ 68000p 0.9
+ 68010p -0.3
+ 70000p -0.3
+ 70010p 0.9
+ 72000p 0.9
+ 72010p -0.3
+ 74000p -0.3
+ 74010p 0.9
+ 76000p 0.9
+ 76010p -0.3
+ 78000p -0.3
+ 78010p 0.9
+ 80000p 0.9
+ 80010p -0.3
+ 82000p -0.3
+ 82010p 0.9
+ 84000p 0.9
+ 84010p -0.3
+ 86000p -0.3
+ 86010p 0.9
+ 88000p 0.9
+ 88010p -0.3
+ 90000p -0.3
+ 90010p 0.9
+ 92000p 0.9
+ 92010p -0.3
+ 94000p -0.3
+ 94010p 0.9
+ 96000p 0.9
+ 96010p -0.3
+ 98000p -0.3
+ 98010p 0.9
+ 100000p 0.9
+ 100010p -0.3
+ 102000p -0.3
+ 102010p 0.9
+ 104000p 0.9
+ 104010p -0.3
+ 106000p -0.3
+ 106010p 0.9
+ 108000p 0.9
+ 108010p -0.3
+ 110000p -0.3
+ 110010p 0.9
+ 112000p 0.9
+ 112010p -0.3
+ 114000p -0.3
+ 114010p 0.9
+ 116000p 0.9
+ 116010p -0.3
+ 118000p -0.3
+ 118010p 0.9
+ 120000p 0.9
+ 120010p -0.3
+ 122000p -0.3
+ 122010p 0.9
+ 124000p 0.9
+ 124010p -0.3
+ 126000p -0.3
+ 126010p 0.9
+ 128000p 0.9
+ 128010p -0.3
+ 130000p -0.3
+ 130010p 0.9
+ 132000p 0.9
+ 132010p -0.3
+ 134000p -0.3
+ 134010p 0.9
+ 136000p 0.9
+ 136010p -0.3
+ 138000p -0.3
+ 138010p 0.9
+ 140000p 0.9
+ 140010p -0.3
+ 142000p -0.3
+ 142010p 0.9
+ 144000p 0.9
+ 144010p -0.3
+ 146000p -0.3
+ 146010p 0.9
+ 148000p 0.9
+ 148010p -0.3
+ 150000p -0.3
+ 150010p 0.9
+ 152000p 0.9
+ 152010p -0.3
+ 154000p -0.3
+ 154010p 0.9
+ 156000p 0.9
+ 156010p -0.3
+ 158000p -0.3
+ 158010p 0.9
+ 160000p 0.9
+ 160010p -0.3
+ 162000p -0.3
+ 162010p 0.9
+ 164000p 0.9
+ 164010p -0.3
+ 166000p -0.3
+ 166010p 0.9
+ 168000p 0.9
+ 168010p -0.3
+ 170000p -0.3
+ 170010p 0.9
+ 172000p 0.9
+ 172010p -0.3
+ 174000p -0.3
+ 174010p 0.9
+ 176000p 0.9
+ 176010p -0.3
+ 178000p -0.3
+ 178010p 0.9
+ 180000p 0.9
+ 180010p -0.3
+ 182000p -0.3
+ 182010p 0.9
+ 184000p 0.9
+ 184010p -0.3
+ 186000p -0.3
+ 186010p 0.9
+ 188000p 0.9
+ 188010p -0.3
+ 190000p -0.3
+ 190010p 0.9
+ 192000p 0.9
+ 192010p -0.3
+ 194000p -0.3
+ 194010p 0.9
+ 196000p 0.9
+ 196010p -0.3
+ 198000p -0.3
+ 198010p 0.9
+ 200000p 0.9
+ 200010p -0.3
+ 202000p -0.3
+ 202010p 0.9
+ 204000p 0.9
+ 204010p -0.3
+ 206000p -0.3
+ 206010p 0.9
+ 208000p 0.9
+ 208010p -0.3
+ 210000p -0.3
+ 210010p 0.9
+ 212000p 0.9
+ 212010p -0.3
+ 214000p -0.3
+ 214010p 0.9
+ 216000p 0.9
+ 216010p -0.3
+ 218000p -0.3
+ 218010p 0.9
+ 220000p 0.9
+ 220010p -0.3
+ 222000p -0.3
+ 222010p 0.9
+ 224000p 0.9
+ 224010p -0.3
+ 226000p -0.3
+ 226010p 0.9
+ 228000p 0.9
+ 228010p -0.3
+ 230000p -0.3
+ 230010p 0.9
+ 232000p 0.9
+ 232010p -0.3
+ 234000p -0.3
+ 234010p 0.9
+ 236000p 0.9
+ 236010p -0.3
+ 238000p -0.3
+ 238010p 0.9
+ 240000p 0.9
+ 240010p -0.3
+ 242000p -0.3
+ 242010p 0.9
+ 244000p 0.9
+ 244010p -0.3
+ 246000p -0.3
+ 246010p 0.9
+ 248000p 0.9
+ 248010p -0.3
+ 250000p -0.3
+ 250010p 0.9
+ 252000p 0.9
+ 252010p -0.3
+ 254000p -0.3
+ 254010p 0.9
+ 256000p 0.9
+ 256010p -0.3
+ 258000p -0.3
+ 258010p 0.9
+ 260000p 0.9
+ 260010p -0.3
+ 262000p -0.3
+ 262010p 0.9
+ 264000p 0.9
+ 264010p -0.3
+ 266000p -0.3
+ 266010p 0.9
+ 268000p 0.9
+ 268010p -0.3
+ 270000p -0.3
+ 270010p 0.9
+ 272000p 0.9
+ 272010p -0.3
+ 274000p -0.3
+ 274010p 0.9
+ 276000p 0.9
+ 276010p -0.3
+ 278000p -0.3
+ 278010p 0.9
+ 280000p 0.9
+ 280010p -0.3
+ 282000p -0.3
+ 282010p 0.9
+ 284000p 0.9
+ 284010p -0.3
+ 286000p -0.3
+ 286010p 0.9
+ 288000p 0.9
+ 288010p -0.3
+ 290000p -0.3
+ 290010p 0.9
+ 292000p 0.9
+ 292010p -0.3
+ 294000p -0.3
+ 294010p 0.9
+ 296000p 0.9
+ 296010p -0.3
+ 298000p -0.3
+ 298010p 0.9
+ 300000p 0.9
+ 300010p -0.3
+ 302000p -0.3
+ 302010p 0.9
+ 304000p 0.9
+ 304010p -0.3
+ 306000p -0.3
+ 306010p 0.9
+ 308000p 0.9
+ 308010p -0.3
+ 310000p -0.3
+ 310010p 0.9
+ 312000p 0.9
+ 312010p -0.3
+ 314000p -0.3
+ 314010p 0.9
+ 316000p 0.9
+ 316010p -0.3
+ 318000p -0.3
+ 318010p 0.9
+ 320000p 0.9
+ 320010p -0.3
+ 322000p -0.3
+ 322010p 0.9
+ 324000p 0.9
+ 324010p -0.3
+ 326000p -0.3
+ 326010p 0.9
+ 328000p 0.9
+ 328010p -0.3
+ 330000p -0.3
+ 330010p 0.9
+ 332000p 0.9
+ 332010p -0.3
+ 334000p -0.3
+ 334010p 0.9
+ 336000p 0.9
+ 336010p -0.3
+ 338000p -0.3
+ 338010p 0.9
+ 340000p 0.9
+ 340010p -0.3
+ 342000p -0.3
+ 342010p 0.9
+ 344000p 0.9
+ 344010p -0.3
+ 346000p -0.3
+ 346010p 0.9
+ 348000p 0.9
+ 348010p -0.3
+ 350000p -0.3
+ 350010p 0.9
+ 352000p 0.9
+ 352010p -0.3
+ 354000p -0.3
+ 354010p 0.9
+ 356000p 0.9
+ 356010p -0.3
+ 358000p -0.3
+ 358010p 0.9
+ 360000p 0.9
+ 360010p -0.3
+ 362000p -0.3
+ 362010p 0.9
+ 364000p 0.9
+ 364010p -0.3
+ 366000p -0.3
+ 366010p 0.9
+ 368000p 0.9
+ 368010p -0.3
+ 370000p -0.3
+ 370010p 0.9
+ 372000p 0.9
+ 372010p -0.3
+ 374000p -0.3
+ 374010p 0.9
+ 376000p 0.9
+ 376010p -0.3
+ 378000p -0.3
+ 378010p 0.9
+ 380000p 0.9
+ 380010p -0.3
+ 382000p -0.3
+ 382010p 0.9
+ 384000p 0.9
+ 384010p -0.3
+ 386000p -0.3
+ 386010p 0.9
+ 388000p 0.9
+ 388010p -0.3
+ 390000p -0.3
+ 390010p 0.9
+ 392000p 0.9
+ 392010p -0.3
+ 394000p -0.3
+ 394010p 0.9
+ 396000p 0.9
+ 396010p -0.3
+ 398000p -0.3
+ 398010p 0.9
+ 400000p 0.9
+ 400010p -0.3
+ 402000p -0.3
+ 402010p 0.9
+ 404000p 0.9
+ 404010p -0.3
+ 406000p -0.3
+ 406010p 0.9
+ 408000p 0.9
+ 408010p -0.3
+ 410000p -0.3
+ 410010p 0.9
+ 412000p 0.9
+ 412010p -0.3
+ 414000p -0.3
+ 414010p 0.9
+ 416000p 0.9
+ 416010p -0.3
+ 418000p -0.3
+ 418010p 0.9
+ 420000p 0.9
+ 420010p -0.3
+ 422000p -0.3
+ 422010p 0.9
+ 424000p 0.9
+ 424010p -0.3
+ 426000p -0.3
+ 426010p 0.9
+ 428000p 0.9
+ 428010p -0.3
+ 430000p -0.3
+ 430010p 0.9
+ 432000p 0.9
+ 432010p -0.3
+ 434000p -0.3
+ 434010p 0.9
+ 436000p 0.9
+ 436010p -0.3
+ 438000p -0.3
+ 438010p 0.9
+ 440000p 0.9
+ 440010p -0.3
+ 442000p -0.3
+ 442010p 0.9
+ 444000p 0.9
+ 444010p -0.3
+ 446000p -0.3
+ 446010p 0.9
+ 448000p 0.9
+ 448010p -0.3
+ 450000p -0.3
+ 450010p 0.9
+ 452000p 0.9
+ 452010p -0.3
+ 454000p -0.3
+ 454010p 0.9
+ 456000p 0.9
+ 456010p -0.3
+ 458000p -0.3
+ 458010p 0.9
+ 460000p 0.9
+ 460010p -0.3
+ 462000p -0.3
+ 462010p 0.9
+ 464000p 0.9
+ 464010p -0.3
+ 466000p -0.3
+ 466010p 0.9
+ 468000p 0.9
+ 468010p -0.3
+ 470000p -0.3
+ 470010p 0.9
+ 472000p 0.9
+ 472010p -0.3
+ 474000p -0.3
+ 474010p 0.9
+ 476000p 0.9
+ 476010p -0.3
+ 478000p -0.3
+ 478010p 0.9
+ 480000p 0.9
+ 480010p -0.3
+ 482000p -0.3
+ 482010p 0.9
+ 484000p 0.9
+ 484010p -0.3
+ 486000p -0.3
+ 486010p 0.9
+ 488000p 0.9
+ 488010p -0.3
+ 490000p -0.3
+ 490010p 0.9
+ 492000p 0.9
+ 492010p -0.3
+ 494000p -0.3
+ 494010p 0.9
+ 496000p 0.9
+ 496010p -0.3
+ 498000p -0.3
+ 498010p 0.9
+ 500000p 0.9
+ 500010p -0.3
+ 502000p -0.3
+ 502010p 0.9
+ 504000p 0.9
+ 504010p -0.3
+ 506000p -0.3
+ 506010p 0.9
+ 508000p 0.9
+ 508010p -0.3
+ 510000p -0.3
+ 510010p 0.9
+ 512000p 0.9
+ 512010p -0.3
+ 514000p -0.3
+ 514010p 0.9
+ 516000p 0.9
+ 516010p -0.3
+ 518000p -0.3
+ 518010p 0.9
+ 520000p 0.9
+ 520010p -0.3
+ 522000p -0.3
+ 522010p 0.9
+ 524000p 0.9
+ 524010p -0.3
+ 526000p -0.3
+ 526010p 0.9
+ 528000p 0.9
+ 528010p -0.3
+ 530000p -0.3
+ 530010p 0.9
+ 532000p 0.9
+ 532010p -0.3
+ 534000p -0.3
+ 534010p 0.9
+ 536000p 0.9
+ 536010p -0.3
+ 538000p -0.3
+ 538010p 0.9
+ 540000p 0.9
+ 540010p -0.3
+ 542000p -0.3
+ 542010p 0.9
+ 544000p 0.9
+ 544010p -0.3
+ 546000p -0.3
+ 546010p 0.9
+ 548000p 0.9
+ 548010p -0.3
+ 550000p -0.3
+ 550010p 0.9
+ 552000p 0.9
+ 552010p -0.3
+ 554000p -0.3
+ 554010p 0.9
+ 556000p 0.9
+ 556010p -0.3
+ 558000p -0.3
+ 558010p 0.9
+ 560000p 0.9
+ 560010p -0.3
+ 562000p -0.3
+ 562010p 0.9
+ 564000p 0.9
+ 564010p -0.3
+ 566000p -0.3
+ 566010p 0.9
+ 568000p 0.9
+ 568010p -0.3
+ 570000p -0.3
+ 570010p 0.9
+ 572000p 0.9
+ 572010p -0.3
+ 574000p -0.3
+ 574010p 0.9
+ 576000p 0.9
+ 576010p -0.3
+ 578000p -0.3
+ 578010p 0.9
+ 580000p 0.9
+ 580010p -0.3
+ 582000p -0.3
+ 582010p 0.9
+ 584000p 0.9
+ 584010p -0.3
+ 586000p -0.3
+ 586010p 0.9
+ 588000p 0.9
+ 588010p -0.3
+ 590000p -0.3
+ 590010p 0.9
+ 592000p 0.9
+ 592010p -0.3
+ 594000p -0.3
+ 594010p 0.9
+ 596000p 0.9
+ 596010p -0.3
+ 598000p -0.3
+ 598010p 0.9
+ 600000p 0.9
+ 600010p -0.3
+ 602000p -0.3
+ 602010p 0.9
+ 604000p 0.9
+ 604010p -0.3
+ 606000p -0.3
+ 606010p 0.9
+ 608000p 0.9
+ 608010p -0.3
+ 610000p -0.3
+ 610010p 0.9
+ 612000p 0.9
+ 612010p -0.3
+ 614000p -0.3
+ 614010p 0.9
+ 616000p 0.9
+ 616010p -0.3
+ 618000p -0.3
+ 618010p 0.9
+ 620000p 0.9
+ 620010p -0.3
+ 622000p -0.3
+ 622010p 0.9
+ 624000p 0.9
+ 624010p -0.3
+ 626000p -0.3
+ 626010p 0.9
+ 628000p 0.9
+ 628010p -0.3
+ 630000p -0.3
+ 630010p 0.9
+ 632000p 0.9
+ 632010p -0.3
+ 634000p -0.3
+ 634010p 0.9
+ 636000p 0.9
+ 636010p -0.3
+ 638000p -0.3
+ 638010p 0.9
+ 640000p 0.9
+ 640010p -0.3
+ 642000p -0.3
+ 642010p 0.9
+ 644000p 0.9
+ 644010p -0.3
+ 646000p -0.3
+ 646010p 0.9
+ 648000p 0.9
+ 648010p -0.3
+ 650000p -0.3
+ 650010p 0.9
+ 652000p 0.9
+ 652010p -0.3
+ 654000p -0.3
+ 654010p 0.9
+ 656000p 0.9
+ 656010p -0.3
+ 658000p -0.3
+ 658010p 0.9
+ 660000p 0.9
+ 660010p -0.3
+ 662000p -0.3
+ 662010p 0.9
+ 664000p 0.9
+ 664010p -0.3
+ 666000p -0.3
+ 666010p 0.9
+ 668000p 0.9
+ 668010p -0.3
+ 670000p -0.3
+ 670010p 0.9
+ 672000p 0.9
+ 672010p -0.3
+ 674000p -0.3
+ 674010p 0.9
+ 676000p 0.9
+ 676010p -0.3
+ 678000p -0.3
+ 678010p 0.9
+ 680000p 0.9
+ 680010p -0.3
+ 682000p -0.3
+ 682010p 0.9
+ 684000p 0.9
+ 684010p -0.3
+ 686000p -0.3
+ 686010p 0.9
+ 688000p 0.9
+ 688010p -0.3
+ 690000p -0.3
+ 690010p 0.9
+ 692000p 0.9
+ 692010p -0.3
+ 694000p -0.3
+ 694010p 0.9
+ 696000p 0.9
+ 696010p -0.3
+ 698000p -0.3
+ 698010p 0.9
+ 700000p 0.9
+ 700010p -0.3
+ 702000p -0.3
+ 702010p 0.9
+ 704000p 0.9
+ 704010p -0.3
+ 706000p -0.3
+ 706010p 0.9
+ 708000p 0.9
+ 708010p -0.3
+ 710000p -0.3
+ 710010p 0.9
+ 712000p 0.9
+ 712010p -0.3
+ 714000p -0.3
+ 714010p 0.9
+ 716000p 0.9
+ 716010p -0.3
+ 718000p -0.3
+ 718010p 0.9
+ 720000p 0.9
+ 720010p -0.3
+ 722000p -0.3
+ 722010p 0.9
+ 724000p 0.9
+ 724010p -0.3
+ 726000p -0.3
+ 726010p 0.9
+ 728000p 0.9
+ 728010p -0.3
+ 730000p -0.3
+ 730010p 0.9
+ 732000p 0.9
+ 732010p -0.3
+ 734000p -0.3
+ 734010p 0.9
+ 736000p 0.9
+ 736010p -0.3
+ 738000p -0.3
+ 738010p 0.9
+ 740000p 0.9
+ 740010p -0.3
+ 742000p -0.3
+ 742010p 0.9
+ 744000p 0.9
+ 744010p -0.3
+ 746000p -0.3
+ 746010p 0.9
+ 748000p 0.9
+ 748010p -0.3
+ 750000p -0.3
+ 750010p 0.9
+ 752000p 0.9
+ 752010p -0.3
+ 754000p -0.3
+ 754010p 0.9
+ 756000p 0.9
+ 756010p -0.3
+ 758000p -0.3
+ 758010p 0.9
+ 760000p 0.9
+ 760010p -0.3
+ 762000p -0.3
+ 762010p 0.9
+ 764000p 0.9
+ 764010p -0.3
+ 766000p -0.3
+ 766010p 0.9
+ 768000p 0.9
+ 768010p -0.3
+ 770000p -0.3
+ 770010p 0.9
+ 772000p 0.9
+ 772010p -0.3
+ 774000p -0.3
+ 774010p 0.9
+ 776000p 0.9
+ 776010p -0.3
+ 778000p -0.3
+ 778010p 0.9
+ 780000p 0.9
+ 780010p -0.3
+ 782000p -0.3
+ 782010p 0.9
+ 784000p 0.9
+ 784010p -0.3
+ 786000p -0.3
+ 786010p 0.9
+ 788000p 0.9
+ 788010p -0.3
+ 790000p -0.3
+ 790010p 0.9
+ 792000p 0.9
+ 792010p -0.3
+ 794000p -0.3
+ 794010p 0.9
+ 796000p 0.9
+ 796010p -0.3
+ 798000p -0.3
+ 798010p 0.9
+ 800000p 0.9
+ 800010p -0.3
+ 802000p -0.3
+ 802010p 0.9
+ 804000p 0.9
+ 804010p -0.3
+ 806000p -0.3
+ 806010p 0.9
+ 808000p 0.9
+ 808010p -0.3
+ 810000p -0.3
+ 810010p 0.9
+ 812000p 0.9
+ 812010p -0.3
+ 814000p -0.3
+ 814010p 0.9
+ 816000p 0.9
+ 816010p -0.3
+ 818000p -0.3
+ 818010p 0.9
+ 820000p 0.9
+ 820010p -0.3
+ 822000p -0.3
+ 822010p 0.9
+ 824000p 0.9
+ 824010p -0.3
+ 826000p -0.3
+ 826010p 0.9
+ 828000p 0.9
+ 828010p -0.3
+ 830000p -0.3
+ 830010p 0.9
+ 832000p 0.9
+ 832010p -0.3
+ 834000p -0.3
+ 834010p 0.9
+ 836000p 0.9
+ 836010p -0.3
+ 838000p -0.3
+ 838010p 0.9
+ 840000p 0.9
+ 840010p -0.3
+ 842000p -0.3
+ 842010p 0.9
+ 844000p 0.9
+ 844010p -0.3
+ 846000p -0.3
+ 846010p 0.9
+ 848000p 0.9
+ 848010p -0.3
+ 850000p -0.3
+ 850010p 0.9
+ 852000p 0.9
+ 852010p -0.3
+ 854000p -0.3
+ 854010p 0.9
+ 856000p 0.9
+ 856010p -0.3
+ 858000p -0.3
+ 858010p 0.9
+ 860000p 0.9
+ 860010p -0.3
+ 862000p -0.3
+ 862010p 0.9
+ 864000p 0.9
+ 864010p -0.3
+ 866000p -0.3
+ 866010p 0.9
+ 868000p 0.9
+ 868010p -0.3
+ 870000p -0.3
+ 870010p 0.9
+ 872000p 0.9
+ 872010p -0.3
+ 874000p -0.3
+ 874010p 0.9
+ 876000p 0.9
+ 876010p -0.3
+ 878000p -0.3
+ 878010p 0.9
+ 880000p 0.9
+ 880010p -0.3
+ 882000p -0.3
+ 882010p 0.9
+ 884000p 0.9
+ 884010p -0.3
+ 886000p -0.3
+ 886010p 0.9
+ 888000p 0.9
+ 888010p -0.3
+ 890000p -0.3
+ 890010p 0.9
+ 892000p 0.9
+ 892010p -0.3
+ 894000p -0.3
+ 894010p 0.9
+ 896000p 0.9
+ 896010p -0.3
+ 898000p -0.3
+ 898010p 0.9
+ 900000p 0.9
+ 900010p -0.3
+ 902000p -0.3
+ 902010p 0.9
+ 904000p 0.9
+ 904010p -0.3
+ 906000p -0.3
+ 906010p 0.9
+ 908000p 0.9
+ 908010p -0.3
+ 910000p -0.3
+ 910010p 0.9
+ 912000p 0.9
+ 912010p -0.3
+ 914000p -0.3
+ 914010p 0.9
+ 916000p 0.9
+ 916010p -0.3
+ 918000p -0.3
+ 918010p 0.9
+ 920000p 0.9
+ 920010p -0.3
+ 922000p -0.3
+ 922010p 0.9
+ 924000p 0.9
+ 924010p -0.3
+ 926000p -0.3
+ 926010p 0.9
+ 928000p 0.9
+ 928010p -0.3
+ 930000p -0.3
+ 930010p 0.9
+ 932000p 0.9
+ 932010p -0.3
+ 934000p -0.3
+ 934010p 0.9
+ 936000p 0.9
+ 936010p -0.3
+ 938000p -0.3
+ 938010p 0.9
+ 940000p 0.9
+ 940010p -0.3
+ 942000p -0.3
+ 942010p 0.9
+ 944000p 0.9
+ 944010p -0.3
+ 946000p -0.3
+ 946010p 0.9
+ 948000p 0.9
+ 948010p -0.3
+ 950000p -0.3
+ 950010p 0.9
+ 952000p 0.9
+ 952010p -0.3
+ 954000p -0.3
+ 954010p 0.9
+ 956000p 0.9
+ 956010p -0.3
+ 958000p -0.3
+ 958010p 0.9
+ 960000p 0.9
+ 960010p -0.3
+ 962000p -0.3
+ 962010p 0.9
+ 964000p 0.9
+ 964010p -0.3
+ 966000p -0.3
+ 966010p 0.9
+ 968000p 0.9
+ 968010p -0.3
+ 970000p -0.3
+ 970010p 0.9
+ 972000p 0.9
+ 972010p -0.3
+ 974000p -0.3
+ 974010p 0.9
+ 976000p 0.9
+ 976010p -0.3
+ 978000p -0.3
+ 978010p 0.9
+ 980000p 0.9
+ 980010p -0.3
+ 982000p -0.3
+ 982010p 0.9
+ 984000p 0.9
+ 984010p -0.3
+ 986000p -0.3
+ 986010p 0.9
+ 988000p 0.9
+ 988010p -0.3
+ 990000p -0.3
+ 990010p 0.9
+ 992000p 0.9
+ 992010p -0.3
+ 994000p -0.3
+ 994010p 0.9
+ 996000p 0.9
+ 996010p -0.3
+ 998000p -0.3
+ 998010p 0.9
+ 1000000p 0.9
+ 1000010p -0.3
+ 1002000p -0.3
+ 1002010p 0.9
+ 1004000p 0.9
+ 1004010p -0.3
+ 1006000p -0.3
+ 1006010p 0.9
+ 1008000p 0.9
+ 1008010p -0.3
+ 1010000p -0.3
+ 1010010p 0.9
+ 1012000p 0.9
+ 1012010p -0.3
+ 1014000p -0.3
+ 1014010p 0.9
+ 1016000p 0.9
+ 1016010p -0.3
+ 1018000p -0.3
+ 1018010p 0.9
+ 1020000p 0.9
+ 1020010p -0.3
+ 1022000p -0.3
+ 1022010p 0.9
+ 1024000p 0.9
+ 1024010p -0.3
+ 1026000p -0.3
+ 1026010p 0.9
+ 1028000p 0.9
+ 1028010p -0.3
+ 1030000p -0.3
+ 1030010p 0.9
+ 1032000p 0.9
+ 1032010p -0.3
+ 1034000p -0.3
+ 1034010p 0.9
+ 1036000p 0.9
+ 1036010p -0.3
+ 1038000p -0.3
+ 1038010p 0.9
+ 1040000p 0.9
+ 1040010p -0.3
+ 1042000p -0.3
+ 1042010p 0.9
+ 1044000p 0.9
+ 1044010p -0.3
+ 1046000p -0.3
+ 1046010p 0.9
+ 1048000p 0.9
+ 1048010p -0.3
+ 1050000p -0.3
+ 1050010p 0.9
+ 1052000p 0.9
+ 1052010p -0.3
+ 1054000p -0.3
+ 1054010p 0.9
+ 1056000p 0.9
+ 1056010p -0.3
+ 1058000p -0.3
+ 1058010p 0.9
+ 1060000p 0.9
+ 1060010p -0.3
+ 1062000p -0.3
+ 1062010p 0.9
+ 1064000p 0.9
+ 1064010p -0.3
+ 1066000p -0.3
+ 1066010p 0.9
+ 1068000p 0.9
+ 1068010p -0.3
+ 1070000p -0.3
+ 1070010p 0.9
+ 1072000p 0.9
+ 1072010p -0.3
+ 1074000p -0.3
+ 1074010p 0.9
+ 1076000p 0.9
+ 1076010p -0.3
+ 1078000p -0.3
+ 1078010p 0.9
+ 1080000p 0.9
+ 1080010p -0.3
+ 1082000p -0.3
+ 1082010p 0.9
+ 1084000p 0.9
+ 1084010p -0.3
+ 1086000p -0.3
+ 1086010p 0.9
+ 1088000p 0.9
+ 1088010p -0.3
+ 1090000p -0.3
+ 1090010p 0.9
+ 1092000p 0.9
+ 1092010p -0.3
+ 1094000p -0.3
+ 1094010p 0.9
+ 1096000p 0.9
+ 1096010p -0.3
+ 1098000p -0.3
+ 1098010p 0.9
+ 1100000p 0.9
+ 1100010p -0.3
+ 1102000p -0.3
+ 1102010p 0.9
+ 1104000p 0.9
+ 1104010p -0.3
+ 1106000p -0.3
+ 1106010p 0.9
+ 1108000p 0.9
+ 1108010p -0.3
+ 1110000p -0.3
+ 1110010p 0.9
+ 1112000p 0.9
+ 1112010p -0.3
+ 1114000p -0.3
+ 1114010p 0.9
+ 1116000p 0.9
+ 1116010p -0.3
+ 1118000p -0.3
+ 1118010p 0.9
+ 1120000p 0.9
+ 1120010p -0.3
+ 1122000p -0.3
+ 1122010p 0.9
+ 1124000p 0.9
+ 1124010p -0.3
+ 1126000p -0.3
+ 1126010p 0.9
+ 1128000p 0.9
+ 1128010p -0.3
+ 1130000p -0.3
+ 1130010p 0.9
+ 1132000p 0.9
+ 1132010p -0.3
+ 1134000p -0.3
+ 1134010p 0.9
+ 1136000p 0.9
+ 1136010p -0.3
+ 1138000p -0.3
+ 1138010p 0.9
+ 1140000p 0.9
+ 1140010p -0.3
+ 1142000p -0.3
+ 1142010p 0.9
+ 1144000p 0.9
+ 1144010p -0.3
+ 1146000p -0.3
+ 1146010p 0.9
+ 1148000p 0.9
+ 1148010p -0.3
+ 1150000p -0.3
+ 1150010p 0.9
+ 1152000p 0.9
+ 1152010p -0.3
+ 1154000p -0.3
+ 1154010p 0.9
+ 1156000p 0.9
+ 1156010p -0.3
+ 1158000p -0.3
+ 1158010p 0.9
+ 1160000p 0.9
+ 1160010p -0.3
+ 1162000p -0.3
+ 1162010p 0.9
+ 1164000p 0.9
+ 1164010p -0.3
+ 1166000p -0.3
+ 1166010p 0.9
+ 1168000p 0.9
+ 1168010p -0.3
+ 1170000p -0.3
+ 1170010p 0.9
+ 1172000p 0.9
+ 1172010p -0.3
+ 1174000p -0.3
+ 1174010p 0.9
+ 1176000p 0.9
+ 1176010p -0.3
+ 1178000p -0.3
+ 1178010p 0.9
+ 1180000p 0.9
+ 1180010p -0.3
+ 1182000p -0.3
+ 1182010p 0.9
+ 1184000p 0.9
+ 1184010p -0.3
+ 1186000p -0.3
+ 1186010p 0.9
+ 1188000p 0.9
+ 1188010p -0.3
+ 1190000p -0.3
+ 1190010p 0.9
+ 1192000p 0.9
+ 1192010p -0.3
+ 1194000p -0.3
+ 1194010p 0.9
+ 1196000p 0.9
+ 1196010p -0.3
+ 1198000p -0.3
+ 1198010p 0.9
+ 1200000p 0.9
+ 1200010p -0.3
+ 1202000p -0.3
+ 1202010p 0.9
+ 1204000p 0.9
+ 1204010p -0.3
+ 1206000p -0.3
+ 1206010p 0.9
+ 1208000p 0.9
+ 1208010p -0.3
+ 1210000p -0.3
+ 1210010p 0.9
+ 1212000p 0.9
+ 1212010p -0.3
+ 1214000p -0.3
+ 1214010p 0.9
+ 1216000p 0.9
+ 1216010p -0.3
+ 1218000p -0.3
+ 1218010p 0.9
+ 1220000p 0.9
+ 1220010p -0.3
+ 1222000p -0.3
+ 1222010p 0.9
+ 1224000p 0.9
+ 1224010p -0.3
+ 1226000p -0.3
+ 1226010p 0.9
+ 1228000p 0.9
+ 1228010p -0.3
+ 1230000p -0.3
+ 1230010p 0.9
+ 1232000p 0.9
+ 1232010p -0.3
+ 1234000p -0.3
+ 1234010p 0.9
+ 1236000p 0.9
+ 1236010p -0.3
+ 1238000p -0.3
+ 1238010p 0.9
+ 1240000p 0.9
+ 1240010p -0.3
+ 1242000p -0.3
+ 1242010p 0.9
+ 1244000p 0.9
+ 1244010p -0.3
+ 1246000p -0.3
+ 1246010p 0.9
+ 1248000p 0.9
+ 1248010p -0.3
+ 1250000p -0.3
+ 1250010p 0.9
+ 1252000p 0.9
+ 1252010p -0.3
+ 1254000p -0.3
+ 1254010p 0.9
+ 1256000p 0.9
+ 1256010p -0.3
+ 1258000p -0.3
+ 1258010p 0.9
+ 1260000p 0.9
+ 1260010p -0.3
+ 1262000p -0.3
+ 1262010p 0.9
+ 1264000p 0.9
+ 1264010p -0.3
+ 1266000p -0.3
+ 1266010p 0.9
+ 1268000p 0.9
+ 1268010p -0.3
+ 1270000p -0.3
+ 1270010p 0.9
+ 1272000p 0.9
+ 1272010p -0.3
+ 1274000p -0.3
+ 1274010p 0.9
+ 1276000p 0.9
+ 1276010p -0.3
+ 1278000p -0.3
+ 1278010p 0.9
+ 1280000p 0.9
+ 1280010p -0.3
+ 1282000p -0.3
+ 1282010p 0.9
+ 1284000p 0.9
+ 1284010p -0.3
+ 1286000p -0.3
+ 1286010p 0.9
+ 1288000p 0.9
+ 1288010p -0.3
+ 1290000p -0.3
+ 1290010p 0.9
+ 1292000p 0.9
+ 1292010p -0.3
+ 1294000p -0.3
+ 1294010p 0.9
+ 1296000p 0.9
+ 1296010p -0.3
+ 1298000p -0.3
+ 1298010p 0.9
+ 1300000p 0.9
+ 1300010p -0.3
+ 1302000p -0.3
+ 1302010p 0.9
+ 1304000p 0.9
+ 1304010p -0.3
+ 1306000p -0.3
+ 1306010p 0.9
+ 1308000p 0.9
+ 1308010p -0.3
+ 1310000p -0.3
+ 1310010p 0.9
+ 1312000p 0.9
+ 1312010p -0.3
+ 1314000p -0.3
+ 1314010p 0.9
+ 1316000p 0.9
+ 1316010p -0.3
+ 1318000p -0.3
+ 1318010p 0.9
+ 1320000p 0.9
+ 1320010p -0.3
+ 1322000p -0.3
+ 1322010p 0.9
+ 1324000p 0.9
+ 1324010p -0.3
+ 1326000p -0.3
+ 1326010p 0.9
+ 1328000p 0.9
+ 1328010p -0.3
+ 1330000p -0.3
+ 1330010p 0.9
+ 1332000p 0.9
+ 1332010p -0.3
+ 1334000p -0.3
+ 1334010p 0.9
+ 1336000p 0.9
+ 1336010p -0.3
+ 1338000p -0.3
+ 1338010p 0.9
+ 1340000p 0.9
+ 1340010p -0.3
+ 1342000p -0.3
+ 1342010p 0.9
+ 1344000p 0.9
+ 1344010p -0.3
+ 1346000p -0.3
+ 1346010p 0.9
+ 1348000p 0.9
+ 1348010p -0.3
+ 1350000p -0.3
+ 1350010p 0.9
+ 1352000p 0.9
+ 1352010p -0.3
+ 1354000p -0.3
+ 1354010p 0.9
+ 1356000p 0.9
+ 1356010p -0.3
+ 1358000p -0.3
+ 1358010p 0.9
+ 1360000p 0.9
+ 1360010p -0.3
+ 1362000p -0.3
+ 1362010p 0.9
+ 1364000p 0.9
+ 1364010p -0.3
+ 1366000p -0.3
+ 1366010p 0.9
+ 1368000p 0.9
+ 1368010p -0.3
+ 1370000p -0.3
+ 1370010p 0.9
+ 1372000p 0.9
+ 1372010p -0.3
+ 1374000p -0.3
+ 1374010p 0.9
+ 1376000p 0.9
+ 1376010p -0.3
+ 1378000p -0.3
+ 1378010p 0.9
+ 1380000p 0.9
+ 1380010p -0.3
+ 1382000p -0.3
+ 1382010p 0.9
+ 1384000p 0.9
+ 1384010p -0.3
+ 1386000p -0.3
+ 1386010p 0.9
+ 1388000p 0.9
+ 1388010p -0.3
+ 1390000p -0.3
+ 1390010p 0.9
+ 1392000p 0.9
+ 1392010p -0.3
+ 1394000p -0.3
+ 1394010p 0.9
+ 1396000p 0.9
+ 1396010p -0.3
+ 1398000p -0.3
+ 1398010p 0.9
+ 1400000p 0.9
+ 1400010p -0.3
+ 1402000p -0.3
+ 1402010p 0.9
+ 1404000p 0.9
+ 1404010p -0.3
+ 1406000p -0.3
+ 1406010p 0.9
+ 1408000p 0.9
+ 1408010p -0.3
+ 1410000p -0.3
+ 1410010p 0.9
+ 1412000p 0.9
+ 1412010p -0.3
+ 1414000p -0.3
+ 1414010p 0.9
+ 1416000p 0.9
+ 1416010p -0.3
+ 1418000p -0.3
+ 1418010p 0.9
+ 1420000p 0.9
+ 1420010p -0.3
+ 1422000p -0.3
+ 1422010p 0.9
+ 1424000p 0.9
+ 1424010p -0.3
+ 1426000p -0.3
+ 1426010p 0.9
+ 1428000p 0.9
+ 1428010p -0.3
+ 1430000p -0.3
+ 1430010p 0.9
+ 1432000p 0.9
+ 1432010p -0.3
+ 1434000p -0.3
+ 1434010p 0.9
+ 1436000p 0.9
+ 1436010p -0.3
+ 1438000p -0.3
+ 1438010p 0.9
+ 1440000p 0.9
+ 1440010p -0.3
+ 1442000p -0.3
+ 1442010p 0.9
+ 1444000p 0.9
+ 1444010p -0.3
+ 1446000p -0.3
+ 1446010p 0.9
+ 1448000p 0.9
+ 1448010p -0.3
+ 1450000p -0.3
+ 1450010p 0.9
+ 1452000p 0.9
+ 1452010p -0.3
+ 1454000p -0.3
+ 1454010p 0.9
+ 1456000p 0.9
+ 1456010p -0.3
+ 1458000p -0.3
+ 1458010p 0.9
+ 1460000p 0.9
+ 1460010p -0.3
+ 1462000p -0.3
+ 1462010p 0.9
+ 1464000p 0.9
+ 1464010p -0.3
+ 1466000p -0.3
+ 1466010p 0.9
+ 1468000p 0.9
+ 1468010p -0.3
+ 1470000p -0.3
+ 1470010p 0.9
+ 1472000p 0.9
+ 1472010p -0.3
+ 1474000p -0.3
+ 1474010p 0.9
+ 1476000p 0.9
+ 1476010p -0.3
+ 1478000p -0.3
+ 1478010p 0.9
+ 1480000p 0.9
+ 1480010p -0.3
+ 1482000p -0.3
+ 1482010p 0.9
+ 1484000p 0.9
+ 1484010p -0.3
+ 1486000p -0.3
+ 1486010p 0.9
+ 1488000p 0.9
+ 1488010p -0.3
+ 1490000p -0.3
+ 1490010p 0.9
+ 1492000p 0.9
+ 1492010p -0.3
+ 1494000p -0.3
+ 1494010p 0.9
+ 1496000p 0.9
+ 1496010p -0.3
+ 1498000p -0.3
+ 1498010p 0.9
+ 1500000p 0.9
+ 1500010p -0.3
+ 1502000p -0.3
+ 1502010p 0.9
+ 1504000p 0.9
+ 1504010p -0.3
+ 1506000p -0.3
+ 1506010p 0.9
+ 1508000p 0.9
+ 1508010p -0.3
+ 1510000p -0.3
+ 1510010p 0.9
+ 1512000p 0.9
+ 1512010p -0.3
+ 1514000p -0.3
+ 1514010p 0.9
+ 1516000p 0.9
+ 1516010p -0.3
+ 1518000p -0.3
+ 1518010p 0.9
+ 1520000p 0.9
+ 1520010p -0.3
+ 1522000p -0.3
+ 1522010p 0.9
+ 1524000p 0.9
+ 1524010p -0.3
+ 1526000p -0.3
+ 1526010p 0.9
+ 1528000p 0.9
+ 1528010p -0.3
+ 1530000p -0.3
+ 1530010p 0.9
+ 1532000p 0.9
+ 1532010p -0.3
+ 1534000p -0.3
+ 1534010p 0.9
+ 1536000p 0.9
+ 1536010p -0.3
+ 1538000p -0.3
+ 1538010p 0.9
+ 1540000p 0.9
+ 1540010p -0.3
+ 1542000p -0.3
+ 1542010p 0.9
+ 1544000p 0.9
+ 1544010p -0.3
+ 1546000p -0.3
+ 1546010p 0.9
+ 1548000p 0.9
+ 1548010p -0.3
+ 1550000p -0.3
+ 1550010p 0.9
+ 1552000p 0.9
+ 1552010p -0.3
+ 1554000p -0.3
+ 1554010p 0.9
+ 1556000p 0.9
+ 1556010p -0.3
+ 1558000p -0.3
+ 1558010p 0.9
+ 1560000p 0.9
+ 1560010p -0.3
+ 1562000p -0.3
+ 1562010p 0.9
+ 1564000p 0.9
+ 1564010p -0.3
+ 1566000p -0.3
+ 1566010p 0.9
+ 1568000p 0.9
+ 1568010p -0.3
+ 1570000p -0.3
+ 1570010p 0.9
+ 1572000p 0.9
+ 1572010p -0.3
+ 1574000p -0.3
+ 1574010p 0.9
+ 1576000p 0.9
+ 1576010p -0.3
+ 1578000p -0.3
+ 1578010p 0.9
+ 1580000p 0.9
+ 1580010p -0.3
+ 1582000p -0.3
+ 1582010p 0.9
+ 1584000p 0.9
+ 1584010p -0.3
+ 1586000p -0.3
+ 1586010p 0.9
+ 1588000p 0.9
+ 1588010p -0.3
+ 1590000p -0.3
+ 1590010p 0.9
+ 1592000p 0.9
+ 1592010p -0.3
+ 1594000p -0.3
+ 1594010p 0.9
+ 1596000p 0.9
+ 1596010p -0.3
+ 1598000p -0.3
+ 1598010p 0.9
+ 1600000p 0.9
+ 1600010p -0.3
+ 1602000p -0.3
+ 1602010p 0.9
+ 1604000p 0.9
+ 1604010p -0.3
+ 1606000p -0.3
+ 1606010p 0.9
+ 1608000p 0.9
+ 1608010p -0.3
+ 1610000p -0.3
+ 1610010p 0.9
+ 1612000p 0.9
+ 1612010p -0.3
+ 1614000p -0.3
+ 1614010p 0.9
+ 1616000p 0.9
+ 1616010p -0.3
+ 1618000p -0.3
+ 1618010p 0.9
+ 1620000p 0.9
+ 1620010p -0.3
+ 1622000p -0.3
+ 1622010p 0.9
+ 1624000p 0.9
+ 1624010p -0.3
+ 1626000p -0.3
+ 1626010p 0.9
+ 1628000p 0.9
+ 1628010p -0.3
+ 1630000p -0.3
+ 1630010p 0.9
+ 1632000p 0.9
+ 1632010p -0.3
+ 1634000p -0.3
+ 1634010p 0.9
+ 1636000p 0.9
+ 1636010p -0.3
+ 1638000p -0.3
+ 1638010p 0.9
+ 1640000p 0.9
+ 1640010p -0.3
+ 1642000p -0.3
+ 1642010p 0.9
+ 1644000p 0.9
+ 1644010p -0.3
+ 1646000p -0.3
+ 1646010p 0.9
+ 1648000p 0.9
+ 1648010p -0.3
+ 1650000p -0.3
+ 1650010p 0.9
+ 1652000p 0.9
+ 1652010p -0.3
+ 1654000p -0.3
+ 1654010p 0.9
+ 1656000p 0.9
+ 1656010p -0.3
+ 1658000p -0.3
+ 1658010p 0.9
+ 1660000p 0.9
+ 1660010p -0.3
+ 1662000p -0.3
+ 1662010p 0.9
+ 1664000p 0.9
+ 1664010p -0.3
+ 1666000p -0.3
+ 1666010p 0.9
+ 1668000p 0.9
+ 1668010p -0.3
+ 1670000p -0.3
+ 1670010p 0.9
+ 1672000p 0.9
+ 1672010p -0.3
+ 1674000p -0.3
+ 1674010p 0.9
+ 1676000p 0.9
+ 1676010p -0.3
+ 1678000p -0.3
+ 1678010p 0.9
+ 1680000p 0.9
+ 1680010p -0.3
+ 1682000p -0.3
+ 1682010p 0.9
+ 1684000p 0.9
+ 1684010p -0.3
+ 1686000p -0.3
+ 1686010p 0.9
+ 1688000p 0.9
+ 1688010p -0.3
+ 1690000p -0.3
+ 1690010p 0.9
+ 1692000p 0.9
+ 1692010p -0.3
+ 1694000p -0.3
+ 1694010p 0.9
+ 1696000p 0.9
+ 1696010p -0.3
+ 1698000p -0.3
+ 1698010p 0.9
+ 1700000p 0.9
+ 1700010p -0.3
+ 1702000p -0.3
+ 1702010p 0.9
+ 1704000p 0.9
+ 1704010p -0.3
+ 1706000p -0.3
+ 1706010p 0.9
+ 1708000p 0.9
+ 1708010p -0.3
+ 1710000p -0.3
+ 1710010p 0.9
+ 1712000p 0.9
+ 1712010p -0.3
+ 1714000p -0.3
+ 1714010p 0.9
+ 1716000p 0.9
+ 1716010p -0.3
+ 1718000p -0.3
+ 1718010p 0.9
+ 1720000p 0.9
+ 1720010p -0.3
+ 1722000p -0.3
+ 1722010p 0.9
+ 1724000p 0.9
+ 1724010p -0.3
+ 1726000p -0.3
+ 1726010p 0.9
+ 1728000p 0.9
+ 1728010p -0.3
+ 1730000p -0.3
+ 1730010p 0.9
+ 1732000p 0.9
+ 1732010p -0.3
+ 1734000p -0.3
+ 1734010p 0.9
+ 1736000p 0.9
+ 1736010p -0.3
+ 1738000p -0.3
+ 1738010p 0.9
+ 1740000p 0.9
+ 1740010p -0.3
+ 1742000p -0.3
+ 1742010p 0.9
+ 1744000p 0.9
+ 1744010p -0.3
+ 1746000p -0.3
+ 1746010p 0.9
+ 1748000p 0.9
+ 1748010p -0.3
+ 1750000p -0.3
+ 1750010p 0.9
+ 1752000p 0.9
+ 1752010p -0.3
+ 1754000p -0.3
+ 1754010p 0.9
+ 1756000p 0.9
+ 1756010p -0.3
+ 1758000p -0.3
+ 1758010p 0.9
+ 1760000p 0.9
+ 1760010p -0.3
+ 1762000p -0.3
+ 1762010p 0.9
+ 1764000p 0.9
+ 1764010p -0.3
+ 1766000p -0.3
+ 1766010p 0.9
+ 1768000p 0.9
+ 1768010p -0.3
+ 1770000p -0.3
+ 1770010p 0.9
+ 1772000p 0.9
+ 1772010p -0.3
+ 1774000p -0.3
+ 1774010p 0.9
+ 1776000p 0.9
+ 1776010p -0.3
+ 1778000p -0.3
+ 1778010p 0.9
+ 1780000p 0.9
+ 1780010p -0.3
+ 1782000p -0.3
+ 1782010p 0.9
+ 1784000p 0.9
+ 1784010p -0.3
+ 1786000p -0.3
+ 1786010p 0.9
+ 1788000p 0.9
+ 1788010p -0.3
+ 1790000p -0.3
+ 1790010p 0.9
+ 1792000p 0.9
+ 1792010p -0.3
+ 1794000p -0.3
+ 1794010p 0.9
+ 1796000p 0.9
+ 1796010p -0.3
+ 1798000p -0.3
+ 1798010p 0.9
+ 1800000p 0.9
+ 1800010p -0.3
+ 1802000p -0.3
+ 1802010p 0.9
+ 1804000p 0.9
+ 1804010p -0.3
+ 1806000p -0.3
+ 1806010p 0.9
+ 1808000p 0.9
+ 1808010p -0.3
+ 1810000p -0.3
+ 1810010p 0.9
+ 1812000p 0.9
+ 1812010p -0.3
+ 1814000p -0.3
+ 1814010p 0.9
+ 1816000p 0.9
+ 1816010p -0.3
+ 1818000p -0.3
+ 1818010p 0.9
+ 1820000p 0.9
+ 1820010p -0.3
+ 1822000p -0.3
+ 1822010p 0.9
+ 1824000p 0.9
+ 1824010p -0.3
+ 1826000p -0.3
+ 1826010p 0.9
+ 1828000p 0.9
+ 1828010p -0.3
+ 1830000p -0.3
+ 1830010p 0.9
+ 1832000p 0.9
+ 1832010p -0.3
+ 1834000p -0.3
+ 1834010p 0.9
+ 1836000p 0.9
+ 1836010p -0.3
+ 1838000p -0.3
+ 1838010p 0.9
+ 1840000p 0.9
+ 1840010p -0.3
+ 1842000p -0.3
+ 1842010p 0.9
+ 1844000p 0.9
+ 1844010p -0.3
+ 1846000p -0.3
+ 1846010p 0.9
+ 1848000p 0.9
+ 1848010p -0.3
+ 1850000p -0.3
+ 1850010p 0.9
+ 1852000p 0.9
+ 1852010p -0.3
+ 1854000p -0.3
+ 1854010p 0.9
+ 1856000p 0.9
+ 1856010p -0.3
+ 1858000p -0.3
+ 1858010p 0.9
+ 1860000p 0.9
+ 1860010p -0.3
+ 1862000p -0.3
+ 1862010p 0.9
+ 1864000p 0.9
+ 1864010p -0.3
+ 1866000p -0.3
+ 1866010p 0.9
+ 1868000p 0.9
+ 1868010p -0.3
+ 1870000p -0.3
+ 1870010p 0.9
+ 1872000p 0.9
+ 1872010p -0.3
+ 1874000p -0.3
+ 1874010p 0.9
+ 1876000p 0.9
+ 1876010p -0.3
+ 1878000p -0.3
+ 1878010p 0.9
+ 1880000p 0.9
+ 1880010p -0.3
+ 1882000p -0.3
+ 1882010p 0.9
+ 1884000p 0.9
+ 1884010p -0.3
+ 1886000p -0.3
+ 1886010p 0.9
+ 1888000p 0.9
+ 1888010p -0.3
+ 1890000p -0.3
+ 1890010p 0.9
+ 1892000p 0.9
+ 1892010p -0.3
+ 1894000p -0.3
+ 1894010p 0.9
+ 1896000p 0.9
+ 1896010p -0.3
+ 1898000p -0.3
+ 1898010p 0.9
+ 1900000p 0.9
+ 1900010p -0.3
+ 1902000p -0.3
+ 1902010p 0.9
+ 1904000p 0.9
+ 1904010p -0.3
+ 1906000p -0.3
+ 1906010p 0.9
+ 1908000p 0.9
+ 1908010p -0.3
+ 1910000p -0.3
+ 1910010p 0.9
+ 1912000p 0.9
+ 1912010p -0.3
+ 1914000p -0.3
+ 1914010p 0.9
+ 1916000p 0.9
+ 1916010p -0.3
+ 1918000p -0.3
+ 1918010p 0.9
+ 1920000p 0.9
+ 1920010p -0.3
+ 1922000p -0.3
+ 1922010p 0.9
+ 1924000p 0.9
+ 1924010p -0.3
+ 1926000p -0.3
+ 1926010p 0.9
+ 1928000p 0.9
+ 1928010p -0.3
+ 1930000p -0.3
+ 1930010p 0.9
+ 1932000p 0.9
+ 1932010p -0.3
+ 1934000p -0.3
+ 1934010p 0.9
+ 1936000p 0.9
+ 1936010p -0.3
+ 1938000p -0.3
+ 1938010p 0.9
+ 1940000p 0.9
+ 1940010p -0.3
+ 1942000p -0.3
+ 1942010p 0.9
+ 1944000p 0.9
+ 1944010p -0.3
+ 1946000p -0.3
+ 1946010p 0.9
+ 1948000p 0.9
+ 1948010p -0.3
+ 1950000p -0.3
+ 1950010p 0.9
+ 1952000p 0.9
+ 1952010p -0.3
+ 1954000p -0.3
+ 1954010p 0.9
+ 1956000p 0.9
+ 1956010p -0.3
+ 1958000p -0.3
+ 1958010p 0.9
+ 1960000p 0.9
+ 1960010p -0.3
+ 1962000p -0.3
+ 1962010p 0.9
+ 1964000p 0.9
+ 1964010p -0.3
+ 1966000p -0.3
+ 1966010p 0.9
+ 1968000p 0.9
+ 1968010p -0.3
+ 1970000p -0.3
+ 1970010p 0.9
+ 1972000p 0.9
+ 1972010p -0.3
+ 1974000p -0.3
+ 1974010p 0.9
+ 1976000p 0.9
+ 1976010p -0.3
+ 1978000p -0.3
+ 1978010p 0.9
+ 1980000p 0.9
+ 1980010p -0.3
+ 1982000p -0.3
+ 1982010p 0.9
+ 1984000p 0.9
+ 1984010p -0.3
+ 1986000p -0.3
+ 1986010p 0.9
+ 1988000p 0.9
+ 1988010p -0.3
+ 1990000p -0.3
+ 1990010p 0.9
+ 1992000p 0.9
+ 1992010p -0.3
+ 1994000p -0.3
+ 1994010p 0.9
+ 1996000p 0.9
+ 1996010p -0.3
+ 1998000p -0.3
+ 1998010p 0.9
+ 2000000p 0.9
+ 2000010p -0.3
+ 2002000p -0.3
+ 2002010p 0.9
+ 2004000p 0.9
+ 2004010p -0.3
+ 2006000p -0.3
+ 2006010p 0.9
+ 2008000p 0.9
+ 2008010p -0.3
+ 2010000p -0.3
+ 2010010p 0.9
+ 2012000p 0.9
+ 2012010p -0.3
+ 2014000p -0.3
+ 2014010p 0.9
+ 2016000p 0.9
+ 2016010p -0.3
+ 2018000p -0.3
+ 2018010p 0.9
+ 2020000p 0.9
+ 2020010p -0.3
+ 2022000p -0.3
+ 2022010p 0.9
+ 2024000p 0.9
+ 2024010p -0.3
+ 2026000p -0.3
+ 2026010p 0.9
+ 2028000p 0.9
+ 2028010p -0.3
+ 2030000p -0.3
+ 2030010p 0.9
+ 2032000p 0.9
+ 2032010p -0.3
+ 2034000p -0.3
+ 2034010p 0.9
+ 2036000p 0.9
+ 2036010p -0.3
+ 2038000p -0.3
+ 2038010p 0.9
+ 2040000p 0.9
+ 2040010p -0.3
+ 2042000p -0.3
+ 2042010p 0.9
+ 2044000p 0.9
+ 2044010p -0.3
+ 2046000p -0.3
+ 2046010p 0.9
+ 2048000p 0.9
+ 2048010p -0.3
+ \]
V_data_15 (Data\\<15\\> gnd!) vsource type=pwl wave=\[
+ 0    0.9
+ 2000p 0.9
+ 2010p -0.3
+ 4000p -0.3
+ 4010p 0.9
+ 6000p 0.9
+ 6010p -0.3
+ 8000p -0.3
+ 8010p 0.9
+ 10000p 0.9
+ 10010p -0.3
+ 12000p -0.3
+ 12010p 0.9
+ 14000p 0.9
+ 14010p -0.3
+ 16000p -0.3
+ 16010p 0.9
+ 18000p 0.9
+ 18010p -0.3
+ 20000p -0.3
+ 20010p 0.9
+ 22000p 0.9
+ 22010p -0.3
+ 24000p -0.3
+ 24010p 0.9
+ 26000p 0.9
+ 26010p -0.3
+ 28000p -0.3
+ 28010p 0.9
+ 30000p 0.9
+ 30010p -0.3
+ 32000p -0.3
+ 32010p 0.9
+ 34000p 0.9
+ 34010p -0.3
+ 36000p -0.3
+ 36010p 0.9
+ 38000p 0.9
+ 38010p -0.3
+ 40000p -0.3
+ 40010p 0.9
+ 42000p 0.9
+ 42010p -0.3
+ 44000p -0.3
+ 44010p 0.9
+ 46000p 0.9
+ 46010p -0.3
+ 48000p -0.3
+ 48010p 0.9
+ 50000p 0.9
+ 50010p -0.3
+ 52000p -0.3
+ 52010p 0.9
+ 54000p 0.9
+ 54010p -0.3
+ 56000p -0.3
+ 56010p 0.9
+ 58000p 0.9
+ 58010p -0.3
+ 60000p -0.3
+ 60010p 0.9
+ 62000p 0.9
+ 62010p -0.3
+ 64000p -0.3
+ 64010p 0.9
+ 66000p 0.9
+ 66010p -0.3
+ 68000p -0.3
+ 68010p 0.9
+ 70000p 0.9
+ 70010p -0.3
+ 72000p -0.3
+ 72010p 0.9
+ 74000p 0.9
+ 74010p -0.3
+ 76000p -0.3
+ 76010p 0.9
+ 78000p 0.9
+ 78010p -0.3
+ 80000p -0.3
+ 80010p 0.9
+ 82000p 0.9
+ 82010p -0.3
+ 84000p -0.3
+ 84010p 0.9
+ 86000p 0.9
+ 86010p -0.3
+ 88000p -0.3
+ 88010p 0.9
+ 90000p 0.9
+ 90010p -0.3
+ 92000p -0.3
+ 92010p 0.9
+ 94000p 0.9
+ 94010p -0.3
+ 96000p -0.3
+ 96010p 0.9
+ 98000p 0.9
+ 98010p -0.3
+ 100000p -0.3
+ 100010p 0.9
+ 102000p 0.9
+ 102010p -0.3
+ 104000p -0.3
+ 104010p 0.9
+ 106000p 0.9
+ 106010p -0.3
+ 108000p -0.3
+ 108010p 0.9
+ 110000p 0.9
+ 110010p -0.3
+ 112000p -0.3
+ 112010p 0.9
+ 114000p 0.9
+ 114010p -0.3
+ 116000p -0.3
+ 116010p 0.9
+ 118000p 0.9
+ 118010p -0.3
+ 120000p -0.3
+ 120010p 0.9
+ 122000p 0.9
+ 122010p -0.3
+ 124000p -0.3
+ 124010p 0.9
+ 126000p 0.9
+ 126010p -0.3
+ 128000p -0.3
+ 128010p 0.9
+ 130000p 0.9
+ 130010p -0.3
+ 132000p -0.3
+ 132010p 0.9
+ 134000p 0.9
+ 134010p -0.3
+ 136000p -0.3
+ 136010p 0.9
+ 138000p 0.9
+ 138010p -0.3
+ 140000p -0.3
+ 140010p 0.9
+ 142000p 0.9
+ 142010p -0.3
+ 144000p -0.3
+ 144010p 0.9
+ 146000p 0.9
+ 146010p -0.3
+ 148000p -0.3
+ 148010p 0.9
+ 150000p 0.9
+ 150010p -0.3
+ 152000p -0.3
+ 152010p 0.9
+ 154000p 0.9
+ 154010p -0.3
+ 156000p -0.3
+ 156010p 0.9
+ 158000p 0.9
+ 158010p -0.3
+ 160000p -0.3
+ 160010p 0.9
+ 162000p 0.9
+ 162010p -0.3
+ 164000p -0.3
+ 164010p 0.9
+ 166000p 0.9
+ 166010p -0.3
+ 168000p -0.3
+ 168010p 0.9
+ 170000p 0.9
+ 170010p -0.3
+ 172000p -0.3
+ 172010p 0.9
+ 174000p 0.9
+ 174010p -0.3
+ 176000p -0.3
+ 176010p 0.9
+ 178000p 0.9
+ 178010p -0.3
+ 180000p -0.3
+ 180010p 0.9
+ 182000p 0.9
+ 182010p -0.3
+ 184000p -0.3
+ 184010p 0.9
+ 186000p 0.9
+ 186010p -0.3
+ 188000p -0.3
+ 188010p 0.9
+ 190000p 0.9
+ 190010p -0.3
+ 192000p -0.3
+ 192010p 0.9
+ 194000p 0.9
+ 194010p -0.3
+ 196000p -0.3
+ 196010p 0.9
+ 198000p 0.9
+ 198010p -0.3
+ 200000p -0.3
+ 200010p 0.9
+ 202000p 0.9
+ 202010p -0.3
+ 204000p -0.3
+ 204010p 0.9
+ 206000p 0.9
+ 206010p -0.3
+ 208000p -0.3
+ 208010p 0.9
+ 210000p 0.9
+ 210010p -0.3
+ 212000p -0.3
+ 212010p 0.9
+ 214000p 0.9
+ 214010p -0.3
+ 216000p -0.3
+ 216010p 0.9
+ 218000p 0.9
+ 218010p -0.3
+ 220000p -0.3
+ 220010p 0.9
+ 222000p 0.9
+ 222010p -0.3
+ 224000p -0.3
+ 224010p 0.9
+ 226000p 0.9
+ 226010p -0.3
+ 228000p -0.3
+ 228010p 0.9
+ 230000p 0.9
+ 230010p -0.3
+ 232000p -0.3
+ 232010p 0.9
+ 234000p 0.9
+ 234010p -0.3
+ 236000p -0.3
+ 236010p 0.9
+ 238000p 0.9
+ 238010p -0.3
+ 240000p -0.3
+ 240010p 0.9
+ 242000p 0.9
+ 242010p -0.3
+ 244000p -0.3
+ 244010p 0.9
+ 246000p 0.9
+ 246010p -0.3
+ 248000p -0.3
+ 248010p 0.9
+ 250000p 0.9
+ 250010p -0.3
+ 252000p -0.3
+ 252010p 0.9
+ 254000p 0.9
+ 254010p -0.3
+ 256000p -0.3
+ 256010p 0.9
+ 258000p 0.9
+ 258010p -0.3
+ 260000p -0.3
+ 260010p 0.9
+ 262000p 0.9
+ 262010p -0.3
+ 264000p -0.3
+ 264010p 0.9
+ 266000p 0.9
+ 266010p -0.3
+ 268000p -0.3
+ 268010p 0.9
+ 270000p 0.9
+ 270010p -0.3
+ 272000p -0.3
+ 272010p 0.9
+ 274000p 0.9
+ 274010p -0.3
+ 276000p -0.3
+ 276010p 0.9
+ 278000p 0.9
+ 278010p -0.3
+ 280000p -0.3
+ 280010p 0.9
+ 282000p 0.9
+ 282010p -0.3
+ 284000p -0.3
+ 284010p 0.9
+ 286000p 0.9
+ 286010p -0.3
+ 288000p -0.3
+ 288010p 0.9
+ 290000p 0.9
+ 290010p -0.3
+ 292000p -0.3
+ 292010p 0.9
+ 294000p 0.9
+ 294010p -0.3
+ 296000p -0.3
+ 296010p 0.9
+ 298000p 0.9
+ 298010p -0.3
+ 300000p -0.3
+ 300010p 0.9
+ 302000p 0.9
+ 302010p -0.3
+ 304000p -0.3
+ 304010p 0.9
+ 306000p 0.9
+ 306010p -0.3
+ 308000p -0.3
+ 308010p 0.9
+ 310000p 0.9
+ 310010p -0.3
+ 312000p -0.3
+ 312010p 0.9
+ 314000p 0.9
+ 314010p -0.3
+ 316000p -0.3
+ 316010p 0.9
+ 318000p 0.9
+ 318010p -0.3
+ 320000p -0.3
+ 320010p 0.9
+ 322000p 0.9
+ 322010p -0.3
+ 324000p -0.3
+ 324010p 0.9
+ 326000p 0.9
+ 326010p -0.3
+ 328000p -0.3
+ 328010p 0.9
+ 330000p 0.9
+ 330010p -0.3
+ 332000p -0.3
+ 332010p 0.9
+ 334000p 0.9
+ 334010p -0.3
+ 336000p -0.3
+ 336010p 0.9
+ 338000p 0.9
+ 338010p -0.3
+ 340000p -0.3
+ 340010p 0.9
+ 342000p 0.9
+ 342010p -0.3
+ 344000p -0.3
+ 344010p 0.9
+ 346000p 0.9
+ 346010p -0.3
+ 348000p -0.3
+ 348010p 0.9
+ 350000p 0.9
+ 350010p -0.3
+ 352000p -0.3
+ 352010p 0.9
+ 354000p 0.9
+ 354010p -0.3
+ 356000p -0.3
+ 356010p 0.9
+ 358000p 0.9
+ 358010p -0.3
+ 360000p -0.3
+ 360010p 0.9
+ 362000p 0.9
+ 362010p -0.3
+ 364000p -0.3
+ 364010p 0.9
+ 366000p 0.9
+ 366010p -0.3
+ 368000p -0.3
+ 368010p 0.9
+ 370000p 0.9
+ 370010p -0.3
+ 372000p -0.3
+ 372010p 0.9
+ 374000p 0.9
+ 374010p -0.3
+ 376000p -0.3
+ 376010p 0.9
+ 378000p 0.9
+ 378010p -0.3
+ 380000p -0.3
+ 380010p 0.9
+ 382000p 0.9
+ 382010p -0.3
+ 384000p -0.3
+ 384010p 0.9
+ 386000p 0.9
+ 386010p -0.3
+ 388000p -0.3
+ 388010p 0.9
+ 390000p 0.9
+ 390010p -0.3
+ 392000p -0.3
+ 392010p 0.9
+ 394000p 0.9
+ 394010p -0.3
+ 396000p -0.3
+ 396010p 0.9
+ 398000p 0.9
+ 398010p -0.3
+ 400000p -0.3
+ 400010p 0.9
+ 402000p 0.9
+ 402010p -0.3
+ 404000p -0.3
+ 404010p 0.9
+ 406000p 0.9
+ 406010p -0.3
+ 408000p -0.3
+ 408010p 0.9
+ 410000p 0.9
+ 410010p -0.3
+ 412000p -0.3
+ 412010p 0.9
+ 414000p 0.9
+ 414010p -0.3
+ 416000p -0.3
+ 416010p 0.9
+ 418000p 0.9
+ 418010p -0.3
+ 420000p -0.3
+ 420010p 0.9
+ 422000p 0.9
+ 422010p -0.3
+ 424000p -0.3
+ 424010p 0.9
+ 426000p 0.9
+ 426010p -0.3
+ 428000p -0.3
+ 428010p 0.9
+ 430000p 0.9
+ 430010p -0.3
+ 432000p -0.3
+ 432010p 0.9
+ 434000p 0.9
+ 434010p -0.3
+ 436000p -0.3
+ 436010p 0.9
+ 438000p 0.9
+ 438010p -0.3
+ 440000p -0.3
+ 440010p 0.9
+ 442000p 0.9
+ 442010p -0.3
+ 444000p -0.3
+ 444010p 0.9
+ 446000p 0.9
+ 446010p -0.3
+ 448000p -0.3
+ 448010p 0.9
+ 450000p 0.9
+ 450010p -0.3
+ 452000p -0.3
+ 452010p 0.9
+ 454000p 0.9
+ 454010p -0.3
+ 456000p -0.3
+ 456010p 0.9
+ 458000p 0.9
+ 458010p -0.3
+ 460000p -0.3
+ 460010p 0.9
+ 462000p 0.9
+ 462010p -0.3
+ 464000p -0.3
+ 464010p 0.9
+ 466000p 0.9
+ 466010p -0.3
+ 468000p -0.3
+ 468010p 0.9
+ 470000p 0.9
+ 470010p -0.3
+ 472000p -0.3
+ 472010p 0.9
+ 474000p 0.9
+ 474010p -0.3
+ 476000p -0.3
+ 476010p 0.9
+ 478000p 0.9
+ 478010p -0.3
+ 480000p -0.3
+ 480010p 0.9
+ 482000p 0.9
+ 482010p -0.3
+ 484000p -0.3
+ 484010p 0.9
+ 486000p 0.9
+ 486010p -0.3
+ 488000p -0.3
+ 488010p 0.9
+ 490000p 0.9
+ 490010p -0.3
+ 492000p -0.3
+ 492010p 0.9
+ 494000p 0.9
+ 494010p -0.3
+ 496000p -0.3
+ 496010p 0.9
+ 498000p 0.9
+ 498010p -0.3
+ 500000p -0.3
+ 500010p 0.9
+ 502000p 0.9
+ 502010p -0.3
+ 504000p -0.3
+ 504010p 0.9
+ 506000p 0.9
+ 506010p -0.3
+ 508000p -0.3
+ 508010p 0.9
+ 510000p 0.9
+ 510010p -0.3
+ 512000p -0.3
+ 512010p 0.9
+ 514000p 0.9
+ 514010p -0.3
+ 516000p -0.3
+ 516010p 0.9
+ 518000p 0.9
+ 518010p -0.3
+ 520000p -0.3
+ 520010p 0.9
+ 522000p 0.9
+ 522010p -0.3
+ 524000p -0.3
+ 524010p 0.9
+ 526000p 0.9
+ 526010p -0.3
+ 528000p -0.3
+ 528010p 0.9
+ 530000p 0.9
+ 530010p -0.3
+ 532000p -0.3
+ 532010p 0.9
+ 534000p 0.9
+ 534010p -0.3
+ 536000p -0.3
+ 536010p 0.9
+ 538000p 0.9
+ 538010p -0.3
+ 540000p -0.3
+ 540010p 0.9
+ 542000p 0.9
+ 542010p -0.3
+ 544000p -0.3
+ 544010p 0.9
+ 546000p 0.9
+ 546010p -0.3
+ 548000p -0.3
+ 548010p 0.9
+ 550000p 0.9
+ 550010p -0.3
+ 552000p -0.3
+ 552010p 0.9
+ 554000p 0.9
+ 554010p -0.3
+ 556000p -0.3
+ 556010p 0.9
+ 558000p 0.9
+ 558010p -0.3
+ 560000p -0.3
+ 560010p 0.9
+ 562000p 0.9
+ 562010p -0.3
+ 564000p -0.3
+ 564010p 0.9
+ 566000p 0.9
+ 566010p -0.3
+ 568000p -0.3
+ 568010p 0.9
+ 570000p 0.9
+ 570010p -0.3
+ 572000p -0.3
+ 572010p 0.9
+ 574000p 0.9
+ 574010p -0.3
+ 576000p -0.3
+ 576010p 0.9
+ 578000p 0.9
+ 578010p -0.3
+ 580000p -0.3
+ 580010p 0.9
+ 582000p 0.9
+ 582010p -0.3
+ 584000p -0.3
+ 584010p 0.9
+ 586000p 0.9
+ 586010p -0.3
+ 588000p -0.3
+ 588010p 0.9
+ 590000p 0.9
+ 590010p -0.3
+ 592000p -0.3
+ 592010p 0.9
+ 594000p 0.9
+ 594010p -0.3
+ 596000p -0.3
+ 596010p 0.9
+ 598000p 0.9
+ 598010p -0.3
+ 600000p -0.3
+ 600010p 0.9
+ 602000p 0.9
+ 602010p -0.3
+ 604000p -0.3
+ 604010p 0.9
+ 606000p 0.9
+ 606010p -0.3
+ 608000p -0.3
+ 608010p 0.9
+ 610000p 0.9
+ 610010p -0.3
+ 612000p -0.3
+ 612010p 0.9
+ 614000p 0.9
+ 614010p -0.3
+ 616000p -0.3
+ 616010p 0.9
+ 618000p 0.9
+ 618010p -0.3
+ 620000p -0.3
+ 620010p 0.9
+ 622000p 0.9
+ 622010p -0.3
+ 624000p -0.3
+ 624010p 0.9
+ 626000p 0.9
+ 626010p -0.3
+ 628000p -0.3
+ 628010p 0.9
+ 630000p 0.9
+ 630010p -0.3
+ 632000p -0.3
+ 632010p 0.9
+ 634000p 0.9
+ 634010p -0.3
+ 636000p -0.3
+ 636010p 0.9
+ 638000p 0.9
+ 638010p -0.3
+ 640000p -0.3
+ 640010p 0.9
+ 642000p 0.9
+ 642010p -0.3
+ 644000p -0.3
+ 644010p 0.9
+ 646000p 0.9
+ 646010p -0.3
+ 648000p -0.3
+ 648010p 0.9
+ 650000p 0.9
+ 650010p -0.3
+ 652000p -0.3
+ 652010p 0.9
+ 654000p 0.9
+ 654010p -0.3
+ 656000p -0.3
+ 656010p 0.9
+ 658000p 0.9
+ 658010p -0.3
+ 660000p -0.3
+ 660010p 0.9
+ 662000p 0.9
+ 662010p -0.3
+ 664000p -0.3
+ 664010p 0.9
+ 666000p 0.9
+ 666010p -0.3
+ 668000p -0.3
+ 668010p 0.9
+ 670000p 0.9
+ 670010p -0.3
+ 672000p -0.3
+ 672010p 0.9
+ 674000p 0.9
+ 674010p -0.3
+ 676000p -0.3
+ 676010p 0.9
+ 678000p 0.9
+ 678010p -0.3
+ 680000p -0.3
+ 680010p 0.9
+ 682000p 0.9
+ 682010p -0.3
+ 684000p -0.3
+ 684010p 0.9
+ 686000p 0.9
+ 686010p -0.3
+ 688000p -0.3
+ 688010p 0.9
+ 690000p 0.9
+ 690010p -0.3
+ 692000p -0.3
+ 692010p 0.9
+ 694000p 0.9
+ 694010p -0.3
+ 696000p -0.3
+ 696010p 0.9
+ 698000p 0.9
+ 698010p -0.3
+ 700000p -0.3
+ 700010p 0.9
+ 702000p 0.9
+ 702010p -0.3
+ 704000p -0.3
+ 704010p 0.9
+ 706000p 0.9
+ 706010p -0.3
+ 708000p -0.3
+ 708010p 0.9
+ 710000p 0.9
+ 710010p -0.3
+ 712000p -0.3
+ 712010p 0.9
+ 714000p 0.9
+ 714010p -0.3
+ 716000p -0.3
+ 716010p 0.9
+ 718000p 0.9
+ 718010p -0.3
+ 720000p -0.3
+ 720010p 0.9
+ 722000p 0.9
+ 722010p -0.3
+ 724000p -0.3
+ 724010p 0.9
+ 726000p 0.9
+ 726010p -0.3
+ 728000p -0.3
+ 728010p 0.9
+ 730000p 0.9
+ 730010p -0.3
+ 732000p -0.3
+ 732010p 0.9
+ 734000p 0.9
+ 734010p -0.3
+ 736000p -0.3
+ 736010p 0.9
+ 738000p 0.9
+ 738010p -0.3
+ 740000p -0.3
+ 740010p 0.9
+ 742000p 0.9
+ 742010p -0.3
+ 744000p -0.3
+ 744010p 0.9
+ 746000p 0.9
+ 746010p -0.3
+ 748000p -0.3
+ 748010p 0.9
+ 750000p 0.9
+ 750010p -0.3
+ 752000p -0.3
+ 752010p 0.9
+ 754000p 0.9
+ 754010p -0.3
+ 756000p -0.3
+ 756010p 0.9
+ 758000p 0.9
+ 758010p -0.3
+ 760000p -0.3
+ 760010p 0.9
+ 762000p 0.9
+ 762010p -0.3
+ 764000p -0.3
+ 764010p 0.9
+ 766000p 0.9
+ 766010p -0.3
+ 768000p -0.3
+ 768010p 0.9
+ 770000p 0.9
+ 770010p -0.3
+ 772000p -0.3
+ 772010p 0.9
+ 774000p 0.9
+ 774010p -0.3
+ 776000p -0.3
+ 776010p 0.9
+ 778000p 0.9
+ 778010p -0.3
+ 780000p -0.3
+ 780010p 0.9
+ 782000p 0.9
+ 782010p -0.3
+ 784000p -0.3
+ 784010p 0.9
+ 786000p 0.9
+ 786010p -0.3
+ 788000p -0.3
+ 788010p 0.9
+ 790000p 0.9
+ 790010p -0.3
+ 792000p -0.3
+ 792010p 0.9
+ 794000p 0.9
+ 794010p -0.3
+ 796000p -0.3
+ 796010p 0.9
+ 798000p 0.9
+ 798010p -0.3
+ 800000p -0.3
+ 800010p 0.9
+ 802000p 0.9
+ 802010p -0.3
+ 804000p -0.3
+ 804010p 0.9
+ 806000p 0.9
+ 806010p -0.3
+ 808000p -0.3
+ 808010p 0.9
+ 810000p 0.9
+ 810010p -0.3
+ 812000p -0.3
+ 812010p 0.9
+ 814000p 0.9
+ 814010p -0.3
+ 816000p -0.3
+ 816010p 0.9
+ 818000p 0.9
+ 818010p -0.3
+ 820000p -0.3
+ 820010p 0.9
+ 822000p 0.9
+ 822010p -0.3
+ 824000p -0.3
+ 824010p 0.9
+ 826000p 0.9
+ 826010p -0.3
+ 828000p -0.3
+ 828010p 0.9
+ 830000p 0.9
+ 830010p -0.3
+ 832000p -0.3
+ 832010p 0.9
+ 834000p 0.9
+ 834010p -0.3
+ 836000p -0.3
+ 836010p 0.9
+ 838000p 0.9
+ 838010p -0.3
+ 840000p -0.3
+ 840010p 0.9
+ 842000p 0.9
+ 842010p -0.3
+ 844000p -0.3
+ 844010p 0.9
+ 846000p 0.9
+ 846010p -0.3
+ 848000p -0.3
+ 848010p 0.9
+ 850000p 0.9
+ 850010p -0.3
+ 852000p -0.3
+ 852010p 0.9
+ 854000p 0.9
+ 854010p -0.3
+ 856000p -0.3
+ 856010p 0.9
+ 858000p 0.9
+ 858010p -0.3
+ 860000p -0.3
+ 860010p 0.9
+ 862000p 0.9
+ 862010p -0.3
+ 864000p -0.3
+ 864010p 0.9
+ 866000p 0.9
+ 866010p -0.3
+ 868000p -0.3
+ 868010p 0.9
+ 870000p 0.9
+ 870010p -0.3
+ 872000p -0.3
+ 872010p 0.9
+ 874000p 0.9
+ 874010p -0.3
+ 876000p -0.3
+ 876010p 0.9
+ 878000p 0.9
+ 878010p -0.3
+ 880000p -0.3
+ 880010p 0.9
+ 882000p 0.9
+ 882010p -0.3
+ 884000p -0.3
+ 884010p 0.9
+ 886000p 0.9
+ 886010p -0.3
+ 888000p -0.3
+ 888010p 0.9
+ 890000p 0.9
+ 890010p -0.3
+ 892000p -0.3
+ 892010p 0.9
+ 894000p 0.9
+ 894010p -0.3
+ 896000p -0.3
+ 896010p 0.9
+ 898000p 0.9
+ 898010p -0.3
+ 900000p -0.3
+ 900010p 0.9
+ 902000p 0.9
+ 902010p -0.3
+ 904000p -0.3
+ 904010p 0.9
+ 906000p 0.9
+ 906010p -0.3
+ 908000p -0.3
+ 908010p 0.9
+ 910000p 0.9
+ 910010p -0.3
+ 912000p -0.3
+ 912010p 0.9
+ 914000p 0.9
+ 914010p -0.3
+ 916000p -0.3
+ 916010p 0.9
+ 918000p 0.9
+ 918010p -0.3
+ 920000p -0.3
+ 920010p 0.9
+ 922000p 0.9
+ 922010p -0.3
+ 924000p -0.3
+ 924010p 0.9
+ 926000p 0.9
+ 926010p -0.3
+ 928000p -0.3
+ 928010p 0.9
+ 930000p 0.9
+ 930010p -0.3
+ 932000p -0.3
+ 932010p 0.9
+ 934000p 0.9
+ 934010p -0.3
+ 936000p -0.3
+ 936010p 0.9
+ 938000p 0.9
+ 938010p -0.3
+ 940000p -0.3
+ 940010p 0.9
+ 942000p 0.9
+ 942010p -0.3
+ 944000p -0.3
+ 944010p 0.9
+ 946000p 0.9
+ 946010p -0.3
+ 948000p -0.3
+ 948010p 0.9
+ 950000p 0.9
+ 950010p -0.3
+ 952000p -0.3
+ 952010p 0.9
+ 954000p 0.9
+ 954010p -0.3
+ 956000p -0.3
+ 956010p 0.9
+ 958000p 0.9
+ 958010p -0.3
+ 960000p -0.3
+ 960010p 0.9
+ 962000p 0.9
+ 962010p -0.3
+ 964000p -0.3
+ 964010p 0.9
+ 966000p 0.9
+ 966010p -0.3
+ 968000p -0.3
+ 968010p 0.9
+ 970000p 0.9
+ 970010p -0.3
+ 972000p -0.3
+ 972010p 0.9
+ 974000p 0.9
+ 974010p -0.3
+ 976000p -0.3
+ 976010p 0.9
+ 978000p 0.9
+ 978010p -0.3
+ 980000p -0.3
+ 980010p 0.9
+ 982000p 0.9
+ 982010p -0.3
+ 984000p -0.3
+ 984010p 0.9
+ 986000p 0.9
+ 986010p -0.3
+ 988000p -0.3
+ 988010p 0.9
+ 990000p 0.9
+ 990010p -0.3
+ 992000p -0.3
+ 992010p 0.9
+ 994000p 0.9
+ 994010p -0.3
+ 996000p -0.3
+ 996010p 0.9
+ 998000p 0.9
+ 998010p -0.3
+ 1000000p -0.3
+ 1000010p 0.9
+ 1002000p 0.9
+ 1002010p -0.3
+ 1004000p -0.3
+ 1004010p 0.9
+ 1006000p 0.9
+ 1006010p -0.3
+ 1008000p -0.3
+ 1008010p 0.9
+ 1010000p 0.9
+ 1010010p -0.3
+ 1012000p -0.3
+ 1012010p 0.9
+ 1014000p 0.9
+ 1014010p -0.3
+ 1016000p -0.3
+ 1016010p 0.9
+ 1018000p 0.9
+ 1018010p -0.3
+ 1020000p -0.3
+ 1020010p 0.9
+ 1022000p 0.9
+ 1022010p -0.3
+ 1024000p -0.3
+ 1024010p 0.9
+ 1026000p 0.9
+ 1026010p -0.3
+ 1028000p -0.3
+ 1028010p 0.9
+ 1030000p 0.9
+ 1030010p -0.3
+ 1032000p -0.3
+ 1032010p 0.9
+ 1034000p 0.9
+ 1034010p -0.3
+ 1036000p -0.3
+ 1036010p 0.9
+ 1038000p 0.9
+ 1038010p -0.3
+ 1040000p -0.3
+ 1040010p 0.9
+ 1042000p 0.9
+ 1042010p -0.3
+ 1044000p -0.3
+ 1044010p 0.9
+ 1046000p 0.9
+ 1046010p -0.3
+ 1048000p -0.3
+ 1048010p 0.9
+ 1050000p 0.9
+ 1050010p -0.3
+ 1052000p -0.3
+ 1052010p 0.9
+ 1054000p 0.9
+ 1054010p -0.3
+ 1056000p -0.3
+ 1056010p 0.9
+ 1058000p 0.9
+ 1058010p -0.3
+ 1060000p -0.3
+ 1060010p 0.9
+ 1062000p 0.9
+ 1062010p -0.3
+ 1064000p -0.3
+ 1064010p 0.9
+ 1066000p 0.9
+ 1066010p -0.3
+ 1068000p -0.3
+ 1068010p 0.9
+ 1070000p 0.9
+ 1070010p -0.3
+ 1072000p -0.3
+ 1072010p 0.9
+ 1074000p 0.9
+ 1074010p -0.3
+ 1076000p -0.3
+ 1076010p 0.9
+ 1078000p 0.9
+ 1078010p -0.3
+ 1080000p -0.3
+ 1080010p 0.9
+ 1082000p 0.9
+ 1082010p -0.3
+ 1084000p -0.3
+ 1084010p 0.9
+ 1086000p 0.9
+ 1086010p -0.3
+ 1088000p -0.3
+ 1088010p 0.9
+ 1090000p 0.9
+ 1090010p -0.3
+ 1092000p -0.3
+ 1092010p 0.9
+ 1094000p 0.9
+ 1094010p -0.3
+ 1096000p -0.3
+ 1096010p 0.9
+ 1098000p 0.9
+ 1098010p -0.3
+ 1100000p -0.3
+ 1100010p 0.9
+ 1102000p 0.9
+ 1102010p -0.3
+ 1104000p -0.3
+ 1104010p 0.9
+ 1106000p 0.9
+ 1106010p -0.3
+ 1108000p -0.3
+ 1108010p 0.9
+ 1110000p 0.9
+ 1110010p -0.3
+ 1112000p -0.3
+ 1112010p 0.9
+ 1114000p 0.9
+ 1114010p -0.3
+ 1116000p -0.3
+ 1116010p 0.9
+ 1118000p 0.9
+ 1118010p -0.3
+ 1120000p -0.3
+ 1120010p 0.9
+ 1122000p 0.9
+ 1122010p -0.3
+ 1124000p -0.3
+ 1124010p 0.9
+ 1126000p 0.9
+ 1126010p -0.3
+ 1128000p -0.3
+ 1128010p 0.9
+ 1130000p 0.9
+ 1130010p -0.3
+ 1132000p -0.3
+ 1132010p 0.9
+ 1134000p 0.9
+ 1134010p -0.3
+ 1136000p -0.3
+ 1136010p 0.9
+ 1138000p 0.9
+ 1138010p -0.3
+ 1140000p -0.3
+ 1140010p 0.9
+ 1142000p 0.9
+ 1142010p -0.3
+ 1144000p -0.3
+ 1144010p 0.9
+ 1146000p 0.9
+ 1146010p -0.3
+ 1148000p -0.3
+ 1148010p 0.9
+ 1150000p 0.9
+ 1150010p -0.3
+ 1152000p -0.3
+ 1152010p 0.9
+ 1154000p 0.9
+ 1154010p -0.3
+ 1156000p -0.3
+ 1156010p 0.9
+ 1158000p 0.9
+ 1158010p -0.3
+ 1160000p -0.3
+ 1160010p 0.9
+ 1162000p 0.9
+ 1162010p -0.3
+ 1164000p -0.3
+ 1164010p 0.9
+ 1166000p 0.9
+ 1166010p -0.3
+ 1168000p -0.3
+ 1168010p 0.9
+ 1170000p 0.9
+ 1170010p -0.3
+ 1172000p -0.3
+ 1172010p 0.9
+ 1174000p 0.9
+ 1174010p -0.3
+ 1176000p -0.3
+ 1176010p 0.9
+ 1178000p 0.9
+ 1178010p -0.3
+ 1180000p -0.3
+ 1180010p 0.9
+ 1182000p 0.9
+ 1182010p -0.3
+ 1184000p -0.3
+ 1184010p 0.9
+ 1186000p 0.9
+ 1186010p -0.3
+ 1188000p -0.3
+ 1188010p 0.9
+ 1190000p 0.9
+ 1190010p -0.3
+ 1192000p -0.3
+ 1192010p 0.9
+ 1194000p 0.9
+ 1194010p -0.3
+ 1196000p -0.3
+ 1196010p 0.9
+ 1198000p 0.9
+ 1198010p -0.3
+ 1200000p -0.3
+ 1200010p 0.9
+ 1202000p 0.9
+ 1202010p -0.3
+ 1204000p -0.3
+ 1204010p 0.9
+ 1206000p 0.9
+ 1206010p -0.3
+ 1208000p -0.3
+ 1208010p 0.9
+ 1210000p 0.9
+ 1210010p -0.3
+ 1212000p -0.3
+ 1212010p 0.9
+ 1214000p 0.9
+ 1214010p -0.3
+ 1216000p -0.3
+ 1216010p 0.9
+ 1218000p 0.9
+ 1218010p -0.3
+ 1220000p -0.3
+ 1220010p 0.9
+ 1222000p 0.9
+ 1222010p -0.3
+ 1224000p -0.3
+ 1224010p 0.9
+ 1226000p 0.9
+ 1226010p -0.3
+ 1228000p -0.3
+ 1228010p 0.9
+ 1230000p 0.9
+ 1230010p -0.3
+ 1232000p -0.3
+ 1232010p 0.9
+ 1234000p 0.9
+ 1234010p -0.3
+ 1236000p -0.3
+ 1236010p 0.9
+ 1238000p 0.9
+ 1238010p -0.3
+ 1240000p -0.3
+ 1240010p 0.9
+ 1242000p 0.9
+ 1242010p -0.3
+ 1244000p -0.3
+ 1244010p 0.9
+ 1246000p 0.9
+ 1246010p -0.3
+ 1248000p -0.3
+ 1248010p 0.9
+ 1250000p 0.9
+ 1250010p -0.3
+ 1252000p -0.3
+ 1252010p 0.9
+ 1254000p 0.9
+ 1254010p -0.3
+ 1256000p -0.3
+ 1256010p 0.9
+ 1258000p 0.9
+ 1258010p -0.3
+ 1260000p -0.3
+ 1260010p 0.9
+ 1262000p 0.9
+ 1262010p -0.3
+ 1264000p -0.3
+ 1264010p 0.9
+ 1266000p 0.9
+ 1266010p -0.3
+ 1268000p -0.3
+ 1268010p 0.9
+ 1270000p 0.9
+ 1270010p -0.3
+ 1272000p -0.3
+ 1272010p 0.9
+ 1274000p 0.9
+ 1274010p -0.3
+ 1276000p -0.3
+ 1276010p 0.9
+ 1278000p 0.9
+ 1278010p -0.3
+ 1280000p -0.3
+ 1280010p 0.9
+ 1282000p 0.9
+ 1282010p -0.3
+ 1284000p -0.3
+ 1284010p 0.9
+ 1286000p 0.9
+ 1286010p -0.3
+ 1288000p -0.3
+ 1288010p 0.9
+ 1290000p 0.9
+ 1290010p -0.3
+ 1292000p -0.3
+ 1292010p 0.9
+ 1294000p 0.9
+ 1294010p -0.3
+ 1296000p -0.3
+ 1296010p 0.9
+ 1298000p 0.9
+ 1298010p -0.3
+ 1300000p -0.3
+ 1300010p 0.9
+ 1302000p 0.9
+ 1302010p -0.3
+ 1304000p -0.3
+ 1304010p 0.9
+ 1306000p 0.9
+ 1306010p -0.3
+ 1308000p -0.3
+ 1308010p 0.9
+ 1310000p 0.9
+ 1310010p -0.3
+ 1312000p -0.3
+ 1312010p 0.9
+ 1314000p 0.9
+ 1314010p -0.3
+ 1316000p -0.3
+ 1316010p 0.9
+ 1318000p 0.9
+ 1318010p -0.3
+ 1320000p -0.3
+ 1320010p 0.9
+ 1322000p 0.9
+ 1322010p -0.3
+ 1324000p -0.3
+ 1324010p 0.9
+ 1326000p 0.9
+ 1326010p -0.3
+ 1328000p -0.3
+ 1328010p 0.9
+ 1330000p 0.9
+ 1330010p -0.3
+ 1332000p -0.3
+ 1332010p 0.9
+ 1334000p 0.9
+ 1334010p -0.3
+ 1336000p -0.3
+ 1336010p 0.9
+ 1338000p 0.9
+ 1338010p -0.3
+ 1340000p -0.3
+ 1340010p 0.9
+ 1342000p 0.9
+ 1342010p -0.3
+ 1344000p -0.3
+ 1344010p 0.9
+ 1346000p 0.9
+ 1346010p -0.3
+ 1348000p -0.3
+ 1348010p 0.9
+ 1350000p 0.9
+ 1350010p -0.3
+ 1352000p -0.3
+ 1352010p 0.9
+ 1354000p 0.9
+ 1354010p -0.3
+ 1356000p -0.3
+ 1356010p 0.9
+ 1358000p 0.9
+ 1358010p -0.3
+ 1360000p -0.3
+ 1360010p 0.9
+ 1362000p 0.9
+ 1362010p -0.3
+ 1364000p -0.3
+ 1364010p 0.9
+ 1366000p 0.9
+ 1366010p -0.3
+ 1368000p -0.3
+ 1368010p 0.9
+ 1370000p 0.9
+ 1370010p -0.3
+ 1372000p -0.3
+ 1372010p 0.9
+ 1374000p 0.9
+ 1374010p -0.3
+ 1376000p -0.3
+ 1376010p 0.9
+ 1378000p 0.9
+ 1378010p -0.3
+ 1380000p -0.3
+ 1380010p 0.9
+ 1382000p 0.9
+ 1382010p -0.3
+ 1384000p -0.3
+ 1384010p 0.9
+ 1386000p 0.9
+ 1386010p -0.3
+ 1388000p -0.3
+ 1388010p 0.9
+ 1390000p 0.9
+ 1390010p -0.3
+ 1392000p -0.3
+ 1392010p 0.9
+ 1394000p 0.9
+ 1394010p -0.3
+ 1396000p -0.3
+ 1396010p 0.9
+ 1398000p 0.9
+ 1398010p -0.3
+ 1400000p -0.3
+ 1400010p 0.9
+ 1402000p 0.9
+ 1402010p -0.3
+ 1404000p -0.3
+ 1404010p 0.9
+ 1406000p 0.9
+ 1406010p -0.3
+ 1408000p -0.3
+ 1408010p 0.9
+ 1410000p 0.9
+ 1410010p -0.3
+ 1412000p -0.3
+ 1412010p 0.9
+ 1414000p 0.9
+ 1414010p -0.3
+ 1416000p -0.3
+ 1416010p 0.9
+ 1418000p 0.9
+ 1418010p -0.3
+ 1420000p -0.3
+ 1420010p 0.9
+ 1422000p 0.9
+ 1422010p -0.3
+ 1424000p -0.3
+ 1424010p 0.9
+ 1426000p 0.9
+ 1426010p -0.3
+ 1428000p -0.3
+ 1428010p 0.9
+ 1430000p 0.9
+ 1430010p -0.3
+ 1432000p -0.3
+ 1432010p 0.9
+ 1434000p 0.9
+ 1434010p -0.3
+ 1436000p -0.3
+ 1436010p 0.9
+ 1438000p 0.9
+ 1438010p -0.3
+ 1440000p -0.3
+ 1440010p 0.9
+ 1442000p 0.9
+ 1442010p -0.3
+ 1444000p -0.3
+ 1444010p 0.9
+ 1446000p 0.9
+ 1446010p -0.3
+ 1448000p -0.3
+ 1448010p 0.9
+ 1450000p 0.9
+ 1450010p -0.3
+ 1452000p -0.3
+ 1452010p 0.9
+ 1454000p 0.9
+ 1454010p -0.3
+ 1456000p -0.3
+ 1456010p 0.9
+ 1458000p 0.9
+ 1458010p -0.3
+ 1460000p -0.3
+ 1460010p 0.9
+ 1462000p 0.9
+ 1462010p -0.3
+ 1464000p -0.3
+ 1464010p 0.9
+ 1466000p 0.9
+ 1466010p -0.3
+ 1468000p -0.3
+ 1468010p 0.9
+ 1470000p 0.9
+ 1470010p -0.3
+ 1472000p -0.3
+ 1472010p 0.9
+ 1474000p 0.9
+ 1474010p -0.3
+ 1476000p -0.3
+ 1476010p 0.9
+ 1478000p 0.9
+ 1478010p -0.3
+ 1480000p -0.3
+ 1480010p 0.9
+ 1482000p 0.9
+ 1482010p -0.3
+ 1484000p -0.3
+ 1484010p 0.9
+ 1486000p 0.9
+ 1486010p -0.3
+ 1488000p -0.3
+ 1488010p 0.9
+ 1490000p 0.9
+ 1490010p -0.3
+ 1492000p -0.3
+ 1492010p 0.9
+ 1494000p 0.9
+ 1494010p -0.3
+ 1496000p -0.3
+ 1496010p 0.9
+ 1498000p 0.9
+ 1498010p -0.3
+ 1500000p -0.3
+ 1500010p 0.9
+ 1502000p 0.9
+ 1502010p -0.3
+ 1504000p -0.3
+ 1504010p 0.9
+ 1506000p 0.9
+ 1506010p -0.3
+ 1508000p -0.3
+ 1508010p 0.9
+ 1510000p 0.9
+ 1510010p -0.3
+ 1512000p -0.3
+ 1512010p 0.9
+ 1514000p 0.9
+ 1514010p -0.3
+ 1516000p -0.3
+ 1516010p 0.9
+ 1518000p 0.9
+ 1518010p -0.3
+ 1520000p -0.3
+ 1520010p 0.9
+ 1522000p 0.9
+ 1522010p -0.3
+ 1524000p -0.3
+ 1524010p 0.9
+ 1526000p 0.9
+ 1526010p -0.3
+ 1528000p -0.3
+ 1528010p 0.9
+ 1530000p 0.9
+ 1530010p -0.3
+ 1532000p -0.3
+ 1532010p 0.9
+ 1534000p 0.9
+ 1534010p -0.3
+ 1536000p -0.3
+ 1536010p 0.9
+ 1538000p 0.9
+ 1538010p -0.3
+ 1540000p -0.3
+ 1540010p 0.9
+ 1542000p 0.9
+ 1542010p -0.3
+ 1544000p -0.3
+ 1544010p 0.9
+ 1546000p 0.9
+ 1546010p -0.3
+ 1548000p -0.3
+ 1548010p 0.9
+ 1550000p 0.9
+ 1550010p -0.3
+ 1552000p -0.3
+ 1552010p 0.9
+ 1554000p 0.9
+ 1554010p -0.3
+ 1556000p -0.3
+ 1556010p 0.9
+ 1558000p 0.9
+ 1558010p -0.3
+ 1560000p -0.3
+ 1560010p 0.9
+ 1562000p 0.9
+ 1562010p -0.3
+ 1564000p -0.3
+ 1564010p 0.9
+ 1566000p 0.9
+ 1566010p -0.3
+ 1568000p -0.3
+ 1568010p 0.9
+ 1570000p 0.9
+ 1570010p -0.3
+ 1572000p -0.3
+ 1572010p 0.9
+ 1574000p 0.9
+ 1574010p -0.3
+ 1576000p -0.3
+ 1576010p 0.9
+ 1578000p 0.9
+ 1578010p -0.3
+ 1580000p -0.3
+ 1580010p 0.9
+ 1582000p 0.9
+ 1582010p -0.3
+ 1584000p -0.3
+ 1584010p 0.9
+ 1586000p 0.9
+ 1586010p -0.3
+ 1588000p -0.3
+ 1588010p 0.9
+ 1590000p 0.9
+ 1590010p -0.3
+ 1592000p -0.3
+ 1592010p 0.9
+ 1594000p 0.9
+ 1594010p -0.3
+ 1596000p -0.3
+ 1596010p 0.9
+ 1598000p 0.9
+ 1598010p -0.3
+ 1600000p -0.3
+ 1600010p 0.9
+ 1602000p 0.9
+ 1602010p -0.3
+ 1604000p -0.3
+ 1604010p 0.9
+ 1606000p 0.9
+ 1606010p -0.3
+ 1608000p -0.3
+ 1608010p 0.9
+ 1610000p 0.9
+ 1610010p -0.3
+ 1612000p -0.3
+ 1612010p 0.9
+ 1614000p 0.9
+ 1614010p -0.3
+ 1616000p -0.3
+ 1616010p 0.9
+ 1618000p 0.9
+ 1618010p -0.3
+ 1620000p -0.3
+ 1620010p 0.9
+ 1622000p 0.9
+ 1622010p -0.3
+ 1624000p -0.3
+ 1624010p 0.9
+ 1626000p 0.9
+ 1626010p -0.3
+ 1628000p -0.3
+ 1628010p 0.9
+ 1630000p 0.9
+ 1630010p -0.3
+ 1632000p -0.3
+ 1632010p 0.9
+ 1634000p 0.9
+ 1634010p -0.3
+ 1636000p -0.3
+ 1636010p 0.9
+ 1638000p 0.9
+ 1638010p -0.3
+ 1640000p -0.3
+ 1640010p 0.9
+ 1642000p 0.9
+ 1642010p -0.3
+ 1644000p -0.3
+ 1644010p 0.9
+ 1646000p 0.9
+ 1646010p -0.3
+ 1648000p -0.3
+ 1648010p 0.9
+ 1650000p 0.9
+ 1650010p -0.3
+ 1652000p -0.3
+ 1652010p 0.9
+ 1654000p 0.9
+ 1654010p -0.3
+ 1656000p -0.3
+ 1656010p 0.9
+ 1658000p 0.9
+ 1658010p -0.3
+ 1660000p -0.3
+ 1660010p 0.9
+ 1662000p 0.9
+ 1662010p -0.3
+ 1664000p -0.3
+ 1664010p 0.9
+ 1666000p 0.9
+ 1666010p -0.3
+ 1668000p -0.3
+ 1668010p 0.9
+ 1670000p 0.9
+ 1670010p -0.3
+ 1672000p -0.3
+ 1672010p 0.9
+ 1674000p 0.9
+ 1674010p -0.3
+ 1676000p -0.3
+ 1676010p 0.9
+ 1678000p 0.9
+ 1678010p -0.3
+ 1680000p -0.3
+ 1680010p 0.9
+ 1682000p 0.9
+ 1682010p -0.3
+ 1684000p -0.3
+ 1684010p 0.9
+ 1686000p 0.9
+ 1686010p -0.3
+ 1688000p -0.3
+ 1688010p 0.9
+ 1690000p 0.9
+ 1690010p -0.3
+ 1692000p -0.3
+ 1692010p 0.9
+ 1694000p 0.9
+ 1694010p -0.3
+ 1696000p -0.3
+ 1696010p 0.9
+ 1698000p 0.9
+ 1698010p -0.3
+ 1700000p -0.3
+ 1700010p 0.9
+ 1702000p 0.9
+ 1702010p -0.3
+ 1704000p -0.3
+ 1704010p 0.9
+ 1706000p 0.9
+ 1706010p -0.3
+ 1708000p -0.3
+ 1708010p 0.9
+ 1710000p 0.9
+ 1710010p -0.3
+ 1712000p -0.3
+ 1712010p 0.9
+ 1714000p 0.9
+ 1714010p -0.3
+ 1716000p -0.3
+ 1716010p 0.9
+ 1718000p 0.9
+ 1718010p -0.3
+ 1720000p -0.3
+ 1720010p 0.9
+ 1722000p 0.9
+ 1722010p -0.3
+ 1724000p -0.3
+ 1724010p 0.9
+ 1726000p 0.9
+ 1726010p -0.3
+ 1728000p -0.3
+ 1728010p 0.9
+ 1730000p 0.9
+ 1730010p -0.3
+ 1732000p -0.3
+ 1732010p 0.9
+ 1734000p 0.9
+ 1734010p -0.3
+ 1736000p -0.3
+ 1736010p 0.9
+ 1738000p 0.9
+ 1738010p -0.3
+ 1740000p -0.3
+ 1740010p 0.9
+ 1742000p 0.9
+ 1742010p -0.3
+ 1744000p -0.3
+ 1744010p 0.9
+ 1746000p 0.9
+ 1746010p -0.3
+ 1748000p -0.3
+ 1748010p 0.9
+ 1750000p 0.9
+ 1750010p -0.3
+ 1752000p -0.3
+ 1752010p 0.9
+ 1754000p 0.9
+ 1754010p -0.3
+ 1756000p -0.3
+ 1756010p 0.9
+ 1758000p 0.9
+ 1758010p -0.3
+ 1760000p -0.3
+ 1760010p 0.9
+ 1762000p 0.9
+ 1762010p -0.3
+ 1764000p -0.3
+ 1764010p 0.9
+ 1766000p 0.9
+ 1766010p -0.3
+ 1768000p -0.3
+ 1768010p 0.9
+ 1770000p 0.9
+ 1770010p -0.3
+ 1772000p -0.3
+ 1772010p 0.9
+ 1774000p 0.9
+ 1774010p -0.3
+ 1776000p -0.3
+ 1776010p 0.9
+ 1778000p 0.9
+ 1778010p -0.3
+ 1780000p -0.3
+ 1780010p 0.9
+ 1782000p 0.9
+ 1782010p -0.3
+ 1784000p -0.3
+ 1784010p 0.9
+ 1786000p 0.9
+ 1786010p -0.3
+ 1788000p -0.3
+ 1788010p 0.9
+ 1790000p 0.9
+ 1790010p -0.3
+ 1792000p -0.3
+ 1792010p 0.9
+ 1794000p 0.9
+ 1794010p -0.3
+ 1796000p -0.3
+ 1796010p 0.9
+ 1798000p 0.9
+ 1798010p -0.3
+ 1800000p -0.3
+ 1800010p 0.9
+ 1802000p 0.9
+ 1802010p -0.3
+ 1804000p -0.3
+ 1804010p 0.9
+ 1806000p 0.9
+ 1806010p -0.3
+ 1808000p -0.3
+ 1808010p 0.9
+ 1810000p 0.9
+ 1810010p -0.3
+ 1812000p -0.3
+ 1812010p 0.9
+ 1814000p 0.9
+ 1814010p -0.3
+ 1816000p -0.3
+ 1816010p 0.9
+ 1818000p 0.9
+ 1818010p -0.3
+ 1820000p -0.3
+ 1820010p 0.9
+ 1822000p 0.9
+ 1822010p -0.3
+ 1824000p -0.3
+ 1824010p 0.9
+ 1826000p 0.9
+ 1826010p -0.3
+ 1828000p -0.3
+ 1828010p 0.9
+ 1830000p 0.9
+ 1830010p -0.3
+ 1832000p -0.3
+ 1832010p 0.9
+ 1834000p 0.9
+ 1834010p -0.3
+ 1836000p -0.3
+ 1836010p 0.9
+ 1838000p 0.9
+ 1838010p -0.3
+ 1840000p -0.3
+ 1840010p 0.9
+ 1842000p 0.9
+ 1842010p -0.3
+ 1844000p -0.3
+ 1844010p 0.9
+ 1846000p 0.9
+ 1846010p -0.3
+ 1848000p -0.3
+ 1848010p 0.9
+ 1850000p 0.9
+ 1850010p -0.3
+ 1852000p -0.3
+ 1852010p 0.9
+ 1854000p 0.9
+ 1854010p -0.3
+ 1856000p -0.3
+ 1856010p 0.9
+ 1858000p 0.9
+ 1858010p -0.3
+ 1860000p -0.3
+ 1860010p 0.9
+ 1862000p 0.9
+ 1862010p -0.3
+ 1864000p -0.3
+ 1864010p 0.9
+ 1866000p 0.9
+ 1866010p -0.3
+ 1868000p -0.3
+ 1868010p 0.9
+ 1870000p 0.9
+ 1870010p -0.3
+ 1872000p -0.3
+ 1872010p 0.9
+ 1874000p 0.9
+ 1874010p -0.3
+ 1876000p -0.3
+ 1876010p 0.9
+ 1878000p 0.9
+ 1878010p -0.3
+ 1880000p -0.3
+ 1880010p 0.9
+ 1882000p 0.9
+ 1882010p -0.3
+ 1884000p -0.3
+ 1884010p 0.9
+ 1886000p 0.9
+ 1886010p -0.3
+ 1888000p -0.3
+ 1888010p 0.9
+ 1890000p 0.9
+ 1890010p -0.3
+ 1892000p -0.3
+ 1892010p 0.9
+ 1894000p 0.9
+ 1894010p -0.3
+ 1896000p -0.3
+ 1896010p 0.9
+ 1898000p 0.9
+ 1898010p -0.3
+ 1900000p -0.3
+ 1900010p 0.9
+ 1902000p 0.9
+ 1902010p -0.3
+ 1904000p -0.3
+ 1904010p 0.9
+ 1906000p 0.9
+ 1906010p -0.3
+ 1908000p -0.3
+ 1908010p 0.9
+ 1910000p 0.9
+ 1910010p -0.3
+ 1912000p -0.3
+ 1912010p 0.9
+ 1914000p 0.9
+ 1914010p -0.3
+ 1916000p -0.3
+ 1916010p 0.9
+ 1918000p 0.9
+ 1918010p -0.3
+ 1920000p -0.3
+ 1920010p 0.9
+ 1922000p 0.9
+ 1922010p -0.3
+ 1924000p -0.3
+ 1924010p 0.9
+ 1926000p 0.9
+ 1926010p -0.3
+ 1928000p -0.3
+ 1928010p 0.9
+ 1930000p 0.9
+ 1930010p -0.3
+ 1932000p -0.3
+ 1932010p 0.9
+ 1934000p 0.9
+ 1934010p -0.3
+ 1936000p -0.3
+ 1936010p 0.9
+ 1938000p 0.9
+ 1938010p -0.3
+ 1940000p -0.3
+ 1940010p 0.9
+ 1942000p 0.9
+ 1942010p -0.3
+ 1944000p -0.3
+ 1944010p 0.9
+ 1946000p 0.9
+ 1946010p -0.3
+ 1948000p -0.3
+ 1948010p 0.9
+ 1950000p 0.9
+ 1950010p -0.3
+ 1952000p -0.3
+ 1952010p 0.9
+ 1954000p 0.9
+ 1954010p -0.3
+ 1956000p -0.3
+ 1956010p 0.9
+ 1958000p 0.9
+ 1958010p -0.3
+ 1960000p -0.3
+ 1960010p 0.9
+ 1962000p 0.9
+ 1962010p -0.3
+ 1964000p -0.3
+ 1964010p 0.9
+ 1966000p 0.9
+ 1966010p -0.3
+ 1968000p -0.3
+ 1968010p 0.9
+ 1970000p 0.9
+ 1970010p -0.3
+ 1972000p -0.3
+ 1972010p 0.9
+ 1974000p 0.9
+ 1974010p -0.3
+ 1976000p -0.3
+ 1976010p 0.9
+ 1978000p 0.9
+ 1978010p -0.3
+ 1980000p -0.3
+ 1980010p 0.9
+ 1982000p 0.9
+ 1982010p -0.3
+ 1984000p -0.3
+ 1984010p 0.9
+ 1986000p 0.9
+ 1986010p -0.3
+ 1988000p -0.3
+ 1988010p 0.9
+ 1990000p 0.9
+ 1990010p -0.3
+ 1992000p -0.3
+ 1992010p 0.9
+ 1994000p 0.9
+ 1994010p -0.3
+ 1996000p -0.3
+ 1996010p 0.9
+ 1998000p 0.9
+ 1998010p -0.3
+ 2000000p -0.3
+ 2000010p 0.9
+ 2002000p 0.9
+ 2002010p -0.3
+ 2004000p -0.3
+ 2004010p 0.9
+ 2006000p 0.9
+ 2006010p -0.3
+ 2008000p -0.3
+ 2008010p 0.9
+ 2010000p 0.9
+ 2010010p -0.3
+ 2012000p -0.3
+ 2012010p 0.9
+ 2014000p 0.9
+ 2014010p -0.3
+ 2016000p -0.3
+ 2016010p 0.9
+ 2018000p 0.9
+ 2018010p -0.3
+ 2020000p -0.3
+ 2020010p 0.9
+ 2022000p 0.9
+ 2022010p -0.3
+ 2024000p -0.3
+ 2024010p 0.9
+ 2026000p 0.9
+ 2026010p -0.3
+ 2028000p -0.3
+ 2028010p 0.9
+ 2030000p 0.9
+ 2030010p -0.3
+ 2032000p -0.3
+ 2032010p 0.9
+ 2034000p 0.9
+ 2034010p -0.3
+ 2036000p -0.3
+ 2036010p 0.9
+ 2038000p 0.9
+ 2038010p -0.3
+ 2040000p -0.3
+ 2040010p 0.9
+ 2042000p 0.9
+ 2042010p -0.3
+ 2044000p -0.3
+ 2044010p 0.9
+ 2046000p 0.9
+ 2046010p -0.3
+ 2048000p -0.3
+ 2048010p 0.9
+ \]
V_data_bar_15 (Data_bar\\<15\\> gnd!) vsource type=pwl wave=\[
+ 0    -0.3
+ 2000p -0.3
+ 2010p 0.9
+ 4000p 0.9
+ 4010p -0.3
+ 6000p -0.3
+ 6010p 0.9
+ 8000p 0.9
+ 8010p -0.3
+ 10000p -0.3
+ 10010p 0.9
+ 12000p 0.9
+ 12010p -0.3
+ 14000p -0.3
+ 14010p 0.9
+ 16000p 0.9
+ 16010p -0.3
+ 18000p -0.3
+ 18010p 0.9
+ 20000p 0.9
+ 20010p -0.3
+ 22000p -0.3
+ 22010p 0.9
+ 24000p 0.9
+ 24010p -0.3
+ 26000p -0.3
+ 26010p 0.9
+ 28000p 0.9
+ 28010p -0.3
+ 30000p -0.3
+ 30010p 0.9
+ 32000p 0.9
+ 32010p -0.3
+ 34000p -0.3
+ 34010p 0.9
+ 36000p 0.9
+ 36010p -0.3
+ 38000p -0.3
+ 38010p 0.9
+ 40000p 0.9
+ 40010p -0.3
+ 42000p -0.3
+ 42010p 0.9
+ 44000p 0.9
+ 44010p -0.3
+ 46000p -0.3
+ 46010p 0.9
+ 48000p 0.9
+ 48010p -0.3
+ 50000p -0.3
+ 50010p 0.9
+ 52000p 0.9
+ 52010p -0.3
+ 54000p -0.3
+ 54010p 0.9
+ 56000p 0.9
+ 56010p -0.3
+ 58000p -0.3
+ 58010p 0.9
+ 60000p 0.9
+ 60010p -0.3
+ 62000p -0.3
+ 62010p 0.9
+ 64000p 0.9
+ 64010p -0.3
+ 66000p -0.3
+ 66010p 0.9
+ 68000p 0.9
+ 68010p -0.3
+ 70000p -0.3
+ 70010p 0.9
+ 72000p 0.9
+ 72010p -0.3
+ 74000p -0.3
+ 74010p 0.9
+ 76000p 0.9
+ 76010p -0.3
+ 78000p -0.3
+ 78010p 0.9
+ 80000p 0.9
+ 80010p -0.3
+ 82000p -0.3
+ 82010p 0.9
+ 84000p 0.9
+ 84010p -0.3
+ 86000p -0.3
+ 86010p 0.9
+ 88000p 0.9
+ 88010p -0.3
+ 90000p -0.3
+ 90010p 0.9
+ 92000p 0.9
+ 92010p -0.3
+ 94000p -0.3
+ 94010p 0.9
+ 96000p 0.9
+ 96010p -0.3
+ 98000p -0.3
+ 98010p 0.9
+ 100000p 0.9
+ 100010p -0.3
+ 102000p -0.3
+ 102010p 0.9
+ 104000p 0.9
+ 104010p -0.3
+ 106000p -0.3
+ 106010p 0.9
+ 108000p 0.9
+ 108010p -0.3
+ 110000p -0.3
+ 110010p 0.9
+ 112000p 0.9
+ 112010p -0.3
+ 114000p -0.3
+ 114010p 0.9
+ 116000p 0.9
+ 116010p -0.3
+ 118000p -0.3
+ 118010p 0.9
+ 120000p 0.9
+ 120010p -0.3
+ 122000p -0.3
+ 122010p 0.9
+ 124000p 0.9
+ 124010p -0.3
+ 126000p -0.3
+ 126010p 0.9
+ 128000p 0.9
+ 128010p -0.3
+ 130000p -0.3
+ 130010p 0.9
+ 132000p 0.9
+ 132010p -0.3
+ 134000p -0.3
+ 134010p 0.9
+ 136000p 0.9
+ 136010p -0.3
+ 138000p -0.3
+ 138010p 0.9
+ 140000p 0.9
+ 140010p -0.3
+ 142000p -0.3
+ 142010p 0.9
+ 144000p 0.9
+ 144010p -0.3
+ 146000p -0.3
+ 146010p 0.9
+ 148000p 0.9
+ 148010p -0.3
+ 150000p -0.3
+ 150010p 0.9
+ 152000p 0.9
+ 152010p -0.3
+ 154000p -0.3
+ 154010p 0.9
+ 156000p 0.9
+ 156010p -0.3
+ 158000p -0.3
+ 158010p 0.9
+ 160000p 0.9
+ 160010p -0.3
+ 162000p -0.3
+ 162010p 0.9
+ 164000p 0.9
+ 164010p -0.3
+ 166000p -0.3
+ 166010p 0.9
+ 168000p 0.9
+ 168010p -0.3
+ 170000p -0.3
+ 170010p 0.9
+ 172000p 0.9
+ 172010p -0.3
+ 174000p -0.3
+ 174010p 0.9
+ 176000p 0.9
+ 176010p -0.3
+ 178000p -0.3
+ 178010p 0.9
+ 180000p 0.9
+ 180010p -0.3
+ 182000p -0.3
+ 182010p 0.9
+ 184000p 0.9
+ 184010p -0.3
+ 186000p -0.3
+ 186010p 0.9
+ 188000p 0.9
+ 188010p -0.3
+ 190000p -0.3
+ 190010p 0.9
+ 192000p 0.9
+ 192010p -0.3
+ 194000p -0.3
+ 194010p 0.9
+ 196000p 0.9
+ 196010p -0.3
+ 198000p -0.3
+ 198010p 0.9
+ 200000p 0.9
+ 200010p -0.3
+ 202000p -0.3
+ 202010p 0.9
+ 204000p 0.9
+ 204010p -0.3
+ 206000p -0.3
+ 206010p 0.9
+ 208000p 0.9
+ 208010p -0.3
+ 210000p -0.3
+ 210010p 0.9
+ 212000p 0.9
+ 212010p -0.3
+ 214000p -0.3
+ 214010p 0.9
+ 216000p 0.9
+ 216010p -0.3
+ 218000p -0.3
+ 218010p 0.9
+ 220000p 0.9
+ 220010p -0.3
+ 222000p -0.3
+ 222010p 0.9
+ 224000p 0.9
+ 224010p -0.3
+ 226000p -0.3
+ 226010p 0.9
+ 228000p 0.9
+ 228010p -0.3
+ 230000p -0.3
+ 230010p 0.9
+ 232000p 0.9
+ 232010p -0.3
+ 234000p -0.3
+ 234010p 0.9
+ 236000p 0.9
+ 236010p -0.3
+ 238000p -0.3
+ 238010p 0.9
+ 240000p 0.9
+ 240010p -0.3
+ 242000p -0.3
+ 242010p 0.9
+ 244000p 0.9
+ 244010p -0.3
+ 246000p -0.3
+ 246010p 0.9
+ 248000p 0.9
+ 248010p -0.3
+ 250000p -0.3
+ 250010p 0.9
+ 252000p 0.9
+ 252010p -0.3
+ 254000p -0.3
+ 254010p 0.9
+ 256000p 0.9
+ 256010p -0.3
+ 258000p -0.3
+ 258010p 0.9
+ 260000p 0.9
+ 260010p -0.3
+ 262000p -0.3
+ 262010p 0.9
+ 264000p 0.9
+ 264010p -0.3
+ 266000p -0.3
+ 266010p 0.9
+ 268000p 0.9
+ 268010p -0.3
+ 270000p -0.3
+ 270010p 0.9
+ 272000p 0.9
+ 272010p -0.3
+ 274000p -0.3
+ 274010p 0.9
+ 276000p 0.9
+ 276010p -0.3
+ 278000p -0.3
+ 278010p 0.9
+ 280000p 0.9
+ 280010p -0.3
+ 282000p -0.3
+ 282010p 0.9
+ 284000p 0.9
+ 284010p -0.3
+ 286000p -0.3
+ 286010p 0.9
+ 288000p 0.9
+ 288010p -0.3
+ 290000p -0.3
+ 290010p 0.9
+ 292000p 0.9
+ 292010p -0.3
+ 294000p -0.3
+ 294010p 0.9
+ 296000p 0.9
+ 296010p -0.3
+ 298000p -0.3
+ 298010p 0.9
+ 300000p 0.9
+ 300010p -0.3
+ 302000p -0.3
+ 302010p 0.9
+ 304000p 0.9
+ 304010p -0.3
+ 306000p -0.3
+ 306010p 0.9
+ 308000p 0.9
+ 308010p -0.3
+ 310000p -0.3
+ 310010p 0.9
+ 312000p 0.9
+ 312010p -0.3
+ 314000p -0.3
+ 314010p 0.9
+ 316000p 0.9
+ 316010p -0.3
+ 318000p -0.3
+ 318010p 0.9
+ 320000p 0.9
+ 320010p -0.3
+ 322000p -0.3
+ 322010p 0.9
+ 324000p 0.9
+ 324010p -0.3
+ 326000p -0.3
+ 326010p 0.9
+ 328000p 0.9
+ 328010p -0.3
+ 330000p -0.3
+ 330010p 0.9
+ 332000p 0.9
+ 332010p -0.3
+ 334000p -0.3
+ 334010p 0.9
+ 336000p 0.9
+ 336010p -0.3
+ 338000p -0.3
+ 338010p 0.9
+ 340000p 0.9
+ 340010p -0.3
+ 342000p -0.3
+ 342010p 0.9
+ 344000p 0.9
+ 344010p -0.3
+ 346000p -0.3
+ 346010p 0.9
+ 348000p 0.9
+ 348010p -0.3
+ 350000p -0.3
+ 350010p 0.9
+ 352000p 0.9
+ 352010p -0.3
+ 354000p -0.3
+ 354010p 0.9
+ 356000p 0.9
+ 356010p -0.3
+ 358000p -0.3
+ 358010p 0.9
+ 360000p 0.9
+ 360010p -0.3
+ 362000p -0.3
+ 362010p 0.9
+ 364000p 0.9
+ 364010p -0.3
+ 366000p -0.3
+ 366010p 0.9
+ 368000p 0.9
+ 368010p -0.3
+ 370000p -0.3
+ 370010p 0.9
+ 372000p 0.9
+ 372010p -0.3
+ 374000p -0.3
+ 374010p 0.9
+ 376000p 0.9
+ 376010p -0.3
+ 378000p -0.3
+ 378010p 0.9
+ 380000p 0.9
+ 380010p -0.3
+ 382000p -0.3
+ 382010p 0.9
+ 384000p 0.9
+ 384010p -0.3
+ 386000p -0.3
+ 386010p 0.9
+ 388000p 0.9
+ 388010p -0.3
+ 390000p -0.3
+ 390010p 0.9
+ 392000p 0.9
+ 392010p -0.3
+ 394000p -0.3
+ 394010p 0.9
+ 396000p 0.9
+ 396010p -0.3
+ 398000p -0.3
+ 398010p 0.9
+ 400000p 0.9
+ 400010p -0.3
+ 402000p -0.3
+ 402010p 0.9
+ 404000p 0.9
+ 404010p -0.3
+ 406000p -0.3
+ 406010p 0.9
+ 408000p 0.9
+ 408010p -0.3
+ 410000p -0.3
+ 410010p 0.9
+ 412000p 0.9
+ 412010p -0.3
+ 414000p -0.3
+ 414010p 0.9
+ 416000p 0.9
+ 416010p -0.3
+ 418000p -0.3
+ 418010p 0.9
+ 420000p 0.9
+ 420010p -0.3
+ 422000p -0.3
+ 422010p 0.9
+ 424000p 0.9
+ 424010p -0.3
+ 426000p -0.3
+ 426010p 0.9
+ 428000p 0.9
+ 428010p -0.3
+ 430000p -0.3
+ 430010p 0.9
+ 432000p 0.9
+ 432010p -0.3
+ 434000p -0.3
+ 434010p 0.9
+ 436000p 0.9
+ 436010p -0.3
+ 438000p -0.3
+ 438010p 0.9
+ 440000p 0.9
+ 440010p -0.3
+ 442000p -0.3
+ 442010p 0.9
+ 444000p 0.9
+ 444010p -0.3
+ 446000p -0.3
+ 446010p 0.9
+ 448000p 0.9
+ 448010p -0.3
+ 450000p -0.3
+ 450010p 0.9
+ 452000p 0.9
+ 452010p -0.3
+ 454000p -0.3
+ 454010p 0.9
+ 456000p 0.9
+ 456010p -0.3
+ 458000p -0.3
+ 458010p 0.9
+ 460000p 0.9
+ 460010p -0.3
+ 462000p -0.3
+ 462010p 0.9
+ 464000p 0.9
+ 464010p -0.3
+ 466000p -0.3
+ 466010p 0.9
+ 468000p 0.9
+ 468010p -0.3
+ 470000p -0.3
+ 470010p 0.9
+ 472000p 0.9
+ 472010p -0.3
+ 474000p -0.3
+ 474010p 0.9
+ 476000p 0.9
+ 476010p -0.3
+ 478000p -0.3
+ 478010p 0.9
+ 480000p 0.9
+ 480010p -0.3
+ 482000p -0.3
+ 482010p 0.9
+ 484000p 0.9
+ 484010p -0.3
+ 486000p -0.3
+ 486010p 0.9
+ 488000p 0.9
+ 488010p -0.3
+ 490000p -0.3
+ 490010p 0.9
+ 492000p 0.9
+ 492010p -0.3
+ 494000p -0.3
+ 494010p 0.9
+ 496000p 0.9
+ 496010p -0.3
+ 498000p -0.3
+ 498010p 0.9
+ 500000p 0.9
+ 500010p -0.3
+ 502000p -0.3
+ 502010p 0.9
+ 504000p 0.9
+ 504010p -0.3
+ 506000p -0.3
+ 506010p 0.9
+ 508000p 0.9
+ 508010p -0.3
+ 510000p -0.3
+ 510010p 0.9
+ 512000p 0.9
+ 512010p -0.3
+ 514000p -0.3
+ 514010p 0.9
+ 516000p 0.9
+ 516010p -0.3
+ 518000p -0.3
+ 518010p 0.9
+ 520000p 0.9
+ 520010p -0.3
+ 522000p -0.3
+ 522010p 0.9
+ 524000p 0.9
+ 524010p -0.3
+ 526000p -0.3
+ 526010p 0.9
+ 528000p 0.9
+ 528010p -0.3
+ 530000p -0.3
+ 530010p 0.9
+ 532000p 0.9
+ 532010p -0.3
+ 534000p -0.3
+ 534010p 0.9
+ 536000p 0.9
+ 536010p -0.3
+ 538000p -0.3
+ 538010p 0.9
+ 540000p 0.9
+ 540010p -0.3
+ 542000p -0.3
+ 542010p 0.9
+ 544000p 0.9
+ 544010p -0.3
+ 546000p -0.3
+ 546010p 0.9
+ 548000p 0.9
+ 548010p -0.3
+ 550000p -0.3
+ 550010p 0.9
+ 552000p 0.9
+ 552010p -0.3
+ 554000p -0.3
+ 554010p 0.9
+ 556000p 0.9
+ 556010p -0.3
+ 558000p -0.3
+ 558010p 0.9
+ 560000p 0.9
+ 560010p -0.3
+ 562000p -0.3
+ 562010p 0.9
+ 564000p 0.9
+ 564010p -0.3
+ 566000p -0.3
+ 566010p 0.9
+ 568000p 0.9
+ 568010p -0.3
+ 570000p -0.3
+ 570010p 0.9
+ 572000p 0.9
+ 572010p -0.3
+ 574000p -0.3
+ 574010p 0.9
+ 576000p 0.9
+ 576010p -0.3
+ 578000p -0.3
+ 578010p 0.9
+ 580000p 0.9
+ 580010p -0.3
+ 582000p -0.3
+ 582010p 0.9
+ 584000p 0.9
+ 584010p -0.3
+ 586000p -0.3
+ 586010p 0.9
+ 588000p 0.9
+ 588010p -0.3
+ 590000p -0.3
+ 590010p 0.9
+ 592000p 0.9
+ 592010p -0.3
+ 594000p -0.3
+ 594010p 0.9
+ 596000p 0.9
+ 596010p -0.3
+ 598000p -0.3
+ 598010p 0.9
+ 600000p 0.9
+ 600010p -0.3
+ 602000p -0.3
+ 602010p 0.9
+ 604000p 0.9
+ 604010p -0.3
+ 606000p -0.3
+ 606010p 0.9
+ 608000p 0.9
+ 608010p -0.3
+ 610000p -0.3
+ 610010p 0.9
+ 612000p 0.9
+ 612010p -0.3
+ 614000p -0.3
+ 614010p 0.9
+ 616000p 0.9
+ 616010p -0.3
+ 618000p -0.3
+ 618010p 0.9
+ 620000p 0.9
+ 620010p -0.3
+ 622000p -0.3
+ 622010p 0.9
+ 624000p 0.9
+ 624010p -0.3
+ 626000p -0.3
+ 626010p 0.9
+ 628000p 0.9
+ 628010p -0.3
+ 630000p -0.3
+ 630010p 0.9
+ 632000p 0.9
+ 632010p -0.3
+ 634000p -0.3
+ 634010p 0.9
+ 636000p 0.9
+ 636010p -0.3
+ 638000p -0.3
+ 638010p 0.9
+ 640000p 0.9
+ 640010p -0.3
+ 642000p -0.3
+ 642010p 0.9
+ 644000p 0.9
+ 644010p -0.3
+ 646000p -0.3
+ 646010p 0.9
+ 648000p 0.9
+ 648010p -0.3
+ 650000p -0.3
+ 650010p 0.9
+ 652000p 0.9
+ 652010p -0.3
+ 654000p -0.3
+ 654010p 0.9
+ 656000p 0.9
+ 656010p -0.3
+ 658000p -0.3
+ 658010p 0.9
+ 660000p 0.9
+ 660010p -0.3
+ 662000p -0.3
+ 662010p 0.9
+ 664000p 0.9
+ 664010p -0.3
+ 666000p -0.3
+ 666010p 0.9
+ 668000p 0.9
+ 668010p -0.3
+ 670000p -0.3
+ 670010p 0.9
+ 672000p 0.9
+ 672010p -0.3
+ 674000p -0.3
+ 674010p 0.9
+ 676000p 0.9
+ 676010p -0.3
+ 678000p -0.3
+ 678010p 0.9
+ 680000p 0.9
+ 680010p -0.3
+ 682000p -0.3
+ 682010p 0.9
+ 684000p 0.9
+ 684010p -0.3
+ 686000p -0.3
+ 686010p 0.9
+ 688000p 0.9
+ 688010p -0.3
+ 690000p -0.3
+ 690010p 0.9
+ 692000p 0.9
+ 692010p -0.3
+ 694000p -0.3
+ 694010p 0.9
+ 696000p 0.9
+ 696010p -0.3
+ 698000p -0.3
+ 698010p 0.9
+ 700000p 0.9
+ 700010p -0.3
+ 702000p -0.3
+ 702010p 0.9
+ 704000p 0.9
+ 704010p -0.3
+ 706000p -0.3
+ 706010p 0.9
+ 708000p 0.9
+ 708010p -0.3
+ 710000p -0.3
+ 710010p 0.9
+ 712000p 0.9
+ 712010p -0.3
+ 714000p -0.3
+ 714010p 0.9
+ 716000p 0.9
+ 716010p -0.3
+ 718000p -0.3
+ 718010p 0.9
+ 720000p 0.9
+ 720010p -0.3
+ 722000p -0.3
+ 722010p 0.9
+ 724000p 0.9
+ 724010p -0.3
+ 726000p -0.3
+ 726010p 0.9
+ 728000p 0.9
+ 728010p -0.3
+ 730000p -0.3
+ 730010p 0.9
+ 732000p 0.9
+ 732010p -0.3
+ 734000p -0.3
+ 734010p 0.9
+ 736000p 0.9
+ 736010p -0.3
+ 738000p -0.3
+ 738010p 0.9
+ 740000p 0.9
+ 740010p -0.3
+ 742000p -0.3
+ 742010p 0.9
+ 744000p 0.9
+ 744010p -0.3
+ 746000p -0.3
+ 746010p 0.9
+ 748000p 0.9
+ 748010p -0.3
+ 750000p -0.3
+ 750010p 0.9
+ 752000p 0.9
+ 752010p -0.3
+ 754000p -0.3
+ 754010p 0.9
+ 756000p 0.9
+ 756010p -0.3
+ 758000p -0.3
+ 758010p 0.9
+ 760000p 0.9
+ 760010p -0.3
+ 762000p -0.3
+ 762010p 0.9
+ 764000p 0.9
+ 764010p -0.3
+ 766000p -0.3
+ 766010p 0.9
+ 768000p 0.9
+ 768010p -0.3
+ 770000p -0.3
+ 770010p 0.9
+ 772000p 0.9
+ 772010p -0.3
+ 774000p -0.3
+ 774010p 0.9
+ 776000p 0.9
+ 776010p -0.3
+ 778000p -0.3
+ 778010p 0.9
+ 780000p 0.9
+ 780010p -0.3
+ 782000p -0.3
+ 782010p 0.9
+ 784000p 0.9
+ 784010p -0.3
+ 786000p -0.3
+ 786010p 0.9
+ 788000p 0.9
+ 788010p -0.3
+ 790000p -0.3
+ 790010p 0.9
+ 792000p 0.9
+ 792010p -0.3
+ 794000p -0.3
+ 794010p 0.9
+ 796000p 0.9
+ 796010p -0.3
+ 798000p -0.3
+ 798010p 0.9
+ 800000p 0.9
+ 800010p -0.3
+ 802000p -0.3
+ 802010p 0.9
+ 804000p 0.9
+ 804010p -0.3
+ 806000p -0.3
+ 806010p 0.9
+ 808000p 0.9
+ 808010p -0.3
+ 810000p -0.3
+ 810010p 0.9
+ 812000p 0.9
+ 812010p -0.3
+ 814000p -0.3
+ 814010p 0.9
+ 816000p 0.9
+ 816010p -0.3
+ 818000p -0.3
+ 818010p 0.9
+ 820000p 0.9
+ 820010p -0.3
+ 822000p -0.3
+ 822010p 0.9
+ 824000p 0.9
+ 824010p -0.3
+ 826000p -0.3
+ 826010p 0.9
+ 828000p 0.9
+ 828010p -0.3
+ 830000p -0.3
+ 830010p 0.9
+ 832000p 0.9
+ 832010p -0.3
+ 834000p -0.3
+ 834010p 0.9
+ 836000p 0.9
+ 836010p -0.3
+ 838000p -0.3
+ 838010p 0.9
+ 840000p 0.9
+ 840010p -0.3
+ 842000p -0.3
+ 842010p 0.9
+ 844000p 0.9
+ 844010p -0.3
+ 846000p -0.3
+ 846010p 0.9
+ 848000p 0.9
+ 848010p -0.3
+ 850000p -0.3
+ 850010p 0.9
+ 852000p 0.9
+ 852010p -0.3
+ 854000p -0.3
+ 854010p 0.9
+ 856000p 0.9
+ 856010p -0.3
+ 858000p -0.3
+ 858010p 0.9
+ 860000p 0.9
+ 860010p -0.3
+ 862000p -0.3
+ 862010p 0.9
+ 864000p 0.9
+ 864010p -0.3
+ 866000p -0.3
+ 866010p 0.9
+ 868000p 0.9
+ 868010p -0.3
+ 870000p -0.3
+ 870010p 0.9
+ 872000p 0.9
+ 872010p -0.3
+ 874000p -0.3
+ 874010p 0.9
+ 876000p 0.9
+ 876010p -0.3
+ 878000p -0.3
+ 878010p 0.9
+ 880000p 0.9
+ 880010p -0.3
+ 882000p -0.3
+ 882010p 0.9
+ 884000p 0.9
+ 884010p -0.3
+ 886000p -0.3
+ 886010p 0.9
+ 888000p 0.9
+ 888010p -0.3
+ 890000p -0.3
+ 890010p 0.9
+ 892000p 0.9
+ 892010p -0.3
+ 894000p -0.3
+ 894010p 0.9
+ 896000p 0.9
+ 896010p -0.3
+ 898000p -0.3
+ 898010p 0.9
+ 900000p 0.9
+ 900010p -0.3
+ 902000p -0.3
+ 902010p 0.9
+ 904000p 0.9
+ 904010p -0.3
+ 906000p -0.3
+ 906010p 0.9
+ 908000p 0.9
+ 908010p -0.3
+ 910000p -0.3
+ 910010p 0.9
+ 912000p 0.9
+ 912010p -0.3
+ 914000p -0.3
+ 914010p 0.9
+ 916000p 0.9
+ 916010p -0.3
+ 918000p -0.3
+ 918010p 0.9
+ 920000p 0.9
+ 920010p -0.3
+ 922000p -0.3
+ 922010p 0.9
+ 924000p 0.9
+ 924010p -0.3
+ 926000p -0.3
+ 926010p 0.9
+ 928000p 0.9
+ 928010p -0.3
+ 930000p -0.3
+ 930010p 0.9
+ 932000p 0.9
+ 932010p -0.3
+ 934000p -0.3
+ 934010p 0.9
+ 936000p 0.9
+ 936010p -0.3
+ 938000p -0.3
+ 938010p 0.9
+ 940000p 0.9
+ 940010p -0.3
+ 942000p -0.3
+ 942010p 0.9
+ 944000p 0.9
+ 944010p -0.3
+ 946000p -0.3
+ 946010p 0.9
+ 948000p 0.9
+ 948010p -0.3
+ 950000p -0.3
+ 950010p 0.9
+ 952000p 0.9
+ 952010p -0.3
+ 954000p -0.3
+ 954010p 0.9
+ 956000p 0.9
+ 956010p -0.3
+ 958000p -0.3
+ 958010p 0.9
+ 960000p 0.9
+ 960010p -0.3
+ 962000p -0.3
+ 962010p 0.9
+ 964000p 0.9
+ 964010p -0.3
+ 966000p -0.3
+ 966010p 0.9
+ 968000p 0.9
+ 968010p -0.3
+ 970000p -0.3
+ 970010p 0.9
+ 972000p 0.9
+ 972010p -0.3
+ 974000p -0.3
+ 974010p 0.9
+ 976000p 0.9
+ 976010p -0.3
+ 978000p -0.3
+ 978010p 0.9
+ 980000p 0.9
+ 980010p -0.3
+ 982000p -0.3
+ 982010p 0.9
+ 984000p 0.9
+ 984010p -0.3
+ 986000p -0.3
+ 986010p 0.9
+ 988000p 0.9
+ 988010p -0.3
+ 990000p -0.3
+ 990010p 0.9
+ 992000p 0.9
+ 992010p -0.3
+ 994000p -0.3
+ 994010p 0.9
+ 996000p 0.9
+ 996010p -0.3
+ 998000p -0.3
+ 998010p 0.9
+ 1000000p 0.9
+ 1000010p -0.3
+ 1002000p -0.3
+ 1002010p 0.9
+ 1004000p 0.9
+ 1004010p -0.3
+ 1006000p -0.3
+ 1006010p 0.9
+ 1008000p 0.9
+ 1008010p -0.3
+ 1010000p -0.3
+ 1010010p 0.9
+ 1012000p 0.9
+ 1012010p -0.3
+ 1014000p -0.3
+ 1014010p 0.9
+ 1016000p 0.9
+ 1016010p -0.3
+ 1018000p -0.3
+ 1018010p 0.9
+ 1020000p 0.9
+ 1020010p -0.3
+ 1022000p -0.3
+ 1022010p 0.9
+ 1024000p 0.9
+ 1024010p -0.3
+ 1026000p -0.3
+ 1026010p 0.9
+ 1028000p 0.9
+ 1028010p -0.3
+ 1030000p -0.3
+ 1030010p 0.9
+ 1032000p 0.9
+ 1032010p -0.3
+ 1034000p -0.3
+ 1034010p 0.9
+ 1036000p 0.9
+ 1036010p -0.3
+ 1038000p -0.3
+ 1038010p 0.9
+ 1040000p 0.9
+ 1040010p -0.3
+ 1042000p -0.3
+ 1042010p 0.9
+ 1044000p 0.9
+ 1044010p -0.3
+ 1046000p -0.3
+ 1046010p 0.9
+ 1048000p 0.9
+ 1048010p -0.3
+ 1050000p -0.3
+ 1050010p 0.9
+ 1052000p 0.9
+ 1052010p -0.3
+ 1054000p -0.3
+ 1054010p 0.9
+ 1056000p 0.9
+ 1056010p -0.3
+ 1058000p -0.3
+ 1058010p 0.9
+ 1060000p 0.9
+ 1060010p -0.3
+ 1062000p -0.3
+ 1062010p 0.9
+ 1064000p 0.9
+ 1064010p -0.3
+ 1066000p -0.3
+ 1066010p 0.9
+ 1068000p 0.9
+ 1068010p -0.3
+ 1070000p -0.3
+ 1070010p 0.9
+ 1072000p 0.9
+ 1072010p -0.3
+ 1074000p -0.3
+ 1074010p 0.9
+ 1076000p 0.9
+ 1076010p -0.3
+ 1078000p -0.3
+ 1078010p 0.9
+ 1080000p 0.9
+ 1080010p -0.3
+ 1082000p -0.3
+ 1082010p 0.9
+ 1084000p 0.9
+ 1084010p -0.3
+ 1086000p -0.3
+ 1086010p 0.9
+ 1088000p 0.9
+ 1088010p -0.3
+ 1090000p -0.3
+ 1090010p 0.9
+ 1092000p 0.9
+ 1092010p -0.3
+ 1094000p -0.3
+ 1094010p 0.9
+ 1096000p 0.9
+ 1096010p -0.3
+ 1098000p -0.3
+ 1098010p 0.9
+ 1100000p 0.9
+ 1100010p -0.3
+ 1102000p -0.3
+ 1102010p 0.9
+ 1104000p 0.9
+ 1104010p -0.3
+ 1106000p -0.3
+ 1106010p 0.9
+ 1108000p 0.9
+ 1108010p -0.3
+ 1110000p -0.3
+ 1110010p 0.9
+ 1112000p 0.9
+ 1112010p -0.3
+ 1114000p -0.3
+ 1114010p 0.9
+ 1116000p 0.9
+ 1116010p -0.3
+ 1118000p -0.3
+ 1118010p 0.9
+ 1120000p 0.9
+ 1120010p -0.3
+ 1122000p -0.3
+ 1122010p 0.9
+ 1124000p 0.9
+ 1124010p -0.3
+ 1126000p -0.3
+ 1126010p 0.9
+ 1128000p 0.9
+ 1128010p -0.3
+ 1130000p -0.3
+ 1130010p 0.9
+ 1132000p 0.9
+ 1132010p -0.3
+ 1134000p -0.3
+ 1134010p 0.9
+ 1136000p 0.9
+ 1136010p -0.3
+ 1138000p -0.3
+ 1138010p 0.9
+ 1140000p 0.9
+ 1140010p -0.3
+ 1142000p -0.3
+ 1142010p 0.9
+ 1144000p 0.9
+ 1144010p -0.3
+ 1146000p -0.3
+ 1146010p 0.9
+ 1148000p 0.9
+ 1148010p -0.3
+ 1150000p -0.3
+ 1150010p 0.9
+ 1152000p 0.9
+ 1152010p -0.3
+ 1154000p -0.3
+ 1154010p 0.9
+ 1156000p 0.9
+ 1156010p -0.3
+ 1158000p -0.3
+ 1158010p 0.9
+ 1160000p 0.9
+ 1160010p -0.3
+ 1162000p -0.3
+ 1162010p 0.9
+ 1164000p 0.9
+ 1164010p -0.3
+ 1166000p -0.3
+ 1166010p 0.9
+ 1168000p 0.9
+ 1168010p -0.3
+ 1170000p -0.3
+ 1170010p 0.9
+ 1172000p 0.9
+ 1172010p -0.3
+ 1174000p -0.3
+ 1174010p 0.9
+ 1176000p 0.9
+ 1176010p -0.3
+ 1178000p -0.3
+ 1178010p 0.9
+ 1180000p 0.9
+ 1180010p -0.3
+ 1182000p -0.3
+ 1182010p 0.9
+ 1184000p 0.9
+ 1184010p -0.3
+ 1186000p -0.3
+ 1186010p 0.9
+ 1188000p 0.9
+ 1188010p -0.3
+ 1190000p -0.3
+ 1190010p 0.9
+ 1192000p 0.9
+ 1192010p -0.3
+ 1194000p -0.3
+ 1194010p 0.9
+ 1196000p 0.9
+ 1196010p -0.3
+ 1198000p -0.3
+ 1198010p 0.9
+ 1200000p 0.9
+ 1200010p -0.3
+ 1202000p -0.3
+ 1202010p 0.9
+ 1204000p 0.9
+ 1204010p -0.3
+ 1206000p -0.3
+ 1206010p 0.9
+ 1208000p 0.9
+ 1208010p -0.3
+ 1210000p -0.3
+ 1210010p 0.9
+ 1212000p 0.9
+ 1212010p -0.3
+ 1214000p -0.3
+ 1214010p 0.9
+ 1216000p 0.9
+ 1216010p -0.3
+ 1218000p -0.3
+ 1218010p 0.9
+ 1220000p 0.9
+ 1220010p -0.3
+ 1222000p -0.3
+ 1222010p 0.9
+ 1224000p 0.9
+ 1224010p -0.3
+ 1226000p -0.3
+ 1226010p 0.9
+ 1228000p 0.9
+ 1228010p -0.3
+ 1230000p -0.3
+ 1230010p 0.9
+ 1232000p 0.9
+ 1232010p -0.3
+ 1234000p -0.3
+ 1234010p 0.9
+ 1236000p 0.9
+ 1236010p -0.3
+ 1238000p -0.3
+ 1238010p 0.9
+ 1240000p 0.9
+ 1240010p -0.3
+ 1242000p -0.3
+ 1242010p 0.9
+ 1244000p 0.9
+ 1244010p -0.3
+ 1246000p -0.3
+ 1246010p 0.9
+ 1248000p 0.9
+ 1248010p -0.3
+ 1250000p -0.3
+ 1250010p 0.9
+ 1252000p 0.9
+ 1252010p -0.3
+ 1254000p -0.3
+ 1254010p 0.9
+ 1256000p 0.9
+ 1256010p -0.3
+ 1258000p -0.3
+ 1258010p 0.9
+ 1260000p 0.9
+ 1260010p -0.3
+ 1262000p -0.3
+ 1262010p 0.9
+ 1264000p 0.9
+ 1264010p -0.3
+ 1266000p -0.3
+ 1266010p 0.9
+ 1268000p 0.9
+ 1268010p -0.3
+ 1270000p -0.3
+ 1270010p 0.9
+ 1272000p 0.9
+ 1272010p -0.3
+ 1274000p -0.3
+ 1274010p 0.9
+ 1276000p 0.9
+ 1276010p -0.3
+ 1278000p -0.3
+ 1278010p 0.9
+ 1280000p 0.9
+ 1280010p -0.3
+ 1282000p -0.3
+ 1282010p 0.9
+ 1284000p 0.9
+ 1284010p -0.3
+ 1286000p -0.3
+ 1286010p 0.9
+ 1288000p 0.9
+ 1288010p -0.3
+ 1290000p -0.3
+ 1290010p 0.9
+ 1292000p 0.9
+ 1292010p -0.3
+ 1294000p -0.3
+ 1294010p 0.9
+ 1296000p 0.9
+ 1296010p -0.3
+ 1298000p -0.3
+ 1298010p 0.9
+ 1300000p 0.9
+ 1300010p -0.3
+ 1302000p -0.3
+ 1302010p 0.9
+ 1304000p 0.9
+ 1304010p -0.3
+ 1306000p -0.3
+ 1306010p 0.9
+ 1308000p 0.9
+ 1308010p -0.3
+ 1310000p -0.3
+ 1310010p 0.9
+ 1312000p 0.9
+ 1312010p -0.3
+ 1314000p -0.3
+ 1314010p 0.9
+ 1316000p 0.9
+ 1316010p -0.3
+ 1318000p -0.3
+ 1318010p 0.9
+ 1320000p 0.9
+ 1320010p -0.3
+ 1322000p -0.3
+ 1322010p 0.9
+ 1324000p 0.9
+ 1324010p -0.3
+ 1326000p -0.3
+ 1326010p 0.9
+ 1328000p 0.9
+ 1328010p -0.3
+ 1330000p -0.3
+ 1330010p 0.9
+ 1332000p 0.9
+ 1332010p -0.3
+ 1334000p -0.3
+ 1334010p 0.9
+ 1336000p 0.9
+ 1336010p -0.3
+ 1338000p -0.3
+ 1338010p 0.9
+ 1340000p 0.9
+ 1340010p -0.3
+ 1342000p -0.3
+ 1342010p 0.9
+ 1344000p 0.9
+ 1344010p -0.3
+ 1346000p -0.3
+ 1346010p 0.9
+ 1348000p 0.9
+ 1348010p -0.3
+ 1350000p -0.3
+ 1350010p 0.9
+ 1352000p 0.9
+ 1352010p -0.3
+ 1354000p -0.3
+ 1354010p 0.9
+ 1356000p 0.9
+ 1356010p -0.3
+ 1358000p -0.3
+ 1358010p 0.9
+ 1360000p 0.9
+ 1360010p -0.3
+ 1362000p -0.3
+ 1362010p 0.9
+ 1364000p 0.9
+ 1364010p -0.3
+ 1366000p -0.3
+ 1366010p 0.9
+ 1368000p 0.9
+ 1368010p -0.3
+ 1370000p -0.3
+ 1370010p 0.9
+ 1372000p 0.9
+ 1372010p -0.3
+ 1374000p -0.3
+ 1374010p 0.9
+ 1376000p 0.9
+ 1376010p -0.3
+ 1378000p -0.3
+ 1378010p 0.9
+ 1380000p 0.9
+ 1380010p -0.3
+ 1382000p -0.3
+ 1382010p 0.9
+ 1384000p 0.9
+ 1384010p -0.3
+ 1386000p -0.3
+ 1386010p 0.9
+ 1388000p 0.9
+ 1388010p -0.3
+ 1390000p -0.3
+ 1390010p 0.9
+ 1392000p 0.9
+ 1392010p -0.3
+ 1394000p -0.3
+ 1394010p 0.9
+ 1396000p 0.9
+ 1396010p -0.3
+ 1398000p -0.3
+ 1398010p 0.9
+ 1400000p 0.9
+ 1400010p -0.3
+ 1402000p -0.3
+ 1402010p 0.9
+ 1404000p 0.9
+ 1404010p -0.3
+ 1406000p -0.3
+ 1406010p 0.9
+ 1408000p 0.9
+ 1408010p -0.3
+ 1410000p -0.3
+ 1410010p 0.9
+ 1412000p 0.9
+ 1412010p -0.3
+ 1414000p -0.3
+ 1414010p 0.9
+ 1416000p 0.9
+ 1416010p -0.3
+ 1418000p -0.3
+ 1418010p 0.9
+ 1420000p 0.9
+ 1420010p -0.3
+ 1422000p -0.3
+ 1422010p 0.9
+ 1424000p 0.9
+ 1424010p -0.3
+ 1426000p -0.3
+ 1426010p 0.9
+ 1428000p 0.9
+ 1428010p -0.3
+ 1430000p -0.3
+ 1430010p 0.9
+ 1432000p 0.9
+ 1432010p -0.3
+ 1434000p -0.3
+ 1434010p 0.9
+ 1436000p 0.9
+ 1436010p -0.3
+ 1438000p -0.3
+ 1438010p 0.9
+ 1440000p 0.9
+ 1440010p -0.3
+ 1442000p -0.3
+ 1442010p 0.9
+ 1444000p 0.9
+ 1444010p -0.3
+ 1446000p -0.3
+ 1446010p 0.9
+ 1448000p 0.9
+ 1448010p -0.3
+ 1450000p -0.3
+ 1450010p 0.9
+ 1452000p 0.9
+ 1452010p -0.3
+ 1454000p -0.3
+ 1454010p 0.9
+ 1456000p 0.9
+ 1456010p -0.3
+ 1458000p -0.3
+ 1458010p 0.9
+ 1460000p 0.9
+ 1460010p -0.3
+ 1462000p -0.3
+ 1462010p 0.9
+ 1464000p 0.9
+ 1464010p -0.3
+ 1466000p -0.3
+ 1466010p 0.9
+ 1468000p 0.9
+ 1468010p -0.3
+ 1470000p -0.3
+ 1470010p 0.9
+ 1472000p 0.9
+ 1472010p -0.3
+ 1474000p -0.3
+ 1474010p 0.9
+ 1476000p 0.9
+ 1476010p -0.3
+ 1478000p -0.3
+ 1478010p 0.9
+ 1480000p 0.9
+ 1480010p -0.3
+ 1482000p -0.3
+ 1482010p 0.9
+ 1484000p 0.9
+ 1484010p -0.3
+ 1486000p -0.3
+ 1486010p 0.9
+ 1488000p 0.9
+ 1488010p -0.3
+ 1490000p -0.3
+ 1490010p 0.9
+ 1492000p 0.9
+ 1492010p -0.3
+ 1494000p -0.3
+ 1494010p 0.9
+ 1496000p 0.9
+ 1496010p -0.3
+ 1498000p -0.3
+ 1498010p 0.9
+ 1500000p 0.9
+ 1500010p -0.3
+ 1502000p -0.3
+ 1502010p 0.9
+ 1504000p 0.9
+ 1504010p -0.3
+ 1506000p -0.3
+ 1506010p 0.9
+ 1508000p 0.9
+ 1508010p -0.3
+ 1510000p -0.3
+ 1510010p 0.9
+ 1512000p 0.9
+ 1512010p -0.3
+ 1514000p -0.3
+ 1514010p 0.9
+ 1516000p 0.9
+ 1516010p -0.3
+ 1518000p -0.3
+ 1518010p 0.9
+ 1520000p 0.9
+ 1520010p -0.3
+ 1522000p -0.3
+ 1522010p 0.9
+ 1524000p 0.9
+ 1524010p -0.3
+ 1526000p -0.3
+ 1526010p 0.9
+ 1528000p 0.9
+ 1528010p -0.3
+ 1530000p -0.3
+ 1530010p 0.9
+ 1532000p 0.9
+ 1532010p -0.3
+ 1534000p -0.3
+ 1534010p 0.9
+ 1536000p 0.9
+ 1536010p -0.3
+ 1538000p -0.3
+ 1538010p 0.9
+ 1540000p 0.9
+ 1540010p -0.3
+ 1542000p -0.3
+ 1542010p 0.9
+ 1544000p 0.9
+ 1544010p -0.3
+ 1546000p -0.3
+ 1546010p 0.9
+ 1548000p 0.9
+ 1548010p -0.3
+ 1550000p -0.3
+ 1550010p 0.9
+ 1552000p 0.9
+ 1552010p -0.3
+ 1554000p -0.3
+ 1554010p 0.9
+ 1556000p 0.9
+ 1556010p -0.3
+ 1558000p -0.3
+ 1558010p 0.9
+ 1560000p 0.9
+ 1560010p -0.3
+ 1562000p -0.3
+ 1562010p 0.9
+ 1564000p 0.9
+ 1564010p -0.3
+ 1566000p -0.3
+ 1566010p 0.9
+ 1568000p 0.9
+ 1568010p -0.3
+ 1570000p -0.3
+ 1570010p 0.9
+ 1572000p 0.9
+ 1572010p -0.3
+ 1574000p -0.3
+ 1574010p 0.9
+ 1576000p 0.9
+ 1576010p -0.3
+ 1578000p -0.3
+ 1578010p 0.9
+ 1580000p 0.9
+ 1580010p -0.3
+ 1582000p -0.3
+ 1582010p 0.9
+ 1584000p 0.9
+ 1584010p -0.3
+ 1586000p -0.3
+ 1586010p 0.9
+ 1588000p 0.9
+ 1588010p -0.3
+ 1590000p -0.3
+ 1590010p 0.9
+ 1592000p 0.9
+ 1592010p -0.3
+ 1594000p -0.3
+ 1594010p 0.9
+ 1596000p 0.9
+ 1596010p -0.3
+ 1598000p -0.3
+ 1598010p 0.9
+ 1600000p 0.9
+ 1600010p -0.3
+ 1602000p -0.3
+ 1602010p 0.9
+ 1604000p 0.9
+ 1604010p -0.3
+ 1606000p -0.3
+ 1606010p 0.9
+ 1608000p 0.9
+ 1608010p -0.3
+ 1610000p -0.3
+ 1610010p 0.9
+ 1612000p 0.9
+ 1612010p -0.3
+ 1614000p -0.3
+ 1614010p 0.9
+ 1616000p 0.9
+ 1616010p -0.3
+ 1618000p -0.3
+ 1618010p 0.9
+ 1620000p 0.9
+ 1620010p -0.3
+ 1622000p -0.3
+ 1622010p 0.9
+ 1624000p 0.9
+ 1624010p -0.3
+ 1626000p -0.3
+ 1626010p 0.9
+ 1628000p 0.9
+ 1628010p -0.3
+ 1630000p -0.3
+ 1630010p 0.9
+ 1632000p 0.9
+ 1632010p -0.3
+ 1634000p -0.3
+ 1634010p 0.9
+ 1636000p 0.9
+ 1636010p -0.3
+ 1638000p -0.3
+ 1638010p 0.9
+ 1640000p 0.9
+ 1640010p -0.3
+ 1642000p -0.3
+ 1642010p 0.9
+ 1644000p 0.9
+ 1644010p -0.3
+ 1646000p -0.3
+ 1646010p 0.9
+ 1648000p 0.9
+ 1648010p -0.3
+ 1650000p -0.3
+ 1650010p 0.9
+ 1652000p 0.9
+ 1652010p -0.3
+ 1654000p -0.3
+ 1654010p 0.9
+ 1656000p 0.9
+ 1656010p -0.3
+ 1658000p -0.3
+ 1658010p 0.9
+ 1660000p 0.9
+ 1660010p -0.3
+ 1662000p -0.3
+ 1662010p 0.9
+ 1664000p 0.9
+ 1664010p -0.3
+ 1666000p -0.3
+ 1666010p 0.9
+ 1668000p 0.9
+ 1668010p -0.3
+ 1670000p -0.3
+ 1670010p 0.9
+ 1672000p 0.9
+ 1672010p -0.3
+ 1674000p -0.3
+ 1674010p 0.9
+ 1676000p 0.9
+ 1676010p -0.3
+ 1678000p -0.3
+ 1678010p 0.9
+ 1680000p 0.9
+ 1680010p -0.3
+ 1682000p -0.3
+ 1682010p 0.9
+ 1684000p 0.9
+ 1684010p -0.3
+ 1686000p -0.3
+ 1686010p 0.9
+ 1688000p 0.9
+ 1688010p -0.3
+ 1690000p -0.3
+ 1690010p 0.9
+ 1692000p 0.9
+ 1692010p -0.3
+ 1694000p -0.3
+ 1694010p 0.9
+ 1696000p 0.9
+ 1696010p -0.3
+ 1698000p -0.3
+ 1698010p 0.9
+ 1700000p 0.9
+ 1700010p -0.3
+ 1702000p -0.3
+ 1702010p 0.9
+ 1704000p 0.9
+ 1704010p -0.3
+ 1706000p -0.3
+ 1706010p 0.9
+ 1708000p 0.9
+ 1708010p -0.3
+ 1710000p -0.3
+ 1710010p 0.9
+ 1712000p 0.9
+ 1712010p -0.3
+ 1714000p -0.3
+ 1714010p 0.9
+ 1716000p 0.9
+ 1716010p -0.3
+ 1718000p -0.3
+ 1718010p 0.9
+ 1720000p 0.9
+ 1720010p -0.3
+ 1722000p -0.3
+ 1722010p 0.9
+ 1724000p 0.9
+ 1724010p -0.3
+ 1726000p -0.3
+ 1726010p 0.9
+ 1728000p 0.9
+ 1728010p -0.3
+ 1730000p -0.3
+ 1730010p 0.9
+ 1732000p 0.9
+ 1732010p -0.3
+ 1734000p -0.3
+ 1734010p 0.9
+ 1736000p 0.9
+ 1736010p -0.3
+ 1738000p -0.3
+ 1738010p 0.9
+ 1740000p 0.9
+ 1740010p -0.3
+ 1742000p -0.3
+ 1742010p 0.9
+ 1744000p 0.9
+ 1744010p -0.3
+ 1746000p -0.3
+ 1746010p 0.9
+ 1748000p 0.9
+ 1748010p -0.3
+ 1750000p -0.3
+ 1750010p 0.9
+ 1752000p 0.9
+ 1752010p -0.3
+ 1754000p -0.3
+ 1754010p 0.9
+ 1756000p 0.9
+ 1756010p -0.3
+ 1758000p -0.3
+ 1758010p 0.9
+ 1760000p 0.9
+ 1760010p -0.3
+ 1762000p -0.3
+ 1762010p 0.9
+ 1764000p 0.9
+ 1764010p -0.3
+ 1766000p -0.3
+ 1766010p 0.9
+ 1768000p 0.9
+ 1768010p -0.3
+ 1770000p -0.3
+ 1770010p 0.9
+ 1772000p 0.9
+ 1772010p -0.3
+ 1774000p -0.3
+ 1774010p 0.9
+ 1776000p 0.9
+ 1776010p -0.3
+ 1778000p -0.3
+ 1778010p 0.9
+ 1780000p 0.9
+ 1780010p -0.3
+ 1782000p -0.3
+ 1782010p 0.9
+ 1784000p 0.9
+ 1784010p -0.3
+ 1786000p -0.3
+ 1786010p 0.9
+ 1788000p 0.9
+ 1788010p -0.3
+ 1790000p -0.3
+ 1790010p 0.9
+ 1792000p 0.9
+ 1792010p -0.3
+ 1794000p -0.3
+ 1794010p 0.9
+ 1796000p 0.9
+ 1796010p -0.3
+ 1798000p -0.3
+ 1798010p 0.9
+ 1800000p 0.9
+ 1800010p -0.3
+ 1802000p -0.3
+ 1802010p 0.9
+ 1804000p 0.9
+ 1804010p -0.3
+ 1806000p -0.3
+ 1806010p 0.9
+ 1808000p 0.9
+ 1808010p -0.3
+ 1810000p -0.3
+ 1810010p 0.9
+ 1812000p 0.9
+ 1812010p -0.3
+ 1814000p -0.3
+ 1814010p 0.9
+ 1816000p 0.9
+ 1816010p -0.3
+ 1818000p -0.3
+ 1818010p 0.9
+ 1820000p 0.9
+ 1820010p -0.3
+ 1822000p -0.3
+ 1822010p 0.9
+ 1824000p 0.9
+ 1824010p -0.3
+ 1826000p -0.3
+ 1826010p 0.9
+ 1828000p 0.9
+ 1828010p -0.3
+ 1830000p -0.3
+ 1830010p 0.9
+ 1832000p 0.9
+ 1832010p -0.3
+ 1834000p -0.3
+ 1834010p 0.9
+ 1836000p 0.9
+ 1836010p -0.3
+ 1838000p -0.3
+ 1838010p 0.9
+ 1840000p 0.9
+ 1840010p -0.3
+ 1842000p -0.3
+ 1842010p 0.9
+ 1844000p 0.9
+ 1844010p -0.3
+ 1846000p -0.3
+ 1846010p 0.9
+ 1848000p 0.9
+ 1848010p -0.3
+ 1850000p -0.3
+ 1850010p 0.9
+ 1852000p 0.9
+ 1852010p -0.3
+ 1854000p -0.3
+ 1854010p 0.9
+ 1856000p 0.9
+ 1856010p -0.3
+ 1858000p -0.3
+ 1858010p 0.9
+ 1860000p 0.9
+ 1860010p -0.3
+ 1862000p -0.3
+ 1862010p 0.9
+ 1864000p 0.9
+ 1864010p -0.3
+ 1866000p -0.3
+ 1866010p 0.9
+ 1868000p 0.9
+ 1868010p -0.3
+ 1870000p -0.3
+ 1870010p 0.9
+ 1872000p 0.9
+ 1872010p -0.3
+ 1874000p -0.3
+ 1874010p 0.9
+ 1876000p 0.9
+ 1876010p -0.3
+ 1878000p -0.3
+ 1878010p 0.9
+ 1880000p 0.9
+ 1880010p -0.3
+ 1882000p -0.3
+ 1882010p 0.9
+ 1884000p 0.9
+ 1884010p -0.3
+ 1886000p -0.3
+ 1886010p 0.9
+ 1888000p 0.9
+ 1888010p -0.3
+ 1890000p -0.3
+ 1890010p 0.9
+ 1892000p 0.9
+ 1892010p -0.3
+ 1894000p -0.3
+ 1894010p 0.9
+ 1896000p 0.9
+ 1896010p -0.3
+ 1898000p -0.3
+ 1898010p 0.9
+ 1900000p 0.9
+ 1900010p -0.3
+ 1902000p -0.3
+ 1902010p 0.9
+ 1904000p 0.9
+ 1904010p -0.3
+ 1906000p -0.3
+ 1906010p 0.9
+ 1908000p 0.9
+ 1908010p -0.3
+ 1910000p -0.3
+ 1910010p 0.9
+ 1912000p 0.9
+ 1912010p -0.3
+ 1914000p -0.3
+ 1914010p 0.9
+ 1916000p 0.9
+ 1916010p -0.3
+ 1918000p -0.3
+ 1918010p 0.9
+ 1920000p 0.9
+ 1920010p -0.3
+ 1922000p -0.3
+ 1922010p 0.9
+ 1924000p 0.9
+ 1924010p -0.3
+ 1926000p -0.3
+ 1926010p 0.9
+ 1928000p 0.9
+ 1928010p -0.3
+ 1930000p -0.3
+ 1930010p 0.9
+ 1932000p 0.9
+ 1932010p -0.3
+ 1934000p -0.3
+ 1934010p 0.9
+ 1936000p 0.9
+ 1936010p -0.3
+ 1938000p -0.3
+ 1938010p 0.9
+ 1940000p 0.9
+ 1940010p -0.3
+ 1942000p -0.3
+ 1942010p 0.9
+ 1944000p 0.9
+ 1944010p -0.3
+ 1946000p -0.3
+ 1946010p 0.9
+ 1948000p 0.9
+ 1948010p -0.3
+ 1950000p -0.3
+ 1950010p 0.9
+ 1952000p 0.9
+ 1952010p -0.3
+ 1954000p -0.3
+ 1954010p 0.9
+ 1956000p 0.9
+ 1956010p -0.3
+ 1958000p -0.3
+ 1958010p 0.9
+ 1960000p 0.9
+ 1960010p -0.3
+ 1962000p -0.3
+ 1962010p 0.9
+ 1964000p 0.9
+ 1964010p -0.3
+ 1966000p -0.3
+ 1966010p 0.9
+ 1968000p 0.9
+ 1968010p -0.3
+ 1970000p -0.3
+ 1970010p 0.9
+ 1972000p 0.9
+ 1972010p -0.3
+ 1974000p -0.3
+ 1974010p 0.9
+ 1976000p 0.9
+ 1976010p -0.3
+ 1978000p -0.3
+ 1978010p 0.9
+ 1980000p 0.9
+ 1980010p -0.3
+ 1982000p -0.3
+ 1982010p 0.9
+ 1984000p 0.9
+ 1984010p -0.3
+ 1986000p -0.3
+ 1986010p 0.9
+ 1988000p 0.9
+ 1988010p -0.3
+ 1990000p -0.3
+ 1990010p 0.9
+ 1992000p 0.9
+ 1992010p -0.3
+ 1994000p -0.3
+ 1994010p 0.9
+ 1996000p 0.9
+ 1996010p -0.3
+ 1998000p -0.3
+ 1998010p 0.9
+ 2000000p 0.9
+ 2000010p -0.3
+ 2002000p -0.3
+ 2002010p 0.9
+ 2004000p 0.9
+ 2004010p -0.3
+ 2006000p -0.3
+ 2006010p 0.9
+ 2008000p 0.9
+ 2008010p -0.3
+ 2010000p -0.3
+ 2010010p 0.9
+ 2012000p 0.9
+ 2012010p -0.3
+ 2014000p -0.3
+ 2014010p 0.9
+ 2016000p 0.9
+ 2016010p -0.3
+ 2018000p -0.3
+ 2018010p 0.9
+ 2020000p 0.9
+ 2020010p -0.3
+ 2022000p -0.3
+ 2022010p 0.9
+ 2024000p 0.9
+ 2024010p -0.3
+ 2026000p -0.3
+ 2026010p 0.9
+ 2028000p 0.9
+ 2028010p -0.3
+ 2030000p -0.3
+ 2030010p 0.9
+ 2032000p 0.9
+ 2032010p -0.3
+ 2034000p -0.3
+ 2034010p 0.9
+ 2036000p 0.9
+ 2036010p -0.3
+ 2038000p -0.3
+ 2038010p 0.9
+ 2040000p 0.9
+ 2040010p -0.3
+ 2042000p -0.3
+ 2042010p 0.9
+ 2044000p 0.9
+ 2044010p -0.3
+ 2046000p -0.3
+ 2046010p 0.9
+ 2048000p 0.9
+ 2048010p -0.3
+ \]
V_data_16 (Data\\<16\\> gnd!) vsource type=pwl wave=\[
+ 0    0.9
+ 2000p 0.9
+ 2010p -0.3
+ 4000p -0.3
+ 4010p 0.9
+ 6000p 0.9
+ 6010p -0.3
+ 8000p -0.3
+ 8010p 0.9
+ 10000p 0.9
+ 10010p -0.3
+ 12000p -0.3
+ 12010p 0.9
+ 14000p 0.9
+ 14010p -0.3
+ 16000p -0.3
+ 16010p 0.9
+ 18000p 0.9
+ 18010p -0.3
+ 20000p -0.3
+ 20010p 0.9
+ 22000p 0.9
+ 22010p -0.3
+ 24000p -0.3
+ 24010p 0.9
+ 26000p 0.9
+ 26010p -0.3
+ 28000p -0.3
+ 28010p 0.9
+ 30000p 0.9
+ 30010p -0.3
+ 32000p -0.3
+ 32010p 0.9
+ 34000p 0.9
+ 34010p -0.3
+ 36000p -0.3
+ 36010p 0.9
+ 38000p 0.9
+ 38010p -0.3
+ 40000p -0.3
+ 40010p 0.9
+ 42000p 0.9
+ 42010p -0.3
+ 44000p -0.3
+ 44010p 0.9
+ 46000p 0.9
+ 46010p -0.3
+ 48000p -0.3
+ 48010p 0.9
+ 50000p 0.9
+ 50010p -0.3
+ 52000p -0.3
+ 52010p 0.9
+ 54000p 0.9
+ 54010p -0.3
+ 56000p -0.3
+ 56010p 0.9
+ 58000p 0.9
+ 58010p -0.3
+ 60000p -0.3
+ 60010p 0.9
+ 62000p 0.9
+ 62010p -0.3
+ 64000p -0.3
+ 64010p 0.9
+ 66000p 0.9
+ 66010p -0.3
+ 68000p -0.3
+ 68010p 0.9
+ 70000p 0.9
+ 70010p -0.3
+ 72000p -0.3
+ 72010p 0.9
+ 74000p 0.9
+ 74010p -0.3
+ 76000p -0.3
+ 76010p 0.9
+ 78000p 0.9
+ 78010p -0.3
+ 80000p -0.3
+ 80010p 0.9
+ 82000p 0.9
+ 82010p -0.3
+ 84000p -0.3
+ 84010p 0.9
+ 86000p 0.9
+ 86010p -0.3
+ 88000p -0.3
+ 88010p 0.9
+ 90000p 0.9
+ 90010p -0.3
+ 92000p -0.3
+ 92010p 0.9
+ 94000p 0.9
+ 94010p -0.3
+ 96000p -0.3
+ 96010p 0.9
+ 98000p 0.9
+ 98010p -0.3
+ 100000p -0.3
+ 100010p 0.9
+ 102000p 0.9
+ 102010p -0.3
+ 104000p -0.3
+ 104010p 0.9
+ 106000p 0.9
+ 106010p -0.3
+ 108000p -0.3
+ 108010p 0.9
+ 110000p 0.9
+ 110010p -0.3
+ 112000p -0.3
+ 112010p 0.9
+ 114000p 0.9
+ 114010p -0.3
+ 116000p -0.3
+ 116010p 0.9
+ 118000p 0.9
+ 118010p -0.3
+ 120000p -0.3
+ 120010p 0.9
+ 122000p 0.9
+ 122010p -0.3
+ 124000p -0.3
+ 124010p 0.9
+ 126000p 0.9
+ 126010p -0.3
+ 128000p -0.3
+ 128010p 0.9
+ 130000p 0.9
+ 130010p -0.3
+ 132000p -0.3
+ 132010p 0.9
+ 134000p 0.9
+ 134010p -0.3
+ 136000p -0.3
+ 136010p 0.9
+ 138000p 0.9
+ 138010p -0.3
+ 140000p -0.3
+ 140010p 0.9
+ 142000p 0.9
+ 142010p -0.3
+ 144000p -0.3
+ 144010p 0.9
+ 146000p 0.9
+ 146010p -0.3
+ 148000p -0.3
+ 148010p 0.9
+ 150000p 0.9
+ 150010p -0.3
+ 152000p -0.3
+ 152010p 0.9
+ 154000p 0.9
+ 154010p -0.3
+ 156000p -0.3
+ 156010p 0.9
+ 158000p 0.9
+ 158010p -0.3
+ 160000p -0.3
+ 160010p 0.9
+ 162000p 0.9
+ 162010p -0.3
+ 164000p -0.3
+ 164010p 0.9
+ 166000p 0.9
+ 166010p -0.3
+ 168000p -0.3
+ 168010p 0.9
+ 170000p 0.9
+ 170010p -0.3
+ 172000p -0.3
+ 172010p 0.9
+ 174000p 0.9
+ 174010p -0.3
+ 176000p -0.3
+ 176010p 0.9
+ 178000p 0.9
+ 178010p -0.3
+ 180000p -0.3
+ 180010p 0.9
+ 182000p 0.9
+ 182010p -0.3
+ 184000p -0.3
+ 184010p 0.9
+ 186000p 0.9
+ 186010p -0.3
+ 188000p -0.3
+ 188010p 0.9
+ 190000p 0.9
+ 190010p -0.3
+ 192000p -0.3
+ 192010p 0.9
+ 194000p 0.9
+ 194010p -0.3
+ 196000p -0.3
+ 196010p 0.9
+ 198000p 0.9
+ 198010p -0.3
+ 200000p -0.3
+ 200010p 0.9
+ 202000p 0.9
+ 202010p -0.3
+ 204000p -0.3
+ 204010p 0.9
+ 206000p 0.9
+ 206010p -0.3
+ 208000p -0.3
+ 208010p 0.9
+ 210000p 0.9
+ 210010p -0.3
+ 212000p -0.3
+ 212010p 0.9
+ 214000p 0.9
+ 214010p -0.3
+ 216000p -0.3
+ 216010p 0.9
+ 218000p 0.9
+ 218010p -0.3
+ 220000p -0.3
+ 220010p 0.9
+ 222000p 0.9
+ 222010p -0.3
+ 224000p -0.3
+ 224010p 0.9
+ 226000p 0.9
+ 226010p -0.3
+ 228000p -0.3
+ 228010p 0.9
+ 230000p 0.9
+ 230010p -0.3
+ 232000p -0.3
+ 232010p 0.9
+ 234000p 0.9
+ 234010p -0.3
+ 236000p -0.3
+ 236010p 0.9
+ 238000p 0.9
+ 238010p -0.3
+ 240000p -0.3
+ 240010p 0.9
+ 242000p 0.9
+ 242010p -0.3
+ 244000p -0.3
+ 244010p 0.9
+ 246000p 0.9
+ 246010p -0.3
+ 248000p -0.3
+ 248010p 0.9
+ 250000p 0.9
+ 250010p -0.3
+ 252000p -0.3
+ 252010p 0.9
+ 254000p 0.9
+ 254010p -0.3
+ 256000p -0.3
+ 256010p 0.9
+ 258000p 0.9
+ 258010p -0.3
+ 260000p -0.3
+ 260010p 0.9
+ 262000p 0.9
+ 262010p -0.3
+ 264000p -0.3
+ 264010p 0.9
+ 266000p 0.9
+ 266010p -0.3
+ 268000p -0.3
+ 268010p 0.9
+ 270000p 0.9
+ 270010p -0.3
+ 272000p -0.3
+ 272010p 0.9
+ 274000p 0.9
+ 274010p -0.3
+ 276000p -0.3
+ 276010p 0.9
+ 278000p 0.9
+ 278010p -0.3
+ 280000p -0.3
+ 280010p 0.9
+ 282000p 0.9
+ 282010p -0.3
+ 284000p -0.3
+ 284010p 0.9
+ 286000p 0.9
+ 286010p -0.3
+ 288000p -0.3
+ 288010p 0.9
+ 290000p 0.9
+ 290010p -0.3
+ 292000p -0.3
+ 292010p 0.9
+ 294000p 0.9
+ 294010p -0.3
+ 296000p -0.3
+ 296010p 0.9
+ 298000p 0.9
+ 298010p -0.3
+ 300000p -0.3
+ 300010p 0.9
+ 302000p 0.9
+ 302010p -0.3
+ 304000p -0.3
+ 304010p 0.9
+ 306000p 0.9
+ 306010p -0.3
+ 308000p -0.3
+ 308010p 0.9
+ 310000p 0.9
+ 310010p -0.3
+ 312000p -0.3
+ 312010p 0.9
+ 314000p 0.9
+ 314010p -0.3
+ 316000p -0.3
+ 316010p 0.9
+ 318000p 0.9
+ 318010p -0.3
+ 320000p -0.3
+ 320010p 0.9
+ 322000p 0.9
+ 322010p -0.3
+ 324000p -0.3
+ 324010p 0.9
+ 326000p 0.9
+ 326010p -0.3
+ 328000p -0.3
+ 328010p 0.9
+ 330000p 0.9
+ 330010p -0.3
+ 332000p -0.3
+ 332010p 0.9
+ 334000p 0.9
+ 334010p -0.3
+ 336000p -0.3
+ 336010p 0.9
+ 338000p 0.9
+ 338010p -0.3
+ 340000p -0.3
+ 340010p 0.9
+ 342000p 0.9
+ 342010p -0.3
+ 344000p -0.3
+ 344010p 0.9
+ 346000p 0.9
+ 346010p -0.3
+ 348000p -0.3
+ 348010p 0.9
+ 350000p 0.9
+ 350010p -0.3
+ 352000p -0.3
+ 352010p 0.9
+ 354000p 0.9
+ 354010p -0.3
+ 356000p -0.3
+ 356010p 0.9
+ 358000p 0.9
+ 358010p -0.3
+ 360000p -0.3
+ 360010p 0.9
+ 362000p 0.9
+ 362010p -0.3
+ 364000p -0.3
+ 364010p 0.9
+ 366000p 0.9
+ 366010p -0.3
+ 368000p -0.3
+ 368010p 0.9
+ 370000p 0.9
+ 370010p -0.3
+ 372000p -0.3
+ 372010p 0.9
+ 374000p 0.9
+ 374010p -0.3
+ 376000p -0.3
+ 376010p 0.9
+ 378000p 0.9
+ 378010p -0.3
+ 380000p -0.3
+ 380010p 0.9
+ 382000p 0.9
+ 382010p -0.3
+ 384000p -0.3
+ 384010p 0.9
+ 386000p 0.9
+ 386010p -0.3
+ 388000p -0.3
+ 388010p 0.9
+ 390000p 0.9
+ 390010p -0.3
+ 392000p -0.3
+ 392010p 0.9
+ 394000p 0.9
+ 394010p -0.3
+ 396000p -0.3
+ 396010p 0.9
+ 398000p 0.9
+ 398010p -0.3
+ 400000p -0.3
+ 400010p 0.9
+ 402000p 0.9
+ 402010p -0.3
+ 404000p -0.3
+ 404010p 0.9
+ 406000p 0.9
+ 406010p -0.3
+ 408000p -0.3
+ 408010p 0.9
+ 410000p 0.9
+ 410010p -0.3
+ 412000p -0.3
+ 412010p 0.9
+ 414000p 0.9
+ 414010p -0.3
+ 416000p -0.3
+ 416010p 0.9
+ 418000p 0.9
+ 418010p -0.3
+ 420000p -0.3
+ 420010p 0.9
+ 422000p 0.9
+ 422010p -0.3
+ 424000p -0.3
+ 424010p 0.9
+ 426000p 0.9
+ 426010p -0.3
+ 428000p -0.3
+ 428010p 0.9
+ 430000p 0.9
+ 430010p -0.3
+ 432000p -0.3
+ 432010p 0.9
+ 434000p 0.9
+ 434010p -0.3
+ 436000p -0.3
+ 436010p 0.9
+ 438000p 0.9
+ 438010p -0.3
+ 440000p -0.3
+ 440010p 0.9
+ 442000p 0.9
+ 442010p -0.3
+ 444000p -0.3
+ 444010p 0.9
+ 446000p 0.9
+ 446010p -0.3
+ 448000p -0.3
+ 448010p 0.9
+ 450000p 0.9
+ 450010p -0.3
+ 452000p -0.3
+ 452010p 0.9
+ 454000p 0.9
+ 454010p -0.3
+ 456000p -0.3
+ 456010p 0.9
+ 458000p 0.9
+ 458010p -0.3
+ 460000p -0.3
+ 460010p 0.9
+ 462000p 0.9
+ 462010p -0.3
+ 464000p -0.3
+ 464010p 0.9
+ 466000p 0.9
+ 466010p -0.3
+ 468000p -0.3
+ 468010p 0.9
+ 470000p 0.9
+ 470010p -0.3
+ 472000p -0.3
+ 472010p 0.9
+ 474000p 0.9
+ 474010p -0.3
+ 476000p -0.3
+ 476010p 0.9
+ 478000p 0.9
+ 478010p -0.3
+ 480000p -0.3
+ 480010p 0.9
+ 482000p 0.9
+ 482010p -0.3
+ 484000p -0.3
+ 484010p 0.9
+ 486000p 0.9
+ 486010p -0.3
+ 488000p -0.3
+ 488010p 0.9
+ 490000p 0.9
+ 490010p -0.3
+ 492000p -0.3
+ 492010p 0.9
+ 494000p 0.9
+ 494010p -0.3
+ 496000p -0.3
+ 496010p 0.9
+ 498000p 0.9
+ 498010p -0.3
+ 500000p -0.3
+ 500010p 0.9
+ 502000p 0.9
+ 502010p -0.3
+ 504000p -0.3
+ 504010p 0.9
+ 506000p 0.9
+ 506010p -0.3
+ 508000p -0.3
+ 508010p 0.9
+ 510000p 0.9
+ 510010p -0.3
+ 512000p -0.3
+ 512010p 0.9
+ 514000p 0.9
+ 514010p -0.3
+ 516000p -0.3
+ 516010p 0.9
+ 518000p 0.9
+ 518010p -0.3
+ 520000p -0.3
+ 520010p 0.9
+ 522000p 0.9
+ 522010p -0.3
+ 524000p -0.3
+ 524010p 0.9
+ 526000p 0.9
+ 526010p -0.3
+ 528000p -0.3
+ 528010p 0.9
+ 530000p 0.9
+ 530010p -0.3
+ 532000p -0.3
+ 532010p 0.9
+ 534000p 0.9
+ 534010p -0.3
+ 536000p -0.3
+ 536010p 0.9
+ 538000p 0.9
+ 538010p -0.3
+ 540000p -0.3
+ 540010p 0.9
+ 542000p 0.9
+ 542010p -0.3
+ 544000p -0.3
+ 544010p 0.9
+ 546000p 0.9
+ 546010p -0.3
+ 548000p -0.3
+ 548010p 0.9
+ 550000p 0.9
+ 550010p -0.3
+ 552000p -0.3
+ 552010p 0.9
+ 554000p 0.9
+ 554010p -0.3
+ 556000p -0.3
+ 556010p 0.9
+ 558000p 0.9
+ 558010p -0.3
+ 560000p -0.3
+ 560010p 0.9
+ 562000p 0.9
+ 562010p -0.3
+ 564000p -0.3
+ 564010p 0.9
+ 566000p 0.9
+ 566010p -0.3
+ 568000p -0.3
+ 568010p 0.9
+ 570000p 0.9
+ 570010p -0.3
+ 572000p -0.3
+ 572010p 0.9
+ 574000p 0.9
+ 574010p -0.3
+ 576000p -0.3
+ 576010p 0.9
+ 578000p 0.9
+ 578010p -0.3
+ 580000p -0.3
+ 580010p 0.9
+ 582000p 0.9
+ 582010p -0.3
+ 584000p -0.3
+ 584010p 0.9
+ 586000p 0.9
+ 586010p -0.3
+ 588000p -0.3
+ 588010p 0.9
+ 590000p 0.9
+ 590010p -0.3
+ 592000p -0.3
+ 592010p 0.9
+ 594000p 0.9
+ 594010p -0.3
+ 596000p -0.3
+ 596010p 0.9
+ 598000p 0.9
+ 598010p -0.3
+ 600000p -0.3
+ 600010p 0.9
+ 602000p 0.9
+ 602010p -0.3
+ 604000p -0.3
+ 604010p 0.9
+ 606000p 0.9
+ 606010p -0.3
+ 608000p -0.3
+ 608010p 0.9
+ 610000p 0.9
+ 610010p -0.3
+ 612000p -0.3
+ 612010p 0.9
+ 614000p 0.9
+ 614010p -0.3
+ 616000p -0.3
+ 616010p 0.9
+ 618000p 0.9
+ 618010p -0.3
+ 620000p -0.3
+ 620010p 0.9
+ 622000p 0.9
+ 622010p -0.3
+ 624000p -0.3
+ 624010p 0.9
+ 626000p 0.9
+ 626010p -0.3
+ 628000p -0.3
+ 628010p 0.9
+ 630000p 0.9
+ 630010p -0.3
+ 632000p -0.3
+ 632010p 0.9
+ 634000p 0.9
+ 634010p -0.3
+ 636000p -0.3
+ 636010p 0.9
+ 638000p 0.9
+ 638010p -0.3
+ 640000p -0.3
+ 640010p 0.9
+ 642000p 0.9
+ 642010p -0.3
+ 644000p -0.3
+ 644010p 0.9
+ 646000p 0.9
+ 646010p -0.3
+ 648000p -0.3
+ 648010p 0.9
+ 650000p 0.9
+ 650010p -0.3
+ 652000p -0.3
+ 652010p 0.9
+ 654000p 0.9
+ 654010p -0.3
+ 656000p -0.3
+ 656010p 0.9
+ 658000p 0.9
+ 658010p -0.3
+ 660000p -0.3
+ 660010p 0.9
+ 662000p 0.9
+ 662010p -0.3
+ 664000p -0.3
+ 664010p 0.9
+ 666000p 0.9
+ 666010p -0.3
+ 668000p -0.3
+ 668010p 0.9
+ 670000p 0.9
+ 670010p -0.3
+ 672000p -0.3
+ 672010p 0.9
+ 674000p 0.9
+ 674010p -0.3
+ 676000p -0.3
+ 676010p 0.9
+ 678000p 0.9
+ 678010p -0.3
+ 680000p -0.3
+ 680010p 0.9
+ 682000p 0.9
+ 682010p -0.3
+ 684000p -0.3
+ 684010p 0.9
+ 686000p 0.9
+ 686010p -0.3
+ 688000p -0.3
+ 688010p 0.9
+ 690000p 0.9
+ 690010p -0.3
+ 692000p -0.3
+ 692010p 0.9
+ 694000p 0.9
+ 694010p -0.3
+ 696000p -0.3
+ 696010p 0.9
+ 698000p 0.9
+ 698010p -0.3
+ 700000p -0.3
+ 700010p 0.9
+ 702000p 0.9
+ 702010p -0.3
+ 704000p -0.3
+ 704010p 0.9
+ 706000p 0.9
+ 706010p -0.3
+ 708000p -0.3
+ 708010p 0.9
+ 710000p 0.9
+ 710010p -0.3
+ 712000p -0.3
+ 712010p 0.9
+ 714000p 0.9
+ 714010p -0.3
+ 716000p -0.3
+ 716010p 0.9
+ 718000p 0.9
+ 718010p -0.3
+ 720000p -0.3
+ 720010p 0.9
+ 722000p 0.9
+ 722010p -0.3
+ 724000p -0.3
+ 724010p 0.9
+ 726000p 0.9
+ 726010p -0.3
+ 728000p -0.3
+ 728010p 0.9
+ 730000p 0.9
+ 730010p -0.3
+ 732000p -0.3
+ 732010p 0.9
+ 734000p 0.9
+ 734010p -0.3
+ 736000p -0.3
+ 736010p 0.9
+ 738000p 0.9
+ 738010p -0.3
+ 740000p -0.3
+ 740010p 0.9
+ 742000p 0.9
+ 742010p -0.3
+ 744000p -0.3
+ 744010p 0.9
+ 746000p 0.9
+ 746010p -0.3
+ 748000p -0.3
+ 748010p 0.9
+ 750000p 0.9
+ 750010p -0.3
+ 752000p -0.3
+ 752010p 0.9
+ 754000p 0.9
+ 754010p -0.3
+ 756000p -0.3
+ 756010p 0.9
+ 758000p 0.9
+ 758010p -0.3
+ 760000p -0.3
+ 760010p 0.9
+ 762000p 0.9
+ 762010p -0.3
+ 764000p -0.3
+ 764010p 0.9
+ 766000p 0.9
+ 766010p -0.3
+ 768000p -0.3
+ 768010p 0.9
+ 770000p 0.9
+ 770010p -0.3
+ 772000p -0.3
+ 772010p 0.9
+ 774000p 0.9
+ 774010p -0.3
+ 776000p -0.3
+ 776010p 0.9
+ 778000p 0.9
+ 778010p -0.3
+ 780000p -0.3
+ 780010p 0.9
+ 782000p 0.9
+ 782010p -0.3
+ 784000p -0.3
+ 784010p 0.9
+ 786000p 0.9
+ 786010p -0.3
+ 788000p -0.3
+ 788010p 0.9
+ 790000p 0.9
+ 790010p -0.3
+ 792000p -0.3
+ 792010p 0.9
+ 794000p 0.9
+ 794010p -0.3
+ 796000p -0.3
+ 796010p 0.9
+ 798000p 0.9
+ 798010p -0.3
+ 800000p -0.3
+ 800010p 0.9
+ 802000p 0.9
+ 802010p -0.3
+ 804000p -0.3
+ 804010p 0.9
+ 806000p 0.9
+ 806010p -0.3
+ 808000p -0.3
+ 808010p 0.9
+ 810000p 0.9
+ 810010p -0.3
+ 812000p -0.3
+ 812010p 0.9
+ 814000p 0.9
+ 814010p -0.3
+ 816000p -0.3
+ 816010p 0.9
+ 818000p 0.9
+ 818010p -0.3
+ 820000p -0.3
+ 820010p 0.9
+ 822000p 0.9
+ 822010p -0.3
+ 824000p -0.3
+ 824010p 0.9
+ 826000p 0.9
+ 826010p -0.3
+ 828000p -0.3
+ 828010p 0.9
+ 830000p 0.9
+ 830010p -0.3
+ 832000p -0.3
+ 832010p 0.9
+ 834000p 0.9
+ 834010p -0.3
+ 836000p -0.3
+ 836010p 0.9
+ 838000p 0.9
+ 838010p -0.3
+ 840000p -0.3
+ 840010p 0.9
+ 842000p 0.9
+ 842010p -0.3
+ 844000p -0.3
+ 844010p 0.9
+ 846000p 0.9
+ 846010p -0.3
+ 848000p -0.3
+ 848010p 0.9
+ 850000p 0.9
+ 850010p -0.3
+ 852000p -0.3
+ 852010p 0.9
+ 854000p 0.9
+ 854010p -0.3
+ 856000p -0.3
+ 856010p 0.9
+ 858000p 0.9
+ 858010p -0.3
+ 860000p -0.3
+ 860010p 0.9
+ 862000p 0.9
+ 862010p -0.3
+ 864000p -0.3
+ 864010p 0.9
+ 866000p 0.9
+ 866010p -0.3
+ 868000p -0.3
+ 868010p 0.9
+ 870000p 0.9
+ 870010p -0.3
+ 872000p -0.3
+ 872010p 0.9
+ 874000p 0.9
+ 874010p -0.3
+ 876000p -0.3
+ 876010p 0.9
+ 878000p 0.9
+ 878010p -0.3
+ 880000p -0.3
+ 880010p 0.9
+ 882000p 0.9
+ 882010p -0.3
+ 884000p -0.3
+ 884010p 0.9
+ 886000p 0.9
+ 886010p -0.3
+ 888000p -0.3
+ 888010p 0.9
+ 890000p 0.9
+ 890010p -0.3
+ 892000p -0.3
+ 892010p 0.9
+ 894000p 0.9
+ 894010p -0.3
+ 896000p -0.3
+ 896010p 0.9
+ 898000p 0.9
+ 898010p -0.3
+ 900000p -0.3
+ 900010p 0.9
+ 902000p 0.9
+ 902010p -0.3
+ 904000p -0.3
+ 904010p 0.9
+ 906000p 0.9
+ 906010p -0.3
+ 908000p -0.3
+ 908010p 0.9
+ 910000p 0.9
+ 910010p -0.3
+ 912000p -0.3
+ 912010p 0.9
+ 914000p 0.9
+ 914010p -0.3
+ 916000p -0.3
+ 916010p 0.9
+ 918000p 0.9
+ 918010p -0.3
+ 920000p -0.3
+ 920010p 0.9
+ 922000p 0.9
+ 922010p -0.3
+ 924000p -0.3
+ 924010p 0.9
+ 926000p 0.9
+ 926010p -0.3
+ 928000p -0.3
+ 928010p 0.9
+ 930000p 0.9
+ 930010p -0.3
+ 932000p -0.3
+ 932010p 0.9
+ 934000p 0.9
+ 934010p -0.3
+ 936000p -0.3
+ 936010p 0.9
+ 938000p 0.9
+ 938010p -0.3
+ 940000p -0.3
+ 940010p 0.9
+ 942000p 0.9
+ 942010p -0.3
+ 944000p -0.3
+ 944010p 0.9
+ 946000p 0.9
+ 946010p -0.3
+ 948000p -0.3
+ 948010p 0.9
+ 950000p 0.9
+ 950010p -0.3
+ 952000p -0.3
+ 952010p 0.9
+ 954000p 0.9
+ 954010p -0.3
+ 956000p -0.3
+ 956010p 0.9
+ 958000p 0.9
+ 958010p -0.3
+ 960000p -0.3
+ 960010p 0.9
+ 962000p 0.9
+ 962010p -0.3
+ 964000p -0.3
+ 964010p 0.9
+ 966000p 0.9
+ 966010p -0.3
+ 968000p -0.3
+ 968010p 0.9
+ 970000p 0.9
+ 970010p -0.3
+ 972000p -0.3
+ 972010p 0.9
+ 974000p 0.9
+ 974010p -0.3
+ 976000p -0.3
+ 976010p 0.9
+ 978000p 0.9
+ 978010p -0.3
+ 980000p -0.3
+ 980010p 0.9
+ 982000p 0.9
+ 982010p -0.3
+ 984000p -0.3
+ 984010p 0.9
+ 986000p 0.9
+ 986010p -0.3
+ 988000p -0.3
+ 988010p 0.9
+ 990000p 0.9
+ 990010p -0.3
+ 992000p -0.3
+ 992010p 0.9
+ 994000p 0.9
+ 994010p -0.3
+ 996000p -0.3
+ 996010p 0.9
+ 998000p 0.9
+ 998010p -0.3
+ 1000000p -0.3
+ 1000010p 0.9
+ 1002000p 0.9
+ 1002010p -0.3
+ 1004000p -0.3
+ 1004010p 0.9
+ 1006000p 0.9
+ 1006010p -0.3
+ 1008000p -0.3
+ 1008010p 0.9
+ 1010000p 0.9
+ 1010010p -0.3
+ 1012000p -0.3
+ 1012010p 0.9
+ 1014000p 0.9
+ 1014010p -0.3
+ 1016000p -0.3
+ 1016010p 0.9
+ 1018000p 0.9
+ 1018010p -0.3
+ 1020000p -0.3
+ 1020010p 0.9
+ 1022000p 0.9
+ 1022010p -0.3
+ 1024000p -0.3
+ 1024010p 0.9
+ 1026000p 0.9
+ 1026010p -0.3
+ 1028000p -0.3
+ 1028010p 0.9
+ 1030000p 0.9
+ 1030010p -0.3
+ 1032000p -0.3
+ 1032010p 0.9
+ 1034000p 0.9
+ 1034010p -0.3
+ 1036000p -0.3
+ 1036010p 0.9
+ 1038000p 0.9
+ 1038010p -0.3
+ 1040000p -0.3
+ 1040010p 0.9
+ 1042000p 0.9
+ 1042010p -0.3
+ 1044000p -0.3
+ 1044010p 0.9
+ 1046000p 0.9
+ 1046010p -0.3
+ 1048000p -0.3
+ 1048010p 0.9
+ 1050000p 0.9
+ 1050010p -0.3
+ 1052000p -0.3
+ 1052010p 0.9
+ 1054000p 0.9
+ 1054010p -0.3
+ 1056000p -0.3
+ 1056010p 0.9
+ 1058000p 0.9
+ 1058010p -0.3
+ 1060000p -0.3
+ 1060010p 0.9
+ 1062000p 0.9
+ 1062010p -0.3
+ 1064000p -0.3
+ 1064010p 0.9
+ 1066000p 0.9
+ 1066010p -0.3
+ 1068000p -0.3
+ 1068010p 0.9
+ 1070000p 0.9
+ 1070010p -0.3
+ 1072000p -0.3
+ 1072010p 0.9
+ 1074000p 0.9
+ 1074010p -0.3
+ 1076000p -0.3
+ 1076010p 0.9
+ 1078000p 0.9
+ 1078010p -0.3
+ 1080000p -0.3
+ 1080010p 0.9
+ 1082000p 0.9
+ 1082010p -0.3
+ 1084000p -0.3
+ 1084010p 0.9
+ 1086000p 0.9
+ 1086010p -0.3
+ 1088000p -0.3
+ 1088010p 0.9
+ 1090000p 0.9
+ 1090010p -0.3
+ 1092000p -0.3
+ 1092010p 0.9
+ 1094000p 0.9
+ 1094010p -0.3
+ 1096000p -0.3
+ 1096010p 0.9
+ 1098000p 0.9
+ 1098010p -0.3
+ 1100000p -0.3
+ 1100010p 0.9
+ 1102000p 0.9
+ 1102010p -0.3
+ 1104000p -0.3
+ 1104010p 0.9
+ 1106000p 0.9
+ 1106010p -0.3
+ 1108000p -0.3
+ 1108010p 0.9
+ 1110000p 0.9
+ 1110010p -0.3
+ 1112000p -0.3
+ 1112010p 0.9
+ 1114000p 0.9
+ 1114010p -0.3
+ 1116000p -0.3
+ 1116010p 0.9
+ 1118000p 0.9
+ 1118010p -0.3
+ 1120000p -0.3
+ 1120010p 0.9
+ 1122000p 0.9
+ 1122010p -0.3
+ 1124000p -0.3
+ 1124010p 0.9
+ 1126000p 0.9
+ 1126010p -0.3
+ 1128000p -0.3
+ 1128010p 0.9
+ 1130000p 0.9
+ 1130010p -0.3
+ 1132000p -0.3
+ 1132010p 0.9
+ 1134000p 0.9
+ 1134010p -0.3
+ 1136000p -0.3
+ 1136010p 0.9
+ 1138000p 0.9
+ 1138010p -0.3
+ 1140000p -0.3
+ 1140010p 0.9
+ 1142000p 0.9
+ 1142010p -0.3
+ 1144000p -0.3
+ 1144010p 0.9
+ 1146000p 0.9
+ 1146010p -0.3
+ 1148000p -0.3
+ 1148010p 0.9
+ 1150000p 0.9
+ 1150010p -0.3
+ 1152000p -0.3
+ 1152010p 0.9
+ 1154000p 0.9
+ 1154010p -0.3
+ 1156000p -0.3
+ 1156010p 0.9
+ 1158000p 0.9
+ 1158010p -0.3
+ 1160000p -0.3
+ 1160010p 0.9
+ 1162000p 0.9
+ 1162010p -0.3
+ 1164000p -0.3
+ 1164010p 0.9
+ 1166000p 0.9
+ 1166010p -0.3
+ 1168000p -0.3
+ 1168010p 0.9
+ 1170000p 0.9
+ 1170010p -0.3
+ 1172000p -0.3
+ 1172010p 0.9
+ 1174000p 0.9
+ 1174010p -0.3
+ 1176000p -0.3
+ 1176010p 0.9
+ 1178000p 0.9
+ 1178010p -0.3
+ 1180000p -0.3
+ 1180010p 0.9
+ 1182000p 0.9
+ 1182010p -0.3
+ 1184000p -0.3
+ 1184010p 0.9
+ 1186000p 0.9
+ 1186010p -0.3
+ 1188000p -0.3
+ 1188010p 0.9
+ 1190000p 0.9
+ 1190010p -0.3
+ 1192000p -0.3
+ 1192010p 0.9
+ 1194000p 0.9
+ 1194010p -0.3
+ 1196000p -0.3
+ 1196010p 0.9
+ 1198000p 0.9
+ 1198010p -0.3
+ 1200000p -0.3
+ 1200010p 0.9
+ 1202000p 0.9
+ 1202010p -0.3
+ 1204000p -0.3
+ 1204010p 0.9
+ 1206000p 0.9
+ 1206010p -0.3
+ 1208000p -0.3
+ 1208010p 0.9
+ 1210000p 0.9
+ 1210010p -0.3
+ 1212000p -0.3
+ 1212010p 0.9
+ 1214000p 0.9
+ 1214010p -0.3
+ 1216000p -0.3
+ 1216010p 0.9
+ 1218000p 0.9
+ 1218010p -0.3
+ 1220000p -0.3
+ 1220010p 0.9
+ 1222000p 0.9
+ 1222010p -0.3
+ 1224000p -0.3
+ 1224010p 0.9
+ 1226000p 0.9
+ 1226010p -0.3
+ 1228000p -0.3
+ 1228010p 0.9
+ 1230000p 0.9
+ 1230010p -0.3
+ 1232000p -0.3
+ 1232010p 0.9
+ 1234000p 0.9
+ 1234010p -0.3
+ 1236000p -0.3
+ 1236010p 0.9
+ 1238000p 0.9
+ 1238010p -0.3
+ 1240000p -0.3
+ 1240010p 0.9
+ 1242000p 0.9
+ 1242010p -0.3
+ 1244000p -0.3
+ 1244010p 0.9
+ 1246000p 0.9
+ 1246010p -0.3
+ 1248000p -0.3
+ 1248010p 0.9
+ 1250000p 0.9
+ 1250010p -0.3
+ 1252000p -0.3
+ 1252010p 0.9
+ 1254000p 0.9
+ 1254010p -0.3
+ 1256000p -0.3
+ 1256010p 0.9
+ 1258000p 0.9
+ 1258010p -0.3
+ 1260000p -0.3
+ 1260010p 0.9
+ 1262000p 0.9
+ 1262010p -0.3
+ 1264000p -0.3
+ 1264010p 0.9
+ 1266000p 0.9
+ 1266010p -0.3
+ 1268000p -0.3
+ 1268010p 0.9
+ 1270000p 0.9
+ 1270010p -0.3
+ 1272000p -0.3
+ 1272010p 0.9
+ 1274000p 0.9
+ 1274010p -0.3
+ 1276000p -0.3
+ 1276010p 0.9
+ 1278000p 0.9
+ 1278010p -0.3
+ 1280000p -0.3
+ 1280010p 0.9
+ 1282000p 0.9
+ 1282010p -0.3
+ 1284000p -0.3
+ 1284010p 0.9
+ 1286000p 0.9
+ 1286010p -0.3
+ 1288000p -0.3
+ 1288010p 0.9
+ 1290000p 0.9
+ 1290010p -0.3
+ 1292000p -0.3
+ 1292010p 0.9
+ 1294000p 0.9
+ 1294010p -0.3
+ 1296000p -0.3
+ 1296010p 0.9
+ 1298000p 0.9
+ 1298010p -0.3
+ 1300000p -0.3
+ 1300010p 0.9
+ 1302000p 0.9
+ 1302010p -0.3
+ 1304000p -0.3
+ 1304010p 0.9
+ 1306000p 0.9
+ 1306010p -0.3
+ 1308000p -0.3
+ 1308010p 0.9
+ 1310000p 0.9
+ 1310010p -0.3
+ 1312000p -0.3
+ 1312010p 0.9
+ 1314000p 0.9
+ 1314010p -0.3
+ 1316000p -0.3
+ 1316010p 0.9
+ 1318000p 0.9
+ 1318010p -0.3
+ 1320000p -0.3
+ 1320010p 0.9
+ 1322000p 0.9
+ 1322010p -0.3
+ 1324000p -0.3
+ 1324010p 0.9
+ 1326000p 0.9
+ 1326010p -0.3
+ 1328000p -0.3
+ 1328010p 0.9
+ 1330000p 0.9
+ 1330010p -0.3
+ 1332000p -0.3
+ 1332010p 0.9
+ 1334000p 0.9
+ 1334010p -0.3
+ 1336000p -0.3
+ 1336010p 0.9
+ 1338000p 0.9
+ 1338010p -0.3
+ 1340000p -0.3
+ 1340010p 0.9
+ 1342000p 0.9
+ 1342010p -0.3
+ 1344000p -0.3
+ 1344010p 0.9
+ 1346000p 0.9
+ 1346010p -0.3
+ 1348000p -0.3
+ 1348010p 0.9
+ 1350000p 0.9
+ 1350010p -0.3
+ 1352000p -0.3
+ 1352010p 0.9
+ 1354000p 0.9
+ 1354010p -0.3
+ 1356000p -0.3
+ 1356010p 0.9
+ 1358000p 0.9
+ 1358010p -0.3
+ 1360000p -0.3
+ 1360010p 0.9
+ 1362000p 0.9
+ 1362010p -0.3
+ 1364000p -0.3
+ 1364010p 0.9
+ 1366000p 0.9
+ 1366010p -0.3
+ 1368000p -0.3
+ 1368010p 0.9
+ 1370000p 0.9
+ 1370010p -0.3
+ 1372000p -0.3
+ 1372010p 0.9
+ 1374000p 0.9
+ 1374010p -0.3
+ 1376000p -0.3
+ 1376010p 0.9
+ 1378000p 0.9
+ 1378010p -0.3
+ 1380000p -0.3
+ 1380010p 0.9
+ 1382000p 0.9
+ 1382010p -0.3
+ 1384000p -0.3
+ 1384010p 0.9
+ 1386000p 0.9
+ 1386010p -0.3
+ 1388000p -0.3
+ 1388010p 0.9
+ 1390000p 0.9
+ 1390010p -0.3
+ 1392000p -0.3
+ 1392010p 0.9
+ 1394000p 0.9
+ 1394010p -0.3
+ 1396000p -0.3
+ 1396010p 0.9
+ 1398000p 0.9
+ 1398010p -0.3
+ 1400000p -0.3
+ 1400010p 0.9
+ 1402000p 0.9
+ 1402010p -0.3
+ 1404000p -0.3
+ 1404010p 0.9
+ 1406000p 0.9
+ 1406010p -0.3
+ 1408000p -0.3
+ 1408010p 0.9
+ 1410000p 0.9
+ 1410010p -0.3
+ 1412000p -0.3
+ 1412010p 0.9
+ 1414000p 0.9
+ 1414010p -0.3
+ 1416000p -0.3
+ 1416010p 0.9
+ 1418000p 0.9
+ 1418010p -0.3
+ 1420000p -0.3
+ 1420010p 0.9
+ 1422000p 0.9
+ 1422010p -0.3
+ 1424000p -0.3
+ 1424010p 0.9
+ 1426000p 0.9
+ 1426010p -0.3
+ 1428000p -0.3
+ 1428010p 0.9
+ 1430000p 0.9
+ 1430010p -0.3
+ 1432000p -0.3
+ 1432010p 0.9
+ 1434000p 0.9
+ 1434010p -0.3
+ 1436000p -0.3
+ 1436010p 0.9
+ 1438000p 0.9
+ 1438010p -0.3
+ 1440000p -0.3
+ 1440010p 0.9
+ 1442000p 0.9
+ 1442010p -0.3
+ 1444000p -0.3
+ 1444010p 0.9
+ 1446000p 0.9
+ 1446010p -0.3
+ 1448000p -0.3
+ 1448010p 0.9
+ 1450000p 0.9
+ 1450010p -0.3
+ 1452000p -0.3
+ 1452010p 0.9
+ 1454000p 0.9
+ 1454010p -0.3
+ 1456000p -0.3
+ 1456010p 0.9
+ 1458000p 0.9
+ 1458010p -0.3
+ 1460000p -0.3
+ 1460010p 0.9
+ 1462000p 0.9
+ 1462010p -0.3
+ 1464000p -0.3
+ 1464010p 0.9
+ 1466000p 0.9
+ 1466010p -0.3
+ 1468000p -0.3
+ 1468010p 0.9
+ 1470000p 0.9
+ 1470010p -0.3
+ 1472000p -0.3
+ 1472010p 0.9
+ 1474000p 0.9
+ 1474010p -0.3
+ 1476000p -0.3
+ 1476010p 0.9
+ 1478000p 0.9
+ 1478010p -0.3
+ 1480000p -0.3
+ 1480010p 0.9
+ 1482000p 0.9
+ 1482010p -0.3
+ 1484000p -0.3
+ 1484010p 0.9
+ 1486000p 0.9
+ 1486010p -0.3
+ 1488000p -0.3
+ 1488010p 0.9
+ 1490000p 0.9
+ 1490010p -0.3
+ 1492000p -0.3
+ 1492010p 0.9
+ 1494000p 0.9
+ 1494010p -0.3
+ 1496000p -0.3
+ 1496010p 0.9
+ 1498000p 0.9
+ 1498010p -0.3
+ 1500000p -0.3
+ 1500010p 0.9
+ 1502000p 0.9
+ 1502010p -0.3
+ 1504000p -0.3
+ 1504010p 0.9
+ 1506000p 0.9
+ 1506010p -0.3
+ 1508000p -0.3
+ 1508010p 0.9
+ 1510000p 0.9
+ 1510010p -0.3
+ 1512000p -0.3
+ 1512010p 0.9
+ 1514000p 0.9
+ 1514010p -0.3
+ 1516000p -0.3
+ 1516010p 0.9
+ 1518000p 0.9
+ 1518010p -0.3
+ 1520000p -0.3
+ 1520010p 0.9
+ 1522000p 0.9
+ 1522010p -0.3
+ 1524000p -0.3
+ 1524010p 0.9
+ 1526000p 0.9
+ 1526010p -0.3
+ 1528000p -0.3
+ 1528010p 0.9
+ 1530000p 0.9
+ 1530010p -0.3
+ 1532000p -0.3
+ 1532010p 0.9
+ 1534000p 0.9
+ 1534010p -0.3
+ 1536000p -0.3
+ 1536010p 0.9
+ 1538000p 0.9
+ 1538010p -0.3
+ 1540000p -0.3
+ 1540010p 0.9
+ 1542000p 0.9
+ 1542010p -0.3
+ 1544000p -0.3
+ 1544010p 0.9
+ 1546000p 0.9
+ 1546010p -0.3
+ 1548000p -0.3
+ 1548010p 0.9
+ 1550000p 0.9
+ 1550010p -0.3
+ 1552000p -0.3
+ 1552010p 0.9
+ 1554000p 0.9
+ 1554010p -0.3
+ 1556000p -0.3
+ 1556010p 0.9
+ 1558000p 0.9
+ 1558010p -0.3
+ 1560000p -0.3
+ 1560010p 0.9
+ 1562000p 0.9
+ 1562010p -0.3
+ 1564000p -0.3
+ 1564010p 0.9
+ 1566000p 0.9
+ 1566010p -0.3
+ 1568000p -0.3
+ 1568010p 0.9
+ 1570000p 0.9
+ 1570010p -0.3
+ 1572000p -0.3
+ 1572010p 0.9
+ 1574000p 0.9
+ 1574010p -0.3
+ 1576000p -0.3
+ 1576010p 0.9
+ 1578000p 0.9
+ 1578010p -0.3
+ 1580000p -0.3
+ 1580010p 0.9
+ 1582000p 0.9
+ 1582010p -0.3
+ 1584000p -0.3
+ 1584010p 0.9
+ 1586000p 0.9
+ 1586010p -0.3
+ 1588000p -0.3
+ 1588010p 0.9
+ 1590000p 0.9
+ 1590010p -0.3
+ 1592000p -0.3
+ 1592010p 0.9
+ 1594000p 0.9
+ 1594010p -0.3
+ 1596000p -0.3
+ 1596010p 0.9
+ 1598000p 0.9
+ 1598010p -0.3
+ 1600000p -0.3
+ 1600010p 0.9
+ 1602000p 0.9
+ 1602010p -0.3
+ 1604000p -0.3
+ 1604010p 0.9
+ 1606000p 0.9
+ 1606010p -0.3
+ 1608000p -0.3
+ 1608010p 0.9
+ 1610000p 0.9
+ 1610010p -0.3
+ 1612000p -0.3
+ 1612010p 0.9
+ 1614000p 0.9
+ 1614010p -0.3
+ 1616000p -0.3
+ 1616010p 0.9
+ 1618000p 0.9
+ 1618010p -0.3
+ 1620000p -0.3
+ 1620010p 0.9
+ 1622000p 0.9
+ 1622010p -0.3
+ 1624000p -0.3
+ 1624010p 0.9
+ 1626000p 0.9
+ 1626010p -0.3
+ 1628000p -0.3
+ 1628010p 0.9
+ 1630000p 0.9
+ 1630010p -0.3
+ 1632000p -0.3
+ 1632010p 0.9
+ 1634000p 0.9
+ 1634010p -0.3
+ 1636000p -0.3
+ 1636010p 0.9
+ 1638000p 0.9
+ 1638010p -0.3
+ 1640000p -0.3
+ 1640010p 0.9
+ 1642000p 0.9
+ 1642010p -0.3
+ 1644000p -0.3
+ 1644010p 0.9
+ 1646000p 0.9
+ 1646010p -0.3
+ 1648000p -0.3
+ 1648010p 0.9
+ 1650000p 0.9
+ 1650010p -0.3
+ 1652000p -0.3
+ 1652010p 0.9
+ 1654000p 0.9
+ 1654010p -0.3
+ 1656000p -0.3
+ 1656010p 0.9
+ 1658000p 0.9
+ 1658010p -0.3
+ 1660000p -0.3
+ 1660010p 0.9
+ 1662000p 0.9
+ 1662010p -0.3
+ 1664000p -0.3
+ 1664010p 0.9
+ 1666000p 0.9
+ 1666010p -0.3
+ 1668000p -0.3
+ 1668010p 0.9
+ 1670000p 0.9
+ 1670010p -0.3
+ 1672000p -0.3
+ 1672010p 0.9
+ 1674000p 0.9
+ 1674010p -0.3
+ 1676000p -0.3
+ 1676010p 0.9
+ 1678000p 0.9
+ 1678010p -0.3
+ 1680000p -0.3
+ 1680010p 0.9
+ 1682000p 0.9
+ 1682010p -0.3
+ 1684000p -0.3
+ 1684010p 0.9
+ 1686000p 0.9
+ 1686010p -0.3
+ 1688000p -0.3
+ 1688010p 0.9
+ 1690000p 0.9
+ 1690010p -0.3
+ 1692000p -0.3
+ 1692010p 0.9
+ 1694000p 0.9
+ 1694010p -0.3
+ 1696000p -0.3
+ 1696010p 0.9
+ 1698000p 0.9
+ 1698010p -0.3
+ 1700000p -0.3
+ 1700010p 0.9
+ 1702000p 0.9
+ 1702010p -0.3
+ 1704000p -0.3
+ 1704010p 0.9
+ 1706000p 0.9
+ 1706010p -0.3
+ 1708000p -0.3
+ 1708010p 0.9
+ 1710000p 0.9
+ 1710010p -0.3
+ 1712000p -0.3
+ 1712010p 0.9
+ 1714000p 0.9
+ 1714010p -0.3
+ 1716000p -0.3
+ 1716010p 0.9
+ 1718000p 0.9
+ 1718010p -0.3
+ 1720000p -0.3
+ 1720010p 0.9
+ 1722000p 0.9
+ 1722010p -0.3
+ 1724000p -0.3
+ 1724010p 0.9
+ 1726000p 0.9
+ 1726010p -0.3
+ 1728000p -0.3
+ 1728010p 0.9
+ 1730000p 0.9
+ 1730010p -0.3
+ 1732000p -0.3
+ 1732010p 0.9
+ 1734000p 0.9
+ 1734010p -0.3
+ 1736000p -0.3
+ 1736010p 0.9
+ 1738000p 0.9
+ 1738010p -0.3
+ 1740000p -0.3
+ 1740010p 0.9
+ 1742000p 0.9
+ 1742010p -0.3
+ 1744000p -0.3
+ 1744010p 0.9
+ 1746000p 0.9
+ 1746010p -0.3
+ 1748000p -0.3
+ 1748010p 0.9
+ 1750000p 0.9
+ 1750010p -0.3
+ 1752000p -0.3
+ 1752010p 0.9
+ 1754000p 0.9
+ 1754010p -0.3
+ 1756000p -0.3
+ 1756010p 0.9
+ 1758000p 0.9
+ 1758010p -0.3
+ 1760000p -0.3
+ 1760010p 0.9
+ 1762000p 0.9
+ 1762010p -0.3
+ 1764000p -0.3
+ 1764010p 0.9
+ 1766000p 0.9
+ 1766010p -0.3
+ 1768000p -0.3
+ 1768010p 0.9
+ 1770000p 0.9
+ 1770010p -0.3
+ 1772000p -0.3
+ 1772010p 0.9
+ 1774000p 0.9
+ 1774010p -0.3
+ 1776000p -0.3
+ 1776010p 0.9
+ 1778000p 0.9
+ 1778010p -0.3
+ 1780000p -0.3
+ 1780010p 0.9
+ 1782000p 0.9
+ 1782010p -0.3
+ 1784000p -0.3
+ 1784010p 0.9
+ 1786000p 0.9
+ 1786010p -0.3
+ 1788000p -0.3
+ 1788010p 0.9
+ 1790000p 0.9
+ 1790010p -0.3
+ 1792000p -0.3
+ 1792010p 0.9
+ 1794000p 0.9
+ 1794010p -0.3
+ 1796000p -0.3
+ 1796010p 0.9
+ 1798000p 0.9
+ 1798010p -0.3
+ 1800000p -0.3
+ 1800010p 0.9
+ 1802000p 0.9
+ 1802010p -0.3
+ 1804000p -0.3
+ 1804010p 0.9
+ 1806000p 0.9
+ 1806010p -0.3
+ 1808000p -0.3
+ 1808010p 0.9
+ 1810000p 0.9
+ 1810010p -0.3
+ 1812000p -0.3
+ 1812010p 0.9
+ 1814000p 0.9
+ 1814010p -0.3
+ 1816000p -0.3
+ 1816010p 0.9
+ 1818000p 0.9
+ 1818010p -0.3
+ 1820000p -0.3
+ 1820010p 0.9
+ 1822000p 0.9
+ 1822010p -0.3
+ 1824000p -0.3
+ 1824010p 0.9
+ 1826000p 0.9
+ 1826010p -0.3
+ 1828000p -0.3
+ 1828010p 0.9
+ 1830000p 0.9
+ 1830010p -0.3
+ 1832000p -0.3
+ 1832010p 0.9
+ 1834000p 0.9
+ 1834010p -0.3
+ 1836000p -0.3
+ 1836010p 0.9
+ 1838000p 0.9
+ 1838010p -0.3
+ 1840000p -0.3
+ 1840010p 0.9
+ 1842000p 0.9
+ 1842010p -0.3
+ 1844000p -0.3
+ 1844010p 0.9
+ 1846000p 0.9
+ 1846010p -0.3
+ 1848000p -0.3
+ 1848010p 0.9
+ 1850000p 0.9
+ 1850010p -0.3
+ 1852000p -0.3
+ 1852010p 0.9
+ 1854000p 0.9
+ 1854010p -0.3
+ 1856000p -0.3
+ 1856010p 0.9
+ 1858000p 0.9
+ 1858010p -0.3
+ 1860000p -0.3
+ 1860010p 0.9
+ 1862000p 0.9
+ 1862010p -0.3
+ 1864000p -0.3
+ 1864010p 0.9
+ 1866000p 0.9
+ 1866010p -0.3
+ 1868000p -0.3
+ 1868010p 0.9
+ 1870000p 0.9
+ 1870010p -0.3
+ 1872000p -0.3
+ 1872010p 0.9
+ 1874000p 0.9
+ 1874010p -0.3
+ 1876000p -0.3
+ 1876010p 0.9
+ 1878000p 0.9
+ 1878010p -0.3
+ 1880000p -0.3
+ 1880010p 0.9
+ 1882000p 0.9
+ 1882010p -0.3
+ 1884000p -0.3
+ 1884010p 0.9
+ 1886000p 0.9
+ 1886010p -0.3
+ 1888000p -0.3
+ 1888010p 0.9
+ 1890000p 0.9
+ 1890010p -0.3
+ 1892000p -0.3
+ 1892010p 0.9
+ 1894000p 0.9
+ 1894010p -0.3
+ 1896000p -0.3
+ 1896010p 0.9
+ 1898000p 0.9
+ 1898010p -0.3
+ 1900000p -0.3
+ 1900010p 0.9
+ 1902000p 0.9
+ 1902010p -0.3
+ 1904000p -0.3
+ 1904010p 0.9
+ 1906000p 0.9
+ 1906010p -0.3
+ 1908000p -0.3
+ 1908010p 0.9
+ 1910000p 0.9
+ 1910010p -0.3
+ 1912000p -0.3
+ 1912010p 0.9
+ 1914000p 0.9
+ 1914010p -0.3
+ 1916000p -0.3
+ 1916010p 0.9
+ 1918000p 0.9
+ 1918010p -0.3
+ 1920000p -0.3
+ 1920010p 0.9
+ 1922000p 0.9
+ 1922010p -0.3
+ 1924000p -0.3
+ 1924010p 0.9
+ 1926000p 0.9
+ 1926010p -0.3
+ 1928000p -0.3
+ 1928010p 0.9
+ 1930000p 0.9
+ 1930010p -0.3
+ 1932000p -0.3
+ 1932010p 0.9
+ 1934000p 0.9
+ 1934010p -0.3
+ 1936000p -0.3
+ 1936010p 0.9
+ 1938000p 0.9
+ 1938010p -0.3
+ 1940000p -0.3
+ 1940010p 0.9
+ 1942000p 0.9
+ 1942010p -0.3
+ 1944000p -0.3
+ 1944010p 0.9
+ 1946000p 0.9
+ 1946010p -0.3
+ 1948000p -0.3
+ 1948010p 0.9
+ 1950000p 0.9
+ 1950010p -0.3
+ 1952000p -0.3
+ 1952010p 0.9
+ 1954000p 0.9
+ 1954010p -0.3
+ 1956000p -0.3
+ 1956010p 0.9
+ 1958000p 0.9
+ 1958010p -0.3
+ 1960000p -0.3
+ 1960010p 0.9
+ 1962000p 0.9
+ 1962010p -0.3
+ 1964000p -0.3
+ 1964010p 0.9
+ 1966000p 0.9
+ 1966010p -0.3
+ 1968000p -0.3
+ 1968010p 0.9
+ 1970000p 0.9
+ 1970010p -0.3
+ 1972000p -0.3
+ 1972010p 0.9
+ 1974000p 0.9
+ 1974010p -0.3
+ 1976000p -0.3
+ 1976010p 0.9
+ 1978000p 0.9
+ 1978010p -0.3
+ 1980000p -0.3
+ 1980010p 0.9
+ 1982000p 0.9
+ 1982010p -0.3
+ 1984000p -0.3
+ 1984010p 0.9
+ 1986000p 0.9
+ 1986010p -0.3
+ 1988000p -0.3
+ 1988010p 0.9
+ 1990000p 0.9
+ 1990010p -0.3
+ 1992000p -0.3
+ 1992010p 0.9
+ 1994000p 0.9
+ 1994010p -0.3
+ 1996000p -0.3
+ 1996010p 0.9
+ 1998000p 0.9
+ 1998010p -0.3
+ 2000000p -0.3
+ 2000010p 0.9
+ 2002000p 0.9
+ 2002010p -0.3
+ 2004000p -0.3
+ 2004010p 0.9
+ 2006000p 0.9
+ 2006010p -0.3
+ 2008000p -0.3
+ 2008010p 0.9
+ 2010000p 0.9
+ 2010010p -0.3
+ 2012000p -0.3
+ 2012010p 0.9
+ 2014000p 0.9
+ 2014010p -0.3
+ 2016000p -0.3
+ 2016010p 0.9
+ 2018000p 0.9
+ 2018010p -0.3
+ 2020000p -0.3
+ 2020010p 0.9
+ 2022000p 0.9
+ 2022010p -0.3
+ 2024000p -0.3
+ 2024010p 0.9
+ 2026000p 0.9
+ 2026010p -0.3
+ 2028000p -0.3
+ 2028010p 0.9
+ 2030000p 0.9
+ 2030010p -0.3
+ 2032000p -0.3
+ 2032010p 0.9
+ 2034000p 0.9
+ 2034010p -0.3
+ 2036000p -0.3
+ 2036010p 0.9
+ 2038000p 0.9
+ 2038010p -0.3
+ 2040000p -0.3
+ 2040010p 0.9
+ 2042000p 0.9
+ 2042010p -0.3
+ 2044000p -0.3
+ 2044010p 0.9
+ 2046000p 0.9
+ 2046010p -0.3
+ 2048000p -0.3
+ 2048010p 0.9
+ \]
V_data_bar_16 (Data_bar\\<16\\> gnd!) vsource type=pwl wave=\[
+ 0    -0.3
+ 2000p -0.3
+ 2010p 0.9
+ 4000p 0.9
+ 4010p -0.3
+ 6000p -0.3
+ 6010p 0.9
+ 8000p 0.9
+ 8010p -0.3
+ 10000p -0.3
+ 10010p 0.9
+ 12000p 0.9
+ 12010p -0.3
+ 14000p -0.3
+ 14010p 0.9
+ 16000p 0.9
+ 16010p -0.3
+ 18000p -0.3
+ 18010p 0.9
+ 20000p 0.9
+ 20010p -0.3
+ 22000p -0.3
+ 22010p 0.9
+ 24000p 0.9
+ 24010p -0.3
+ 26000p -0.3
+ 26010p 0.9
+ 28000p 0.9
+ 28010p -0.3
+ 30000p -0.3
+ 30010p 0.9
+ 32000p 0.9
+ 32010p -0.3
+ 34000p -0.3
+ 34010p 0.9
+ 36000p 0.9
+ 36010p -0.3
+ 38000p -0.3
+ 38010p 0.9
+ 40000p 0.9
+ 40010p -0.3
+ 42000p -0.3
+ 42010p 0.9
+ 44000p 0.9
+ 44010p -0.3
+ 46000p -0.3
+ 46010p 0.9
+ 48000p 0.9
+ 48010p -0.3
+ 50000p -0.3
+ 50010p 0.9
+ 52000p 0.9
+ 52010p -0.3
+ 54000p -0.3
+ 54010p 0.9
+ 56000p 0.9
+ 56010p -0.3
+ 58000p -0.3
+ 58010p 0.9
+ 60000p 0.9
+ 60010p -0.3
+ 62000p -0.3
+ 62010p 0.9
+ 64000p 0.9
+ 64010p -0.3
+ 66000p -0.3
+ 66010p 0.9
+ 68000p 0.9
+ 68010p -0.3
+ 70000p -0.3
+ 70010p 0.9
+ 72000p 0.9
+ 72010p -0.3
+ 74000p -0.3
+ 74010p 0.9
+ 76000p 0.9
+ 76010p -0.3
+ 78000p -0.3
+ 78010p 0.9
+ 80000p 0.9
+ 80010p -0.3
+ 82000p -0.3
+ 82010p 0.9
+ 84000p 0.9
+ 84010p -0.3
+ 86000p -0.3
+ 86010p 0.9
+ 88000p 0.9
+ 88010p -0.3
+ 90000p -0.3
+ 90010p 0.9
+ 92000p 0.9
+ 92010p -0.3
+ 94000p -0.3
+ 94010p 0.9
+ 96000p 0.9
+ 96010p -0.3
+ 98000p -0.3
+ 98010p 0.9
+ 100000p 0.9
+ 100010p -0.3
+ 102000p -0.3
+ 102010p 0.9
+ 104000p 0.9
+ 104010p -0.3
+ 106000p -0.3
+ 106010p 0.9
+ 108000p 0.9
+ 108010p -0.3
+ 110000p -0.3
+ 110010p 0.9
+ 112000p 0.9
+ 112010p -0.3
+ 114000p -0.3
+ 114010p 0.9
+ 116000p 0.9
+ 116010p -0.3
+ 118000p -0.3
+ 118010p 0.9
+ 120000p 0.9
+ 120010p -0.3
+ 122000p -0.3
+ 122010p 0.9
+ 124000p 0.9
+ 124010p -0.3
+ 126000p -0.3
+ 126010p 0.9
+ 128000p 0.9
+ 128010p -0.3
+ 130000p -0.3
+ 130010p 0.9
+ 132000p 0.9
+ 132010p -0.3
+ 134000p -0.3
+ 134010p 0.9
+ 136000p 0.9
+ 136010p -0.3
+ 138000p -0.3
+ 138010p 0.9
+ 140000p 0.9
+ 140010p -0.3
+ 142000p -0.3
+ 142010p 0.9
+ 144000p 0.9
+ 144010p -0.3
+ 146000p -0.3
+ 146010p 0.9
+ 148000p 0.9
+ 148010p -0.3
+ 150000p -0.3
+ 150010p 0.9
+ 152000p 0.9
+ 152010p -0.3
+ 154000p -0.3
+ 154010p 0.9
+ 156000p 0.9
+ 156010p -0.3
+ 158000p -0.3
+ 158010p 0.9
+ 160000p 0.9
+ 160010p -0.3
+ 162000p -0.3
+ 162010p 0.9
+ 164000p 0.9
+ 164010p -0.3
+ 166000p -0.3
+ 166010p 0.9
+ 168000p 0.9
+ 168010p -0.3
+ 170000p -0.3
+ 170010p 0.9
+ 172000p 0.9
+ 172010p -0.3
+ 174000p -0.3
+ 174010p 0.9
+ 176000p 0.9
+ 176010p -0.3
+ 178000p -0.3
+ 178010p 0.9
+ 180000p 0.9
+ 180010p -0.3
+ 182000p -0.3
+ 182010p 0.9
+ 184000p 0.9
+ 184010p -0.3
+ 186000p -0.3
+ 186010p 0.9
+ 188000p 0.9
+ 188010p -0.3
+ 190000p -0.3
+ 190010p 0.9
+ 192000p 0.9
+ 192010p -0.3
+ 194000p -0.3
+ 194010p 0.9
+ 196000p 0.9
+ 196010p -0.3
+ 198000p -0.3
+ 198010p 0.9
+ 200000p 0.9
+ 200010p -0.3
+ 202000p -0.3
+ 202010p 0.9
+ 204000p 0.9
+ 204010p -0.3
+ 206000p -0.3
+ 206010p 0.9
+ 208000p 0.9
+ 208010p -0.3
+ 210000p -0.3
+ 210010p 0.9
+ 212000p 0.9
+ 212010p -0.3
+ 214000p -0.3
+ 214010p 0.9
+ 216000p 0.9
+ 216010p -0.3
+ 218000p -0.3
+ 218010p 0.9
+ 220000p 0.9
+ 220010p -0.3
+ 222000p -0.3
+ 222010p 0.9
+ 224000p 0.9
+ 224010p -0.3
+ 226000p -0.3
+ 226010p 0.9
+ 228000p 0.9
+ 228010p -0.3
+ 230000p -0.3
+ 230010p 0.9
+ 232000p 0.9
+ 232010p -0.3
+ 234000p -0.3
+ 234010p 0.9
+ 236000p 0.9
+ 236010p -0.3
+ 238000p -0.3
+ 238010p 0.9
+ 240000p 0.9
+ 240010p -0.3
+ 242000p -0.3
+ 242010p 0.9
+ 244000p 0.9
+ 244010p -0.3
+ 246000p -0.3
+ 246010p 0.9
+ 248000p 0.9
+ 248010p -0.3
+ 250000p -0.3
+ 250010p 0.9
+ 252000p 0.9
+ 252010p -0.3
+ 254000p -0.3
+ 254010p 0.9
+ 256000p 0.9
+ 256010p -0.3
+ 258000p -0.3
+ 258010p 0.9
+ 260000p 0.9
+ 260010p -0.3
+ 262000p -0.3
+ 262010p 0.9
+ 264000p 0.9
+ 264010p -0.3
+ 266000p -0.3
+ 266010p 0.9
+ 268000p 0.9
+ 268010p -0.3
+ 270000p -0.3
+ 270010p 0.9
+ 272000p 0.9
+ 272010p -0.3
+ 274000p -0.3
+ 274010p 0.9
+ 276000p 0.9
+ 276010p -0.3
+ 278000p -0.3
+ 278010p 0.9
+ 280000p 0.9
+ 280010p -0.3
+ 282000p -0.3
+ 282010p 0.9
+ 284000p 0.9
+ 284010p -0.3
+ 286000p -0.3
+ 286010p 0.9
+ 288000p 0.9
+ 288010p -0.3
+ 290000p -0.3
+ 290010p 0.9
+ 292000p 0.9
+ 292010p -0.3
+ 294000p -0.3
+ 294010p 0.9
+ 296000p 0.9
+ 296010p -0.3
+ 298000p -0.3
+ 298010p 0.9
+ 300000p 0.9
+ 300010p -0.3
+ 302000p -0.3
+ 302010p 0.9
+ 304000p 0.9
+ 304010p -0.3
+ 306000p -0.3
+ 306010p 0.9
+ 308000p 0.9
+ 308010p -0.3
+ 310000p -0.3
+ 310010p 0.9
+ 312000p 0.9
+ 312010p -0.3
+ 314000p -0.3
+ 314010p 0.9
+ 316000p 0.9
+ 316010p -0.3
+ 318000p -0.3
+ 318010p 0.9
+ 320000p 0.9
+ 320010p -0.3
+ 322000p -0.3
+ 322010p 0.9
+ 324000p 0.9
+ 324010p -0.3
+ 326000p -0.3
+ 326010p 0.9
+ 328000p 0.9
+ 328010p -0.3
+ 330000p -0.3
+ 330010p 0.9
+ 332000p 0.9
+ 332010p -0.3
+ 334000p -0.3
+ 334010p 0.9
+ 336000p 0.9
+ 336010p -0.3
+ 338000p -0.3
+ 338010p 0.9
+ 340000p 0.9
+ 340010p -0.3
+ 342000p -0.3
+ 342010p 0.9
+ 344000p 0.9
+ 344010p -0.3
+ 346000p -0.3
+ 346010p 0.9
+ 348000p 0.9
+ 348010p -0.3
+ 350000p -0.3
+ 350010p 0.9
+ 352000p 0.9
+ 352010p -0.3
+ 354000p -0.3
+ 354010p 0.9
+ 356000p 0.9
+ 356010p -0.3
+ 358000p -0.3
+ 358010p 0.9
+ 360000p 0.9
+ 360010p -0.3
+ 362000p -0.3
+ 362010p 0.9
+ 364000p 0.9
+ 364010p -0.3
+ 366000p -0.3
+ 366010p 0.9
+ 368000p 0.9
+ 368010p -0.3
+ 370000p -0.3
+ 370010p 0.9
+ 372000p 0.9
+ 372010p -0.3
+ 374000p -0.3
+ 374010p 0.9
+ 376000p 0.9
+ 376010p -0.3
+ 378000p -0.3
+ 378010p 0.9
+ 380000p 0.9
+ 380010p -0.3
+ 382000p -0.3
+ 382010p 0.9
+ 384000p 0.9
+ 384010p -0.3
+ 386000p -0.3
+ 386010p 0.9
+ 388000p 0.9
+ 388010p -0.3
+ 390000p -0.3
+ 390010p 0.9
+ 392000p 0.9
+ 392010p -0.3
+ 394000p -0.3
+ 394010p 0.9
+ 396000p 0.9
+ 396010p -0.3
+ 398000p -0.3
+ 398010p 0.9
+ 400000p 0.9
+ 400010p -0.3
+ 402000p -0.3
+ 402010p 0.9
+ 404000p 0.9
+ 404010p -0.3
+ 406000p -0.3
+ 406010p 0.9
+ 408000p 0.9
+ 408010p -0.3
+ 410000p -0.3
+ 410010p 0.9
+ 412000p 0.9
+ 412010p -0.3
+ 414000p -0.3
+ 414010p 0.9
+ 416000p 0.9
+ 416010p -0.3
+ 418000p -0.3
+ 418010p 0.9
+ 420000p 0.9
+ 420010p -0.3
+ 422000p -0.3
+ 422010p 0.9
+ 424000p 0.9
+ 424010p -0.3
+ 426000p -0.3
+ 426010p 0.9
+ 428000p 0.9
+ 428010p -0.3
+ 430000p -0.3
+ 430010p 0.9
+ 432000p 0.9
+ 432010p -0.3
+ 434000p -0.3
+ 434010p 0.9
+ 436000p 0.9
+ 436010p -0.3
+ 438000p -0.3
+ 438010p 0.9
+ 440000p 0.9
+ 440010p -0.3
+ 442000p -0.3
+ 442010p 0.9
+ 444000p 0.9
+ 444010p -0.3
+ 446000p -0.3
+ 446010p 0.9
+ 448000p 0.9
+ 448010p -0.3
+ 450000p -0.3
+ 450010p 0.9
+ 452000p 0.9
+ 452010p -0.3
+ 454000p -0.3
+ 454010p 0.9
+ 456000p 0.9
+ 456010p -0.3
+ 458000p -0.3
+ 458010p 0.9
+ 460000p 0.9
+ 460010p -0.3
+ 462000p -0.3
+ 462010p 0.9
+ 464000p 0.9
+ 464010p -0.3
+ 466000p -0.3
+ 466010p 0.9
+ 468000p 0.9
+ 468010p -0.3
+ 470000p -0.3
+ 470010p 0.9
+ 472000p 0.9
+ 472010p -0.3
+ 474000p -0.3
+ 474010p 0.9
+ 476000p 0.9
+ 476010p -0.3
+ 478000p -0.3
+ 478010p 0.9
+ 480000p 0.9
+ 480010p -0.3
+ 482000p -0.3
+ 482010p 0.9
+ 484000p 0.9
+ 484010p -0.3
+ 486000p -0.3
+ 486010p 0.9
+ 488000p 0.9
+ 488010p -0.3
+ 490000p -0.3
+ 490010p 0.9
+ 492000p 0.9
+ 492010p -0.3
+ 494000p -0.3
+ 494010p 0.9
+ 496000p 0.9
+ 496010p -0.3
+ 498000p -0.3
+ 498010p 0.9
+ 500000p 0.9
+ 500010p -0.3
+ 502000p -0.3
+ 502010p 0.9
+ 504000p 0.9
+ 504010p -0.3
+ 506000p -0.3
+ 506010p 0.9
+ 508000p 0.9
+ 508010p -0.3
+ 510000p -0.3
+ 510010p 0.9
+ 512000p 0.9
+ 512010p -0.3
+ 514000p -0.3
+ 514010p 0.9
+ 516000p 0.9
+ 516010p -0.3
+ 518000p -0.3
+ 518010p 0.9
+ 520000p 0.9
+ 520010p -0.3
+ 522000p -0.3
+ 522010p 0.9
+ 524000p 0.9
+ 524010p -0.3
+ 526000p -0.3
+ 526010p 0.9
+ 528000p 0.9
+ 528010p -0.3
+ 530000p -0.3
+ 530010p 0.9
+ 532000p 0.9
+ 532010p -0.3
+ 534000p -0.3
+ 534010p 0.9
+ 536000p 0.9
+ 536010p -0.3
+ 538000p -0.3
+ 538010p 0.9
+ 540000p 0.9
+ 540010p -0.3
+ 542000p -0.3
+ 542010p 0.9
+ 544000p 0.9
+ 544010p -0.3
+ 546000p -0.3
+ 546010p 0.9
+ 548000p 0.9
+ 548010p -0.3
+ 550000p -0.3
+ 550010p 0.9
+ 552000p 0.9
+ 552010p -0.3
+ 554000p -0.3
+ 554010p 0.9
+ 556000p 0.9
+ 556010p -0.3
+ 558000p -0.3
+ 558010p 0.9
+ 560000p 0.9
+ 560010p -0.3
+ 562000p -0.3
+ 562010p 0.9
+ 564000p 0.9
+ 564010p -0.3
+ 566000p -0.3
+ 566010p 0.9
+ 568000p 0.9
+ 568010p -0.3
+ 570000p -0.3
+ 570010p 0.9
+ 572000p 0.9
+ 572010p -0.3
+ 574000p -0.3
+ 574010p 0.9
+ 576000p 0.9
+ 576010p -0.3
+ 578000p -0.3
+ 578010p 0.9
+ 580000p 0.9
+ 580010p -0.3
+ 582000p -0.3
+ 582010p 0.9
+ 584000p 0.9
+ 584010p -0.3
+ 586000p -0.3
+ 586010p 0.9
+ 588000p 0.9
+ 588010p -0.3
+ 590000p -0.3
+ 590010p 0.9
+ 592000p 0.9
+ 592010p -0.3
+ 594000p -0.3
+ 594010p 0.9
+ 596000p 0.9
+ 596010p -0.3
+ 598000p -0.3
+ 598010p 0.9
+ 600000p 0.9
+ 600010p -0.3
+ 602000p -0.3
+ 602010p 0.9
+ 604000p 0.9
+ 604010p -0.3
+ 606000p -0.3
+ 606010p 0.9
+ 608000p 0.9
+ 608010p -0.3
+ 610000p -0.3
+ 610010p 0.9
+ 612000p 0.9
+ 612010p -0.3
+ 614000p -0.3
+ 614010p 0.9
+ 616000p 0.9
+ 616010p -0.3
+ 618000p -0.3
+ 618010p 0.9
+ 620000p 0.9
+ 620010p -0.3
+ 622000p -0.3
+ 622010p 0.9
+ 624000p 0.9
+ 624010p -0.3
+ 626000p -0.3
+ 626010p 0.9
+ 628000p 0.9
+ 628010p -0.3
+ 630000p -0.3
+ 630010p 0.9
+ 632000p 0.9
+ 632010p -0.3
+ 634000p -0.3
+ 634010p 0.9
+ 636000p 0.9
+ 636010p -0.3
+ 638000p -0.3
+ 638010p 0.9
+ 640000p 0.9
+ 640010p -0.3
+ 642000p -0.3
+ 642010p 0.9
+ 644000p 0.9
+ 644010p -0.3
+ 646000p -0.3
+ 646010p 0.9
+ 648000p 0.9
+ 648010p -0.3
+ 650000p -0.3
+ 650010p 0.9
+ 652000p 0.9
+ 652010p -0.3
+ 654000p -0.3
+ 654010p 0.9
+ 656000p 0.9
+ 656010p -0.3
+ 658000p -0.3
+ 658010p 0.9
+ 660000p 0.9
+ 660010p -0.3
+ 662000p -0.3
+ 662010p 0.9
+ 664000p 0.9
+ 664010p -0.3
+ 666000p -0.3
+ 666010p 0.9
+ 668000p 0.9
+ 668010p -0.3
+ 670000p -0.3
+ 670010p 0.9
+ 672000p 0.9
+ 672010p -0.3
+ 674000p -0.3
+ 674010p 0.9
+ 676000p 0.9
+ 676010p -0.3
+ 678000p -0.3
+ 678010p 0.9
+ 680000p 0.9
+ 680010p -0.3
+ 682000p -0.3
+ 682010p 0.9
+ 684000p 0.9
+ 684010p -0.3
+ 686000p -0.3
+ 686010p 0.9
+ 688000p 0.9
+ 688010p -0.3
+ 690000p -0.3
+ 690010p 0.9
+ 692000p 0.9
+ 692010p -0.3
+ 694000p -0.3
+ 694010p 0.9
+ 696000p 0.9
+ 696010p -0.3
+ 698000p -0.3
+ 698010p 0.9
+ 700000p 0.9
+ 700010p -0.3
+ 702000p -0.3
+ 702010p 0.9
+ 704000p 0.9
+ 704010p -0.3
+ 706000p -0.3
+ 706010p 0.9
+ 708000p 0.9
+ 708010p -0.3
+ 710000p -0.3
+ 710010p 0.9
+ 712000p 0.9
+ 712010p -0.3
+ 714000p -0.3
+ 714010p 0.9
+ 716000p 0.9
+ 716010p -0.3
+ 718000p -0.3
+ 718010p 0.9
+ 720000p 0.9
+ 720010p -0.3
+ 722000p -0.3
+ 722010p 0.9
+ 724000p 0.9
+ 724010p -0.3
+ 726000p -0.3
+ 726010p 0.9
+ 728000p 0.9
+ 728010p -0.3
+ 730000p -0.3
+ 730010p 0.9
+ 732000p 0.9
+ 732010p -0.3
+ 734000p -0.3
+ 734010p 0.9
+ 736000p 0.9
+ 736010p -0.3
+ 738000p -0.3
+ 738010p 0.9
+ 740000p 0.9
+ 740010p -0.3
+ 742000p -0.3
+ 742010p 0.9
+ 744000p 0.9
+ 744010p -0.3
+ 746000p -0.3
+ 746010p 0.9
+ 748000p 0.9
+ 748010p -0.3
+ 750000p -0.3
+ 750010p 0.9
+ 752000p 0.9
+ 752010p -0.3
+ 754000p -0.3
+ 754010p 0.9
+ 756000p 0.9
+ 756010p -0.3
+ 758000p -0.3
+ 758010p 0.9
+ 760000p 0.9
+ 760010p -0.3
+ 762000p -0.3
+ 762010p 0.9
+ 764000p 0.9
+ 764010p -0.3
+ 766000p -0.3
+ 766010p 0.9
+ 768000p 0.9
+ 768010p -0.3
+ 770000p -0.3
+ 770010p 0.9
+ 772000p 0.9
+ 772010p -0.3
+ 774000p -0.3
+ 774010p 0.9
+ 776000p 0.9
+ 776010p -0.3
+ 778000p -0.3
+ 778010p 0.9
+ 780000p 0.9
+ 780010p -0.3
+ 782000p -0.3
+ 782010p 0.9
+ 784000p 0.9
+ 784010p -0.3
+ 786000p -0.3
+ 786010p 0.9
+ 788000p 0.9
+ 788010p -0.3
+ 790000p -0.3
+ 790010p 0.9
+ 792000p 0.9
+ 792010p -0.3
+ 794000p -0.3
+ 794010p 0.9
+ 796000p 0.9
+ 796010p -0.3
+ 798000p -0.3
+ 798010p 0.9
+ 800000p 0.9
+ 800010p -0.3
+ 802000p -0.3
+ 802010p 0.9
+ 804000p 0.9
+ 804010p -0.3
+ 806000p -0.3
+ 806010p 0.9
+ 808000p 0.9
+ 808010p -0.3
+ 810000p -0.3
+ 810010p 0.9
+ 812000p 0.9
+ 812010p -0.3
+ 814000p -0.3
+ 814010p 0.9
+ 816000p 0.9
+ 816010p -0.3
+ 818000p -0.3
+ 818010p 0.9
+ 820000p 0.9
+ 820010p -0.3
+ 822000p -0.3
+ 822010p 0.9
+ 824000p 0.9
+ 824010p -0.3
+ 826000p -0.3
+ 826010p 0.9
+ 828000p 0.9
+ 828010p -0.3
+ 830000p -0.3
+ 830010p 0.9
+ 832000p 0.9
+ 832010p -0.3
+ 834000p -0.3
+ 834010p 0.9
+ 836000p 0.9
+ 836010p -0.3
+ 838000p -0.3
+ 838010p 0.9
+ 840000p 0.9
+ 840010p -0.3
+ 842000p -0.3
+ 842010p 0.9
+ 844000p 0.9
+ 844010p -0.3
+ 846000p -0.3
+ 846010p 0.9
+ 848000p 0.9
+ 848010p -0.3
+ 850000p -0.3
+ 850010p 0.9
+ 852000p 0.9
+ 852010p -0.3
+ 854000p -0.3
+ 854010p 0.9
+ 856000p 0.9
+ 856010p -0.3
+ 858000p -0.3
+ 858010p 0.9
+ 860000p 0.9
+ 860010p -0.3
+ 862000p -0.3
+ 862010p 0.9
+ 864000p 0.9
+ 864010p -0.3
+ 866000p -0.3
+ 866010p 0.9
+ 868000p 0.9
+ 868010p -0.3
+ 870000p -0.3
+ 870010p 0.9
+ 872000p 0.9
+ 872010p -0.3
+ 874000p -0.3
+ 874010p 0.9
+ 876000p 0.9
+ 876010p -0.3
+ 878000p -0.3
+ 878010p 0.9
+ 880000p 0.9
+ 880010p -0.3
+ 882000p -0.3
+ 882010p 0.9
+ 884000p 0.9
+ 884010p -0.3
+ 886000p -0.3
+ 886010p 0.9
+ 888000p 0.9
+ 888010p -0.3
+ 890000p -0.3
+ 890010p 0.9
+ 892000p 0.9
+ 892010p -0.3
+ 894000p -0.3
+ 894010p 0.9
+ 896000p 0.9
+ 896010p -0.3
+ 898000p -0.3
+ 898010p 0.9
+ 900000p 0.9
+ 900010p -0.3
+ 902000p -0.3
+ 902010p 0.9
+ 904000p 0.9
+ 904010p -0.3
+ 906000p -0.3
+ 906010p 0.9
+ 908000p 0.9
+ 908010p -0.3
+ 910000p -0.3
+ 910010p 0.9
+ 912000p 0.9
+ 912010p -0.3
+ 914000p -0.3
+ 914010p 0.9
+ 916000p 0.9
+ 916010p -0.3
+ 918000p -0.3
+ 918010p 0.9
+ 920000p 0.9
+ 920010p -0.3
+ 922000p -0.3
+ 922010p 0.9
+ 924000p 0.9
+ 924010p -0.3
+ 926000p -0.3
+ 926010p 0.9
+ 928000p 0.9
+ 928010p -0.3
+ 930000p -0.3
+ 930010p 0.9
+ 932000p 0.9
+ 932010p -0.3
+ 934000p -0.3
+ 934010p 0.9
+ 936000p 0.9
+ 936010p -0.3
+ 938000p -0.3
+ 938010p 0.9
+ 940000p 0.9
+ 940010p -0.3
+ 942000p -0.3
+ 942010p 0.9
+ 944000p 0.9
+ 944010p -0.3
+ 946000p -0.3
+ 946010p 0.9
+ 948000p 0.9
+ 948010p -0.3
+ 950000p -0.3
+ 950010p 0.9
+ 952000p 0.9
+ 952010p -0.3
+ 954000p -0.3
+ 954010p 0.9
+ 956000p 0.9
+ 956010p -0.3
+ 958000p -0.3
+ 958010p 0.9
+ 960000p 0.9
+ 960010p -0.3
+ 962000p -0.3
+ 962010p 0.9
+ 964000p 0.9
+ 964010p -0.3
+ 966000p -0.3
+ 966010p 0.9
+ 968000p 0.9
+ 968010p -0.3
+ 970000p -0.3
+ 970010p 0.9
+ 972000p 0.9
+ 972010p -0.3
+ 974000p -0.3
+ 974010p 0.9
+ 976000p 0.9
+ 976010p -0.3
+ 978000p -0.3
+ 978010p 0.9
+ 980000p 0.9
+ 980010p -0.3
+ 982000p -0.3
+ 982010p 0.9
+ 984000p 0.9
+ 984010p -0.3
+ 986000p -0.3
+ 986010p 0.9
+ 988000p 0.9
+ 988010p -0.3
+ 990000p -0.3
+ 990010p 0.9
+ 992000p 0.9
+ 992010p -0.3
+ 994000p -0.3
+ 994010p 0.9
+ 996000p 0.9
+ 996010p -0.3
+ 998000p -0.3
+ 998010p 0.9
+ 1000000p 0.9
+ 1000010p -0.3
+ 1002000p -0.3
+ 1002010p 0.9
+ 1004000p 0.9
+ 1004010p -0.3
+ 1006000p -0.3
+ 1006010p 0.9
+ 1008000p 0.9
+ 1008010p -0.3
+ 1010000p -0.3
+ 1010010p 0.9
+ 1012000p 0.9
+ 1012010p -0.3
+ 1014000p -0.3
+ 1014010p 0.9
+ 1016000p 0.9
+ 1016010p -0.3
+ 1018000p -0.3
+ 1018010p 0.9
+ 1020000p 0.9
+ 1020010p -0.3
+ 1022000p -0.3
+ 1022010p 0.9
+ 1024000p 0.9
+ 1024010p -0.3
+ 1026000p -0.3
+ 1026010p 0.9
+ 1028000p 0.9
+ 1028010p -0.3
+ 1030000p -0.3
+ 1030010p 0.9
+ 1032000p 0.9
+ 1032010p -0.3
+ 1034000p -0.3
+ 1034010p 0.9
+ 1036000p 0.9
+ 1036010p -0.3
+ 1038000p -0.3
+ 1038010p 0.9
+ 1040000p 0.9
+ 1040010p -0.3
+ 1042000p -0.3
+ 1042010p 0.9
+ 1044000p 0.9
+ 1044010p -0.3
+ 1046000p -0.3
+ 1046010p 0.9
+ 1048000p 0.9
+ 1048010p -0.3
+ 1050000p -0.3
+ 1050010p 0.9
+ 1052000p 0.9
+ 1052010p -0.3
+ 1054000p -0.3
+ 1054010p 0.9
+ 1056000p 0.9
+ 1056010p -0.3
+ 1058000p -0.3
+ 1058010p 0.9
+ 1060000p 0.9
+ 1060010p -0.3
+ 1062000p -0.3
+ 1062010p 0.9
+ 1064000p 0.9
+ 1064010p -0.3
+ 1066000p -0.3
+ 1066010p 0.9
+ 1068000p 0.9
+ 1068010p -0.3
+ 1070000p -0.3
+ 1070010p 0.9
+ 1072000p 0.9
+ 1072010p -0.3
+ 1074000p -0.3
+ 1074010p 0.9
+ 1076000p 0.9
+ 1076010p -0.3
+ 1078000p -0.3
+ 1078010p 0.9
+ 1080000p 0.9
+ 1080010p -0.3
+ 1082000p -0.3
+ 1082010p 0.9
+ 1084000p 0.9
+ 1084010p -0.3
+ 1086000p -0.3
+ 1086010p 0.9
+ 1088000p 0.9
+ 1088010p -0.3
+ 1090000p -0.3
+ 1090010p 0.9
+ 1092000p 0.9
+ 1092010p -0.3
+ 1094000p -0.3
+ 1094010p 0.9
+ 1096000p 0.9
+ 1096010p -0.3
+ 1098000p -0.3
+ 1098010p 0.9
+ 1100000p 0.9
+ 1100010p -0.3
+ 1102000p -0.3
+ 1102010p 0.9
+ 1104000p 0.9
+ 1104010p -0.3
+ 1106000p -0.3
+ 1106010p 0.9
+ 1108000p 0.9
+ 1108010p -0.3
+ 1110000p -0.3
+ 1110010p 0.9
+ 1112000p 0.9
+ 1112010p -0.3
+ 1114000p -0.3
+ 1114010p 0.9
+ 1116000p 0.9
+ 1116010p -0.3
+ 1118000p -0.3
+ 1118010p 0.9
+ 1120000p 0.9
+ 1120010p -0.3
+ 1122000p -0.3
+ 1122010p 0.9
+ 1124000p 0.9
+ 1124010p -0.3
+ 1126000p -0.3
+ 1126010p 0.9
+ 1128000p 0.9
+ 1128010p -0.3
+ 1130000p -0.3
+ 1130010p 0.9
+ 1132000p 0.9
+ 1132010p -0.3
+ 1134000p -0.3
+ 1134010p 0.9
+ 1136000p 0.9
+ 1136010p -0.3
+ 1138000p -0.3
+ 1138010p 0.9
+ 1140000p 0.9
+ 1140010p -0.3
+ 1142000p -0.3
+ 1142010p 0.9
+ 1144000p 0.9
+ 1144010p -0.3
+ 1146000p -0.3
+ 1146010p 0.9
+ 1148000p 0.9
+ 1148010p -0.3
+ 1150000p -0.3
+ 1150010p 0.9
+ 1152000p 0.9
+ 1152010p -0.3
+ 1154000p -0.3
+ 1154010p 0.9
+ 1156000p 0.9
+ 1156010p -0.3
+ 1158000p -0.3
+ 1158010p 0.9
+ 1160000p 0.9
+ 1160010p -0.3
+ 1162000p -0.3
+ 1162010p 0.9
+ 1164000p 0.9
+ 1164010p -0.3
+ 1166000p -0.3
+ 1166010p 0.9
+ 1168000p 0.9
+ 1168010p -0.3
+ 1170000p -0.3
+ 1170010p 0.9
+ 1172000p 0.9
+ 1172010p -0.3
+ 1174000p -0.3
+ 1174010p 0.9
+ 1176000p 0.9
+ 1176010p -0.3
+ 1178000p -0.3
+ 1178010p 0.9
+ 1180000p 0.9
+ 1180010p -0.3
+ 1182000p -0.3
+ 1182010p 0.9
+ 1184000p 0.9
+ 1184010p -0.3
+ 1186000p -0.3
+ 1186010p 0.9
+ 1188000p 0.9
+ 1188010p -0.3
+ 1190000p -0.3
+ 1190010p 0.9
+ 1192000p 0.9
+ 1192010p -0.3
+ 1194000p -0.3
+ 1194010p 0.9
+ 1196000p 0.9
+ 1196010p -0.3
+ 1198000p -0.3
+ 1198010p 0.9
+ 1200000p 0.9
+ 1200010p -0.3
+ 1202000p -0.3
+ 1202010p 0.9
+ 1204000p 0.9
+ 1204010p -0.3
+ 1206000p -0.3
+ 1206010p 0.9
+ 1208000p 0.9
+ 1208010p -0.3
+ 1210000p -0.3
+ 1210010p 0.9
+ 1212000p 0.9
+ 1212010p -0.3
+ 1214000p -0.3
+ 1214010p 0.9
+ 1216000p 0.9
+ 1216010p -0.3
+ 1218000p -0.3
+ 1218010p 0.9
+ 1220000p 0.9
+ 1220010p -0.3
+ 1222000p -0.3
+ 1222010p 0.9
+ 1224000p 0.9
+ 1224010p -0.3
+ 1226000p -0.3
+ 1226010p 0.9
+ 1228000p 0.9
+ 1228010p -0.3
+ 1230000p -0.3
+ 1230010p 0.9
+ 1232000p 0.9
+ 1232010p -0.3
+ 1234000p -0.3
+ 1234010p 0.9
+ 1236000p 0.9
+ 1236010p -0.3
+ 1238000p -0.3
+ 1238010p 0.9
+ 1240000p 0.9
+ 1240010p -0.3
+ 1242000p -0.3
+ 1242010p 0.9
+ 1244000p 0.9
+ 1244010p -0.3
+ 1246000p -0.3
+ 1246010p 0.9
+ 1248000p 0.9
+ 1248010p -0.3
+ 1250000p -0.3
+ 1250010p 0.9
+ 1252000p 0.9
+ 1252010p -0.3
+ 1254000p -0.3
+ 1254010p 0.9
+ 1256000p 0.9
+ 1256010p -0.3
+ 1258000p -0.3
+ 1258010p 0.9
+ 1260000p 0.9
+ 1260010p -0.3
+ 1262000p -0.3
+ 1262010p 0.9
+ 1264000p 0.9
+ 1264010p -0.3
+ 1266000p -0.3
+ 1266010p 0.9
+ 1268000p 0.9
+ 1268010p -0.3
+ 1270000p -0.3
+ 1270010p 0.9
+ 1272000p 0.9
+ 1272010p -0.3
+ 1274000p -0.3
+ 1274010p 0.9
+ 1276000p 0.9
+ 1276010p -0.3
+ 1278000p -0.3
+ 1278010p 0.9
+ 1280000p 0.9
+ 1280010p -0.3
+ 1282000p -0.3
+ 1282010p 0.9
+ 1284000p 0.9
+ 1284010p -0.3
+ 1286000p -0.3
+ 1286010p 0.9
+ 1288000p 0.9
+ 1288010p -0.3
+ 1290000p -0.3
+ 1290010p 0.9
+ 1292000p 0.9
+ 1292010p -0.3
+ 1294000p -0.3
+ 1294010p 0.9
+ 1296000p 0.9
+ 1296010p -0.3
+ 1298000p -0.3
+ 1298010p 0.9
+ 1300000p 0.9
+ 1300010p -0.3
+ 1302000p -0.3
+ 1302010p 0.9
+ 1304000p 0.9
+ 1304010p -0.3
+ 1306000p -0.3
+ 1306010p 0.9
+ 1308000p 0.9
+ 1308010p -0.3
+ 1310000p -0.3
+ 1310010p 0.9
+ 1312000p 0.9
+ 1312010p -0.3
+ 1314000p -0.3
+ 1314010p 0.9
+ 1316000p 0.9
+ 1316010p -0.3
+ 1318000p -0.3
+ 1318010p 0.9
+ 1320000p 0.9
+ 1320010p -0.3
+ 1322000p -0.3
+ 1322010p 0.9
+ 1324000p 0.9
+ 1324010p -0.3
+ 1326000p -0.3
+ 1326010p 0.9
+ 1328000p 0.9
+ 1328010p -0.3
+ 1330000p -0.3
+ 1330010p 0.9
+ 1332000p 0.9
+ 1332010p -0.3
+ 1334000p -0.3
+ 1334010p 0.9
+ 1336000p 0.9
+ 1336010p -0.3
+ 1338000p -0.3
+ 1338010p 0.9
+ 1340000p 0.9
+ 1340010p -0.3
+ 1342000p -0.3
+ 1342010p 0.9
+ 1344000p 0.9
+ 1344010p -0.3
+ 1346000p -0.3
+ 1346010p 0.9
+ 1348000p 0.9
+ 1348010p -0.3
+ 1350000p -0.3
+ 1350010p 0.9
+ 1352000p 0.9
+ 1352010p -0.3
+ 1354000p -0.3
+ 1354010p 0.9
+ 1356000p 0.9
+ 1356010p -0.3
+ 1358000p -0.3
+ 1358010p 0.9
+ 1360000p 0.9
+ 1360010p -0.3
+ 1362000p -0.3
+ 1362010p 0.9
+ 1364000p 0.9
+ 1364010p -0.3
+ 1366000p -0.3
+ 1366010p 0.9
+ 1368000p 0.9
+ 1368010p -0.3
+ 1370000p -0.3
+ 1370010p 0.9
+ 1372000p 0.9
+ 1372010p -0.3
+ 1374000p -0.3
+ 1374010p 0.9
+ 1376000p 0.9
+ 1376010p -0.3
+ 1378000p -0.3
+ 1378010p 0.9
+ 1380000p 0.9
+ 1380010p -0.3
+ 1382000p -0.3
+ 1382010p 0.9
+ 1384000p 0.9
+ 1384010p -0.3
+ 1386000p -0.3
+ 1386010p 0.9
+ 1388000p 0.9
+ 1388010p -0.3
+ 1390000p -0.3
+ 1390010p 0.9
+ 1392000p 0.9
+ 1392010p -0.3
+ 1394000p -0.3
+ 1394010p 0.9
+ 1396000p 0.9
+ 1396010p -0.3
+ 1398000p -0.3
+ 1398010p 0.9
+ 1400000p 0.9
+ 1400010p -0.3
+ 1402000p -0.3
+ 1402010p 0.9
+ 1404000p 0.9
+ 1404010p -0.3
+ 1406000p -0.3
+ 1406010p 0.9
+ 1408000p 0.9
+ 1408010p -0.3
+ 1410000p -0.3
+ 1410010p 0.9
+ 1412000p 0.9
+ 1412010p -0.3
+ 1414000p -0.3
+ 1414010p 0.9
+ 1416000p 0.9
+ 1416010p -0.3
+ 1418000p -0.3
+ 1418010p 0.9
+ 1420000p 0.9
+ 1420010p -0.3
+ 1422000p -0.3
+ 1422010p 0.9
+ 1424000p 0.9
+ 1424010p -0.3
+ 1426000p -0.3
+ 1426010p 0.9
+ 1428000p 0.9
+ 1428010p -0.3
+ 1430000p -0.3
+ 1430010p 0.9
+ 1432000p 0.9
+ 1432010p -0.3
+ 1434000p -0.3
+ 1434010p 0.9
+ 1436000p 0.9
+ 1436010p -0.3
+ 1438000p -0.3
+ 1438010p 0.9
+ 1440000p 0.9
+ 1440010p -0.3
+ 1442000p -0.3
+ 1442010p 0.9
+ 1444000p 0.9
+ 1444010p -0.3
+ 1446000p -0.3
+ 1446010p 0.9
+ 1448000p 0.9
+ 1448010p -0.3
+ 1450000p -0.3
+ 1450010p 0.9
+ 1452000p 0.9
+ 1452010p -0.3
+ 1454000p -0.3
+ 1454010p 0.9
+ 1456000p 0.9
+ 1456010p -0.3
+ 1458000p -0.3
+ 1458010p 0.9
+ 1460000p 0.9
+ 1460010p -0.3
+ 1462000p -0.3
+ 1462010p 0.9
+ 1464000p 0.9
+ 1464010p -0.3
+ 1466000p -0.3
+ 1466010p 0.9
+ 1468000p 0.9
+ 1468010p -0.3
+ 1470000p -0.3
+ 1470010p 0.9
+ 1472000p 0.9
+ 1472010p -0.3
+ 1474000p -0.3
+ 1474010p 0.9
+ 1476000p 0.9
+ 1476010p -0.3
+ 1478000p -0.3
+ 1478010p 0.9
+ 1480000p 0.9
+ 1480010p -0.3
+ 1482000p -0.3
+ 1482010p 0.9
+ 1484000p 0.9
+ 1484010p -0.3
+ 1486000p -0.3
+ 1486010p 0.9
+ 1488000p 0.9
+ 1488010p -0.3
+ 1490000p -0.3
+ 1490010p 0.9
+ 1492000p 0.9
+ 1492010p -0.3
+ 1494000p -0.3
+ 1494010p 0.9
+ 1496000p 0.9
+ 1496010p -0.3
+ 1498000p -0.3
+ 1498010p 0.9
+ 1500000p 0.9
+ 1500010p -0.3
+ 1502000p -0.3
+ 1502010p 0.9
+ 1504000p 0.9
+ 1504010p -0.3
+ 1506000p -0.3
+ 1506010p 0.9
+ 1508000p 0.9
+ 1508010p -0.3
+ 1510000p -0.3
+ 1510010p 0.9
+ 1512000p 0.9
+ 1512010p -0.3
+ 1514000p -0.3
+ 1514010p 0.9
+ 1516000p 0.9
+ 1516010p -0.3
+ 1518000p -0.3
+ 1518010p 0.9
+ 1520000p 0.9
+ 1520010p -0.3
+ 1522000p -0.3
+ 1522010p 0.9
+ 1524000p 0.9
+ 1524010p -0.3
+ 1526000p -0.3
+ 1526010p 0.9
+ 1528000p 0.9
+ 1528010p -0.3
+ 1530000p -0.3
+ 1530010p 0.9
+ 1532000p 0.9
+ 1532010p -0.3
+ 1534000p -0.3
+ 1534010p 0.9
+ 1536000p 0.9
+ 1536010p -0.3
+ 1538000p -0.3
+ 1538010p 0.9
+ 1540000p 0.9
+ 1540010p -0.3
+ 1542000p -0.3
+ 1542010p 0.9
+ 1544000p 0.9
+ 1544010p -0.3
+ 1546000p -0.3
+ 1546010p 0.9
+ 1548000p 0.9
+ 1548010p -0.3
+ 1550000p -0.3
+ 1550010p 0.9
+ 1552000p 0.9
+ 1552010p -0.3
+ 1554000p -0.3
+ 1554010p 0.9
+ 1556000p 0.9
+ 1556010p -0.3
+ 1558000p -0.3
+ 1558010p 0.9
+ 1560000p 0.9
+ 1560010p -0.3
+ 1562000p -0.3
+ 1562010p 0.9
+ 1564000p 0.9
+ 1564010p -0.3
+ 1566000p -0.3
+ 1566010p 0.9
+ 1568000p 0.9
+ 1568010p -0.3
+ 1570000p -0.3
+ 1570010p 0.9
+ 1572000p 0.9
+ 1572010p -0.3
+ 1574000p -0.3
+ 1574010p 0.9
+ 1576000p 0.9
+ 1576010p -0.3
+ 1578000p -0.3
+ 1578010p 0.9
+ 1580000p 0.9
+ 1580010p -0.3
+ 1582000p -0.3
+ 1582010p 0.9
+ 1584000p 0.9
+ 1584010p -0.3
+ 1586000p -0.3
+ 1586010p 0.9
+ 1588000p 0.9
+ 1588010p -0.3
+ 1590000p -0.3
+ 1590010p 0.9
+ 1592000p 0.9
+ 1592010p -0.3
+ 1594000p -0.3
+ 1594010p 0.9
+ 1596000p 0.9
+ 1596010p -0.3
+ 1598000p -0.3
+ 1598010p 0.9
+ 1600000p 0.9
+ 1600010p -0.3
+ 1602000p -0.3
+ 1602010p 0.9
+ 1604000p 0.9
+ 1604010p -0.3
+ 1606000p -0.3
+ 1606010p 0.9
+ 1608000p 0.9
+ 1608010p -0.3
+ 1610000p -0.3
+ 1610010p 0.9
+ 1612000p 0.9
+ 1612010p -0.3
+ 1614000p -0.3
+ 1614010p 0.9
+ 1616000p 0.9
+ 1616010p -0.3
+ 1618000p -0.3
+ 1618010p 0.9
+ 1620000p 0.9
+ 1620010p -0.3
+ 1622000p -0.3
+ 1622010p 0.9
+ 1624000p 0.9
+ 1624010p -0.3
+ 1626000p -0.3
+ 1626010p 0.9
+ 1628000p 0.9
+ 1628010p -0.3
+ 1630000p -0.3
+ 1630010p 0.9
+ 1632000p 0.9
+ 1632010p -0.3
+ 1634000p -0.3
+ 1634010p 0.9
+ 1636000p 0.9
+ 1636010p -0.3
+ 1638000p -0.3
+ 1638010p 0.9
+ 1640000p 0.9
+ 1640010p -0.3
+ 1642000p -0.3
+ 1642010p 0.9
+ 1644000p 0.9
+ 1644010p -0.3
+ 1646000p -0.3
+ 1646010p 0.9
+ 1648000p 0.9
+ 1648010p -0.3
+ 1650000p -0.3
+ 1650010p 0.9
+ 1652000p 0.9
+ 1652010p -0.3
+ 1654000p -0.3
+ 1654010p 0.9
+ 1656000p 0.9
+ 1656010p -0.3
+ 1658000p -0.3
+ 1658010p 0.9
+ 1660000p 0.9
+ 1660010p -0.3
+ 1662000p -0.3
+ 1662010p 0.9
+ 1664000p 0.9
+ 1664010p -0.3
+ 1666000p -0.3
+ 1666010p 0.9
+ 1668000p 0.9
+ 1668010p -0.3
+ 1670000p -0.3
+ 1670010p 0.9
+ 1672000p 0.9
+ 1672010p -0.3
+ 1674000p -0.3
+ 1674010p 0.9
+ 1676000p 0.9
+ 1676010p -0.3
+ 1678000p -0.3
+ 1678010p 0.9
+ 1680000p 0.9
+ 1680010p -0.3
+ 1682000p -0.3
+ 1682010p 0.9
+ 1684000p 0.9
+ 1684010p -0.3
+ 1686000p -0.3
+ 1686010p 0.9
+ 1688000p 0.9
+ 1688010p -0.3
+ 1690000p -0.3
+ 1690010p 0.9
+ 1692000p 0.9
+ 1692010p -0.3
+ 1694000p -0.3
+ 1694010p 0.9
+ 1696000p 0.9
+ 1696010p -0.3
+ 1698000p -0.3
+ 1698010p 0.9
+ 1700000p 0.9
+ 1700010p -0.3
+ 1702000p -0.3
+ 1702010p 0.9
+ 1704000p 0.9
+ 1704010p -0.3
+ 1706000p -0.3
+ 1706010p 0.9
+ 1708000p 0.9
+ 1708010p -0.3
+ 1710000p -0.3
+ 1710010p 0.9
+ 1712000p 0.9
+ 1712010p -0.3
+ 1714000p -0.3
+ 1714010p 0.9
+ 1716000p 0.9
+ 1716010p -0.3
+ 1718000p -0.3
+ 1718010p 0.9
+ 1720000p 0.9
+ 1720010p -0.3
+ 1722000p -0.3
+ 1722010p 0.9
+ 1724000p 0.9
+ 1724010p -0.3
+ 1726000p -0.3
+ 1726010p 0.9
+ 1728000p 0.9
+ 1728010p -0.3
+ 1730000p -0.3
+ 1730010p 0.9
+ 1732000p 0.9
+ 1732010p -0.3
+ 1734000p -0.3
+ 1734010p 0.9
+ 1736000p 0.9
+ 1736010p -0.3
+ 1738000p -0.3
+ 1738010p 0.9
+ 1740000p 0.9
+ 1740010p -0.3
+ 1742000p -0.3
+ 1742010p 0.9
+ 1744000p 0.9
+ 1744010p -0.3
+ 1746000p -0.3
+ 1746010p 0.9
+ 1748000p 0.9
+ 1748010p -0.3
+ 1750000p -0.3
+ 1750010p 0.9
+ 1752000p 0.9
+ 1752010p -0.3
+ 1754000p -0.3
+ 1754010p 0.9
+ 1756000p 0.9
+ 1756010p -0.3
+ 1758000p -0.3
+ 1758010p 0.9
+ 1760000p 0.9
+ 1760010p -0.3
+ 1762000p -0.3
+ 1762010p 0.9
+ 1764000p 0.9
+ 1764010p -0.3
+ 1766000p -0.3
+ 1766010p 0.9
+ 1768000p 0.9
+ 1768010p -0.3
+ 1770000p -0.3
+ 1770010p 0.9
+ 1772000p 0.9
+ 1772010p -0.3
+ 1774000p -0.3
+ 1774010p 0.9
+ 1776000p 0.9
+ 1776010p -0.3
+ 1778000p -0.3
+ 1778010p 0.9
+ 1780000p 0.9
+ 1780010p -0.3
+ 1782000p -0.3
+ 1782010p 0.9
+ 1784000p 0.9
+ 1784010p -0.3
+ 1786000p -0.3
+ 1786010p 0.9
+ 1788000p 0.9
+ 1788010p -0.3
+ 1790000p -0.3
+ 1790010p 0.9
+ 1792000p 0.9
+ 1792010p -0.3
+ 1794000p -0.3
+ 1794010p 0.9
+ 1796000p 0.9
+ 1796010p -0.3
+ 1798000p -0.3
+ 1798010p 0.9
+ 1800000p 0.9
+ 1800010p -0.3
+ 1802000p -0.3
+ 1802010p 0.9
+ 1804000p 0.9
+ 1804010p -0.3
+ 1806000p -0.3
+ 1806010p 0.9
+ 1808000p 0.9
+ 1808010p -0.3
+ 1810000p -0.3
+ 1810010p 0.9
+ 1812000p 0.9
+ 1812010p -0.3
+ 1814000p -0.3
+ 1814010p 0.9
+ 1816000p 0.9
+ 1816010p -0.3
+ 1818000p -0.3
+ 1818010p 0.9
+ 1820000p 0.9
+ 1820010p -0.3
+ 1822000p -0.3
+ 1822010p 0.9
+ 1824000p 0.9
+ 1824010p -0.3
+ 1826000p -0.3
+ 1826010p 0.9
+ 1828000p 0.9
+ 1828010p -0.3
+ 1830000p -0.3
+ 1830010p 0.9
+ 1832000p 0.9
+ 1832010p -0.3
+ 1834000p -0.3
+ 1834010p 0.9
+ 1836000p 0.9
+ 1836010p -0.3
+ 1838000p -0.3
+ 1838010p 0.9
+ 1840000p 0.9
+ 1840010p -0.3
+ 1842000p -0.3
+ 1842010p 0.9
+ 1844000p 0.9
+ 1844010p -0.3
+ 1846000p -0.3
+ 1846010p 0.9
+ 1848000p 0.9
+ 1848010p -0.3
+ 1850000p -0.3
+ 1850010p 0.9
+ 1852000p 0.9
+ 1852010p -0.3
+ 1854000p -0.3
+ 1854010p 0.9
+ 1856000p 0.9
+ 1856010p -0.3
+ 1858000p -0.3
+ 1858010p 0.9
+ 1860000p 0.9
+ 1860010p -0.3
+ 1862000p -0.3
+ 1862010p 0.9
+ 1864000p 0.9
+ 1864010p -0.3
+ 1866000p -0.3
+ 1866010p 0.9
+ 1868000p 0.9
+ 1868010p -0.3
+ 1870000p -0.3
+ 1870010p 0.9
+ 1872000p 0.9
+ 1872010p -0.3
+ 1874000p -0.3
+ 1874010p 0.9
+ 1876000p 0.9
+ 1876010p -0.3
+ 1878000p -0.3
+ 1878010p 0.9
+ 1880000p 0.9
+ 1880010p -0.3
+ 1882000p -0.3
+ 1882010p 0.9
+ 1884000p 0.9
+ 1884010p -0.3
+ 1886000p -0.3
+ 1886010p 0.9
+ 1888000p 0.9
+ 1888010p -0.3
+ 1890000p -0.3
+ 1890010p 0.9
+ 1892000p 0.9
+ 1892010p -0.3
+ 1894000p -0.3
+ 1894010p 0.9
+ 1896000p 0.9
+ 1896010p -0.3
+ 1898000p -0.3
+ 1898010p 0.9
+ 1900000p 0.9
+ 1900010p -0.3
+ 1902000p -0.3
+ 1902010p 0.9
+ 1904000p 0.9
+ 1904010p -0.3
+ 1906000p -0.3
+ 1906010p 0.9
+ 1908000p 0.9
+ 1908010p -0.3
+ 1910000p -0.3
+ 1910010p 0.9
+ 1912000p 0.9
+ 1912010p -0.3
+ 1914000p -0.3
+ 1914010p 0.9
+ 1916000p 0.9
+ 1916010p -0.3
+ 1918000p -0.3
+ 1918010p 0.9
+ 1920000p 0.9
+ 1920010p -0.3
+ 1922000p -0.3
+ 1922010p 0.9
+ 1924000p 0.9
+ 1924010p -0.3
+ 1926000p -0.3
+ 1926010p 0.9
+ 1928000p 0.9
+ 1928010p -0.3
+ 1930000p -0.3
+ 1930010p 0.9
+ 1932000p 0.9
+ 1932010p -0.3
+ 1934000p -0.3
+ 1934010p 0.9
+ 1936000p 0.9
+ 1936010p -0.3
+ 1938000p -0.3
+ 1938010p 0.9
+ 1940000p 0.9
+ 1940010p -0.3
+ 1942000p -0.3
+ 1942010p 0.9
+ 1944000p 0.9
+ 1944010p -0.3
+ 1946000p -0.3
+ 1946010p 0.9
+ 1948000p 0.9
+ 1948010p -0.3
+ 1950000p -0.3
+ 1950010p 0.9
+ 1952000p 0.9
+ 1952010p -0.3
+ 1954000p -0.3
+ 1954010p 0.9
+ 1956000p 0.9
+ 1956010p -0.3
+ 1958000p -0.3
+ 1958010p 0.9
+ 1960000p 0.9
+ 1960010p -0.3
+ 1962000p -0.3
+ 1962010p 0.9
+ 1964000p 0.9
+ 1964010p -0.3
+ 1966000p -0.3
+ 1966010p 0.9
+ 1968000p 0.9
+ 1968010p -0.3
+ 1970000p -0.3
+ 1970010p 0.9
+ 1972000p 0.9
+ 1972010p -0.3
+ 1974000p -0.3
+ 1974010p 0.9
+ 1976000p 0.9
+ 1976010p -0.3
+ 1978000p -0.3
+ 1978010p 0.9
+ 1980000p 0.9
+ 1980010p -0.3
+ 1982000p -0.3
+ 1982010p 0.9
+ 1984000p 0.9
+ 1984010p -0.3
+ 1986000p -0.3
+ 1986010p 0.9
+ 1988000p 0.9
+ 1988010p -0.3
+ 1990000p -0.3
+ 1990010p 0.9
+ 1992000p 0.9
+ 1992010p -0.3
+ 1994000p -0.3
+ 1994010p 0.9
+ 1996000p 0.9
+ 1996010p -0.3
+ 1998000p -0.3
+ 1998010p 0.9
+ 2000000p 0.9
+ 2000010p -0.3
+ 2002000p -0.3
+ 2002010p 0.9
+ 2004000p 0.9
+ 2004010p -0.3
+ 2006000p -0.3
+ 2006010p 0.9
+ 2008000p 0.9
+ 2008010p -0.3
+ 2010000p -0.3
+ 2010010p 0.9
+ 2012000p 0.9
+ 2012010p -0.3
+ 2014000p -0.3
+ 2014010p 0.9
+ 2016000p 0.9
+ 2016010p -0.3
+ 2018000p -0.3
+ 2018010p 0.9
+ 2020000p 0.9
+ 2020010p -0.3
+ 2022000p -0.3
+ 2022010p 0.9
+ 2024000p 0.9
+ 2024010p -0.3
+ 2026000p -0.3
+ 2026010p 0.9
+ 2028000p 0.9
+ 2028010p -0.3
+ 2030000p -0.3
+ 2030010p 0.9
+ 2032000p 0.9
+ 2032010p -0.3
+ 2034000p -0.3
+ 2034010p 0.9
+ 2036000p 0.9
+ 2036010p -0.3
+ 2038000p -0.3
+ 2038010p 0.9
+ 2040000p 0.9
+ 2040010p -0.3
+ 2042000p -0.3
+ 2042010p 0.9
+ 2044000p 0.9
+ 2044010p -0.3
+ 2046000p -0.3
+ 2046010p 0.9
+ 2048000p 0.9
+ 2048010p -0.3
+ \]
V_data_17 (Data\\<17\\> gnd!) vsource type=pwl wave=\[
+ 0    0.9
+ 2000p 0.9
+ 2010p -0.3
+ 4000p -0.3
+ 4010p 0.9
+ 6000p 0.9
+ 6010p -0.3
+ 8000p -0.3
+ 8010p 0.9
+ 10000p 0.9
+ 10010p -0.3
+ 12000p -0.3
+ 12010p 0.9
+ 14000p 0.9
+ 14010p -0.3
+ 16000p -0.3
+ 16010p 0.9
+ 18000p 0.9
+ 18010p -0.3
+ 20000p -0.3
+ 20010p 0.9
+ 22000p 0.9
+ 22010p -0.3
+ 24000p -0.3
+ 24010p 0.9
+ 26000p 0.9
+ 26010p -0.3
+ 28000p -0.3
+ 28010p 0.9
+ 30000p 0.9
+ 30010p -0.3
+ 32000p -0.3
+ 32010p 0.9
+ 34000p 0.9
+ 34010p -0.3
+ 36000p -0.3
+ 36010p 0.9
+ 38000p 0.9
+ 38010p -0.3
+ 40000p -0.3
+ 40010p 0.9
+ 42000p 0.9
+ 42010p -0.3
+ 44000p -0.3
+ 44010p 0.9
+ 46000p 0.9
+ 46010p -0.3
+ 48000p -0.3
+ 48010p 0.9
+ 50000p 0.9
+ 50010p -0.3
+ 52000p -0.3
+ 52010p 0.9
+ 54000p 0.9
+ 54010p -0.3
+ 56000p -0.3
+ 56010p 0.9
+ 58000p 0.9
+ 58010p -0.3
+ 60000p -0.3
+ 60010p 0.9
+ 62000p 0.9
+ 62010p -0.3
+ 64000p -0.3
+ 64010p 0.9
+ 66000p 0.9
+ 66010p -0.3
+ 68000p -0.3
+ 68010p 0.9
+ 70000p 0.9
+ 70010p -0.3
+ 72000p -0.3
+ 72010p 0.9
+ 74000p 0.9
+ 74010p -0.3
+ 76000p -0.3
+ 76010p 0.9
+ 78000p 0.9
+ 78010p -0.3
+ 80000p -0.3
+ 80010p 0.9
+ 82000p 0.9
+ 82010p -0.3
+ 84000p -0.3
+ 84010p 0.9
+ 86000p 0.9
+ 86010p -0.3
+ 88000p -0.3
+ 88010p 0.9
+ 90000p 0.9
+ 90010p -0.3
+ 92000p -0.3
+ 92010p 0.9
+ 94000p 0.9
+ 94010p -0.3
+ 96000p -0.3
+ 96010p 0.9
+ 98000p 0.9
+ 98010p -0.3
+ 100000p -0.3
+ 100010p 0.9
+ 102000p 0.9
+ 102010p -0.3
+ 104000p -0.3
+ 104010p 0.9
+ 106000p 0.9
+ 106010p -0.3
+ 108000p -0.3
+ 108010p 0.9
+ 110000p 0.9
+ 110010p -0.3
+ 112000p -0.3
+ 112010p 0.9
+ 114000p 0.9
+ 114010p -0.3
+ 116000p -0.3
+ 116010p 0.9
+ 118000p 0.9
+ 118010p -0.3
+ 120000p -0.3
+ 120010p 0.9
+ 122000p 0.9
+ 122010p -0.3
+ 124000p -0.3
+ 124010p 0.9
+ 126000p 0.9
+ 126010p -0.3
+ 128000p -0.3
+ 128010p 0.9
+ 130000p 0.9
+ 130010p -0.3
+ 132000p -0.3
+ 132010p 0.9
+ 134000p 0.9
+ 134010p -0.3
+ 136000p -0.3
+ 136010p 0.9
+ 138000p 0.9
+ 138010p -0.3
+ 140000p -0.3
+ 140010p 0.9
+ 142000p 0.9
+ 142010p -0.3
+ 144000p -0.3
+ 144010p 0.9
+ 146000p 0.9
+ 146010p -0.3
+ 148000p -0.3
+ 148010p 0.9
+ 150000p 0.9
+ 150010p -0.3
+ 152000p -0.3
+ 152010p 0.9
+ 154000p 0.9
+ 154010p -0.3
+ 156000p -0.3
+ 156010p 0.9
+ 158000p 0.9
+ 158010p -0.3
+ 160000p -0.3
+ 160010p 0.9
+ 162000p 0.9
+ 162010p -0.3
+ 164000p -0.3
+ 164010p 0.9
+ 166000p 0.9
+ 166010p -0.3
+ 168000p -0.3
+ 168010p 0.9
+ 170000p 0.9
+ 170010p -0.3
+ 172000p -0.3
+ 172010p 0.9
+ 174000p 0.9
+ 174010p -0.3
+ 176000p -0.3
+ 176010p 0.9
+ 178000p 0.9
+ 178010p -0.3
+ 180000p -0.3
+ 180010p 0.9
+ 182000p 0.9
+ 182010p -0.3
+ 184000p -0.3
+ 184010p 0.9
+ 186000p 0.9
+ 186010p -0.3
+ 188000p -0.3
+ 188010p 0.9
+ 190000p 0.9
+ 190010p -0.3
+ 192000p -0.3
+ 192010p 0.9
+ 194000p 0.9
+ 194010p -0.3
+ 196000p -0.3
+ 196010p 0.9
+ 198000p 0.9
+ 198010p -0.3
+ 200000p -0.3
+ 200010p 0.9
+ 202000p 0.9
+ 202010p -0.3
+ 204000p -0.3
+ 204010p 0.9
+ 206000p 0.9
+ 206010p -0.3
+ 208000p -0.3
+ 208010p 0.9
+ 210000p 0.9
+ 210010p -0.3
+ 212000p -0.3
+ 212010p 0.9
+ 214000p 0.9
+ 214010p -0.3
+ 216000p -0.3
+ 216010p 0.9
+ 218000p 0.9
+ 218010p -0.3
+ 220000p -0.3
+ 220010p 0.9
+ 222000p 0.9
+ 222010p -0.3
+ 224000p -0.3
+ 224010p 0.9
+ 226000p 0.9
+ 226010p -0.3
+ 228000p -0.3
+ 228010p 0.9
+ 230000p 0.9
+ 230010p -0.3
+ 232000p -0.3
+ 232010p 0.9
+ 234000p 0.9
+ 234010p -0.3
+ 236000p -0.3
+ 236010p 0.9
+ 238000p 0.9
+ 238010p -0.3
+ 240000p -0.3
+ 240010p 0.9
+ 242000p 0.9
+ 242010p -0.3
+ 244000p -0.3
+ 244010p 0.9
+ 246000p 0.9
+ 246010p -0.3
+ 248000p -0.3
+ 248010p 0.9
+ 250000p 0.9
+ 250010p -0.3
+ 252000p -0.3
+ 252010p 0.9
+ 254000p 0.9
+ 254010p -0.3
+ 256000p -0.3
+ 256010p 0.9
+ 258000p 0.9
+ 258010p -0.3
+ 260000p -0.3
+ 260010p 0.9
+ 262000p 0.9
+ 262010p -0.3
+ 264000p -0.3
+ 264010p 0.9
+ 266000p 0.9
+ 266010p -0.3
+ 268000p -0.3
+ 268010p 0.9
+ 270000p 0.9
+ 270010p -0.3
+ 272000p -0.3
+ 272010p 0.9
+ 274000p 0.9
+ 274010p -0.3
+ 276000p -0.3
+ 276010p 0.9
+ 278000p 0.9
+ 278010p -0.3
+ 280000p -0.3
+ 280010p 0.9
+ 282000p 0.9
+ 282010p -0.3
+ 284000p -0.3
+ 284010p 0.9
+ 286000p 0.9
+ 286010p -0.3
+ 288000p -0.3
+ 288010p 0.9
+ 290000p 0.9
+ 290010p -0.3
+ 292000p -0.3
+ 292010p 0.9
+ 294000p 0.9
+ 294010p -0.3
+ 296000p -0.3
+ 296010p 0.9
+ 298000p 0.9
+ 298010p -0.3
+ 300000p -0.3
+ 300010p 0.9
+ 302000p 0.9
+ 302010p -0.3
+ 304000p -0.3
+ 304010p 0.9
+ 306000p 0.9
+ 306010p -0.3
+ 308000p -0.3
+ 308010p 0.9
+ 310000p 0.9
+ 310010p -0.3
+ 312000p -0.3
+ 312010p 0.9
+ 314000p 0.9
+ 314010p -0.3
+ 316000p -0.3
+ 316010p 0.9
+ 318000p 0.9
+ 318010p -0.3
+ 320000p -0.3
+ 320010p 0.9
+ 322000p 0.9
+ 322010p -0.3
+ 324000p -0.3
+ 324010p 0.9
+ 326000p 0.9
+ 326010p -0.3
+ 328000p -0.3
+ 328010p 0.9
+ 330000p 0.9
+ 330010p -0.3
+ 332000p -0.3
+ 332010p 0.9
+ 334000p 0.9
+ 334010p -0.3
+ 336000p -0.3
+ 336010p 0.9
+ 338000p 0.9
+ 338010p -0.3
+ 340000p -0.3
+ 340010p 0.9
+ 342000p 0.9
+ 342010p -0.3
+ 344000p -0.3
+ 344010p 0.9
+ 346000p 0.9
+ 346010p -0.3
+ 348000p -0.3
+ 348010p 0.9
+ 350000p 0.9
+ 350010p -0.3
+ 352000p -0.3
+ 352010p 0.9
+ 354000p 0.9
+ 354010p -0.3
+ 356000p -0.3
+ 356010p 0.9
+ 358000p 0.9
+ 358010p -0.3
+ 360000p -0.3
+ 360010p 0.9
+ 362000p 0.9
+ 362010p -0.3
+ 364000p -0.3
+ 364010p 0.9
+ 366000p 0.9
+ 366010p -0.3
+ 368000p -0.3
+ 368010p 0.9
+ 370000p 0.9
+ 370010p -0.3
+ 372000p -0.3
+ 372010p 0.9
+ 374000p 0.9
+ 374010p -0.3
+ 376000p -0.3
+ 376010p 0.9
+ 378000p 0.9
+ 378010p -0.3
+ 380000p -0.3
+ 380010p 0.9
+ 382000p 0.9
+ 382010p -0.3
+ 384000p -0.3
+ 384010p 0.9
+ 386000p 0.9
+ 386010p -0.3
+ 388000p -0.3
+ 388010p 0.9
+ 390000p 0.9
+ 390010p -0.3
+ 392000p -0.3
+ 392010p 0.9
+ 394000p 0.9
+ 394010p -0.3
+ 396000p -0.3
+ 396010p 0.9
+ 398000p 0.9
+ 398010p -0.3
+ 400000p -0.3
+ 400010p 0.9
+ 402000p 0.9
+ 402010p -0.3
+ 404000p -0.3
+ 404010p 0.9
+ 406000p 0.9
+ 406010p -0.3
+ 408000p -0.3
+ 408010p 0.9
+ 410000p 0.9
+ 410010p -0.3
+ 412000p -0.3
+ 412010p 0.9
+ 414000p 0.9
+ 414010p -0.3
+ 416000p -0.3
+ 416010p 0.9
+ 418000p 0.9
+ 418010p -0.3
+ 420000p -0.3
+ 420010p 0.9
+ 422000p 0.9
+ 422010p -0.3
+ 424000p -0.3
+ 424010p 0.9
+ 426000p 0.9
+ 426010p -0.3
+ 428000p -0.3
+ 428010p 0.9
+ 430000p 0.9
+ 430010p -0.3
+ 432000p -0.3
+ 432010p 0.9
+ 434000p 0.9
+ 434010p -0.3
+ 436000p -0.3
+ 436010p 0.9
+ 438000p 0.9
+ 438010p -0.3
+ 440000p -0.3
+ 440010p 0.9
+ 442000p 0.9
+ 442010p -0.3
+ 444000p -0.3
+ 444010p 0.9
+ 446000p 0.9
+ 446010p -0.3
+ 448000p -0.3
+ 448010p 0.9
+ 450000p 0.9
+ 450010p -0.3
+ 452000p -0.3
+ 452010p 0.9
+ 454000p 0.9
+ 454010p -0.3
+ 456000p -0.3
+ 456010p 0.9
+ 458000p 0.9
+ 458010p -0.3
+ 460000p -0.3
+ 460010p 0.9
+ 462000p 0.9
+ 462010p -0.3
+ 464000p -0.3
+ 464010p 0.9
+ 466000p 0.9
+ 466010p -0.3
+ 468000p -0.3
+ 468010p 0.9
+ 470000p 0.9
+ 470010p -0.3
+ 472000p -0.3
+ 472010p 0.9
+ 474000p 0.9
+ 474010p -0.3
+ 476000p -0.3
+ 476010p 0.9
+ 478000p 0.9
+ 478010p -0.3
+ 480000p -0.3
+ 480010p 0.9
+ 482000p 0.9
+ 482010p -0.3
+ 484000p -0.3
+ 484010p 0.9
+ 486000p 0.9
+ 486010p -0.3
+ 488000p -0.3
+ 488010p 0.9
+ 490000p 0.9
+ 490010p -0.3
+ 492000p -0.3
+ 492010p 0.9
+ 494000p 0.9
+ 494010p -0.3
+ 496000p -0.3
+ 496010p 0.9
+ 498000p 0.9
+ 498010p -0.3
+ 500000p -0.3
+ 500010p 0.9
+ 502000p 0.9
+ 502010p -0.3
+ 504000p -0.3
+ 504010p 0.9
+ 506000p 0.9
+ 506010p -0.3
+ 508000p -0.3
+ 508010p 0.9
+ 510000p 0.9
+ 510010p -0.3
+ 512000p -0.3
+ 512010p 0.9
+ 514000p 0.9
+ 514010p -0.3
+ 516000p -0.3
+ 516010p 0.9
+ 518000p 0.9
+ 518010p -0.3
+ 520000p -0.3
+ 520010p 0.9
+ 522000p 0.9
+ 522010p -0.3
+ 524000p -0.3
+ 524010p 0.9
+ 526000p 0.9
+ 526010p -0.3
+ 528000p -0.3
+ 528010p 0.9
+ 530000p 0.9
+ 530010p -0.3
+ 532000p -0.3
+ 532010p 0.9
+ 534000p 0.9
+ 534010p -0.3
+ 536000p -0.3
+ 536010p 0.9
+ 538000p 0.9
+ 538010p -0.3
+ 540000p -0.3
+ 540010p 0.9
+ 542000p 0.9
+ 542010p -0.3
+ 544000p -0.3
+ 544010p 0.9
+ 546000p 0.9
+ 546010p -0.3
+ 548000p -0.3
+ 548010p 0.9
+ 550000p 0.9
+ 550010p -0.3
+ 552000p -0.3
+ 552010p 0.9
+ 554000p 0.9
+ 554010p -0.3
+ 556000p -0.3
+ 556010p 0.9
+ 558000p 0.9
+ 558010p -0.3
+ 560000p -0.3
+ 560010p 0.9
+ 562000p 0.9
+ 562010p -0.3
+ 564000p -0.3
+ 564010p 0.9
+ 566000p 0.9
+ 566010p -0.3
+ 568000p -0.3
+ 568010p 0.9
+ 570000p 0.9
+ 570010p -0.3
+ 572000p -0.3
+ 572010p 0.9
+ 574000p 0.9
+ 574010p -0.3
+ 576000p -0.3
+ 576010p 0.9
+ 578000p 0.9
+ 578010p -0.3
+ 580000p -0.3
+ 580010p 0.9
+ 582000p 0.9
+ 582010p -0.3
+ 584000p -0.3
+ 584010p 0.9
+ 586000p 0.9
+ 586010p -0.3
+ 588000p -0.3
+ 588010p 0.9
+ 590000p 0.9
+ 590010p -0.3
+ 592000p -0.3
+ 592010p 0.9
+ 594000p 0.9
+ 594010p -0.3
+ 596000p -0.3
+ 596010p 0.9
+ 598000p 0.9
+ 598010p -0.3
+ 600000p -0.3
+ 600010p 0.9
+ 602000p 0.9
+ 602010p -0.3
+ 604000p -0.3
+ 604010p 0.9
+ 606000p 0.9
+ 606010p -0.3
+ 608000p -0.3
+ 608010p 0.9
+ 610000p 0.9
+ 610010p -0.3
+ 612000p -0.3
+ 612010p 0.9
+ 614000p 0.9
+ 614010p -0.3
+ 616000p -0.3
+ 616010p 0.9
+ 618000p 0.9
+ 618010p -0.3
+ 620000p -0.3
+ 620010p 0.9
+ 622000p 0.9
+ 622010p -0.3
+ 624000p -0.3
+ 624010p 0.9
+ 626000p 0.9
+ 626010p -0.3
+ 628000p -0.3
+ 628010p 0.9
+ 630000p 0.9
+ 630010p -0.3
+ 632000p -0.3
+ 632010p 0.9
+ 634000p 0.9
+ 634010p -0.3
+ 636000p -0.3
+ 636010p 0.9
+ 638000p 0.9
+ 638010p -0.3
+ 640000p -0.3
+ 640010p 0.9
+ 642000p 0.9
+ 642010p -0.3
+ 644000p -0.3
+ 644010p 0.9
+ 646000p 0.9
+ 646010p -0.3
+ 648000p -0.3
+ 648010p 0.9
+ 650000p 0.9
+ 650010p -0.3
+ 652000p -0.3
+ 652010p 0.9
+ 654000p 0.9
+ 654010p -0.3
+ 656000p -0.3
+ 656010p 0.9
+ 658000p 0.9
+ 658010p -0.3
+ 660000p -0.3
+ 660010p 0.9
+ 662000p 0.9
+ 662010p -0.3
+ 664000p -0.3
+ 664010p 0.9
+ 666000p 0.9
+ 666010p -0.3
+ 668000p -0.3
+ 668010p 0.9
+ 670000p 0.9
+ 670010p -0.3
+ 672000p -0.3
+ 672010p 0.9
+ 674000p 0.9
+ 674010p -0.3
+ 676000p -0.3
+ 676010p 0.9
+ 678000p 0.9
+ 678010p -0.3
+ 680000p -0.3
+ 680010p 0.9
+ 682000p 0.9
+ 682010p -0.3
+ 684000p -0.3
+ 684010p 0.9
+ 686000p 0.9
+ 686010p -0.3
+ 688000p -0.3
+ 688010p 0.9
+ 690000p 0.9
+ 690010p -0.3
+ 692000p -0.3
+ 692010p 0.9
+ 694000p 0.9
+ 694010p -0.3
+ 696000p -0.3
+ 696010p 0.9
+ 698000p 0.9
+ 698010p -0.3
+ 700000p -0.3
+ 700010p 0.9
+ 702000p 0.9
+ 702010p -0.3
+ 704000p -0.3
+ 704010p 0.9
+ 706000p 0.9
+ 706010p -0.3
+ 708000p -0.3
+ 708010p 0.9
+ 710000p 0.9
+ 710010p -0.3
+ 712000p -0.3
+ 712010p 0.9
+ 714000p 0.9
+ 714010p -0.3
+ 716000p -0.3
+ 716010p 0.9
+ 718000p 0.9
+ 718010p -0.3
+ 720000p -0.3
+ 720010p 0.9
+ 722000p 0.9
+ 722010p -0.3
+ 724000p -0.3
+ 724010p 0.9
+ 726000p 0.9
+ 726010p -0.3
+ 728000p -0.3
+ 728010p 0.9
+ 730000p 0.9
+ 730010p -0.3
+ 732000p -0.3
+ 732010p 0.9
+ 734000p 0.9
+ 734010p -0.3
+ 736000p -0.3
+ 736010p 0.9
+ 738000p 0.9
+ 738010p -0.3
+ 740000p -0.3
+ 740010p 0.9
+ 742000p 0.9
+ 742010p -0.3
+ 744000p -0.3
+ 744010p 0.9
+ 746000p 0.9
+ 746010p -0.3
+ 748000p -0.3
+ 748010p 0.9
+ 750000p 0.9
+ 750010p -0.3
+ 752000p -0.3
+ 752010p 0.9
+ 754000p 0.9
+ 754010p -0.3
+ 756000p -0.3
+ 756010p 0.9
+ 758000p 0.9
+ 758010p -0.3
+ 760000p -0.3
+ 760010p 0.9
+ 762000p 0.9
+ 762010p -0.3
+ 764000p -0.3
+ 764010p 0.9
+ 766000p 0.9
+ 766010p -0.3
+ 768000p -0.3
+ 768010p 0.9
+ 770000p 0.9
+ 770010p -0.3
+ 772000p -0.3
+ 772010p 0.9
+ 774000p 0.9
+ 774010p -0.3
+ 776000p -0.3
+ 776010p 0.9
+ 778000p 0.9
+ 778010p -0.3
+ 780000p -0.3
+ 780010p 0.9
+ 782000p 0.9
+ 782010p -0.3
+ 784000p -0.3
+ 784010p 0.9
+ 786000p 0.9
+ 786010p -0.3
+ 788000p -0.3
+ 788010p 0.9
+ 790000p 0.9
+ 790010p -0.3
+ 792000p -0.3
+ 792010p 0.9
+ 794000p 0.9
+ 794010p -0.3
+ 796000p -0.3
+ 796010p 0.9
+ 798000p 0.9
+ 798010p -0.3
+ 800000p -0.3
+ 800010p 0.9
+ 802000p 0.9
+ 802010p -0.3
+ 804000p -0.3
+ 804010p 0.9
+ 806000p 0.9
+ 806010p -0.3
+ 808000p -0.3
+ 808010p 0.9
+ 810000p 0.9
+ 810010p -0.3
+ 812000p -0.3
+ 812010p 0.9
+ 814000p 0.9
+ 814010p -0.3
+ 816000p -0.3
+ 816010p 0.9
+ 818000p 0.9
+ 818010p -0.3
+ 820000p -0.3
+ 820010p 0.9
+ 822000p 0.9
+ 822010p -0.3
+ 824000p -0.3
+ 824010p 0.9
+ 826000p 0.9
+ 826010p -0.3
+ 828000p -0.3
+ 828010p 0.9
+ 830000p 0.9
+ 830010p -0.3
+ 832000p -0.3
+ 832010p 0.9
+ 834000p 0.9
+ 834010p -0.3
+ 836000p -0.3
+ 836010p 0.9
+ 838000p 0.9
+ 838010p -0.3
+ 840000p -0.3
+ 840010p 0.9
+ 842000p 0.9
+ 842010p -0.3
+ 844000p -0.3
+ 844010p 0.9
+ 846000p 0.9
+ 846010p -0.3
+ 848000p -0.3
+ 848010p 0.9
+ 850000p 0.9
+ 850010p -0.3
+ 852000p -0.3
+ 852010p 0.9
+ 854000p 0.9
+ 854010p -0.3
+ 856000p -0.3
+ 856010p 0.9
+ 858000p 0.9
+ 858010p -0.3
+ 860000p -0.3
+ 860010p 0.9
+ 862000p 0.9
+ 862010p -0.3
+ 864000p -0.3
+ 864010p 0.9
+ 866000p 0.9
+ 866010p -0.3
+ 868000p -0.3
+ 868010p 0.9
+ 870000p 0.9
+ 870010p -0.3
+ 872000p -0.3
+ 872010p 0.9
+ 874000p 0.9
+ 874010p -0.3
+ 876000p -0.3
+ 876010p 0.9
+ 878000p 0.9
+ 878010p -0.3
+ 880000p -0.3
+ 880010p 0.9
+ 882000p 0.9
+ 882010p -0.3
+ 884000p -0.3
+ 884010p 0.9
+ 886000p 0.9
+ 886010p -0.3
+ 888000p -0.3
+ 888010p 0.9
+ 890000p 0.9
+ 890010p -0.3
+ 892000p -0.3
+ 892010p 0.9
+ 894000p 0.9
+ 894010p -0.3
+ 896000p -0.3
+ 896010p 0.9
+ 898000p 0.9
+ 898010p -0.3
+ 900000p -0.3
+ 900010p 0.9
+ 902000p 0.9
+ 902010p -0.3
+ 904000p -0.3
+ 904010p 0.9
+ 906000p 0.9
+ 906010p -0.3
+ 908000p -0.3
+ 908010p 0.9
+ 910000p 0.9
+ 910010p -0.3
+ 912000p -0.3
+ 912010p 0.9
+ 914000p 0.9
+ 914010p -0.3
+ 916000p -0.3
+ 916010p 0.9
+ 918000p 0.9
+ 918010p -0.3
+ 920000p -0.3
+ 920010p 0.9
+ 922000p 0.9
+ 922010p -0.3
+ 924000p -0.3
+ 924010p 0.9
+ 926000p 0.9
+ 926010p -0.3
+ 928000p -0.3
+ 928010p 0.9
+ 930000p 0.9
+ 930010p -0.3
+ 932000p -0.3
+ 932010p 0.9
+ 934000p 0.9
+ 934010p -0.3
+ 936000p -0.3
+ 936010p 0.9
+ 938000p 0.9
+ 938010p -0.3
+ 940000p -0.3
+ 940010p 0.9
+ 942000p 0.9
+ 942010p -0.3
+ 944000p -0.3
+ 944010p 0.9
+ 946000p 0.9
+ 946010p -0.3
+ 948000p -0.3
+ 948010p 0.9
+ 950000p 0.9
+ 950010p -0.3
+ 952000p -0.3
+ 952010p 0.9
+ 954000p 0.9
+ 954010p -0.3
+ 956000p -0.3
+ 956010p 0.9
+ 958000p 0.9
+ 958010p -0.3
+ 960000p -0.3
+ 960010p 0.9
+ 962000p 0.9
+ 962010p -0.3
+ 964000p -0.3
+ 964010p 0.9
+ 966000p 0.9
+ 966010p -0.3
+ 968000p -0.3
+ 968010p 0.9
+ 970000p 0.9
+ 970010p -0.3
+ 972000p -0.3
+ 972010p 0.9
+ 974000p 0.9
+ 974010p -0.3
+ 976000p -0.3
+ 976010p 0.9
+ 978000p 0.9
+ 978010p -0.3
+ 980000p -0.3
+ 980010p 0.9
+ 982000p 0.9
+ 982010p -0.3
+ 984000p -0.3
+ 984010p 0.9
+ 986000p 0.9
+ 986010p -0.3
+ 988000p -0.3
+ 988010p 0.9
+ 990000p 0.9
+ 990010p -0.3
+ 992000p -0.3
+ 992010p 0.9
+ 994000p 0.9
+ 994010p -0.3
+ 996000p -0.3
+ 996010p 0.9
+ 998000p 0.9
+ 998010p -0.3
+ 1000000p -0.3
+ 1000010p 0.9
+ 1002000p 0.9
+ 1002010p -0.3
+ 1004000p -0.3
+ 1004010p 0.9
+ 1006000p 0.9
+ 1006010p -0.3
+ 1008000p -0.3
+ 1008010p 0.9
+ 1010000p 0.9
+ 1010010p -0.3
+ 1012000p -0.3
+ 1012010p 0.9
+ 1014000p 0.9
+ 1014010p -0.3
+ 1016000p -0.3
+ 1016010p 0.9
+ 1018000p 0.9
+ 1018010p -0.3
+ 1020000p -0.3
+ 1020010p 0.9
+ 1022000p 0.9
+ 1022010p -0.3
+ 1024000p -0.3
+ 1024010p 0.9
+ 1026000p 0.9
+ 1026010p -0.3
+ 1028000p -0.3
+ 1028010p 0.9
+ 1030000p 0.9
+ 1030010p -0.3
+ 1032000p -0.3
+ 1032010p 0.9
+ 1034000p 0.9
+ 1034010p -0.3
+ 1036000p -0.3
+ 1036010p 0.9
+ 1038000p 0.9
+ 1038010p -0.3
+ 1040000p -0.3
+ 1040010p 0.9
+ 1042000p 0.9
+ 1042010p -0.3
+ 1044000p -0.3
+ 1044010p 0.9
+ 1046000p 0.9
+ 1046010p -0.3
+ 1048000p -0.3
+ 1048010p 0.9
+ 1050000p 0.9
+ 1050010p -0.3
+ 1052000p -0.3
+ 1052010p 0.9
+ 1054000p 0.9
+ 1054010p -0.3
+ 1056000p -0.3
+ 1056010p 0.9
+ 1058000p 0.9
+ 1058010p -0.3
+ 1060000p -0.3
+ 1060010p 0.9
+ 1062000p 0.9
+ 1062010p -0.3
+ 1064000p -0.3
+ 1064010p 0.9
+ 1066000p 0.9
+ 1066010p -0.3
+ 1068000p -0.3
+ 1068010p 0.9
+ 1070000p 0.9
+ 1070010p -0.3
+ 1072000p -0.3
+ 1072010p 0.9
+ 1074000p 0.9
+ 1074010p -0.3
+ 1076000p -0.3
+ 1076010p 0.9
+ 1078000p 0.9
+ 1078010p -0.3
+ 1080000p -0.3
+ 1080010p 0.9
+ 1082000p 0.9
+ 1082010p -0.3
+ 1084000p -0.3
+ 1084010p 0.9
+ 1086000p 0.9
+ 1086010p -0.3
+ 1088000p -0.3
+ 1088010p 0.9
+ 1090000p 0.9
+ 1090010p -0.3
+ 1092000p -0.3
+ 1092010p 0.9
+ 1094000p 0.9
+ 1094010p -0.3
+ 1096000p -0.3
+ 1096010p 0.9
+ 1098000p 0.9
+ 1098010p -0.3
+ 1100000p -0.3
+ 1100010p 0.9
+ 1102000p 0.9
+ 1102010p -0.3
+ 1104000p -0.3
+ 1104010p 0.9
+ 1106000p 0.9
+ 1106010p -0.3
+ 1108000p -0.3
+ 1108010p 0.9
+ 1110000p 0.9
+ 1110010p -0.3
+ 1112000p -0.3
+ 1112010p 0.9
+ 1114000p 0.9
+ 1114010p -0.3
+ 1116000p -0.3
+ 1116010p 0.9
+ 1118000p 0.9
+ 1118010p -0.3
+ 1120000p -0.3
+ 1120010p 0.9
+ 1122000p 0.9
+ 1122010p -0.3
+ 1124000p -0.3
+ 1124010p 0.9
+ 1126000p 0.9
+ 1126010p -0.3
+ 1128000p -0.3
+ 1128010p 0.9
+ 1130000p 0.9
+ 1130010p -0.3
+ 1132000p -0.3
+ 1132010p 0.9
+ 1134000p 0.9
+ 1134010p -0.3
+ 1136000p -0.3
+ 1136010p 0.9
+ 1138000p 0.9
+ 1138010p -0.3
+ 1140000p -0.3
+ 1140010p 0.9
+ 1142000p 0.9
+ 1142010p -0.3
+ 1144000p -0.3
+ 1144010p 0.9
+ 1146000p 0.9
+ 1146010p -0.3
+ 1148000p -0.3
+ 1148010p 0.9
+ 1150000p 0.9
+ 1150010p -0.3
+ 1152000p -0.3
+ 1152010p 0.9
+ 1154000p 0.9
+ 1154010p -0.3
+ 1156000p -0.3
+ 1156010p 0.9
+ 1158000p 0.9
+ 1158010p -0.3
+ 1160000p -0.3
+ 1160010p 0.9
+ 1162000p 0.9
+ 1162010p -0.3
+ 1164000p -0.3
+ 1164010p 0.9
+ 1166000p 0.9
+ 1166010p -0.3
+ 1168000p -0.3
+ 1168010p 0.9
+ 1170000p 0.9
+ 1170010p -0.3
+ 1172000p -0.3
+ 1172010p 0.9
+ 1174000p 0.9
+ 1174010p -0.3
+ 1176000p -0.3
+ 1176010p 0.9
+ 1178000p 0.9
+ 1178010p -0.3
+ 1180000p -0.3
+ 1180010p 0.9
+ 1182000p 0.9
+ 1182010p -0.3
+ 1184000p -0.3
+ 1184010p 0.9
+ 1186000p 0.9
+ 1186010p -0.3
+ 1188000p -0.3
+ 1188010p 0.9
+ 1190000p 0.9
+ 1190010p -0.3
+ 1192000p -0.3
+ 1192010p 0.9
+ 1194000p 0.9
+ 1194010p -0.3
+ 1196000p -0.3
+ 1196010p 0.9
+ 1198000p 0.9
+ 1198010p -0.3
+ 1200000p -0.3
+ 1200010p 0.9
+ 1202000p 0.9
+ 1202010p -0.3
+ 1204000p -0.3
+ 1204010p 0.9
+ 1206000p 0.9
+ 1206010p -0.3
+ 1208000p -0.3
+ 1208010p 0.9
+ 1210000p 0.9
+ 1210010p -0.3
+ 1212000p -0.3
+ 1212010p 0.9
+ 1214000p 0.9
+ 1214010p -0.3
+ 1216000p -0.3
+ 1216010p 0.9
+ 1218000p 0.9
+ 1218010p -0.3
+ 1220000p -0.3
+ 1220010p 0.9
+ 1222000p 0.9
+ 1222010p -0.3
+ 1224000p -0.3
+ 1224010p 0.9
+ 1226000p 0.9
+ 1226010p -0.3
+ 1228000p -0.3
+ 1228010p 0.9
+ 1230000p 0.9
+ 1230010p -0.3
+ 1232000p -0.3
+ 1232010p 0.9
+ 1234000p 0.9
+ 1234010p -0.3
+ 1236000p -0.3
+ 1236010p 0.9
+ 1238000p 0.9
+ 1238010p -0.3
+ 1240000p -0.3
+ 1240010p 0.9
+ 1242000p 0.9
+ 1242010p -0.3
+ 1244000p -0.3
+ 1244010p 0.9
+ 1246000p 0.9
+ 1246010p -0.3
+ 1248000p -0.3
+ 1248010p 0.9
+ 1250000p 0.9
+ 1250010p -0.3
+ 1252000p -0.3
+ 1252010p 0.9
+ 1254000p 0.9
+ 1254010p -0.3
+ 1256000p -0.3
+ 1256010p 0.9
+ 1258000p 0.9
+ 1258010p -0.3
+ 1260000p -0.3
+ 1260010p 0.9
+ 1262000p 0.9
+ 1262010p -0.3
+ 1264000p -0.3
+ 1264010p 0.9
+ 1266000p 0.9
+ 1266010p -0.3
+ 1268000p -0.3
+ 1268010p 0.9
+ 1270000p 0.9
+ 1270010p -0.3
+ 1272000p -0.3
+ 1272010p 0.9
+ 1274000p 0.9
+ 1274010p -0.3
+ 1276000p -0.3
+ 1276010p 0.9
+ 1278000p 0.9
+ 1278010p -0.3
+ 1280000p -0.3
+ 1280010p 0.9
+ 1282000p 0.9
+ 1282010p -0.3
+ 1284000p -0.3
+ 1284010p 0.9
+ 1286000p 0.9
+ 1286010p -0.3
+ 1288000p -0.3
+ 1288010p 0.9
+ 1290000p 0.9
+ 1290010p -0.3
+ 1292000p -0.3
+ 1292010p 0.9
+ 1294000p 0.9
+ 1294010p -0.3
+ 1296000p -0.3
+ 1296010p 0.9
+ 1298000p 0.9
+ 1298010p -0.3
+ 1300000p -0.3
+ 1300010p 0.9
+ 1302000p 0.9
+ 1302010p -0.3
+ 1304000p -0.3
+ 1304010p 0.9
+ 1306000p 0.9
+ 1306010p -0.3
+ 1308000p -0.3
+ 1308010p 0.9
+ 1310000p 0.9
+ 1310010p -0.3
+ 1312000p -0.3
+ 1312010p 0.9
+ 1314000p 0.9
+ 1314010p -0.3
+ 1316000p -0.3
+ 1316010p 0.9
+ 1318000p 0.9
+ 1318010p -0.3
+ 1320000p -0.3
+ 1320010p 0.9
+ 1322000p 0.9
+ 1322010p -0.3
+ 1324000p -0.3
+ 1324010p 0.9
+ 1326000p 0.9
+ 1326010p -0.3
+ 1328000p -0.3
+ 1328010p 0.9
+ 1330000p 0.9
+ 1330010p -0.3
+ 1332000p -0.3
+ 1332010p 0.9
+ 1334000p 0.9
+ 1334010p -0.3
+ 1336000p -0.3
+ 1336010p 0.9
+ 1338000p 0.9
+ 1338010p -0.3
+ 1340000p -0.3
+ 1340010p 0.9
+ 1342000p 0.9
+ 1342010p -0.3
+ 1344000p -0.3
+ 1344010p 0.9
+ 1346000p 0.9
+ 1346010p -0.3
+ 1348000p -0.3
+ 1348010p 0.9
+ 1350000p 0.9
+ 1350010p -0.3
+ 1352000p -0.3
+ 1352010p 0.9
+ 1354000p 0.9
+ 1354010p -0.3
+ 1356000p -0.3
+ 1356010p 0.9
+ 1358000p 0.9
+ 1358010p -0.3
+ 1360000p -0.3
+ 1360010p 0.9
+ 1362000p 0.9
+ 1362010p -0.3
+ 1364000p -0.3
+ 1364010p 0.9
+ 1366000p 0.9
+ 1366010p -0.3
+ 1368000p -0.3
+ 1368010p 0.9
+ 1370000p 0.9
+ 1370010p -0.3
+ 1372000p -0.3
+ 1372010p 0.9
+ 1374000p 0.9
+ 1374010p -0.3
+ 1376000p -0.3
+ 1376010p 0.9
+ 1378000p 0.9
+ 1378010p -0.3
+ 1380000p -0.3
+ 1380010p 0.9
+ 1382000p 0.9
+ 1382010p -0.3
+ 1384000p -0.3
+ 1384010p 0.9
+ 1386000p 0.9
+ 1386010p -0.3
+ 1388000p -0.3
+ 1388010p 0.9
+ 1390000p 0.9
+ 1390010p -0.3
+ 1392000p -0.3
+ 1392010p 0.9
+ 1394000p 0.9
+ 1394010p -0.3
+ 1396000p -0.3
+ 1396010p 0.9
+ 1398000p 0.9
+ 1398010p -0.3
+ 1400000p -0.3
+ 1400010p 0.9
+ 1402000p 0.9
+ 1402010p -0.3
+ 1404000p -0.3
+ 1404010p 0.9
+ 1406000p 0.9
+ 1406010p -0.3
+ 1408000p -0.3
+ 1408010p 0.9
+ 1410000p 0.9
+ 1410010p -0.3
+ 1412000p -0.3
+ 1412010p 0.9
+ 1414000p 0.9
+ 1414010p -0.3
+ 1416000p -0.3
+ 1416010p 0.9
+ 1418000p 0.9
+ 1418010p -0.3
+ 1420000p -0.3
+ 1420010p 0.9
+ 1422000p 0.9
+ 1422010p -0.3
+ 1424000p -0.3
+ 1424010p 0.9
+ 1426000p 0.9
+ 1426010p -0.3
+ 1428000p -0.3
+ 1428010p 0.9
+ 1430000p 0.9
+ 1430010p -0.3
+ 1432000p -0.3
+ 1432010p 0.9
+ 1434000p 0.9
+ 1434010p -0.3
+ 1436000p -0.3
+ 1436010p 0.9
+ 1438000p 0.9
+ 1438010p -0.3
+ 1440000p -0.3
+ 1440010p 0.9
+ 1442000p 0.9
+ 1442010p -0.3
+ 1444000p -0.3
+ 1444010p 0.9
+ 1446000p 0.9
+ 1446010p -0.3
+ 1448000p -0.3
+ 1448010p 0.9
+ 1450000p 0.9
+ 1450010p -0.3
+ 1452000p -0.3
+ 1452010p 0.9
+ 1454000p 0.9
+ 1454010p -0.3
+ 1456000p -0.3
+ 1456010p 0.9
+ 1458000p 0.9
+ 1458010p -0.3
+ 1460000p -0.3
+ 1460010p 0.9
+ 1462000p 0.9
+ 1462010p -0.3
+ 1464000p -0.3
+ 1464010p 0.9
+ 1466000p 0.9
+ 1466010p -0.3
+ 1468000p -0.3
+ 1468010p 0.9
+ 1470000p 0.9
+ 1470010p -0.3
+ 1472000p -0.3
+ 1472010p 0.9
+ 1474000p 0.9
+ 1474010p -0.3
+ 1476000p -0.3
+ 1476010p 0.9
+ 1478000p 0.9
+ 1478010p -0.3
+ 1480000p -0.3
+ 1480010p 0.9
+ 1482000p 0.9
+ 1482010p -0.3
+ 1484000p -0.3
+ 1484010p 0.9
+ 1486000p 0.9
+ 1486010p -0.3
+ 1488000p -0.3
+ 1488010p 0.9
+ 1490000p 0.9
+ 1490010p -0.3
+ 1492000p -0.3
+ 1492010p 0.9
+ 1494000p 0.9
+ 1494010p -0.3
+ 1496000p -0.3
+ 1496010p 0.9
+ 1498000p 0.9
+ 1498010p -0.3
+ 1500000p -0.3
+ 1500010p 0.9
+ 1502000p 0.9
+ 1502010p -0.3
+ 1504000p -0.3
+ 1504010p 0.9
+ 1506000p 0.9
+ 1506010p -0.3
+ 1508000p -0.3
+ 1508010p 0.9
+ 1510000p 0.9
+ 1510010p -0.3
+ 1512000p -0.3
+ 1512010p 0.9
+ 1514000p 0.9
+ 1514010p -0.3
+ 1516000p -0.3
+ 1516010p 0.9
+ 1518000p 0.9
+ 1518010p -0.3
+ 1520000p -0.3
+ 1520010p 0.9
+ 1522000p 0.9
+ 1522010p -0.3
+ 1524000p -0.3
+ 1524010p 0.9
+ 1526000p 0.9
+ 1526010p -0.3
+ 1528000p -0.3
+ 1528010p 0.9
+ 1530000p 0.9
+ 1530010p -0.3
+ 1532000p -0.3
+ 1532010p 0.9
+ 1534000p 0.9
+ 1534010p -0.3
+ 1536000p -0.3
+ 1536010p 0.9
+ 1538000p 0.9
+ 1538010p -0.3
+ 1540000p -0.3
+ 1540010p 0.9
+ 1542000p 0.9
+ 1542010p -0.3
+ 1544000p -0.3
+ 1544010p 0.9
+ 1546000p 0.9
+ 1546010p -0.3
+ 1548000p -0.3
+ 1548010p 0.9
+ 1550000p 0.9
+ 1550010p -0.3
+ 1552000p -0.3
+ 1552010p 0.9
+ 1554000p 0.9
+ 1554010p -0.3
+ 1556000p -0.3
+ 1556010p 0.9
+ 1558000p 0.9
+ 1558010p -0.3
+ 1560000p -0.3
+ 1560010p 0.9
+ 1562000p 0.9
+ 1562010p -0.3
+ 1564000p -0.3
+ 1564010p 0.9
+ 1566000p 0.9
+ 1566010p -0.3
+ 1568000p -0.3
+ 1568010p 0.9
+ 1570000p 0.9
+ 1570010p -0.3
+ 1572000p -0.3
+ 1572010p 0.9
+ 1574000p 0.9
+ 1574010p -0.3
+ 1576000p -0.3
+ 1576010p 0.9
+ 1578000p 0.9
+ 1578010p -0.3
+ 1580000p -0.3
+ 1580010p 0.9
+ 1582000p 0.9
+ 1582010p -0.3
+ 1584000p -0.3
+ 1584010p 0.9
+ 1586000p 0.9
+ 1586010p -0.3
+ 1588000p -0.3
+ 1588010p 0.9
+ 1590000p 0.9
+ 1590010p -0.3
+ 1592000p -0.3
+ 1592010p 0.9
+ 1594000p 0.9
+ 1594010p -0.3
+ 1596000p -0.3
+ 1596010p 0.9
+ 1598000p 0.9
+ 1598010p -0.3
+ 1600000p -0.3
+ 1600010p 0.9
+ 1602000p 0.9
+ 1602010p -0.3
+ 1604000p -0.3
+ 1604010p 0.9
+ 1606000p 0.9
+ 1606010p -0.3
+ 1608000p -0.3
+ 1608010p 0.9
+ 1610000p 0.9
+ 1610010p -0.3
+ 1612000p -0.3
+ 1612010p 0.9
+ 1614000p 0.9
+ 1614010p -0.3
+ 1616000p -0.3
+ 1616010p 0.9
+ 1618000p 0.9
+ 1618010p -0.3
+ 1620000p -0.3
+ 1620010p 0.9
+ 1622000p 0.9
+ 1622010p -0.3
+ 1624000p -0.3
+ 1624010p 0.9
+ 1626000p 0.9
+ 1626010p -0.3
+ 1628000p -0.3
+ 1628010p 0.9
+ 1630000p 0.9
+ 1630010p -0.3
+ 1632000p -0.3
+ 1632010p 0.9
+ 1634000p 0.9
+ 1634010p -0.3
+ 1636000p -0.3
+ 1636010p 0.9
+ 1638000p 0.9
+ 1638010p -0.3
+ 1640000p -0.3
+ 1640010p 0.9
+ 1642000p 0.9
+ 1642010p -0.3
+ 1644000p -0.3
+ 1644010p 0.9
+ 1646000p 0.9
+ 1646010p -0.3
+ 1648000p -0.3
+ 1648010p 0.9
+ 1650000p 0.9
+ 1650010p -0.3
+ 1652000p -0.3
+ 1652010p 0.9
+ 1654000p 0.9
+ 1654010p -0.3
+ 1656000p -0.3
+ 1656010p 0.9
+ 1658000p 0.9
+ 1658010p -0.3
+ 1660000p -0.3
+ 1660010p 0.9
+ 1662000p 0.9
+ 1662010p -0.3
+ 1664000p -0.3
+ 1664010p 0.9
+ 1666000p 0.9
+ 1666010p -0.3
+ 1668000p -0.3
+ 1668010p 0.9
+ 1670000p 0.9
+ 1670010p -0.3
+ 1672000p -0.3
+ 1672010p 0.9
+ 1674000p 0.9
+ 1674010p -0.3
+ 1676000p -0.3
+ 1676010p 0.9
+ 1678000p 0.9
+ 1678010p -0.3
+ 1680000p -0.3
+ 1680010p 0.9
+ 1682000p 0.9
+ 1682010p -0.3
+ 1684000p -0.3
+ 1684010p 0.9
+ 1686000p 0.9
+ 1686010p -0.3
+ 1688000p -0.3
+ 1688010p 0.9
+ 1690000p 0.9
+ 1690010p -0.3
+ 1692000p -0.3
+ 1692010p 0.9
+ 1694000p 0.9
+ 1694010p -0.3
+ 1696000p -0.3
+ 1696010p 0.9
+ 1698000p 0.9
+ 1698010p -0.3
+ 1700000p -0.3
+ 1700010p 0.9
+ 1702000p 0.9
+ 1702010p -0.3
+ 1704000p -0.3
+ 1704010p 0.9
+ 1706000p 0.9
+ 1706010p -0.3
+ 1708000p -0.3
+ 1708010p 0.9
+ 1710000p 0.9
+ 1710010p -0.3
+ 1712000p -0.3
+ 1712010p 0.9
+ 1714000p 0.9
+ 1714010p -0.3
+ 1716000p -0.3
+ 1716010p 0.9
+ 1718000p 0.9
+ 1718010p -0.3
+ 1720000p -0.3
+ 1720010p 0.9
+ 1722000p 0.9
+ 1722010p -0.3
+ 1724000p -0.3
+ 1724010p 0.9
+ 1726000p 0.9
+ 1726010p -0.3
+ 1728000p -0.3
+ 1728010p 0.9
+ 1730000p 0.9
+ 1730010p -0.3
+ 1732000p -0.3
+ 1732010p 0.9
+ 1734000p 0.9
+ 1734010p -0.3
+ 1736000p -0.3
+ 1736010p 0.9
+ 1738000p 0.9
+ 1738010p -0.3
+ 1740000p -0.3
+ 1740010p 0.9
+ 1742000p 0.9
+ 1742010p -0.3
+ 1744000p -0.3
+ 1744010p 0.9
+ 1746000p 0.9
+ 1746010p -0.3
+ 1748000p -0.3
+ 1748010p 0.9
+ 1750000p 0.9
+ 1750010p -0.3
+ 1752000p -0.3
+ 1752010p 0.9
+ 1754000p 0.9
+ 1754010p -0.3
+ 1756000p -0.3
+ 1756010p 0.9
+ 1758000p 0.9
+ 1758010p -0.3
+ 1760000p -0.3
+ 1760010p 0.9
+ 1762000p 0.9
+ 1762010p -0.3
+ 1764000p -0.3
+ 1764010p 0.9
+ 1766000p 0.9
+ 1766010p -0.3
+ 1768000p -0.3
+ 1768010p 0.9
+ 1770000p 0.9
+ 1770010p -0.3
+ 1772000p -0.3
+ 1772010p 0.9
+ 1774000p 0.9
+ 1774010p -0.3
+ 1776000p -0.3
+ 1776010p 0.9
+ 1778000p 0.9
+ 1778010p -0.3
+ 1780000p -0.3
+ 1780010p 0.9
+ 1782000p 0.9
+ 1782010p -0.3
+ 1784000p -0.3
+ 1784010p 0.9
+ 1786000p 0.9
+ 1786010p -0.3
+ 1788000p -0.3
+ 1788010p 0.9
+ 1790000p 0.9
+ 1790010p -0.3
+ 1792000p -0.3
+ 1792010p 0.9
+ 1794000p 0.9
+ 1794010p -0.3
+ 1796000p -0.3
+ 1796010p 0.9
+ 1798000p 0.9
+ 1798010p -0.3
+ 1800000p -0.3
+ 1800010p 0.9
+ 1802000p 0.9
+ 1802010p -0.3
+ 1804000p -0.3
+ 1804010p 0.9
+ 1806000p 0.9
+ 1806010p -0.3
+ 1808000p -0.3
+ 1808010p 0.9
+ 1810000p 0.9
+ 1810010p -0.3
+ 1812000p -0.3
+ 1812010p 0.9
+ 1814000p 0.9
+ 1814010p -0.3
+ 1816000p -0.3
+ 1816010p 0.9
+ 1818000p 0.9
+ 1818010p -0.3
+ 1820000p -0.3
+ 1820010p 0.9
+ 1822000p 0.9
+ 1822010p -0.3
+ 1824000p -0.3
+ 1824010p 0.9
+ 1826000p 0.9
+ 1826010p -0.3
+ 1828000p -0.3
+ 1828010p 0.9
+ 1830000p 0.9
+ 1830010p -0.3
+ 1832000p -0.3
+ 1832010p 0.9
+ 1834000p 0.9
+ 1834010p -0.3
+ 1836000p -0.3
+ 1836010p 0.9
+ 1838000p 0.9
+ 1838010p -0.3
+ 1840000p -0.3
+ 1840010p 0.9
+ 1842000p 0.9
+ 1842010p -0.3
+ 1844000p -0.3
+ 1844010p 0.9
+ 1846000p 0.9
+ 1846010p -0.3
+ 1848000p -0.3
+ 1848010p 0.9
+ 1850000p 0.9
+ 1850010p -0.3
+ 1852000p -0.3
+ 1852010p 0.9
+ 1854000p 0.9
+ 1854010p -0.3
+ 1856000p -0.3
+ 1856010p 0.9
+ 1858000p 0.9
+ 1858010p -0.3
+ 1860000p -0.3
+ 1860010p 0.9
+ 1862000p 0.9
+ 1862010p -0.3
+ 1864000p -0.3
+ 1864010p 0.9
+ 1866000p 0.9
+ 1866010p -0.3
+ 1868000p -0.3
+ 1868010p 0.9
+ 1870000p 0.9
+ 1870010p -0.3
+ 1872000p -0.3
+ 1872010p 0.9
+ 1874000p 0.9
+ 1874010p -0.3
+ 1876000p -0.3
+ 1876010p 0.9
+ 1878000p 0.9
+ 1878010p -0.3
+ 1880000p -0.3
+ 1880010p 0.9
+ 1882000p 0.9
+ 1882010p -0.3
+ 1884000p -0.3
+ 1884010p 0.9
+ 1886000p 0.9
+ 1886010p -0.3
+ 1888000p -0.3
+ 1888010p 0.9
+ 1890000p 0.9
+ 1890010p -0.3
+ 1892000p -0.3
+ 1892010p 0.9
+ 1894000p 0.9
+ 1894010p -0.3
+ 1896000p -0.3
+ 1896010p 0.9
+ 1898000p 0.9
+ 1898010p -0.3
+ 1900000p -0.3
+ 1900010p 0.9
+ 1902000p 0.9
+ 1902010p -0.3
+ 1904000p -0.3
+ 1904010p 0.9
+ 1906000p 0.9
+ 1906010p -0.3
+ 1908000p -0.3
+ 1908010p 0.9
+ 1910000p 0.9
+ 1910010p -0.3
+ 1912000p -0.3
+ 1912010p 0.9
+ 1914000p 0.9
+ 1914010p -0.3
+ 1916000p -0.3
+ 1916010p 0.9
+ 1918000p 0.9
+ 1918010p -0.3
+ 1920000p -0.3
+ 1920010p 0.9
+ 1922000p 0.9
+ 1922010p -0.3
+ 1924000p -0.3
+ 1924010p 0.9
+ 1926000p 0.9
+ 1926010p -0.3
+ 1928000p -0.3
+ 1928010p 0.9
+ 1930000p 0.9
+ 1930010p -0.3
+ 1932000p -0.3
+ 1932010p 0.9
+ 1934000p 0.9
+ 1934010p -0.3
+ 1936000p -0.3
+ 1936010p 0.9
+ 1938000p 0.9
+ 1938010p -0.3
+ 1940000p -0.3
+ 1940010p 0.9
+ 1942000p 0.9
+ 1942010p -0.3
+ 1944000p -0.3
+ 1944010p 0.9
+ 1946000p 0.9
+ 1946010p -0.3
+ 1948000p -0.3
+ 1948010p 0.9
+ 1950000p 0.9
+ 1950010p -0.3
+ 1952000p -0.3
+ 1952010p 0.9
+ 1954000p 0.9
+ 1954010p -0.3
+ 1956000p -0.3
+ 1956010p 0.9
+ 1958000p 0.9
+ 1958010p -0.3
+ 1960000p -0.3
+ 1960010p 0.9
+ 1962000p 0.9
+ 1962010p -0.3
+ 1964000p -0.3
+ 1964010p 0.9
+ 1966000p 0.9
+ 1966010p -0.3
+ 1968000p -0.3
+ 1968010p 0.9
+ 1970000p 0.9
+ 1970010p -0.3
+ 1972000p -0.3
+ 1972010p 0.9
+ 1974000p 0.9
+ 1974010p -0.3
+ 1976000p -0.3
+ 1976010p 0.9
+ 1978000p 0.9
+ 1978010p -0.3
+ 1980000p -0.3
+ 1980010p 0.9
+ 1982000p 0.9
+ 1982010p -0.3
+ 1984000p -0.3
+ 1984010p 0.9
+ 1986000p 0.9
+ 1986010p -0.3
+ 1988000p -0.3
+ 1988010p 0.9
+ 1990000p 0.9
+ 1990010p -0.3
+ 1992000p -0.3
+ 1992010p 0.9
+ 1994000p 0.9
+ 1994010p -0.3
+ 1996000p -0.3
+ 1996010p 0.9
+ 1998000p 0.9
+ 1998010p -0.3
+ 2000000p -0.3
+ 2000010p 0.9
+ 2002000p 0.9
+ 2002010p -0.3
+ 2004000p -0.3
+ 2004010p 0.9
+ 2006000p 0.9
+ 2006010p -0.3
+ 2008000p -0.3
+ 2008010p 0.9
+ 2010000p 0.9
+ 2010010p -0.3
+ 2012000p -0.3
+ 2012010p 0.9
+ 2014000p 0.9
+ 2014010p -0.3
+ 2016000p -0.3
+ 2016010p 0.9
+ 2018000p 0.9
+ 2018010p -0.3
+ 2020000p -0.3
+ 2020010p 0.9
+ 2022000p 0.9
+ 2022010p -0.3
+ 2024000p -0.3
+ 2024010p 0.9
+ 2026000p 0.9
+ 2026010p -0.3
+ 2028000p -0.3
+ 2028010p 0.9
+ 2030000p 0.9
+ 2030010p -0.3
+ 2032000p -0.3
+ 2032010p 0.9
+ 2034000p 0.9
+ 2034010p -0.3
+ 2036000p -0.3
+ 2036010p 0.9
+ 2038000p 0.9
+ 2038010p -0.3
+ 2040000p -0.3
+ 2040010p 0.9
+ 2042000p 0.9
+ 2042010p -0.3
+ 2044000p -0.3
+ 2044010p 0.9
+ 2046000p 0.9
+ 2046010p -0.3
+ 2048000p -0.3
+ 2048010p 0.9
+ \]
V_data_bar_17 (Data_bar\\<17\\> gnd!) vsource type=pwl wave=\[
+ 0    -0.3
+ 2000p -0.3
+ 2010p 0.9
+ 4000p 0.9
+ 4010p -0.3
+ 6000p -0.3
+ 6010p 0.9
+ 8000p 0.9
+ 8010p -0.3
+ 10000p -0.3
+ 10010p 0.9
+ 12000p 0.9
+ 12010p -0.3
+ 14000p -0.3
+ 14010p 0.9
+ 16000p 0.9
+ 16010p -0.3
+ 18000p -0.3
+ 18010p 0.9
+ 20000p 0.9
+ 20010p -0.3
+ 22000p -0.3
+ 22010p 0.9
+ 24000p 0.9
+ 24010p -0.3
+ 26000p -0.3
+ 26010p 0.9
+ 28000p 0.9
+ 28010p -0.3
+ 30000p -0.3
+ 30010p 0.9
+ 32000p 0.9
+ 32010p -0.3
+ 34000p -0.3
+ 34010p 0.9
+ 36000p 0.9
+ 36010p -0.3
+ 38000p -0.3
+ 38010p 0.9
+ 40000p 0.9
+ 40010p -0.3
+ 42000p -0.3
+ 42010p 0.9
+ 44000p 0.9
+ 44010p -0.3
+ 46000p -0.3
+ 46010p 0.9
+ 48000p 0.9
+ 48010p -0.3
+ 50000p -0.3
+ 50010p 0.9
+ 52000p 0.9
+ 52010p -0.3
+ 54000p -0.3
+ 54010p 0.9
+ 56000p 0.9
+ 56010p -0.3
+ 58000p -0.3
+ 58010p 0.9
+ 60000p 0.9
+ 60010p -0.3
+ 62000p -0.3
+ 62010p 0.9
+ 64000p 0.9
+ 64010p -0.3
+ 66000p -0.3
+ 66010p 0.9
+ 68000p 0.9
+ 68010p -0.3
+ 70000p -0.3
+ 70010p 0.9
+ 72000p 0.9
+ 72010p -0.3
+ 74000p -0.3
+ 74010p 0.9
+ 76000p 0.9
+ 76010p -0.3
+ 78000p -0.3
+ 78010p 0.9
+ 80000p 0.9
+ 80010p -0.3
+ 82000p -0.3
+ 82010p 0.9
+ 84000p 0.9
+ 84010p -0.3
+ 86000p -0.3
+ 86010p 0.9
+ 88000p 0.9
+ 88010p -0.3
+ 90000p -0.3
+ 90010p 0.9
+ 92000p 0.9
+ 92010p -0.3
+ 94000p -0.3
+ 94010p 0.9
+ 96000p 0.9
+ 96010p -0.3
+ 98000p -0.3
+ 98010p 0.9
+ 100000p 0.9
+ 100010p -0.3
+ 102000p -0.3
+ 102010p 0.9
+ 104000p 0.9
+ 104010p -0.3
+ 106000p -0.3
+ 106010p 0.9
+ 108000p 0.9
+ 108010p -0.3
+ 110000p -0.3
+ 110010p 0.9
+ 112000p 0.9
+ 112010p -0.3
+ 114000p -0.3
+ 114010p 0.9
+ 116000p 0.9
+ 116010p -0.3
+ 118000p -0.3
+ 118010p 0.9
+ 120000p 0.9
+ 120010p -0.3
+ 122000p -0.3
+ 122010p 0.9
+ 124000p 0.9
+ 124010p -0.3
+ 126000p -0.3
+ 126010p 0.9
+ 128000p 0.9
+ 128010p -0.3
+ 130000p -0.3
+ 130010p 0.9
+ 132000p 0.9
+ 132010p -0.3
+ 134000p -0.3
+ 134010p 0.9
+ 136000p 0.9
+ 136010p -0.3
+ 138000p -0.3
+ 138010p 0.9
+ 140000p 0.9
+ 140010p -0.3
+ 142000p -0.3
+ 142010p 0.9
+ 144000p 0.9
+ 144010p -0.3
+ 146000p -0.3
+ 146010p 0.9
+ 148000p 0.9
+ 148010p -0.3
+ 150000p -0.3
+ 150010p 0.9
+ 152000p 0.9
+ 152010p -0.3
+ 154000p -0.3
+ 154010p 0.9
+ 156000p 0.9
+ 156010p -0.3
+ 158000p -0.3
+ 158010p 0.9
+ 160000p 0.9
+ 160010p -0.3
+ 162000p -0.3
+ 162010p 0.9
+ 164000p 0.9
+ 164010p -0.3
+ 166000p -0.3
+ 166010p 0.9
+ 168000p 0.9
+ 168010p -0.3
+ 170000p -0.3
+ 170010p 0.9
+ 172000p 0.9
+ 172010p -0.3
+ 174000p -0.3
+ 174010p 0.9
+ 176000p 0.9
+ 176010p -0.3
+ 178000p -0.3
+ 178010p 0.9
+ 180000p 0.9
+ 180010p -0.3
+ 182000p -0.3
+ 182010p 0.9
+ 184000p 0.9
+ 184010p -0.3
+ 186000p -0.3
+ 186010p 0.9
+ 188000p 0.9
+ 188010p -0.3
+ 190000p -0.3
+ 190010p 0.9
+ 192000p 0.9
+ 192010p -0.3
+ 194000p -0.3
+ 194010p 0.9
+ 196000p 0.9
+ 196010p -0.3
+ 198000p -0.3
+ 198010p 0.9
+ 200000p 0.9
+ 200010p -0.3
+ 202000p -0.3
+ 202010p 0.9
+ 204000p 0.9
+ 204010p -0.3
+ 206000p -0.3
+ 206010p 0.9
+ 208000p 0.9
+ 208010p -0.3
+ 210000p -0.3
+ 210010p 0.9
+ 212000p 0.9
+ 212010p -0.3
+ 214000p -0.3
+ 214010p 0.9
+ 216000p 0.9
+ 216010p -0.3
+ 218000p -0.3
+ 218010p 0.9
+ 220000p 0.9
+ 220010p -0.3
+ 222000p -0.3
+ 222010p 0.9
+ 224000p 0.9
+ 224010p -0.3
+ 226000p -0.3
+ 226010p 0.9
+ 228000p 0.9
+ 228010p -0.3
+ 230000p -0.3
+ 230010p 0.9
+ 232000p 0.9
+ 232010p -0.3
+ 234000p -0.3
+ 234010p 0.9
+ 236000p 0.9
+ 236010p -0.3
+ 238000p -0.3
+ 238010p 0.9
+ 240000p 0.9
+ 240010p -0.3
+ 242000p -0.3
+ 242010p 0.9
+ 244000p 0.9
+ 244010p -0.3
+ 246000p -0.3
+ 246010p 0.9
+ 248000p 0.9
+ 248010p -0.3
+ 250000p -0.3
+ 250010p 0.9
+ 252000p 0.9
+ 252010p -0.3
+ 254000p -0.3
+ 254010p 0.9
+ 256000p 0.9
+ 256010p -0.3
+ 258000p -0.3
+ 258010p 0.9
+ 260000p 0.9
+ 260010p -0.3
+ 262000p -0.3
+ 262010p 0.9
+ 264000p 0.9
+ 264010p -0.3
+ 266000p -0.3
+ 266010p 0.9
+ 268000p 0.9
+ 268010p -0.3
+ 270000p -0.3
+ 270010p 0.9
+ 272000p 0.9
+ 272010p -0.3
+ 274000p -0.3
+ 274010p 0.9
+ 276000p 0.9
+ 276010p -0.3
+ 278000p -0.3
+ 278010p 0.9
+ 280000p 0.9
+ 280010p -0.3
+ 282000p -0.3
+ 282010p 0.9
+ 284000p 0.9
+ 284010p -0.3
+ 286000p -0.3
+ 286010p 0.9
+ 288000p 0.9
+ 288010p -0.3
+ 290000p -0.3
+ 290010p 0.9
+ 292000p 0.9
+ 292010p -0.3
+ 294000p -0.3
+ 294010p 0.9
+ 296000p 0.9
+ 296010p -0.3
+ 298000p -0.3
+ 298010p 0.9
+ 300000p 0.9
+ 300010p -0.3
+ 302000p -0.3
+ 302010p 0.9
+ 304000p 0.9
+ 304010p -0.3
+ 306000p -0.3
+ 306010p 0.9
+ 308000p 0.9
+ 308010p -0.3
+ 310000p -0.3
+ 310010p 0.9
+ 312000p 0.9
+ 312010p -0.3
+ 314000p -0.3
+ 314010p 0.9
+ 316000p 0.9
+ 316010p -0.3
+ 318000p -0.3
+ 318010p 0.9
+ 320000p 0.9
+ 320010p -0.3
+ 322000p -0.3
+ 322010p 0.9
+ 324000p 0.9
+ 324010p -0.3
+ 326000p -0.3
+ 326010p 0.9
+ 328000p 0.9
+ 328010p -0.3
+ 330000p -0.3
+ 330010p 0.9
+ 332000p 0.9
+ 332010p -0.3
+ 334000p -0.3
+ 334010p 0.9
+ 336000p 0.9
+ 336010p -0.3
+ 338000p -0.3
+ 338010p 0.9
+ 340000p 0.9
+ 340010p -0.3
+ 342000p -0.3
+ 342010p 0.9
+ 344000p 0.9
+ 344010p -0.3
+ 346000p -0.3
+ 346010p 0.9
+ 348000p 0.9
+ 348010p -0.3
+ 350000p -0.3
+ 350010p 0.9
+ 352000p 0.9
+ 352010p -0.3
+ 354000p -0.3
+ 354010p 0.9
+ 356000p 0.9
+ 356010p -0.3
+ 358000p -0.3
+ 358010p 0.9
+ 360000p 0.9
+ 360010p -0.3
+ 362000p -0.3
+ 362010p 0.9
+ 364000p 0.9
+ 364010p -0.3
+ 366000p -0.3
+ 366010p 0.9
+ 368000p 0.9
+ 368010p -0.3
+ 370000p -0.3
+ 370010p 0.9
+ 372000p 0.9
+ 372010p -0.3
+ 374000p -0.3
+ 374010p 0.9
+ 376000p 0.9
+ 376010p -0.3
+ 378000p -0.3
+ 378010p 0.9
+ 380000p 0.9
+ 380010p -0.3
+ 382000p -0.3
+ 382010p 0.9
+ 384000p 0.9
+ 384010p -0.3
+ 386000p -0.3
+ 386010p 0.9
+ 388000p 0.9
+ 388010p -0.3
+ 390000p -0.3
+ 390010p 0.9
+ 392000p 0.9
+ 392010p -0.3
+ 394000p -0.3
+ 394010p 0.9
+ 396000p 0.9
+ 396010p -0.3
+ 398000p -0.3
+ 398010p 0.9
+ 400000p 0.9
+ 400010p -0.3
+ 402000p -0.3
+ 402010p 0.9
+ 404000p 0.9
+ 404010p -0.3
+ 406000p -0.3
+ 406010p 0.9
+ 408000p 0.9
+ 408010p -0.3
+ 410000p -0.3
+ 410010p 0.9
+ 412000p 0.9
+ 412010p -0.3
+ 414000p -0.3
+ 414010p 0.9
+ 416000p 0.9
+ 416010p -0.3
+ 418000p -0.3
+ 418010p 0.9
+ 420000p 0.9
+ 420010p -0.3
+ 422000p -0.3
+ 422010p 0.9
+ 424000p 0.9
+ 424010p -0.3
+ 426000p -0.3
+ 426010p 0.9
+ 428000p 0.9
+ 428010p -0.3
+ 430000p -0.3
+ 430010p 0.9
+ 432000p 0.9
+ 432010p -0.3
+ 434000p -0.3
+ 434010p 0.9
+ 436000p 0.9
+ 436010p -0.3
+ 438000p -0.3
+ 438010p 0.9
+ 440000p 0.9
+ 440010p -0.3
+ 442000p -0.3
+ 442010p 0.9
+ 444000p 0.9
+ 444010p -0.3
+ 446000p -0.3
+ 446010p 0.9
+ 448000p 0.9
+ 448010p -0.3
+ 450000p -0.3
+ 450010p 0.9
+ 452000p 0.9
+ 452010p -0.3
+ 454000p -0.3
+ 454010p 0.9
+ 456000p 0.9
+ 456010p -0.3
+ 458000p -0.3
+ 458010p 0.9
+ 460000p 0.9
+ 460010p -0.3
+ 462000p -0.3
+ 462010p 0.9
+ 464000p 0.9
+ 464010p -0.3
+ 466000p -0.3
+ 466010p 0.9
+ 468000p 0.9
+ 468010p -0.3
+ 470000p -0.3
+ 470010p 0.9
+ 472000p 0.9
+ 472010p -0.3
+ 474000p -0.3
+ 474010p 0.9
+ 476000p 0.9
+ 476010p -0.3
+ 478000p -0.3
+ 478010p 0.9
+ 480000p 0.9
+ 480010p -0.3
+ 482000p -0.3
+ 482010p 0.9
+ 484000p 0.9
+ 484010p -0.3
+ 486000p -0.3
+ 486010p 0.9
+ 488000p 0.9
+ 488010p -0.3
+ 490000p -0.3
+ 490010p 0.9
+ 492000p 0.9
+ 492010p -0.3
+ 494000p -0.3
+ 494010p 0.9
+ 496000p 0.9
+ 496010p -0.3
+ 498000p -0.3
+ 498010p 0.9
+ 500000p 0.9
+ 500010p -0.3
+ 502000p -0.3
+ 502010p 0.9
+ 504000p 0.9
+ 504010p -0.3
+ 506000p -0.3
+ 506010p 0.9
+ 508000p 0.9
+ 508010p -0.3
+ 510000p -0.3
+ 510010p 0.9
+ 512000p 0.9
+ 512010p -0.3
+ 514000p -0.3
+ 514010p 0.9
+ 516000p 0.9
+ 516010p -0.3
+ 518000p -0.3
+ 518010p 0.9
+ 520000p 0.9
+ 520010p -0.3
+ 522000p -0.3
+ 522010p 0.9
+ 524000p 0.9
+ 524010p -0.3
+ 526000p -0.3
+ 526010p 0.9
+ 528000p 0.9
+ 528010p -0.3
+ 530000p -0.3
+ 530010p 0.9
+ 532000p 0.9
+ 532010p -0.3
+ 534000p -0.3
+ 534010p 0.9
+ 536000p 0.9
+ 536010p -0.3
+ 538000p -0.3
+ 538010p 0.9
+ 540000p 0.9
+ 540010p -0.3
+ 542000p -0.3
+ 542010p 0.9
+ 544000p 0.9
+ 544010p -0.3
+ 546000p -0.3
+ 546010p 0.9
+ 548000p 0.9
+ 548010p -0.3
+ 550000p -0.3
+ 550010p 0.9
+ 552000p 0.9
+ 552010p -0.3
+ 554000p -0.3
+ 554010p 0.9
+ 556000p 0.9
+ 556010p -0.3
+ 558000p -0.3
+ 558010p 0.9
+ 560000p 0.9
+ 560010p -0.3
+ 562000p -0.3
+ 562010p 0.9
+ 564000p 0.9
+ 564010p -0.3
+ 566000p -0.3
+ 566010p 0.9
+ 568000p 0.9
+ 568010p -0.3
+ 570000p -0.3
+ 570010p 0.9
+ 572000p 0.9
+ 572010p -0.3
+ 574000p -0.3
+ 574010p 0.9
+ 576000p 0.9
+ 576010p -0.3
+ 578000p -0.3
+ 578010p 0.9
+ 580000p 0.9
+ 580010p -0.3
+ 582000p -0.3
+ 582010p 0.9
+ 584000p 0.9
+ 584010p -0.3
+ 586000p -0.3
+ 586010p 0.9
+ 588000p 0.9
+ 588010p -0.3
+ 590000p -0.3
+ 590010p 0.9
+ 592000p 0.9
+ 592010p -0.3
+ 594000p -0.3
+ 594010p 0.9
+ 596000p 0.9
+ 596010p -0.3
+ 598000p -0.3
+ 598010p 0.9
+ 600000p 0.9
+ 600010p -0.3
+ 602000p -0.3
+ 602010p 0.9
+ 604000p 0.9
+ 604010p -0.3
+ 606000p -0.3
+ 606010p 0.9
+ 608000p 0.9
+ 608010p -0.3
+ 610000p -0.3
+ 610010p 0.9
+ 612000p 0.9
+ 612010p -0.3
+ 614000p -0.3
+ 614010p 0.9
+ 616000p 0.9
+ 616010p -0.3
+ 618000p -0.3
+ 618010p 0.9
+ 620000p 0.9
+ 620010p -0.3
+ 622000p -0.3
+ 622010p 0.9
+ 624000p 0.9
+ 624010p -0.3
+ 626000p -0.3
+ 626010p 0.9
+ 628000p 0.9
+ 628010p -0.3
+ 630000p -0.3
+ 630010p 0.9
+ 632000p 0.9
+ 632010p -0.3
+ 634000p -0.3
+ 634010p 0.9
+ 636000p 0.9
+ 636010p -0.3
+ 638000p -0.3
+ 638010p 0.9
+ 640000p 0.9
+ 640010p -0.3
+ 642000p -0.3
+ 642010p 0.9
+ 644000p 0.9
+ 644010p -0.3
+ 646000p -0.3
+ 646010p 0.9
+ 648000p 0.9
+ 648010p -0.3
+ 650000p -0.3
+ 650010p 0.9
+ 652000p 0.9
+ 652010p -0.3
+ 654000p -0.3
+ 654010p 0.9
+ 656000p 0.9
+ 656010p -0.3
+ 658000p -0.3
+ 658010p 0.9
+ 660000p 0.9
+ 660010p -0.3
+ 662000p -0.3
+ 662010p 0.9
+ 664000p 0.9
+ 664010p -0.3
+ 666000p -0.3
+ 666010p 0.9
+ 668000p 0.9
+ 668010p -0.3
+ 670000p -0.3
+ 670010p 0.9
+ 672000p 0.9
+ 672010p -0.3
+ 674000p -0.3
+ 674010p 0.9
+ 676000p 0.9
+ 676010p -0.3
+ 678000p -0.3
+ 678010p 0.9
+ 680000p 0.9
+ 680010p -0.3
+ 682000p -0.3
+ 682010p 0.9
+ 684000p 0.9
+ 684010p -0.3
+ 686000p -0.3
+ 686010p 0.9
+ 688000p 0.9
+ 688010p -0.3
+ 690000p -0.3
+ 690010p 0.9
+ 692000p 0.9
+ 692010p -0.3
+ 694000p -0.3
+ 694010p 0.9
+ 696000p 0.9
+ 696010p -0.3
+ 698000p -0.3
+ 698010p 0.9
+ 700000p 0.9
+ 700010p -0.3
+ 702000p -0.3
+ 702010p 0.9
+ 704000p 0.9
+ 704010p -0.3
+ 706000p -0.3
+ 706010p 0.9
+ 708000p 0.9
+ 708010p -0.3
+ 710000p -0.3
+ 710010p 0.9
+ 712000p 0.9
+ 712010p -0.3
+ 714000p -0.3
+ 714010p 0.9
+ 716000p 0.9
+ 716010p -0.3
+ 718000p -0.3
+ 718010p 0.9
+ 720000p 0.9
+ 720010p -0.3
+ 722000p -0.3
+ 722010p 0.9
+ 724000p 0.9
+ 724010p -0.3
+ 726000p -0.3
+ 726010p 0.9
+ 728000p 0.9
+ 728010p -0.3
+ 730000p -0.3
+ 730010p 0.9
+ 732000p 0.9
+ 732010p -0.3
+ 734000p -0.3
+ 734010p 0.9
+ 736000p 0.9
+ 736010p -0.3
+ 738000p -0.3
+ 738010p 0.9
+ 740000p 0.9
+ 740010p -0.3
+ 742000p -0.3
+ 742010p 0.9
+ 744000p 0.9
+ 744010p -0.3
+ 746000p -0.3
+ 746010p 0.9
+ 748000p 0.9
+ 748010p -0.3
+ 750000p -0.3
+ 750010p 0.9
+ 752000p 0.9
+ 752010p -0.3
+ 754000p -0.3
+ 754010p 0.9
+ 756000p 0.9
+ 756010p -0.3
+ 758000p -0.3
+ 758010p 0.9
+ 760000p 0.9
+ 760010p -0.3
+ 762000p -0.3
+ 762010p 0.9
+ 764000p 0.9
+ 764010p -0.3
+ 766000p -0.3
+ 766010p 0.9
+ 768000p 0.9
+ 768010p -0.3
+ 770000p -0.3
+ 770010p 0.9
+ 772000p 0.9
+ 772010p -0.3
+ 774000p -0.3
+ 774010p 0.9
+ 776000p 0.9
+ 776010p -0.3
+ 778000p -0.3
+ 778010p 0.9
+ 780000p 0.9
+ 780010p -0.3
+ 782000p -0.3
+ 782010p 0.9
+ 784000p 0.9
+ 784010p -0.3
+ 786000p -0.3
+ 786010p 0.9
+ 788000p 0.9
+ 788010p -0.3
+ 790000p -0.3
+ 790010p 0.9
+ 792000p 0.9
+ 792010p -0.3
+ 794000p -0.3
+ 794010p 0.9
+ 796000p 0.9
+ 796010p -0.3
+ 798000p -0.3
+ 798010p 0.9
+ 800000p 0.9
+ 800010p -0.3
+ 802000p -0.3
+ 802010p 0.9
+ 804000p 0.9
+ 804010p -0.3
+ 806000p -0.3
+ 806010p 0.9
+ 808000p 0.9
+ 808010p -0.3
+ 810000p -0.3
+ 810010p 0.9
+ 812000p 0.9
+ 812010p -0.3
+ 814000p -0.3
+ 814010p 0.9
+ 816000p 0.9
+ 816010p -0.3
+ 818000p -0.3
+ 818010p 0.9
+ 820000p 0.9
+ 820010p -0.3
+ 822000p -0.3
+ 822010p 0.9
+ 824000p 0.9
+ 824010p -0.3
+ 826000p -0.3
+ 826010p 0.9
+ 828000p 0.9
+ 828010p -0.3
+ 830000p -0.3
+ 830010p 0.9
+ 832000p 0.9
+ 832010p -0.3
+ 834000p -0.3
+ 834010p 0.9
+ 836000p 0.9
+ 836010p -0.3
+ 838000p -0.3
+ 838010p 0.9
+ 840000p 0.9
+ 840010p -0.3
+ 842000p -0.3
+ 842010p 0.9
+ 844000p 0.9
+ 844010p -0.3
+ 846000p -0.3
+ 846010p 0.9
+ 848000p 0.9
+ 848010p -0.3
+ 850000p -0.3
+ 850010p 0.9
+ 852000p 0.9
+ 852010p -0.3
+ 854000p -0.3
+ 854010p 0.9
+ 856000p 0.9
+ 856010p -0.3
+ 858000p -0.3
+ 858010p 0.9
+ 860000p 0.9
+ 860010p -0.3
+ 862000p -0.3
+ 862010p 0.9
+ 864000p 0.9
+ 864010p -0.3
+ 866000p -0.3
+ 866010p 0.9
+ 868000p 0.9
+ 868010p -0.3
+ 870000p -0.3
+ 870010p 0.9
+ 872000p 0.9
+ 872010p -0.3
+ 874000p -0.3
+ 874010p 0.9
+ 876000p 0.9
+ 876010p -0.3
+ 878000p -0.3
+ 878010p 0.9
+ 880000p 0.9
+ 880010p -0.3
+ 882000p -0.3
+ 882010p 0.9
+ 884000p 0.9
+ 884010p -0.3
+ 886000p -0.3
+ 886010p 0.9
+ 888000p 0.9
+ 888010p -0.3
+ 890000p -0.3
+ 890010p 0.9
+ 892000p 0.9
+ 892010p -0.3
+ 894000p -0.3
+ 894010p 0.9
+ 896000p 0.9
+ 896010p -0.3
+ 898000p -0.3
+ 898010p 0.9
+ 900000p 0.9
+ 900010p -0.3
+ 902000p -0.3
+ 902010p 0.9
+ 904000p 0.9
+ 904010p -0.3
+ 906000p -0.3
+ 906010p 0.9
+ 908000p 0.9
+ 908010p -0.3
+ 910000p -0.3
+ 910010p 0.9
+ 912000p 0.9
+ 912010p -0.3
+ 914000p -0.3
+ 914010p 0.9
+ 916000p 0.9
+ 916010p -0.3
+ 918000p -0.3
+ 918010p 0.9
+ 920000p 0.9
+ 920010p -0.3
+ 922000p -0.3
+ 922010p 0.9
+ 924000p 0.9
+ 924010p -0.3
+ 926000p -0.3
+ 926010p 0.9
+ 928000p 0.9
+ 928010p -0.3
+ 930000p -0.3
+ 930010p 0.9
+ 932000p 0.9
+ 932010p -0.3
+ 934000p -0.3
+ 934010p 0.9
+ 936000p 0.9
+ 936010p -0.3
+ 938000p -0.3
+ 938010p 0.9
+ 940000p 0.9
+ 940010p -0.3
+ 942000p -0.3
+ 942010p 0.9
+ 944000p 0.9
+ 944010p -0.3
+ 946000p -0.3
+ 946010p 0.9
+ 948000p 0.9
+ 948010p -0.3
+ 950000p -0.3
+ 950010p 0.9
+ 952000p 0.9
+ 952010p -0.3
+ 954000p -0.3
+ 954010p 0.9
+ 956000p 0.9
+ 956010p -0.3
+ 958000p -0.3
+ 958010p 0.9
+ 960000p 0.9
+ 960010p -0.3
+ 962000p -0.3
+ 962010p 0.9
+ 964000p 0.9
+ 964010p -0.3
+ 966000p -0.3
+ 966010p 0.9
+ 968000p 0.9
+ 968010p -0.3
+ 970000p -0.3
+ 970010p 0.9
+ 972000p 0.9
+ 972010p -0.3
+ 974000p -0.3
+ 974010p 0.9
+ 976000p 0.9
+ 976010p -0.3
+ 978000p -0.3
+ 978010p 0.9
+ 980000p 0.9
+ 980010p -0.3
+ 982000p -0.3
+ 982010p 0.9
+ 984000p 0.9
+ 984010p -0.3
+ 986000p -0.3
+ 986010p 0.9
+ 988000p 0.9
+ 988010p -0.3
+ 990000p -0.3
+ 990010p 0.9
+ 992000p 0.9
+ 992010p -0.3
+ 994000p -0.3
+ 994010p 0.9
+ 996000p 0.9
+ 996010p -0.3
+ 998000p -0.3
+ 998010p 0.9
+ 1000000p 0.9
+ 1000010p -0.3
+ 1002000p -0.3
+ 1002010p 0.9
+ 1004000p 0.9
+ 1004010p -0.3
+ 1006000p -0.3
+ 1006010p 0.9
+ 1008000p 0.9
+ 1008010p -0.3
+ 1010000p -0.3
+ 1010010p 0.9
+ 1012000p 0.9
+ 1012010p -0.3
+ 1014000p -0.3
+ 1014010p 0.9
+ 1016000p 0.9
+ 1016010p -0.3
+ 1018000p -0.3
+ 1018010p 0.9
+ 1020000p 0.9
+ 1020010p -0.3
+ 1022000p -0.3
+ 1022010p 0.9
+ 1024000p 0.9
+ 1024010p -0.3
+ 1026000p -0.3
+ 1026010p 0.9
+ 1028000p 0.9
+ 1028010p -0.3
+ 1030000p -0.3
+ 1030010p 0.9
+ 1032000p 0.9
+ 1032010p -0.3
+ 1034000p -0.3
+ 1034010p 0.9
+ 1036000p 0.9
+ 1036010p -0.3
+ 1038000p -0.3
+ 1038010p 0.9
+ 1040000p 0.9
+ 1040010p -0.3
+ 1042000p -0.3
+ 1042010p 0.9
+ 1044000p 0.9
+ 1044010p -0.3
+ 1046000p -0.3
+ 1046010p 0.9
+ 1048000p 0.9
+ 1048010p -0.3
+ 1050000p -0.3
+ 1050010p 0.9
+ 1052000p 0.9
+ 1052010p -0.3
+ 1054000p -0.3
+ 1054010p 0.9
+ 1056000p 0.9
+ 1056010p -0.3
+ 1058000p -0.3
+ 1058010p 0.9
+ 1060000p 0.9
+ 1060010p -0.3
+ 1062000p -0.3
+ 1062010p 0.9
+ 1064000p 0.9
+ 1064010p -0.3
+ 1066000p -0.3
+ 1066010p 0.9
+ 1068000p 0.9
+ 1068010p -0.3
+ 1070000p -0.3
+ 1070010p 0.9
+ 1072000p 0.9
+ 1072010p -0.3
+ 1074000p -0.3
+ 1074010p 0.9
+ 1076000p 0.9
+ 1076010p -0.3
+ 1078000p -0.3
+ 1078010p 0.9
+ 1080000p 0.9
+ 1080010p -0.3
+ 1082000p -0.3
+ 1082010p 0.9
+ 1084000p 0.9
+ 1084010p -0.3
+ 1086000p -0.3
+ 1086010p 0.9
+ 1088000p 0.9
+ 1088010p -0.3
+ 1090000p -0.3
+ 1090010p 0.9
+ 1092000p 0.9
+ 1092010p -0.3
+ 1094000p -0.3
+ 1094010p 0.9
+ 1096000p 0.9
+ 1096010p -0.3
+ 1098000p -0.3
+ 1098010p 0.9
+ 1100000p 0.9
+ 1100010p -0.3
+ 1102000p -0.3
+ 1102010p 0.9
+ 1104000p 0.9
+ 1104010p -0.3
+ 1106000p -0.3
+ 1106010p 0.9
+ 1108000p 0.9
+ 1108010p -0.3
+ 1110000p -0.3
+ 1110010p 0.9
+ 1112000p 0.9
+ 1112010p -0.3
+ 1114000p -0.3
+ 1114010p 0.9
+ 1116000p 0.9
+ 1116010p -0.3
+ 1118000p -0.3
+ 1118010p 0.9
+ 1120000p 0.9
+ 1120010p -0.3
+ 1122000p -0.3
+ 1122010p 0.9
+ 1124000p 0.9
+ 1124010p -0.3
+ 1126000p -0.3
+ 1126010p 0.9
+ 1128000p 0.9
+ 1128010p -0.3
+ 1130000p -0.3
+ 1130010p 0.9
+ 1132000p 0.9
+ 1132010p -0.3
+ 1134000p -0.3
+ 1134010p 0.9
+ 1136000p 0.9
+ 1136010p -0.3
+ 1138000p -0.3
+ 1138010p 0.9
+ 1140000p 0.9
+ 1140010p -0.3
+ 1142000p -0.3
+ 1142010p 0.9
+ 1144000p 0.9
+ 1144010p -0.3
+ 1146000p -0.3
+ 1146010p 0.9
+ 1148000p 0.9
+ 1148010p -0.3
+ 1150000p -0.3
+ 1150010p 0.9
+ 1152000p 0.9
+ 1152010p -0.3
+ 1154000p -0.3
+ 1154010p 0.9
+ 1156000p 0.9
+ 1156010p -0.3
+ 1158000p -0.3
+ 1158010p 0.9
+ 1160000p 0.9
+ 1160010p -0.3
+ 1162000p -0.3
+ 1162010p 0.9
+ 1164000p 0.9
+ 1164010p -0.3
+ 1166000p -0.3
+ 1166010p 0.9
+ 1168000p 0.9
+ 1168010p -0.3
+ 1170000p -0.3
+ 1170010p 0.9
+ 1172000p 0.9
+ 1172010p -0.3
+ 1174000p -0.3
+ 1174010p 0.9
+ 1176000p 0.9
+ 1176010p -0.3
+ 1178000p -0.3
+ 1178010p 0.9
+ 1180000p 0.9
+ 1180010p -0.3
+ 1182000p -0.3
+ 1182010p 0.9
+ 1184000p 0.9
+ 1184010p -0.3
+ 1186000p -0.3
+ 1186010p 0.9
+ 1188000p 0.9
+ 1188010p -0.3
+ 1190000p -0.3
+ 1190010p 0.9
+ 1192000p 0.9
+ 1192010p -0.3
+ 1194000p -0.3
+ 1194010p 0.9
+ 1196000p 0.9
+ 1196010p -0.3
+ 1198000p -0.3
+ 1198010p 0.9
+ 1200000p 0.9
+ 1200010p -0.3
+ 1202000p -0.3
+ 1202010p 0.9
+ 1204000p 0.9
+ 1204010p -0.3
+ 1206000p -0.3
+ 1206010p 0.9
+ 1208000p 0.9
+ 1208010p -0.3
+ 1210000p -0.3
+ 1210010p 0.9
+ 1212000p 0.9
+ 1212010p -0.3
+ 1214000p -0.3
+ 1214010p 0.9
+ 1216000p 0.9
+ 1216010p -0.3
+ 1218000p -0.3
+ 1218010p 0.9
+ 1220000p 0.9
+ 1220010p -0.3
+ 1222000p -0.3
+ 1222010p 0.9
+ 1224000p 0.9
+ 1224010p -0.3
+ 1226000p -0.3
+ 1226010p 0.9
+ 1228000p 0.9
+ 1228010p -0.3
+ 1230000p -0.3
+ 1230010p 0.9
+ 1232000p 0.9
+ 1232010p -0.3
+ 1234000p -0.3
+ 1234010p 0.9
+ 1236000p 0.9
+ 1236010p -0.3
+ 1238000p -0.3
+ 1238010p 0.9
+ 1240000p 0.9
+ 1240010p -0.3
+ 1242000p -0.3
+ 1242010p 0.9
+ 1244000p 0.9
+ 1244010p -0.3
+ 1246000p -0.3
+ 1246010p 0.9
+ 1248000p 0.9
+ 1248010p -0.3
+ 1250000p -0.3
+ 1250010p 0.9
+ 1252000p 0.9
+ 1252010p -0.3
+ 1254000p -0.3
+ 1254010p 0.9
+ 1256000p 0.9
+ 1256010p -0.3
+ 1258000p -0.3
+ 1258010p 0.9
+ 1260000p 0.9
+ 1260010p -0.3
+ 1262000p -0.3
+ 1262010p 0.9
+ 1264000p 0.9
+ 1264010p -0.3
+ 1266000p -0.3
+ 1266010p 0.9
+ 1268000p 0.9
+ 1268010p -0.3
+ 1270000p -0.3
+ 1270010p 0.9
+ 1272000p 0.9
+ 1272010p -0.3
+ 1274000p -0.3
+ 1274010p 0.9
+ 1276000p 0.9
+ 1276010p -0.3
+ 1278000p -0.3
+ 1278010p 0.9
+ 1280000p 0.9
+ 1280010p -0.3
+ 1282000p -0.3
+ 1282010p 0.9
+ 1284000p 0.9
+ 1284010p -0.3
+ 1286000p -0.3
+ 1286010p 0.9
+ 1288000p 0.9
+ 1288010p -0.3
+ 1290000p -0.3
+ 1290010p 0.9
+ 1292000p 0.9
+ 1292010p -0.3
+ 1294000p -0.3
+ 1294010p 0.9
+ 1296000p 0.9
+ 1296010p -0.3
+ 1298000p -0.3
+ 1298010p 0.9
+ 1300000p 0.9
+ 1300010p -0.3
+ 1302000p -0.3
+ 1302010p 0.9
+ 1304000p 0.9
+ 1304010p -0.3
+ 1306000p -0.3
+ 1306010p 0.9
+ 1308000p 0.9
+ 1308010p -0.3
+ 1310000p -0.3
+ 1310010p 0.9
+ 1312000p 0.9
+ 1312010p -0.3
+ 1314000p -0.3
+ 1314010p 0.9
+ 1316000p 0.9
+ 1316010p -0.3
+ 1318000p -0.3
+ 1318010p 0.9
+ 1320000p 0.9
+ 1320010p -0.3
+ 1322000p -0.3
+ 1322010p 0.9
+ 1324000p 0.9
+ 1324010p -0.3
+ 1326000p -0.3
+ 1326010p 0.9
+ 1328000p 0.9
+ 1328010p -0.3
+ 1330000p -0.3
+ 1330010p 0.9
+ 1332000p 0.9
+ 1332010p -0.3
+ 1334000p -0.3
+ 1334010p 0.9
+ 1336000p 0.9
+ 1336010p -0.3
+ 1338000p -0.3
+ 1338010p 0.9
+ 1340000p 0.9
+ 1340010p -0.3
+ 1342000p -0.3
+ 1342010p 0.9
+ 1344000p 0.9
+ 1344010p -0.3
+ 1346000p -0.3
+ 1346010p 0.9
+ 1348000p 0.9
+ 1348010p -0.3
+ 1350000p -0.3
+ 1350010p 0.9
+ 1352000p 0.9
+ 1352010p -0.3
+ 1354000p -0.3
+ 1354010p 0.9
+ 1356000p 0.9
+ 1356010p -0.3
+ 1358000p -0.3
+ 1358010p 0.9
+ 1360000p 0.9
+ 1360010p -0.3
+ 1362000p -0.3
+ 1362010p 0.9
+ 1364000p 0.9
+ 1364010p -0.3
+ 1366000p -0.3
+ 1366010p 0.9
+ 1368000p 0.9
+ 1368010p -0.3
+ 1370000p -0.3
+ 1370010p 0.9
+ 1372000p 0.9
+ 1372010p -0.3
+ 1374000p -0.3
+ 1374010p 0.9
+ 1376000p 0.9
+ 1376010p -0.3
+ 1378000p -0.3
+ 1378010p 0.9
+ 1380000p 0.9
+ 1380010p -0.3
+ 1382000p -0.3
+ 1382010p 0.9
+ 1384000p 0.9
+ 1384010p -0.3
+ 1386000p -0.3
+ 1386010p 0.9
+ 1388000p 0.9
+ 1388010p -0.3
+ 1390000p -0.3
+ 1390010p 0.9
+ 1392000p 0.9
+ 1392010p -0.3
+ 1394000p -0.3
+ 1394010p 0.9
+ 1396000p 0.9
+ 1396010p -0.3
+ 1398000p -0.3
+ 1398010p 0.9
+ 1400000p 0.9
+ 1400010p -0.3
+ 1402000p -0.3
+ 1402010p 0.9
+ 1404000p 0.9
+ 1404010p -0.3
+ 1406000p -0.3
+ 1406010p 0.9
+ 1408000p 0.9
+ 1408010p -0.3
+ 1410000p -0.3
+ 1410010p 0.9
+ 1412000p 0.9
+ 1412010p -0.3
+ 1414000p -0.3
+ 1414010p 0.9
+ 1416000p 0.9
+ 1416010p -0.3
+ 1418000p -0.3
+ 1418010p 0.9
+ 1420000p 0.9
+ 1420010p -0.3
+ 1422000p -0.3
+ 1422010p 0.9
+ 1424000p 0.9
+ 1424010p -0.3
+ 1426000p -0.3
+ 1426010p 0.9
+ 1428000p 0.9
+ 1428010p -0.3
+ 1430000p -0.3
+ 1430010p 0.9
+ 1432000p 0.9
+ 1432010p -0.3
+ 1434000p -0.3
+ 1434010p 0.9
+ 1436000p 0.9
+ 1436010p -0.3
+ 1438000p -0.3
+ 1438010p 0.9
+ 1440000p 0.9
+ 1440010p -0.3
+ 1442000p -0.3
+ 1442010p 0.9
+ 1444000p 0.9
+ 1444010p -0.3
+ 1446000p -0.3
+ 1446010p 0.9
+ 1448000p 0.9
+ 1448010p -0.3
+ 1450000p -0.3
+ 1450010p 0.9
+ 1452000p 0.9
+ 1452010p -0.3
+ 1454000p -0.3
+ 1454010p 0.9
+ 1456000p 0.9
+ 1456010p -0.3
+ 1458000p -0.3
+ 1458010p 0.9
+ 1460000p 0.9
+ 1460010p -0.3
+ 1462000p -0.3
+ 1462010p 0.9
+ 1464000p 0.9
+ 1464010p -0.3
+ 1466000p -0.3
+ 1466010p 0.9
+ 1468000p 0.9
+ 1468010p -0.3
+ 1470000p -0.3
+ 1470010p 0.9
+ 1472000p 0.9
+ 1472010p -0.3
+ 1474000p -0.3
+ 1474010p 0.9
+ 1476000p 0.9
+ 1476010p -0.3
+ 1478000p -0.3
+ 1478010p 0.9
+ 1480000p 0.9
+ 1480010p -0.3
+ 1482000p -0.3
+ 1482010p 0.9
+ 1484000p 0.9
+ 1484010p -0.3
+ 1486000p -0.3
+ 1486010p 0.9
+ 1488000p 0.9
+ 1488010p -0.3
+ 1490000p -0.3
+ 1490010p 0.9
+ 1492000p 0.9
+ 1492010p -0.3
+ 1494000p -0.3
+ 1494010p 0.9
+ 1496000p 0.9
+ 1496010p -0.3
+ 1498000p -0.3
+ 1498010p 0.9
+ 1500000p 0.9
+ 1500010p -0.3
+ 1502000p -0.3
+ 1502010p 0.9
+ 1504000p 0.9
+ 1504010p -0.3
+ 1506000p -0.3
+ 1506010p 0.9
+ 1508000p 0.9
+ 1508010p -0.3
+ 1510000p -0.3
+ 1510010p 0.9
+ 1512000p 0.9
+ 1512010p -0.3
+ 1514000p -0.3
+ 1514010p 0.9
+ 1516000p 0.9
+ 1516010p -0.3
+ 1518000p -0.3
+ 1518010p 0.9
+ 1520000p 0.9
+ 1520010p -0.3
+ 1522000p -0.3
+ 1522010p 0.9
+ 1524000p 0.9
+ 1524010p -0.3
+ 1526000p -0.3
+ 1526010p 0.9
+ 1528000p 0.9
+ 1528010p -0.3
+ 1530000p -0.3
+ 1530010p 0.9
+ 1532000p 0.9
+ 1532010p -0.3
+ 1534000p -0.3
+ 1534010p 0.9
+ 1536000p 0.9
+ 1536010p -0.3
+ 1538000p -0.3
+ 1538010p 0.9
+ 1540000p 0.9
+ 1540010p -0.3
+ 1542000p -0.3
+ 1542010p 0.9
+ 1544000p 0.9
+ 1544010p -0.3
+ 1546000p -0.3
+ 1546010p 0.9
+ 1548000p 0.9
+ 1548010p -0.3
+ 1550000p -0.3
+ 1550010p 0.9
+ 1552000p 0.9
+ 1552010p -0.3
+ 1554000p -0.3
+ 1554010p 0.9
+ 1556000p 0.9
+ 1556010p -0.3
+ 1558000p -0.3
+ 1558010p 0.9
+ 1560000p 0.9
+ 1560010p -0.3
+ 1562000p -0.3
+ 1562010p 0.9
+ 1564000p 0.9
+ 1564010p -0.3
+ 1566000p -0.3
+ 1566010p 0.9
+ 1568000p 0.9
+ 1568010p -0.3
+ 1570000p -0.3
+ 1570010p 0.9
+ 1572000p 0.9
+ 1572010p -0.3
+ 1574000p -0.3
+ 1574010p 0.9
+ 1576000p 0.9
+ 1576010p -0.3
+ 1578000p -0.3
+ 1578010p 0.9
+ 1580000p 0.9
+ 1580010p -0.3
+ 1582000p -0.3
+ 1582010p 0.9
+ 1584000p 0.9
+ 1584010p -0.3
+ 1586000p -0.3
+ 1586010p 0.9
+ 1588000p 0.9
+ 1588010p -0.3
+ 1590000p -0.3
+ 1590010p 0.9
+ 1592000p 0.9
+ 1592010p -0.3
+ 1594000p -0.3
+ 1594010p 0.9
+ 1596000p 0.9
+ 1596010p -0.3
+ 1598000p -0.3
+ 1598010p 0.9
+ 1600000p 0.9
+ 1600010p -0.3
+ 1602000p -0.3
+ 1602010p 0.9
+ 1604000p 0.9
+ 1604010p -0.3
+ 1606000p -0.3
+ 1606010p 0.9
+ 1608000p 0.9
+ 1608010p -0.3
+ 1610000p -0.3
+ 1610010p 0.9
+ 1612000p 0.9
+ 1612010p -0.3
+ 1614000p -0.3
+ 1614010p 0.9
+ 1616000p 0.9
+ 1616010p -0.3
+ 1618000p -0.3
+ 1618010p 0.9
+ 1620000p 0.9
+ 1620010p -0.3
+ 1622000p -0.3
+ 1622010p 0.9
+ 1624000p 0.9
+ 1624010p -0.3
+ 1626000p -0.3
+ 1626010p 0.9
+ 1628000p 0.9
+ 1628010p -0.3
+ 1630000p -0.3
+ 1630010p 0.9
+ 1632000p 0.9
+ 1632010p -0.3
+ 1634000p -0.3
+ 1634010p 0.9
+ 1636000p 0.9
+ 1636010p -0.3
+ 1638000p -0.3
+ 1638010p 0.9
+ 1640000p 0.9
+ 1640010p -0.3
+ 1642000p -0.3
+ 1642010p 0.9
+ 1644000p 0.9
+ 1644010p -0.3
+ 1646000p -0.3
+ 1646010p 0.9
+ 1648000p 0.9
+ 1648010p -0.3
+ 1650000p -0.3
+ 1650010p 0.9
+ 1652000p 0.9
+ 1652010p -0.3
+ 1654000p -0.3
+ 1654010p 0.9
+ 1656000p 0.9
+ 1656010p -0.3
+ 1658000p -0.3
+ 1658010p 0.9
+ 1660000p 0.9
+ 1660010p -0.3
+ 1662000p -0.3
+ 1662010p 0.9
+ 1664000p 0.9
+ 1664010p -0.3
+ 1666000p -0.3
+ 1666010p 0.9
+ 1668000p 0.9
+ 1668010p -0.3
+ 1670000p -0.3
+ 1670010p 0.9
+ 1672000p 0.9
+ 1672010p -0.3
+ 1674000p -0.3
+ 1674010p 0.9
+ 1676000p 0.9
+ 1676010p -0.3
+ 1678000p -0.3
+ 1678010p 0.9
+ 1680000p 0.9
+ 1680010p -0.3
+ 1682000p -0.3
+ 1682010p 0.9
+ 1684000p 0.9
+ 1684010p -0.3
+ 1686000p -0.3
+ 1686010p 0.9
+ 1688000p 0.9
+ 1688010p -0.3
+ 1690000p -0.3
+ 1690010p 0.9
+ 1692000p 0.9
+ 1692010p -0.3
+ 1694000p -0.3
+ 1694010p 0.9
+ 1696000p 0.9
+ 1696010p -0.3
+ 1698000p -0.3
+ 1698010p 0.9
+ 1700000p 0.9
+ 1700010p -0.3
+ 1702000p -0.3
+ 1702010p 0.9
+ 1704000p 0.9
+ 1704010p -0.3
+ 1706000p -0.3
+ 1706010p 0.9
+ 1708000p 0.9
+ 1708010p -0.3
+ 1710000p -0.3
+ 1710010p 0.9
+ 1712000p 0.9
+ 1712010p -0.3
+ 1714000p -0.3
+ 1714010p 0.9
+ 1716000p 0.9
+ 1716010p -0.3
+ 1718000p -0.3
+ 1718010p 0.9
+ 1720000p 0.9
+ 1720010p -0.3
+ 1722000p -0.3
+ 1722010p 0.9
+ 1724000p 0.9
+ 1724010p -0.3
+ 1726000p -0.3
+ 1726010p 0.9
+ 1728000p 0.9
+ 1728010p -0.3
+ 1730000p -0.3
+ 1730010p 0.9
+ 1732000p 0.9
+ 1732010p -0.3
+ 1734000p -0.3
+ 1734010p 0.9
+ 1736000p 0.9
+ 1736010p -0.3
+ 1738000p -0.3
+ 1738010p 0.9
+ 1740000p 0.9
+ 1740010p -0.3
+ 1742000p -0.3
+ 1742010p 0.9
+ 1744000p 0.9
+ 1744010p -0.3
+ 1746000p -0.3
+ 1746010p 0.9
+ 1748000p 0.9
+ 1748010p -0.3
+ 1750000p -0.3
+ 1750010p 0.9
+ 1752000p 0.9
+ 1752010p -0.3
+ 1754000p -0.3
+ 1754010p 0.9
+ 1756000p 0.9
+ 1756010p -0.3
+ 1758000p -0.3
+ 1758010p 0.9
+ 1760000p 0.9
+ 1760010p -0.3
+ 1762000p -0.3
+ 1762010p 0.9
+ 1764000p 0.9
+ 1764010p -0.3
+ 1766000p -0.3
+ 1766010p 0.9
+ 1768000p 0.9
+ 1768010p -0.3
+ 1770000p -0.3
+ 1770010p 0.9
+ 1772000p 0.9
+ 1772010p -0.3
+ 1774000p -0.3
+ 1774010p 0.9
+ 1776000p 0.9
+ 1776010p -0.3
+ 1778000p -0.3
+ 1778010p 0.9
+ 1780000p 0.9
+ 1780010p -0.3
+ 1782000p -0.3
+ 1782010p 0.9
+ 1784000p 0.9
+ 1784010p -0.3
+ 1786000p -0.3
+ 1786010p 0.9
+ 1788000p 0.9
+ 1788010p -0.3
+ 1790000p -0.3
+ 1790010p 0.9
+ 1792000p 0.9
+ 1792010p -0.3
+ 1794000p -0.3
+ 1794010p 0.9
+ 1796000p 0.9
+ 1796010p -0.3
+ 1798000p -0.3
+ 1798010p 0.9
+ 1800000p 0.9
+ 1800010p -0.3
+ 1802000p -0.3
+ 1802010p 0.9
+ 1804000p 0.9
+ 1804010p -0.3
+ 1806000p -0.3
+ 1806010p 0.9
+ 1808000p 0.9
+ 1808010p -0.3
+ 1810000p -0.3
+ 1810010p 0.9
+ 1812000p 0.9
+ 1812010p -0.3
+ 1814000p -0.3
+ 1814010p 0.9
+ 1816000p 0.9
+ 1816010p -0.3
+ 1818000p -0.3
+ 1818010p 0.9
+ 1820000p 0.9
+ 1820010p -0.3
+ 1822000p -0.3
+ 1822010p 0.9
+ 1824000p 0.9
+ 1824010p -0.3
+ 1826000p -0.3
+ 1826010p 0.9
+ 1828000p 0.9
+ 1828010p -0.3
+ 1830000p -0.3
+ 1830010p 0.9
+ 1832000p 0.9
+ 1832010p -0.3
+ 1834000p -0.3
+ 1834010p 0.9
+ 1836000p 0.9
+ 1836010p -0.3
+ 1838000p -0.3
+ 1838010p 0.9
+ 1840000p 0.9
+ 1840010p -0.3
+ 1842000p -0.3
+ 1842010p 0.9
+ 1844000p 0.9
+ 1844010p -0.3
+ 1846000p -0.3
+ 1846010p 0.9
+ 1848000p 0.9
+ 1848010p -0.3
+ 1850000p -0.3
+ 1850010p 0.9
+ 1852000p 0.9
+ 1852010p -0.3
+ 1854000p -0.3
+ 1854010p 0.9
+ 1856000p 0.9
+ 1856010p -0.3
+ 1858000p -0.3
+ 1858010p 0.9
+ 1860000p 0.9
+ 1860010p -0.3
+ 1862000p -0.3
+ 1862010p 0.9
+ 1864000p 0.9
+ 1864010p -0.3
+ 1866000p -0.3
+ 1866010p 0.9
+ 1868000p 0.9
+ 1868010p -0.3
+ 1870000p -0.3
+ 1870010p 0.9
+ 1872000p 0.9
+ 1872010p -0.3
+ 1874000p -0.3
+ 1874010p 0.9
+ 1876000p 0.9
+ 1876010p -0.3
+ 1878000p -0.3
+ 1878010p 0.9
+ 1880000p 0.9
+ 1880010p -0.3
+ 1882000p -0.3
+ 1882010p 0.9
+ 1884000p 0.9
+ 1884010p -0.3
+ 1886000p -0.3
+ 1886010p 0.9
+ 1888000p 0.9
+ 1888010p -0.3
+ 1890000p -0.3
+ 1890010p 0.9
+ 1892000p 0.9
+ 1892010p -0.3
+ 1894000p -0.3
+ 1894010p 0.9
+ 1896000p 0.9
+ 1896010p -0.3
+ 1898000p -0.3
+ 1898010p 0.9
+ 1900000p 0.9
+ 1900010p -0.3
+ 1902000p -0.3
+ 1902010p 0.9
+ 1904000p 0.9
+ 1904010p -0.3
+ 1906000p -0.3
+ 1906010p 0.9
+ 1908000p 0.9
+ 1908010p -0.3
+ 1910000p -0.3
+ 1910010p 0.9
+ 1912000p 0.9
+ 1912010p -0.3
+ 1914000p -0.3
+ 1914010p 0.9
+ 1916000p 0.9
+ 1916010p -0.3
+ 1918000p -0.3
+ 1918010p 0.9
+ 1920000p 0.9
+ 1920010p -0.3
+ 1922000p -0.3
+ 1922010p 0.9
+ 1924000p 0.9
+ 1924010p -0.3
+ 1926000p -0.3
+ 1926010p 0.9
+ 1928000p 0.9
+ 1928010p -0.3
+ 1930000p -0.3
+ 1930010p 0.9
+ 1932000p 0.9
+ 1932010p -0.3
+ 1934000p -0.3
+ 1934010p 0.9
+ 1936000p 0.9
+ 1936010p -0.3
+ 1938000p -0.3
+ 1938010p 0.9
+ 1940000p 0.9
+ 1940010p -0.3
+ 1942000p -0.3
+ 1942010p 0.9
+ 1944000p 0.9
+ 1944010p -0.3
+ 1946000p -0.3
+ 1946010p 0.9
+ 1948000p 0.9
+ 1948010p -0.3
+ 1950000p -0.3
+ 1950010p 0.9
+ 1952000p 0.9
+ 1952010p -0.3
+ 1954000p -0.3
+ 1954010p 0.9
+ 1956000p 0.9
+ 1956010p -0.3
+ 1958000p -0.3
+ 1958010p 0.9
+ 1960000p 0.9
+ 1960010p -0.3
+ 1962000p -0.3
+ 1962010p 0.9
+ 1964000p 0.9
+ 1964010p -0.3
+ 1966000p -0.3
+ 1966010p 0.9
+ 1968000p 0.9
+ 1968010p -0.3
+ 1970000p -0.3
+ 1970010p 0.9
+ 1972000p 0.9
+ 1972010p -0.3
+ 1974000p -0.3
+ 1974010p 0.9
+ 1976000p 0.9
+ 1976010p -0.3
+ 1978000p -0.3
+ 1978010p 0.9
+ 1980000p 0.9
+ 1980010p -0.3
+ 1982000p -0.3
+ 1982010p 0.9
+ 1984000p 0.9
+ 1984010p -0.3
+ 1986000p -0.3
+ 1986010p 0.9
+ 1988000p 0.9
+ 1988010p -0.3
+ 1990000p -0.3
+ 1990010p 0.9
+ 1992000p 0.9
+ 1992010p -0.3
+ 1994000p -0.3
+ 1994010p 0.9
+ 1996000p 0.9
+ 1996010p -0.3
+ 1998000p -0.3
+ 1998010p 0.9
+ 2000000p 0.9
+ 2000010p -0.3
+ 2002000p -0.3
+ 2002010p 0.9
+ 2004000p 0.9
+ 2004010p -0.3
+ 2006000p -0.3
+ 2006010p 0.9
+ 2008000p 0.9
+ 2008010p -0.3
+ 2010000p -0.3
+ 2010010p 0.9
+ 2012000p 0.9
+ 2012010p -0.3
+ 2014000p -0.3
+ 2014010p 0.9
+ 2016000p 0.9
+ 2016010p -0.3
+ 2018000p -0.3
+ 2018010p 0.9
+ 2020000p 0.9
+ 2020010p -0.3
+ 2022000p -0.3
+ 2022010p 0.9
+ 2024000p 0.9
+ 2024010p -0.3
+ 2026000p -0.3
+ 2026010p 0.9
+ 2028000p 0.9
+ 2028010p -0.3
+ 2030000p -0.3
+ 2030010p 0.9
+ 2032000p 0.9
+ 2032010p -0.3
+ 2034000p -0.3
+ 2034010p 0.9
+ 2036000p 0.9
+ 2036010p -0.3
+ 2038000p -0.3
+ 2038010p 0.9
+ 2040000p 0.9
+ 2040010p -0.3
+ 2042000p -0.3
+ 2042010p 0.9
+ 2044000p 0.9
+ 2044010p -0.3
+ 2046000p -0.3
+ 2046010p 0.9
+ 2048000p 0.9
+ 2048010p -0.3
+ \]
V_data_18 (Data\\<18\\> gnd!) vsource type=pwl wave=\[
+ 0    0.9
+ 2000p 0.9
+ 2010p -0.3
+ 4000p -0.3
+ 4010p 0.9
+ 6000p 0.9
+ 6010p -0.3
+ 8000p -0.3
+ 8010p 0.9
+ 10000p 0.9
+ 10010p -0.3
+ 12000p -0.3
+ 12010p 0.9
+ 14000p 0.9
+ 14010p -0.3
+ 16000p -0.3
+ 16010p 0.9
+ 18000p 0.9
+ 18010p -0.3
+ 20000p -0.3
+ 20010p 0.9
+ 22000p 0.9
+ 22010p -0.3
+ 24000p -0.3
+ 24010p 0.9
+ 26000p 0.9
+ 26010p -0.3
+ 28000p -0.3
+ 28010p 0.9
+ 30000p 0.9
+ 30010p -0.3
+ 32000p -0.3
+ 32010p 0.9
+ 34000p 0.9
+ 34010p -0.3
+ 36000p -0.3
+ 36010p 0.9
+ 38000p 0.9
+ 38010p -0.3
+ 40000p -0.3
+ 40010p 0.9
+ 42000p 0.9
+ 42010p -0.3
+ 44000p -0.3
+ 44010p 0.9
+ 46000p 0.9
+ 46010p -0.3
+ 48000p -0.3
+ 48010p 0.9
+ 50000p 0.9
+ 50010p -0.3
+ 52000p -0.3
+ 52010p 0.9
+ 54000p 0.9
+ 54010p -0.3
+ 56000p -0.3
+ 56010p 0.9
+ 58000p 0.9
+ 58010p -0.3
+ 60000p -0.3
+ 60010p 0.9
+ 62000p 0.9
+ 62010p -0.3
+ 64000p -0.3
+ 64010p 0.9
+ 66000p 0.9
+ 66010p -0.3
+ 68000p -0.3
+ 68010p 0.9
+ 70000p 0.9
+ 70010p -0.3
+ 72000p -0.3
+ 72010p 0.9
+ 74000p 0.9
+ 74010p -0.3
+ 76000p -0.3
+ 76010p 0.9
+ 78000p 0.9
+ 78010p -0.3
+ 80000p -0.3
+ 80010p 0.9
+ 82000p 0.9
+ 82010p -0.3
+ 84000p -0.3
+ 84010p 0.9
+ 86000p 0.9
+ 86010p -0.3
+ 88000p -0.3
+ 88010p 0.9
+ 90000p 0.9
+ 90010p -0.3
+ 92000p -0.3
+ 92010p 0.9
+ 94000p 0.9
+ 94010p -0.3
+ 96000p -0.3
+ 96010p 0.9
+ 98000p 0.9
+ 98010p -0.3
+ 100000p -0.3
+ 100010p 0.9
+ 102000p 0.9
+ 102010p -0.3
+ 104000p -0.3
+ 104010p 0.9
+ 106000p 0.9
+ 106010p -0.3
+ 108000p -0.3
+ 108010p 0.9
+ 110000p 0.9
+ 110010p -0.3
+ 112000p -0.3
+ 112010p 0.9
+ 114000p 0.9
+ 114010p -0.3
+ 116000p -0.3
+ 116010p 0.9
+ 118000p 0.9
+ 118010p -0.3
+ 120000p -0.3
+ 120010p 0.9
+ 122000p 0.9
+ 122010p -0.3
+ 124000p -0.3
+ 124010p 0.9
+ 126000p 0.9
+ 126010p -0.3
+ 128000p -0.3
+ 128010p 0.9
+ 130000p 0.9
+ 130010p -0.3
+ 132000p -0.3
+ 132010p 0.9
+ 134000p 0.9
+ 134010p -0.3
+ 136000p -0.3
+ 136010p 0.9
+ 138000p 0.9
+ 138010p -0.3
+ 140000p -0.3
+ 140010p 0.9
+ 142000p 0.9
+ 142010p -0.3
+ 144000p -0.3
+ 144010p 0.9
+ 146000p 0.9
+ 146010p -0.3
+ 148000p -0.3
+ 148010p 0.9
+ 150000p 0.9
+ 150010p -0.3
+ 152000p -0.3
+ 152010p 0.9
+ 154000p 0.9
+ 154010p -0.3
+ 156000p -0.3
+ 156010p 0.9
+ 158000p 0.9
+ 158010p -0.3
+ 160000p -0.3
+ 160010p 0.9
+ 162000p 0.9
+ 162010p -0.3
+ 164000p -0.3
+ 164010p 0.9
+ 166000p 0.9
+ 166010p -0.3
+ 168000p -0.3
+ 168010p 0.9
+ 170000p 0.9
+ 170010p -0.3
+ 172000p -0.3
+ 172010p 0.9
+ 174000p 0.9
+ 174010p -0.3
+ 176000p -0.3
+ 176010p 0.9
+ 178000p 0.9
+ 178010p -0.3
+ 180000p -0.3
+ 180010p 0.9
+ 182000p 0.9
+ 182010p -0.3
+ 184000p -0.3
+ 184010p 0.9
+ 186000p 0.9
+ 186010p -0.3
+ 188000p -0.3
+ 188010p 0.9
+ 190000p 0.9
+ 190010p -0.3
+ 192000p -0.3
+ 192010p 0.9
+ 194000p 0.9
+ 194010p -0.3
+ 196000p -0.3
+ 196010p 0.9
+ 198000p 0.9
+ 198010p -0.3
+ 200000p -0.3
+ 200010p 0.9
+ 202000p 0.9
+ 202010p -0.3
+ 204000p -0.3
+ 204010p 0.9
+ 206000p 0.9
+ 206010p -0.3
+ 208000p -0.3
+ 208010p 0.9
+ 210000p 0.9
+ 210010p -0.3
+ 212000p -0.3
+ 212010p 0.9
+ 214000p 0.9
+ 214010p -0.3
+ 216000p -0.3
+ 216010p 0.9
+ 218000p 0.9
+ 218010p -0.3
+ 220000p -0.3
+ 220010p 0.9
+ 222000p 0.9
+ 222010p -0.3
+ 224000p -0.3
+ 224010p 0.9
+ 226000p 0.9
+ 226010p -0.3
+ 228000p -0.3
+ 228010p 0.9
+ 230000p 0.9
+ 230010p -0.3
+ 232000p -0.3
+ 232010p 0.9
+ 234000p 0.9
+ 234010p -0.3
+ 236000p -0.3
+ 236010p 0.9
+ 238000p 0.9
+ 238010p -0.3
+ 240000p -0.3
+ 240010p 0.9
+ 242000p 0.9
+ 242010p -0.3
+ 244000p -0.3
+ 244010p 0.9
+ 246000p 0.9
+ 246010p -0.3
+ 248000p -0.3
+ 248010p 0.9
+ 250000p 0.9
+ 250010p -0.3
+ 252000p -0.3
+ 252010p 0.9
+ 254000p 0.9
+ 254010p -0.3
+ 256000p -0.3
+ 256010p 0.9
+ 258000p 0.9
+ 258010p -0.3
+ 260000p -0.3
+ 260010p 0.9
+ 262000p 0.9
+ 262010p -0.3
+ 264000p -0.3
+ 264010p 0.9
+ 266000p 0.9
+ 266010p -0.3
+ 268000p -0.3
+ 268010p 0.9
+ 270000p 0.9
+ 270010p -0.3
+ 272000p -0.3
+ 272010p 0.9
+ 274000p 0.9
+ 274010p -0.3
+ 276000p -0.3
+ 276010p 0.9
+ 278000p 0.9
+ 278010p -0.3
+ 280000p -0.3
+ 280010p 0.9
+ 282000p 0.9
+ 282010p -0.3
+ 284000p -0.3
+ 284010p 0.9
+ 286000p 0.9
+ 286010p -0.3
+ 288000p -0.3
+ 288010p 0.9
+ 290000p 0.9
+ 290010p -0.3
+ 292000p -0.3
+ 292010p 0.9
+ 294000p 0.9
+ 294010p -0.3
+ 296000p -0.3
+ 296010p 0.9
+ 298000p 0.9
+ 298010p -0.3
+ 300000p -0.3
+ 300010p 0.9
+ 302000p 0.9
+ 302010p -0.3
+ 304000p -0.3
+ 304010p 0.9
+ 306000p 0.9
+ 306010p -0.3
+ 308000p -0.3
+ 308010p 0.9
+ 310000p 0.9
+ 310010p -0.3
+ 312000p -0.3
+ 312010p 0.9
+ 314000p 0.9
+ 314010p -0.3
+ 316000p -0.3
+ 316010p 0.9
+ 318000p 0.9
+ 318010p -0.3
+ 320000p -0.3
+ 320010p 0.9
+ 322000p 0.9
+ 322010p -0.3
+ 324000p -0.3
+ 324010p 0.9
+ 326000p 0.9
+ 326010p -0.3
+ 328000p -0.3
+ 328010p 0.9
+ 330000p 0.9
+ 330010p -0.3
+ 332000p -0.3
+ 332010p 0.9
+ 334000p 0.9
+ 334010p -0.3
+ 336000p -0.3
+ 336010p 0.9
+ 338000p 0.9
+ 338010p -0.3
+ 340000p -0.3
+ 340010p 0.9
+ 342000p 0.9
+ 342010p -0.3
+ 344000p -0.3
+ 344010p 0.9
+ 346000p 0.9
+ 346010p -0.3
+ 348000p -0.3
+ 348010p 0.9
+ 350000p 0.9
+ 350010p -0.3
+ 352000p -0.3
+ 352010p 0.9
+ 354000p 0.9
+ 354010p -0.3
+ 356000p -0.3
+ 356010p 0.9
+ 358000p 0.9
+ 358010p -0.3
+ 360000p -0.3
+ 360010p 0.9
+ 362000p 0.9
+ 362010p -0.3
+ 364000p -0.3
+ 364010p 0.9
+ 366000p 0.9
+ 366010p -0.3
+ 368000p -0.3
+ 368010p 0.9
+ 370000p 0.9
+ 370010p -0.3
+ 372000p -0.3
+ 372010p 0.9
+ 374000p 0.9
+ 374010p -0.3
+ 376000p -0.3
+ 376010p 0.9
+ 378000p 0.9
+ 378010p -0.3
+ 380000p -0.3
+ 380010p 0.9
+ 382000p 0.9
+ 382010p -0.3
+ 384000p -0.3
+ 384010p 0.9
+ 386000p 0.9
+ 386010p -0.3
+ 388000p -0.3
+ 388010p 0.9
+ 390000p 0.9
+ 390010p -0.3
+ 392000p -0.3
+ 392010p 0.9
+ 394000p 0.9
+ 394010p -0.3
+ 396000p -0.3
+ 396010p 0.9
+ 398000p 0.9
+ 398010p -0.3
+ 400000p -0.3
+ 400010p 0.9
+ 402000p 0.9
+ 402010p -0.3
+ 404000p -0.3
+ 404010p 0.9
+ 406000p 0.9
+ 406010p -0.3
+ 408000p -0.3
+ 408010p 0.9
+ 410000p 0.9
+ 410010p -0.3
+ 412000p -0.3
+ 412010p 0.9
+ 414000p 0.9
+ 414010p -0.3
+ 416000p -0.3
+ 416010p 0.9
+ 418000p 0.9
+ 418010p -0.3
+ 420000p -0.3
+ 420010p 0.9
+ 422000p 0.9
+ 422010p -0.3
+ 424000p -0.3
+ 424010p 0.9
+ 426000p 0.9
+ 426010p -0.3
+ 428000p -0.3
+ 428010p 0.9
+ 430000p 0.9
+ 430010p -0.3
+ 432000p -0.3
+ 432010p 0.9
+ 434000p 0.9
+ 434010p -0.3
+ 436000p -0.3
+ 436010p 0.9
+ 438000p 0.9
+ 438010p -0.3
+ 440000p -0.3
+ 440010p 0.9
+ 442000p 0.9
+ 442010p -0.3
+ 444000p -0.3
+ 444010p 0.9
+ 446000p 0.9
+ 446010p -0.3
+ 448000p -0.3
+ 448010p 0.9
+ 450000p 0.9
+ 450010p -0.3
+ 452000p -0.3
+ 452010p 0.9
+ 454000p 0.9
+ 454010p -0.3
+ 456000p -0.3
+ 456010p 0.9
+ 458000p 0.9
+ 458010p -0.3
+ 460000p -0.3
+ 460010p 0.9
+ 462000p 0.9
+ 462010p -0.3
+ 464000p -0.3
+ 464010p 0.9
+ 466000p 0.9
+ 466010p -0.3
+ 468000p -0.3
+ 468010p 0.9
+ 470000p 0.9
+ 470010p -0.3
+ 472000p -0.3
+ 472010p 0.9
+ 474000p 0.9
+ 474010p -0.3
+ 476000p -0.3
+ 476010p 0.9
+ 478000p 0.9
+ 478010p -0.3
+ 480000p -0.3
+ 480010p 0.9
+ 482000p 0.9
+ 482010p -0.3
+ 484000p -0.3
+ 484010p 0.9
+ 486000p 0.9
+ 486010p -0.3
+ 488000p -0.3
+ 488010p 0.9
+ 490000p 0.9
+ 490010p -0.3
+ 492000p -0.3
+ 492010p 0.9
+ 494000p 0.9
+ 494010p -0.3
+ 496000p -0.3
+ 496010p 0.9
+ 498000p 0.9
+ 498010p -0.3
+ 500000p -0.3
+ 500010p 0.9
+ 502000p 0.9
+ 502010p -0.3
+ 504000p -0.3
+ 504010p 0.9
+ 506000p 0.9
+ 506010p -0.3
+ 508000p -0.3
+ 508010p 0.9
+ 510000p 0.9
+ 510010p -0.3
+ 512000p -0.3
+ 512010p 0.9
+ 514000p 0.9
+ 514010p -0.3
+ 516000p -0.3
+ 516010p 0.9
+ 518000p 0.9
+ 518010p -0.3
+ 520000p -0.3
+ 520010p 0.9
+ 522000p 0.9
+ 522010p -0.3
+ 524000p -0.3
+ 524010p 0.9
+ 526000p 0.9
+ 526010p -0.3
+ 528000p -0.3
+ 528010p 0.9
+ 530000p 0.9
+ 530010p -0.3
+ 532000p -0.3
+ 532010p 0.9
+ 534000p 0.9
+ 534010p -0.3
+ 536000p -0.3
+ 536010p 0.9
+ 538000p 0.9
+ 538010p -0.3
+ 540000p -0.3
+ 540010p 0.9
+ 542000p 0.9
+ 542010p -0.3
+ 544000p -0.3
+ 544010p 0.9
+ 546000p 0.9
+ 546010p -0.3
+ 548000p -0.3
+ 548010p 0.9
+ 550000p 0.9
+ 550010p -0.3
+ 552000p -0.3
+ 552010p 0.9
+ 554000p 0.9
+ 554010p -0.3
+ 556000p -0.3
+ 556010p 0.9
+ 558000p 0.9
+ 558010p -0.3
+ 560000p -0.3
+ 560010p 0.9
+ 562000p 0.9
+ 562010p -0.3
+ 564000p -0.3
+ 564010p 0.9
+ 566000p 0.9
+ 566010p -0.3
+ 568000p -0.3
+ 568010p 0.9
+ 570000p 0.9
+ 570010p -0.3
+ 572000p -0.3
+ 572010p 0.9
+ 574000p 0.9
+ 574010p -0.3
+ 576000p -0.3
+ 576010p 0.9
+ 578000p 0.9
+ 578010p -0.3
+ 580000p -0.3
+ 580010p 0.9
+ 582000p 0.9
+ 582010p -0.3
+ 584000p -0.3
+ 584010p 0.9
+ 586000p 0.9
+ 586010p -0.3
+ 588000p -0.3
+ 588010p 0.9
+ 590000p 0.9
+ 590010p -0.3
+ 592000p -0.3
+ 592010p 0.9
+ 594000p 0.9
+ 594010p -0.3
+ 596000p -0.3
+ 596010p 0.9
+ 598000p 0.9
+ 598010p -0.3
+ 600000p -0.3
+ 600010p 0.9
+ 602000p 0.9
+ 602010p -0.3
+ 604000p -0.3
+ 604010p 0.9
+ 606000p 0.9
+ 606010p -0.3
+ 608000p -0.3
+ 608010p 0.9
+ 610000p 0.9
+ 610010p -0.3
+ 612000p -0.3
+ 612010p 0.9
+ 614000p 0.9
+ 614010p -0.3
+ 616000p -0.3
+ 616010p 0.9
+ 618000p 0.9
+ 618010p -0.3
+ 620000p -0.3
+ 620010p 0.9
+ 622000p 0.9
+ 622010p -0.3
+ 624000p -0.3
+ 624010p 0.9
+ 626000p 0.9
+ 626010p -0.3
+ 628000p -0.3
+ 628010p 0.9
+ 630000p 0.9
+ 630010p -0.3
+ 632000p -0.3
+ 632010p 0.9
+ 634000p 0.9
+ 634010p -0.3
+ 636000p -0.3
+ 636010p 0.9
+ 638000p 0.9
+ 638010p -0.3
+ 640000p -0.3
+ 640010p 0.9
+ 642000p 0.9
+ 642010p -0.3
+ 644000p -0.3
+ 644010p 0.9
+ 646000p 0.9
+ 646010p -0.3
+ 648000p -0.3
+ 648010p 0.9
+ 650000p 0.9
+ 650010p -0.3
+ 652000p -0.3
+ 652010p 0.9
+ 654000p 0.9
+ 654010p -0.3
+ 656000p -0.3
+ 656010p 0.9
+ 658000p 0.9
+ 658010p -0.3
+ 660000p -0.3
+ 660010p 0.9
+ 662000p 0.9
+ 662010p -0.3
+ 664000p -0.3
+ 664010p 0.9
+ 666000p 0.9
+ 666010p -0.3
+ 668000p -0.3
+ 668010p 0.9
+ 670000p 0.9
+ 670010p -0.3
+ 672000p -0.3
+ 672010p 0.9
+ 674000p 0.9
+ 674010p -0.3
+ 676000p -0.3
+ 676010p 0.9
+ 678000p 0.9
+ 678010p -0.3
+ 680000p -0.3
+ 680010p 0.9
+ 682000p 0.9
+ 682010p -0.3
+ 684000p -0.3
+ 684010p 0.9
+ 686000p 0.9
+ 686010p -0.3
+ 688000p -0.3
+ 688010p 0.9
+ 690000p 0.9
+ 690010p -0.3
+ 692000p -0.3
+ 692010p 0.9
+ 694000p 0.9
+ 694010p -0.3
+ 696000p -0.3
+ 696010p 0.9
+ 698000p 0.9
+ 698010p -0.3
+ 700000p -0.3
+ 700010p 0.9
+ 702000p 0.9
+ 702010p -0.3
+ 704000p -0.3
+ 704010p 0.9
+ 706000p 0.9
+ 706010p -0.3
+ 708000p -0.3
+ 708010p 0.9
+ 710000p 0.9
+ 710010p -0.3
+ 712000p -0.3
+ 712010p 0.9
+ 714000p 0.9
+ 714010p -0.3
+ 716000p -0.3
+ 716010p 0.9
+ 718000p 0.9
+ 718010p -0.3
+ 720000p -0.3
+ 720010p 0.9
+ 722000p 0.9
+ 722010p -0.3
+ 724000p -0.3
+ 724010p 0.9
+ 726000p 0.9
+ 726010p -0.3
+ 728000p -0.3
+ 728010p 0.9
+ 730000p 0.9
+ 730010p -0.3
+ 732000p -0.3
+ 732010p 0.9
+ 734000p 0.9
+ 734010p -0.3
+ 736000p -0.3
+ 736010p 0.9
+ 738000p 0.9
+ 738010p -0.3
+ 740000p -0.3
+ 740010p 0.9
+ 742000p 0.9
+ 742010p -0.3
+ 744000p -0.3
+ 744010p 0.9
+ 746000p 0.9
+ 746010p -0.3
+ 748000p -0.3
+ 748010p 0.9
+ 750000p 0.9
+ 750010p -0.3
+ 752000p -0.3
+ 752010p 0.9
+ 754000p 0.9
+ 754010p -0.3
+ 756000p -0.3
+ 756010p 0.9
+ 758000p 0.9
+ 758010p -0.3
+ 760000p -0.3
+ 760010p 0.9
+ 762000p 0.9
+ 762010p -0.3
+ 764000p -0.3
+ 764010p 0.9
+ 766000p 0.9
+ 766010p -0.3
+ 768000p -0.3
+ 768010p 0.9
+ 770000p 0.9
+ 770010p -0.3
+ 772000p -0.3
+ 772010p 0.9
+ 774000p 0.9
+ 774010p -0.3
+ 776000p -0.3
+ 776010p 0.9
+ 778000p 0.9
+ 778010p -0.3
+ 780000p -0.3
+ 780010p 0.9
+ 782000p 0.9
+ 782010p -0.3
+ 784000p -0.3
+ 784010p 0.9
+ 786000p 0.9
+ 786010p -0.3
+ 788000p -0.3
+ 788010p 0.9
+ 790000p 0.9
+ 790010p -0.3
+ 792000p -0.3
+ 792010p 0.9
+ 794000p 0.9
+ 794010p -0.3
+ 796000p -0.3
+ 796010p 0.9
+ 798000p 0.9
+ 798010p -0.3
+ 800000p -0.3
+ 800010p 0.9
+ 802000p 0.9
+ 802010p -0.3
+ 804000p -0.3
+ 804010p 0.9
+ 806000p 0.9
+ 806010p -0.3
+ 808000p -0.3
+ 808010p 0.9
+ 810000p 0.9
+ 810010p -0.3
+ 812000p -0.3
+ 812010p 0.9
+ 814000p 0.9
+ 814010p -0.3
+ 816000p -0.3
+ 816010p 0.9
+ 818000p 0.9
+ 818010p -0.3
+ 820000p -0.3
+ 820010p 0.9
+ 822000p 0.9
+ 822010p -0.3
+ 824000p -0.3
+ 824010p 0.9
+ 826000p 0.9
+ 826010p -0.3
+ 828000p -0.3
+ 828010p 0.9
+ 830000p 0.9
+ 830010p -0.3
+ 832000p -0.3
+ 832010p 0.9
+ 834000p 0.9
+ 834010p -0.3
+ 836000p -0.3
+ 836010p 0.9
+ 838000p 0.9
+ 838010p -0.3
+ 840000p -0.3
+ 840010p 0.9
+ 842000p 0.9
+ 842010p -0.3
+ 844000p -0.3
+ 844010p 0.9
+ 846000p 0.9
+ 846010p -0.3
+ 848000p -0.3
+ 848010p 0.9
+ 850000p 0.9
+ 850010p -0.3
+ 852000p -0.3
+ 852010p 0.9
+ 854000p 0.9
+ 854010p -0.3
+ 856000p -0.3
+ 856010p 0.9
+ 858000p 0.9
+ 858010p -0.3
+ 860000p -0.3
+ 860010p 0.9
+ 862000p 0.9
+ 862010p -0.3
+ 864000p -0.3
+ 864010p 0.9
+ 866000p 0.9
+ 866010p -0.3
+ 868000p -0.3
+ 868010p 0.9
+ 870000p 0.9
+ 870010p -0.3
+ 872000p -0.3
+ 872010p 0.9
+ 874000p 0.9
+ 874010p -0.3
+ 876000p -0.3
+ 876010p 0.9
+ 878000p 0.9
+ 878010p -0.3
+ 880000p -0.3
+ 880010p 0.9
+ 882000p 0.9
+ 882010p -0.3
+ 884000p -0.3
+ 884010p 0.9
+ 886000p 0.9
+ 886010p -0.3
+ 888000p -0.3
+ 888010p 0.9
+ 890000p 0.9
+ 890010p -0.3
+ 892000p -0.3
+ 892010p 0.9
+ 894000p 0.9
+ 894010p -0.3
+ 896000p -0.3
+ 896010p 0.9
+ 898000p 0.9
+ 898010p -0.3
+ 900000p -0.3
+ 900010p 0.9
+ 902000p 0.9
+ 902010p -0.3
+ 904000p -0.3
+ 904010p 0.9
+ 906000p 0.9
+ 906010p -0.3
+ 908000p -0.3
+ 908010p 0.9
+ 910000p 0.9
+ 910010p -0.3
+ 912000p -0.3
+ 912010p 0.9
+ 914000p 0.9
+ 914010p -0.3
+ 916000p -0.3
+ 916010p 0.9
+ 918000p 0.9
+ 918010p -0.3
+ 920000p -0.3
+ 920010p 0.9
+ 922000p 0.9
+ 922010p -0.3
+ 924000p -0.3
+ 924010p 0.9
+ 926000p 0.9
+ 926010p -0.3
+ 928000p -0.3
+ 928010p 0.9
+ 930000p 0.9
+ 930010p -0.3
+ 932000p -0.3
+ 932010p 0.9
+ 934000p 0.9
+ 934010p -0.3
+ 936000p -0.3
+ 936010p 0.9
+ 938000p 0.9
+ 938010p -0.3
+ 940000p -0.3
+ 940010p 0.9
+ 942000p 0.9
+ 942010p -0.3
+ 944000p -0.3
+ 944010p 0.9
+ 946000p 0.9
+ 946010p -0.3
+ 948000p -0.3
+ 948010p 0.9
+ 950000p 0.9
+ 950010p -0.3
+ 952000p -0.3
+ 952010p 0.9
+ 954000p 0.9
+ 954010p -0.3
+ 956000p -0.3
+ 956010p 0.9
+ 958000p 0.9
+ 958010p -0.3
+ 960000p -0.3
+ 960010p 0.9
+ 962000p 0.9
+ 962010p -0.3
+ 964000p -0.3
+ 964010p 0.9
+ 966000p 0.9
+ 966010p -0.3
+ 968000p -0.3
+ 968010p 0.9
+ 970000p 0.9
+ 970010p -0.3
+ 972000p -0.3
+ 972010p 0.9
+ 974000p 0.9
+ 974010p -0.3
+ 976000p -0.3
+ 976010p 0.9
+ 978000p 0.9
+ 978010p -0.3
+ 980000p -0.3
+ 980010p 0.9
+ 982000p 0.9
+ 982010p -0.3
+ 984000p -0.3
+ 984010p 0.9
+ 986000p 0.9
+ 986010p -0.3
+ 988000p -0.3
+ 988010p 0.9
+ 990000p 0.9
+ 990010p -0.3
+ 992000p -0.3
+ 992010p 0.9
+ 994000p 0.9
+ 994010p -0.3
+ 996000p -0.3
+ 996010p 0.9
+ 998000p 0.9
+ 998010p -0.3
+ 1000000p -0.3
+ 1000010p 0.9
+ 1002000p 0.9
+ 1002010p -0.3
+ 1004000p -0.3
+ 1004010p 0.9
+ 1006000p 0.9
+ 1006010p -0.3
+ 1008000p -0.3
+ 1008010p 0.9
+ 1010000p 0.9
+ 1010010p -0.3
+ 1012000p -0.3
+ 1012010p 0.9
+ 1014000p 0.9
+ 1014010p -0.3
+ 1016000p -0.3
+ 1016010p 0.9
+ 1018000p 0.9
+ 1018010p -0.3
+ 1020000p -0.3
+ 1020010p 0.9
+ 1022000p 0.9
+ 1022010p -0.3
+ 1024000p -0.3
+ 1024010p 0.9
+ 1026000p 0.9
+ 1026010p -0.3
+ 1028000p -0.3
+ 1028010p 0.9
+ 1030000p 0.9
+ 1030010p -0.3
+ 1032000p -0.3
+ 1032010p 0.9
+ 1034000p 0.9
+ 1034010p -0.3
+ 1036000p -0.3
+ 1036010p 0.9
+ 1038000p 0.9
+ 1038010p -0.3
+ 1040000p -0.3
+ 1040010p 0.9
+ 1042000p 0.9
+ 1042010p -0.3
+ 1044000p -0.3
+ 1044010p 0.9
+ 1046000p 0.9
+ 1046010p -0.3
+ 1048000p -0.3
+ 1048010p 0.9
+ 1050000p 0.9
+ 1050010p -0.3
+ 1052000p -0.3
+ 1052010p 0.9
+ 1054000p 0.9
+ 1054010p -0.3
+ 1056000p -0.3
+ 1056010p 0.9
+ 1058000p 0.9
+ 1058010p -0.3
+ 1060000p -0.3
+ 1060010p 0.9
+ 1062000p 0.9
+ 1062010p -0.3
+ 1064000p -0.3
+ 1064010p 0.9
+ 1066000p 0.9
+ 1066010p -0.3
+ 1068000p -0.3
+ 1068010p 0.9
+ 1070000p 0.9
+ 1070010p -0.3
+ 1072000p -0.3
+ 1072010p 0.9
+ 1074000p 0.9
+ 1074010p -0.3
+ 1076000p -0.3
+ 1076010p 0.9
+ 1078000p 0.9
+ 1078010p -0.3
+ 1080000p -0.3
+ 1080010p 0.9
+ 1082000p 0.9
+ 1082010p -0.3
+ 1084000p -0.3
+ 1084010p 0.9
+ 1086000p 0.9
+ 1086010p -0.3
+ 1088000p -0.3
+ 1088010p 0.9
+ 1090000p 0.9
+ 1090010p -0.3
+ 1092000p -0.3
+ 1092010p 0.9
+ 1094000p 0.9
+ 1094010p -0.3
+ 1096000p -0.3
+ 1096010p 0.9
+ 1098000p 0.9
+ 1098010p -0.3
+ 1100000p -0.3
+ 1100010p 0.9
+ 1102000p 0.9
+ 1102010p -0.3
+ 1104000p -0.3
+ 1104010p 0.9
+ 1106000p 0.9
+ 1106010p -0.3
+ 1108000p -0.3
+ 1108010p 0.9
+ 1110000p 0.9
+ 1110010p -0.3
+ 1112000p -0.3
+ 1112010p 0.9
+ 1114000p 0.9
+ 1114010p -0.3
+ 1116000p -0.3
+ 1116010p 0.9
+ 1118000p 0.9
+ 1118010p -0.3
+ 1120000p -0.3
+ 1120010p 0.9
+ 1122000p 0.9
+ 1122010p -0.3
+ 1124000p -0.3
+ 1124010p 0.9
+ 1126000p 0.9
+ 1126010p -0.3
+ 1128000p -0.3
+ 1128010p 0.9
+ 1130000p 0.9
+ 1130010p -0.3
+ 1132000p -0.3
+ 1132010p 0.9
+ 1134000p 0.9
+ 1134010p -0.3
+ 1136000p -0.3
+ 1136010p 0.9
+ 1138000p 0.9
+ 1138010p -0.3
+ 1140000p -0.3
+ 1140010p 0.9
+ 1142000p 0.9
+ 1142010p -0.3
+ 1144000p -0.3
+ 1144010p 0.9
+ 1146000p 0.9
+ 1146010p -0.3
+ 1148000p -0.3
+ 1148010p 0.9
+ 1150000p 0.9
+ 1150010p -0.3
+ 1152000p -0.3
+ 1152010p 0.9
+ 1154000p 0.9
+ 1154010p -0.3
+ 1156000p -0.3
+ 1156010p 0.9
+ 1158000p 0.9
+ 1158010p -0.3
+ 1160000p -0.3
+ 1160010p 0.9
+ 1162000p 0.9
+ 1162010p -0.3
+ 1164000p -0.3
+ 1164010p 0.9
+ 1166000p 0.9
+ 1166010p -0.3
+ 1168000p -0.3
+ 1168010p 0.9
+ 1170000p 0.9
+ 1170010p -0.3
+ 1172000p -0.3
+ 1172010p 0.9
+ 1174000p 0.9
+ 1174010p -0.3
+ 1176000p -0.3
+ 1176010p 0.9
+ 1178000p 0.9
+ 1178010p -0.3
+ 1180000p -0.3
+ 1180010p 0.9
+ 1182000p 0.9
+ 1182010p -0.3
+ 1184000p -0.3
+ 1184010p 0.9
+ 1186000p 0.9
+ 1186010p -0.3
+ 1188000p -0.3
+ 1188010p 0.9
+ 1190000p 0.9
+ 1190010p -0.3
+ 1192000p -0.3
+ 1192010p 0.9
+ 1194000p 0.9
+ 1194010p -0.3
+ 1196000p -0.3
+ 1196010p 0.9
+ 1198000p 0.9
+ 1198010p -0.3
+ 1200000p -0.3
+ 1200010p 0.9
+ 1202000p 0.9
+ 1202010p -0.3
+ 1204000p -0.3
+ 1204010p 0.9
+ 1206000p 0.9
+ 1206010p -0.3
+ 1208000p -0.3
+ 1208010p 0.9
+ 1210000p 0.9
+ 1210010p -0.3
+ 1212000p -0.3
+ 1212010p 0.9
+ 1214000p 0.9
+ 1214010p -0.3
+ 1216000p -0.3
+ 1216010p 0.9
+ 1218000p 0.9
+ 1218010p -0.3
+ 1220000p -0.3
+ 1220010p 0.9
+ 1222000p 0.9
+ 1222010p -0.3
+ 1224000p -0.3
+ 1224010p 0.9
+ 1226000p 0.9
+ 1226010p -0.3
+ 1228000p -0.3
+ 1228010p 0.9
+ 1230000p 0.9
+ 1230010p -0.3
+ 1232000p -0.3
+ 1232010p 0.9
+ 1234000p 0.9
+ 1234010p -0.3
+ 1236000p -0.3
+ 1236010p 0.9
+ 1238000p 0.9
+ 1238010p -0.3
+ 1240000p -0.3
+ 1240010p 0.9
+ 1242000p 0.9
+ 1242010p -0.3
+ 1244000p -0.3
+ 1244010p 0.9
+ 1246000p 0.9
+ 1246010p -0.3
+ 1248000p -0.3
+ 1248010p 0.9
+ 1250000p 0.9
+ 1250010p -0.3
+ 1252000p -0.3
+ 1252010p 0.9
+ 1254000p 0.9
+ 1254010p -0.3
+ 1256000p -0.3
+ 1256010p 0.9
+ 1258000p 0.9
+ 1258010p -0.3
+ 1260000p -0.3
+ 1260010p 0.9
+ 1262000p 0.9
+ 1262010p -0.3
+ 1264000p -0.3
+ 1264010p 0.9
+ 1266000p 0.9
+ 1266010p -0.3
+ 1268000p -0.3
+ 1268010p 0.9
+ 1270000p 0.9
+ 1270010p -0.3
+ 1272000p -0.3
+ 1272010p 0.9
+ 1274000p 0.9
+ 1274010p -0.3
+ 1276000p -0.3
+ 1276010p 0.9
+ 1278000p 0.9
+ 1278010p -0.3
+ 1280000p -0.3
+ 1280010p 0.9
+ 1282000p 0.9
+ 1282010p -0.3
+ 1284000p -0.3
+ 1284010p 0.9
+ 1286000p 0.9
+ 1286010p -0.3
+ 1288000p -0.3
+ 1288010p 0.9
+ 1290000p 0.9
+ 1290010p -0.3
+ 1292000p -0.3
+ 1292010p 0.9
+ 1294000p 0.9
+ 1294010p -0.3
+ 1296000p -0.3
+ 1296010p 0.9
+ 1298000p 0.9
+ 1298010p -0.3
+ 1300000p -0.3
+ 1300010p 0.9
+ 1302000p 0.9
+ 1302010p -0.3
+ 1304000p -0.3
+ 1304010p 0.9
+ 1306000p 0.9
+ 1306010p -0.3
+ 1308000p -0.3
+ 1308010p 0.9
+ 1310000p 0.9
+ 1310010p -0.3
+ 1312000p -0.3
+ 1312010p 0.9
+ 1314000p 0.9
+ 1314010p -0.3
+ 1316000p -0.3
+ 1316010p 0.9
+ 1318000p 0.9
+ 1318010p -0.3
+ 1320000p -0.3
+ 1320010p 0.9
+ 1322000p 0.9
+ 1322010p -0.3
+ 1324000p -0.3
+ 1324010p 0.9
+ 1326000p 0.9
+ 1326010p -0.3
+ 1328000p -0.3
+ 1328010p 0.9
+ 1330000p 0.9
+ 1330010p -0.3
+ 1332000p -0.3
+ 1332010p 0.9
+ 1334000p 0.9
+ 1334010p -0.3
+ 1336000p -0.3
+ 1336010p 0.9
+ 1338000p 0.9
+ 1338010p -0.3
+ 1340000p -0.3
+ 1340010p 0.9
+ 1342000p 0.9
+ 1342010p -0.3
+ 1344000p -0.3
+ 1344010p 0.9
+ 1346000p 0.9
+ 1346010p -0.3
+ 1348000p -0.3
+ 1348010p 0.9
+ 1350000p 0.9
+ 1350010p -0.3
+ 1352000p -0.3
+ 1352010p 0.9
+ 1354000p 0.9
+ 1354010p -0.3
+ 1356000p -0.3
+ 1356010p 0.9
+ 1358000p 0.9
+ 1358010p -0.3
+ 1360000p -0.3
+ 1360010p 0.9
+ 1362000p 0.9
+ 1362010p -0.3
+ 1364000p -0.3
+ 1364010p 0.9
+ 1366000p 0.9
+ 1366010p -0.3
+ 1368000p -0.3
+ 1368010p 0.9
+ 1370000p 0.9
+ 1370010p -0.3
+ 1372000p -0.3
+ 1372010p 0.9
+ 1374000p 0.9
+ 1374010p -0.3
+ 1376000p -0.3
+ 1376010p 0.9
+ 1378000p 0.9
+ 1378010p -0.3
+ 1380000p -0.3
+ 1380010p 0.9
+ 1382000p 0.9
+ 1382010p -0.3
+ 1384000p -0.3
+ 1384010p 0.9
+ 1386000p 0.9
+ 1386010p -0.3
+ 1388000p -0.3
+ 1388010p 0.9
+ 1390000p 0.9
+ 1390010p -0.3
+ 1392000p -0.3
+ 1392010p 0.9
+ 1394000p 0.9
+ 1394010p -0.3
+ 1396000p -0.3
+ 1396010p 0.9
+ 1398000p 0.9
+ 1398010p -0.3
+ 1400000p -0.3
+ 1400010p 0.9
+ 1402000p 0.9
+ 1402010p -0.3
+ 1404000p -0.3
+ 1404010p 0.9
+ 1406000p 0.9
+ 1406010p -0.3
+ 1408000p -0.3
+ 1408010p 0.9
+ 1410000p 0.9
+ 1410010p -0.3
+ 1412000p -0.3
+ 1412010p 0.9
+ 1414000p 0.9
+ 1414010p -0.3
+ 1416000p -0.3
+ 1416010p 0.9
+ 1418000p 0.9
+ 1418010p -0.3
+ 1420000p -0.3
+ 1420010p 0.9
+ 1422000p 0.9
+ 1422010p -0.3
+ 1424000p -0.3
+ 1424010p 0.9
+ 1426000p 0.9
+ 1426010p -0.3
+ 1428000p -0.3
+ 1428010p 0.9
+ 1430000p 0.9
+ 1430010p -0.3
+ 1432000p -0.3
+ 1432010p 0.9
+ 1434000p 0.9
+ 1434010p -0.3
+ 1436000p -0.3
+ 1436010p 0.9
+ 1438000p 0.9
+ 1438010p -0.3
+ 1440000p -0.3
+ 1440010p 0.9
+ 1442000p 0.9
+ 1442010p -0.3
+ 1444000p -0.3
+ 1444010p 0.9
+ 1446000p 0.9
+ 1446010p -0.3
+ 1448000p -0.3
+ 1448010p 0.9
+ 1450000p 0.9
+ 1450010p -0.3
+ 1452000p -0.3
+ 1452010p 0.9
+ 1454000p 0.9
+ 1454010p -0.3
+ 1456000p -0.3
+ 1456010p 0.9
+ 1458000p 0.9
+ 1458010p -0.3
+ 1460000p -0.3
+ 1460010p 0.9
+ 1462000p 0.9
+ 1462010p -0.3
+ 1464000p -0.3
+ 1464010p 0.9
+ 1466000p 0.9
+ 1466010p -0.3
+ 1468000p -0.3
+ 1468010p 0.9
+ 1470000p 0.9
+ 1470010p -0.3
+ 1472000p -0.3
+ 1472010p 0.9
+ 1474000p 0.9
+ 1474010p -0.3
+ 1476000p -0.3
+ 1476010p 0.9
+ 1478000p 0.9
+ 1478010p -0.3
+ 1480000p -0.3
+ 1480010p 0.9
+ 1482000p 0.9
+ 1482010p -0.3
+ 1484000p -0.3
+ 1484010p 0.9
+ 1486000p 0.9
+ 1486010p -0.3
+ 1488000p -0.3
+ 1488010p 0.9
+ 1490000p 0.9
+ 1490010p -0.3
+ 1492000p -0.3
+ 1492010p 0.9
+ 1494000p 0.9
+ 1494010p -0.3
+ 1496000p -0.3
+ 1496010p 0.9
+ 1498000p 0.9
+ 1498010p -0.3
+ 1500000p -0.3
+ 1500010p 0.9
+ 1502000p 0.9
+ 1502010p -0.3
+ 1504000p -0.3
+ 1504010p 0.9
+ 1506000p 0.9
+ 1506010p -0.3
+ 1508000p -0.3
+ 1508010p 0.9
+ 1510000p 0.9
+ 1510010p -0.3
+ 1512000p -0.3
+ 1512010p 0.9
+ 1514000p 0.9
+ 1514010p -0.3
+ 1516000p -0.3
+ 1516010p 0.9
+ 1518000p 0.9
+ 1518010p -0.3
+ 1520000p -0.3
+ 1520010p 0.9
+ 1522000p 0.9
+ 1522010p -0.3
+ 1524000p -0.3
+ 1524010p 0.9
+ 1526000p 0.9
+ 1526010p -0.3
+ 1528000p -0.3
+ 1528010p 0.9
+ 1530000p 0.9
+ 1530010p -0.3
+ 1532000p -0.3
+ 1532010p 0.9
+ 1534000p 0.9
+ 1534010p -0.3
+ 1536000p -0.3
+ 1536010p 0.9
+ 1538000p 0.9
+ 1538010p -0.3
+ 1540000p -0.3
+ 1540010p 0.9
+ 1542000p 0.9
+ 1542010p -0.3
+ 1544000p -0.3
+ 1544010p 0.9
+ 1546000p 0.9
+ 1546010p -0.3
+ 1548000p -0.3
+ 1548010p 0.9
+ 1550000p 0.9
+ 1550010p -0.3
+ 1552000p -0.3
+ 1552010p 0.9
+ 1554000p 0.9
+ 1554010p -0.3
+ 1556000p -0.3
+ 1556010p 0.9
+ 1558000p 0.9
+ 1558010p -0.3
+ 1560000p -0.3
+ 1560010p 0.9
+ 1562000p 0.9
+ 1562010p -0.3
+ 1564000p -0.3
+ 1564010p 0.9
+ 1566000p 0.9
+ 1566010p -0.3
+ 1568000p -0.3
+ 1568010p 0.9
+ 1570000p 0.9
+ 1570010p -0.3
+ 1572000p -0.3
+ 1572010p 0.9
+ 1574000p 0.9
+ 1574010p -0.3
+ 1576000p -0.3
+ 1576010p 0.9
+ 1578000p 0.9
+ 1578010p -0.3
+ 1580000p -0.3
+ 1580010p 0.9
+ 1582000p 0.9
+ 1582010p -0.3
+ 1584000p -0.3
+ 1584010p 0.9
+ 1586000p 0.9
+ 1586010p -0.3
+ 1588000p -0.3
+ 1588010p 0.9
+ 1590000p 0.9
+ 1590010p -0.3
+ 1592000p -0.3
+ 1592010p 0.9
+ 1594000p 0.9
+ 1594010p -0.3
+ 1596000p -0.3
+ 1596010p 0.9
+ 1598000p 0.9
+ 1598010p -0.3
+ 1600000p -0.3
+ 1600010p 0.9
+ 1602000p 0.9
+ 1602010p -0.3
+ 1604000p -0.3
+ 1604010p 0.9
+ 1606000p 0.9
+ 1606010p -0.3
+ 1608000p -0.3
+ 1608010p 0.9
+ 1610000p 0.9
+ 1610010p -0.3
+ 1612000p -0.3
+ 1612010p 0.9
+ 1614000p 0.9
+ 1614010p -0.3
+ 1616000p -0.3
+ 1616010p 0.9
+ 1618000p 0.9
+ 1618010p -0.3
+ 1620000p -0.3
+ 1620010p 0.9
+ 1622000p 0.9
+ 1622010p -0.3
+ 1624000p -0.3
+ 1624010p 0.9
+ 1626000p 0.9
+ 1626010p -0.3
+ 1628000p -0.3
+ 1628010p 0.9
+ 1630000p 0.9
+ 1630010p -0.3
+ 1632000p -0.3
+ 1632010p 0.9
+ 1634000p 0.9
+ 1634010p -0.3
+ 1636000p -0.3
+ 1636010p 0.9
+ 1638000p 0.9
+ 1638010p -0.3
+ 1640000p -0.3
+ 1640010p 0.9
+ 1642000p 0.9
+ 1642010p -0.3
+ 1644000p -0.3
+ 1644010p 0.9
+ 1646000p 0.9
+ 1646010p -0.3
+ 1648000p -0.3
+ 1648010p 0.9
+ 1650000p 0.9
+ 1650010p -0.3
+ 1652000p -0.3
+ 1652010p 0.9
+ 1654000p 0.9
+ 1654010p -0.3
+ 1656000p -0.3
+ 1656010p 0.9
+ 1658000p 0.9
+ 1658010p -0.3
+ 1660000p -0.3
+ 1660010p 0.9
+ 1662000p 0.9
+ 1662010p -0.3
+ 1664000p -0.3
+ 1664010p 0.9
+ 1666000p 0.9
+ 1666010p -0.3
+ 1668000p -0.3
+ 1668010p 0.9
+ 1670000p 0.9
+ 1670010p -0.3
+ 1672000p -0.3
+ 1672010p 0.9
+ 1674000p 0.9
+ 1674010p -0.3
+ 1676000p -0.3
+ 1676010p 0.9
+ 1678000p 0.9
+ 1678010p -0.3
+ 1680000p -0.3
+ 1680010p 0.9
+ 1682000p 0.9
+ 1682010p -0.3
+ 1684000p -0.3
+ 1684010p 0.9
+ 1686000p 0.9
+ 1686010p -0.3
+ 1688000p -0.3
+ 1688010p 0.9
+ 1690000p 0.9
+ 1690010p -0.3
+ 1692000p -0.3
+ 1692010p 0.9
+ 1694000p 0.9
+ 1694010p -0.3
+ 1696000p -0.3
+ 1696010p 0.9
+ 1698000p 0.9
+ 1698010p -0.3
+ 1700000p -0.3
+ 1700010p 0.9
+ 1702000p 0.9
+ 1702010p -0.3
+ 1704000p -0.3
+ 1704010p 0.9
+ 1706000p 0.9
+ 1706010p -0.3
+ 1708000p -0.3
+ 1708010p 0.9
+ 1710000p 0.9
+ 1710010p -0.3
+ 1712000p -0.3
+ 1712010p 0.9
+ 1714000p 0.9
+ 1714010p -0.3
+ 1716000p -0.3
+ 1716010p 0.9
+ 1718000p 0.9
+ 1718010p -0.3
+ 1720000p -0.3
+ 1720010p 0.9
+ 1722000p 0.9
+ 1722010p -0.3
+ 1724000p -0.3
+ 1724010p 0.9
+ 1726000p 0.9
+ 1726010p -0.3
+ 1728000p -0.3
+ 1728010p 0.9
+ 1730000p 0.9
+ 1730010p -0.3
+ 1732000p -0.3
+ 1732010p 0.9
+ 1734000p 0.9
+ 1734010p -0.3
+ 1736000p -0.3
+ 1736010p 0.9
+ 1738000p 0.9
+ 1738010p -0.3
+ 1740000p -0.3
+ 1740010p 0.9
+ 1742000p 0.9
+ 1742010p -0.3
+ 1744000p -0.3
+ 1744010p 0.9
+ 1746000p 0.9
+ 1746010p -0.3
+ 1748000p -0.3
+ 1748010p 0.9
+ 1750000p 0.9
+ 1750010p -0.3
+ 1752000p -0.3
+ 1752010p 0.9
+ 1754000p 0.9
+ 1754010p -0.3
+ 1756000p -0.3
+ 1756010p 0.9
+ 1758000p 0.9
+ 1758010p -0.3
+ 1760000p -0.3
+ 1760010p 0.9
+ 1762000p 0.9
+ 1762010p -0.3
+ 1764000p -0.3
+ 1764010p 0.9
+ 1766000p 0.9
+ 1766010p -0.3
+ 1768000p -0.3
+ 1768010p 0.9
+ 1770000p 0.9
+ 1770010p -0.3
+ 1772000p -0.3
+ 1772010p 0.9
+ 1774000p 0.9
+ 1774010p -0.3
+ 1776000p -0.3
+ 1776010p 0.9
+ 1778000p 0.9
+ 1778010p -0.3
+ 1780000p -0.3
+ 1780010p 0.9
+ 1782000p 0.9
+ 1782010p -0.3
+ 1784000p -0.3
+ 1784010p 0.9
+ 1786000p 0.9
+ 1786010p -0.3
+ 1788000p -0.3
+ 1788010p 0.9
+ 1790000p 0.9
+ 1790010p -0.3
+ 1792000p -0.3
+ 1792010p 0.9
+ 1794000p 0.9
+ 1794010p -0.3
+ 1796000p -0.3
+ 1796010p 0.9
+ 1798000p 0.9
+ 1798010p -0.3
+ 1800000p -0.3
+ 1800010p 0.9
+ 1802000p 0.9
+ 1802010p -0.3
+ 1804000p -0.3
+ 1804010p 0.9
+ 1806000p 0.9
+ 1806010p -0.3
+ 1808000p -0.3
+ 1808010p 0.9
+ 1810000p 0.9
+ 1810010p -0.3
+ 1812000p -0.3
+ 1812010p 0.9
+ 1814000p 0.9
+ 1814010p -0.3
+ 1816000p -0.3
+ 1816010p 0.9
+ 1818000p 0.9
+ 1818010p -0.3
+ 1820000p -0.3
+ 1820010p 0.9
+ 1822000p 0.9
+ 1822010p -0.3
+ 1824000p -0.3
+ 1824010p 0.9
+ 1826000p 0.9
+ 1826010p -0.3
+ 1828000p -0.3
+ 1828010p 0.9
+ 1830000p 0.9
+ 1830010p -0.3
+ 1832000p -0.3
+ 1832010p 0.9
+ 1834000p 0.9
+ 1834010p -0.3
+ 1836000p -0.3
+ 1836010p 0.9
+ 1838000p 0.9
+ 1838010p -0.3
+ 1840000p -0.3
+ 1840010p 0.9
+ 1842000p 0.9
+ 1842010p -0.3
+ 1844000p -0.3
+ 1844010p 0.9
+ 1846000p 0.9
+ 1846010p -0.3
+ 1848000p -0.3
+ 1848010p 0.9
+ 1850000p 0.9
+ 1850010p -0.3
+ 1852000p -0.3
+ 1852010p 0.9
+ 1854000p 0.9
+ 1854010p -0.3
+ 1856000p -0.3
+ 1856010p 0.9
+ 1858000p 0.9
+ 1858010p -0.3
+ 1860000p -0.3
+ 1860010p 0.9
+ 1862000p 0.9
+ 1862010p -0.3
+ 1864000p -0.3
+ 1864010p 0.9
+ 1866000p 0.9
+ 1866010p -0.3
+ 1868000p -0.3
+ 1868010p 0.9
+ 1870000p 0.9
+ 1870010p -0.3
+ 1872000p -0.3
+ 1872010p 0.9
+ 1874000p 0.9
+ 1874010p -0.3
+ 1876000p -0.3
+ 1876010p 0.9
+ 1878000p 0.9
+ 1878010p -0.3
+ 1880000p -0.3
+ 1880010p 0.9
+ 1882000p 0.9
+ 1882010p -0.3
+ 1884000p -0.3
+ 1884010p 0.9
+ 1886000p 0.9
+ 1886010p -0.3
+ 1888000p -0.3
+ 1888010p 0.9
+ 1890000p 0.9
+ 1890010p -0.3
+ 1892000p -0.3
+ 1892010p 0.9
+ 1894000p 0.9
+ 1894010p -0.3
+ 1896000p -0.3
+ 1896010p 0.9
+ 1898000p 0.9
+ 1898010p -0.3
+ 1900000p -0.3
+ 1900010p 0.9
+ 1902000p 0.9
+ 1902010p -0.3
+ 1904000p -0.3
+ 1904010p 0.9
+ 1906000p 0.9
+ 1906010p -0.3
+ 1908000p -0.3
+ 1908010p 0.9
+ 1910000p 0.9
+ 1910010p -0.3
+ 1912000p -0.3
+ 1912010p 0.9
+ 1914000p 0.9
+ 1914010p -0.3
+ 1916000p -0.3
+ 1916010p 0.9
+ 1918000p 0.9
+ 1918010p -0.3
+ 1920000p -0.3
+ 1920010p 0.9
+ 1922000p 0.9
+ 1922010p -0.3
+ 1924000p -0.3
+ 1924010p 0.9
+ 1926000p 0.9
+ 1926010p -0.3
+ 1928000p -0.3
+ 1928010p 0.9
+ 1930000p 0.9
+ 1930010p -0.3
+ 1932000p -0.3
+ 1932010p 0.9
+ 1934000p 0.9
+ 1934010p -0.3
+ 1936000p -0.3
+ 1936010p 0.9
+ 1938000p 0.9
+ 1938010p -0.3
+ 1940000p -0.3
+ 1940010p 0.9
+ 1942000p 0.9
+ 1942010p -0.3
+ 1944000p -0.3
+ 1944010p 0.9
+ 1946000p 0.9
+ 1946010p -0.3
+ 1948000p -0.3
+ 1948010p 0.9
+ 1950000p 0.9
+ 1950010p -0.3
+ 1952000p -0.3
+ 1952010p 0.9
+ 1954000p 0.9
+ 1954010p -0.3
+ 1956000p -0.3
+ 1956010p 0.9
+ 1958000p 0.9
+ 1958010p -0.3
+ 1960000p -0.3
+ 1960010p 0.9
+ 1962000p 0.9
+ 1962010p -0.3
+ 1964000p -0.3
+ 1964010p 0.9
+ 1966000p 0.9
+ 1966010p -0.3
+ 1968000p -0.3
+ 1968010p 0.9
+ 1970000p 0.9
+ 1970010p -0.3
+ 1972000p -0.3
+ 1972010p 0.9
+ 1974000p 0.9
+ 1974010p -0.3
+ 1976000p -0.3
+ 1976010p 0.9
+ 1978000p 0.9
+ 1978010p -0.3
+ 1980000p -0.3
+ 1980010p 0.9
+ 1982000p 0.9
+ 1982010p -0.3
+ 1984000p -0.3
+ 1984010p 0.9
+ 1986000p 0.9
+ 1986010p -0.3
+ 1988000p -0.3
+ 1988010p 0.9
+ 1990000p 0.9
+ 1990010p -0.3
+ 1992000p -0.3
+ 1992010p 0.9
+ 1994000p 0.9
+ 1994010p -0.3
+ 1996000p -0.3
+ 1996010p 0.9
+ 1998000p 0.9
+ 1998010p -0.3
+ 2000000p -0.3
+ 2000010p 0.9
+ 2002000p 0.9
+ 2002010p -0.3
+ 2004000p -0.3
+ 2004010p 0.9
+ 2006000p 0.9
+ 2006010p -0.3
+ 2008000p -0.3
+ 2008010p 0.9
+ 2010000p 0.9
+ 2010010p -0.3
+ 2012000p -0.3
+ 2012010p 0.9
+ 2014000p 0.9
+ 2014010p -0.3
+ 2016000p -0.3
+ 2016010p 0.9
+ 2018000p 0.9
+ 2018010p -0.3
+ 2020000p -0.3
+ 2020010p 0.9
+ 2022000p 0.9
+ 2022010p -0.3
+ 2024000p -0.3
+ 2024010p 0.9
+ 2026000p 0.9
+ 2026010p -0.3
+ 2028000p -0.3
+ 2028010p 0.9
+ 2030000p 0.9
+ 2030010p -0.3
+ 2032000p -0.3
+ 2032010p 0.9
+ 2034000p 0.9
+ 2034010p -0.3
+ 2036000p -0.3
+ 2036010p 0.9
+ 2038000p 0.9
+ 2038010p -0.3
+ 2040000p -0.3
+ 2040010p 0.9
+ 2042000p 0.9
+ 2042010p -0.3
+ 2044000p -0.3
+ 2044010p 0.9
+ 2046000p 0.9
+ 2046010p -0.3
+ 2048000p -0.3
+ 2048010p 0.9
+ \]
V_data_bar_18 (Data_bar\\<18\\> gnd!) vsource type=pwl wave=\[
+ 0    -0.3
+ 2000p -0.3
+ 2010p 0.9
+ 4000p 0.9
+ 4010p -0.3
+ 6000p -0.3
+ 6010p 0.9
+ 8000p 0.9
+ 8010p -0.3
+ 10000p -0.3
+ 10010p 0.9
+ 12000p 0.9
+ 12010p -0.3
+ 14000p -0.3
+ 14010p 0.9
+ 16000p 0.9
+ 16010p -0.3
+ 18000p -0.3
+ 18010p 0.9
+ 20000p 0.9
+ 20010p -0.3
+ 22000p -0.3
+ 22010p 0.9
+ 24000p 0.9
+ 24010p -0.3
+ 26000p -0.3
+ 26010p 0.9
+ 28000p 0.9
+ 28010p -0.3
+ 30000p -0.3
+ 30010p 0.9
+ 32000p 0.9
+ 32010p -0.3
+ 34000p -0.3
+ 34010p 0.9
+ 36000p 0.9
+ 36010p -0.3
+ 38000p -0.3
+ 38010p 0.9
+ 40000p 0.9
+ 40010p -0.3
+ 42000p -0.3
+ 42010p 0.9
+ 44000p 0.9
+ 44010p -0.3
+ 46000p -0.3
+ 46010p 0.9
+ 48000p 0.9
+ 48010p -0.3
+ 50000p -0.3
+ 50010p 0.9
+ 52000p 0.9
+ 52010p -0.3
+ 54000p -0.3
+ 54010p 0.9
+ 56000p 0.9
+ 56010p -0.3
+ 58000p -0.3
+ 58010p 0.9
+ 60000p 0.9
+ 60010p -0.3
+ 62000p -0.3
+ 62010p 0.9
+ 64000p 0.9
+ 64010p -0.3
+ 66000p -0.3
+ 66010p 0.9
+ 68000p 0.9
+ 68010p -0.3
+ 70000p -0.3
+ 70010p 0.9
+ 72000p 0.9
+ 72010p -0.3
+ 74000p -0.3
+ 74010p 0.9
+ 76000p 0.9
+ 76010p -0.3
+ 78000p -0.3
+ 78010p 0.9
+ 80000p 0.9
+ 80010p -0.3
+ 82000p -0.3
+ 82010p 0.9
+ 84000p 0.9
+ 84010p -0.3
+ 86000p -0.3
+ 86010p 0.9
+ 88000p 0.9
+ 88010p -0.3
+ 90000p -0.3
+ 90010p 0.9
+ 92000p 0.9
+ 92010p -0.3
+ 94000p -0.3
+ 94010p 0.9
+ 96000p 0.9
+ 96010p -0.3
+ 98000p -0.3
+ 98010p 0.9
+ 100000p 0.9
+ 100010p -0.3
+ 102000p -0.3
+ 102010p 0.9
+ 104000p 0.9
+ 104010p -0.3
+ 106000p -0.3
+ 106010p 0.9
+ 108000p 0.9
+ 108010p -0.3
+ 110000p -0.3
+ 110010p 0.9
+ 112000p 0.9
+ 112010p -0.3
+ 114000p -0.3
+ 114010p 0.9
+ 116000p 0.9
+ 116010p -0.3
+ 118000p -0.3
+ 118010p 0.9
+ 120000p 0.9
+ 120010p -0.3
+ 122000p -0.3
+ 122010p 0.9
+ 124000p 0.9
+ 124010p -0.3
+ 126000p -0.3
+ 126010p 0.9
+ 128000p 0.9
+ 128010p -0.3
+ 130000p -0.3
+ 130010p 0.9
+ 132000p 0.9
+ 132010p -0.3
+ 134000p -0.3
+ 134010p 0.9
+ 136000p 0.9
+ 136010p -0.3
+ 138000p -0.3
+ 138010p 0.9
+ 140000p 0.9
+ 140010p -0.3
+ 142000p -0.3
+ 142010p 0.9
+ 144000p 0.9
+ 144010p -0.3
+ 146000p -0.3
+ 146010p 0.9
+ 148000p 0.9
+ 148010p -0.3
+ 150000p -0.3
+ 150010p 0.9
+ 152000p 0.9
+ 152010p -0.3
+ 154000p -0.3
+ 154010p 0.9
+ 156000p 0.9
+ 156010p -0.3
+ 158000p -0.3
+ 158010p 0.9
+ 160000p 0.9
+ 160010p -0.3
+ 162000p -0.3
+ 162010p 0.9
+ 164000p 0.9
+ 164010p -0.3
+ 166000p -0.3
+ 166010p 0.9
+ 168000p 0.9
+ 168010p -0.3
+ 170000p -0.3
+ 170010p 0.9
+ 172000p 0.9
+ 172010p -0.3
+ 174000p -0.3
+ 174010p 0.9
+ 176000p 0.9
+ 176010p -0.3
+ 178000p -0.3
+ 178010p 0.9
+ 180000p 0.9
+ 180010p -0.3
+ 182000p -0.3
+ 182010p 0.9
+ 184000p 0.9
+ 184010p -0.3
+ 186000p -0.3
+ 186010p 0.9
+ 188000p 0.9
+ 188010p -0.3
+ 190000p -0.3
+ 190010p 0.9
+ 192000p 0.9
+ 192010p -0.3
+ 194000p -0.3
+ 194010p 0.9
+ 196000p 0.9
+ 196010p -0.3
+ 198000p -0.3
+ 198010p 0.9
+ 200000p 0.9
+ 200010p -0.3
+ 202000p -0.3
+ 202010p 0.9
+ 204000p 0.9
+ 204010p -0.3
+ 206000p -0.3
+ 206010p 0.9
+ 208000p 0.9
+ 208010p -0.3
+ 210000p -0.3
+ 210010p 0.9
+ 212000p 0.9
+ 212010p -0.3
+ 214000p -0.3
+ 214010p 0.9
+ 216000p 0.9
+ 216010p -0.3
+ 218000p -0.3
+ 218010p 0.9
+ 220000p 0.9
+ 220010p -0.3
+ 222000p -0.3
+ 222010p 0.9
+ 224000p 0.9
+ 224010p -0.3
+ 226000p -0.3
+ 226010p 0.9
+ 228000p 0.9
+ 228010p -0.3
+ 230000p -0.3
+ 230010p 0.9
+ 232000p 0.9
+ 232010p -0.3
+ 234000p -0.3
+ 234010p 0.9
+ 236000p 0.9
+ 236010p -0.3
+ 238000p -0.3
+ 238010p 0.9
+ 240000p 0.9
+ 240010p -0.3
+ 242000p -0.3
+ 242010p 0.9
+ 244000p 0.9
+ 244010p -0.3
+ 246000p -0.3
+ 246010p 0.9
+ 248000p 0.9
+ 248010p -0.3
+ 250000p -0.3
+ 250010p 0.9
+ 252000p 0.9
+ 252010p -0.3
+ 254000p -0.3
+ 254010p 0.9
+ 256000p 0.9
+ 256010p -0.3
+ 258000p -0.3
+ 258010p 0.9
+ 260000p 0.9
+ 260010p -0.3
+ 262000p -0.3
+ 262010p 0.9
+ 264000p 0.9
+ 264010p -0.3
+ 266000p -0.3
+ 266010p 0.9
+ 268000p 0.9
+ 268010p -0.3
+ 270000p -0.3
+ 270010p 0.9
+ 272000p 0.9
+ 272010p -0.3
+ 274000p -0.3
+ 274010p 0.9
+ 276000p 0.9
+ 276010p -0.3
+ 278000p -0.3
+ 278010p 0.9
+ 280000p 0.9
+ 280010p -0.3
+ 282000p -0.3
+ 282010p 0.9
+ 284000p 0.9
+ 284010p -0.3
+ 286000p -0.3
+ 286010p 0.9
+ 288000p 0.9
+ 288010p -0.3
+ 290000p -0.3
+ 290010p 0.9
+ 292000p 0.9
+ 292010p -0.3
+ 294000p -0.3
+ 294010p 0.9
+ 296000p 0.9
+ 296010p -0.3
+ 298000p -0.3
+ 298010p 0.9
+ 300000p 0.9
+ 300010p -0.3
+ 302000p -0.3
+ 302010p 0.9
+ 304000p 0.9
+ 304010p -0.3
+ 306000p -0.3
+ 306010p 0.9
+ 308000p 0.9
+ 308010p -0.3
+ 310000p -0.3
+ 310010p 0.9
+ 312000p 0.9
+ 312010p -0.3
+ 314000p -0.3
+ 314010p 0.9
+ 316000p 0.9
+ 316010p -0.3
+ 318000p -0.3
+ 318010p 0.9
+ 320000p 0.9
+ 320010p -0.3
+ 322000p -0.3
+ 322010p 0.9
+ 324000p 0.9
+ 324010p -0.3
+ 326000p -0.3
+ 326010p 0.9
+ 328000p 0.9
+ 328010p -0.3
+ 330000p -0.3
+ 330010p 0.9
+ 332000p 0.9
+ 332010p -0.3
+ 334000p -0.3
+ 334010p 0.9
+ 336000p 0.9
+ 336010p -0.3
+ 338000p -0.3
+ 338010p 0.9
+ 340000p 0.9
+ 340010p -0.3
+ 342000p -0.3
+ 342010p 0.9
+ 344000p 0.9
+ 344010p -0.3
+ 346000p -0.3
+ 346010p 0.9
+ 348000p 0.9
+ 348010p -0.3
+ 350000p -0.3
+ 350010p 0.9
+ 352000p 0.9
+ 352010p -0.3
+ 354000p -0.3
+ 354010p 0.9
+ 356000p 0.9
+ 356010p -0.3
+ 358000p -0.3
+ 358010p 0.9
+ 360000p 0.9
+ 360010p -0.3
+ 362000p -0.3
+ 362010p 0.9
+ 364000p 0.9
+ 364010p -0.3
+ 366000p -0.3
+ 366010p 0.9
+ 368000p 0.9
+ 368010p -0.3
+ 370000p -0.3
+ 370010p 0.9
+ 372000p 0.9
+ 372010p -0.3
+ 374000p -0.3
+ 374010p 0.9
+ 376000p 0.9
+ 376010p -0.3
+ 378000p -0.3
+ 378010p 0.9
+ 380000p 0.9
+ 380010p -0.3
+ 382000p -0.3
+ 382010p 0.9
+ 384000p 0.9
+ 384010p -0.3
+ 386000p -0.3
+ 386010p 0.9
+ 388000p 0.9
+ 388010p -0.3
+ 390000p -0.3
+ 390010p 0.9
+ 392000p 0.9
+ 392010p -0.3
+ 394000p -0.3
+ 394010p 0.9
+ 396000p 0.9
+ 396010p -0.3
+ 398000p -0.3
+ 398010p 0.9
+ 400000p 0.9
+ 400010p -0.3
+ 402000p -0.3
+ 402010p 0.9
+ 404000p 0.9
+ 404010p -0.3
+ 406000p -0.3
+ 406010p 0.9
+ 408000p 0.9
+ 408010p -0.3
+ 410000p -0.3
+ 410010p 0.9
+ 412000p 0.9
+ 412010p -0.3
+ 414000p -0.3
+ 414010p 0.9
+ 416000p 0.9
+ 416010p -0.3
+ 418000p -0.3
+ 418010p 0.9
+ 420000p 0.9
+ 420010p -0.3
+ 422000p -0.3
+ 422010p 0.9
+ 424000p 0.9
+ 424010p -0.3
+ 426000p -0.3
+ 426010p 0.9
+ 428000p 0.9
+ 428010p -0.3
+ 430000p -0.3
+ 430010p 0.9
+ 432000p 0.9
+ 432010p -0.3
+ 434000p -0.3
+ 434010p 0.9
+ 436000p 0.9
+ 436010p -0.3
+ 438000p -0.3
+ 438010p 0.9
+ 440000p 0.9
+ 440010p -0.3
+ 442000p -0.3
+ 442010p 0.9
+ 444000p 0.9
+ 444010p -0.3
+ 446000p -0.3
+ 446010p 0.9
+ 448000p 0.9
+ 448010p -0.3
+ 450000p -0.3
+ 450010p 0.9
+ 452000p 0.9
+ 452010p -0.3
+ 454000p -0.3
+ 454010p 0.9
+ 456000p 0.9
+ 456010p -0.3
+ 458000p -0.3
+ 458010p 0.9
+ 460000p 0.9
+ 460010p -0.3
+ 462000p -0.3
+ 462010p 0.9
+ 464000p 0.9
+ 464010p -0.3
+ 466000p -0.3
+ 466010p 0.9
+ 468000p 0.9
+ 468010p -0.3
+ 470000p -0.3
+ 470010p 0.9
+ 472000p 0.9
+ 472010p -0.3
+ 474000p -0.3
+ 474010p 0.9
+ 476000p 0.9
+ 476010p -0.3
+ 478000p -0.3
+ 478010p 0.9
+ 480000p 0.9
+ 480010p -0.3
+ 482000p -0.3
+ 482010p 0.9
+ 484000p 0.9
+ 484010p -0.3
+ 486000p -0.3
+ 486010p 0.9
+ 488000p 0.9
+ 488010p -0.3
+ 490000p -0.3
+ 490010p 0.9
+ 492000p 0.9
+ 492010p -0.3
+ 494000p -0.3
+ 494010p 0.9
+ 496000p 0.9
+ 496010p -0.3
+ 498000p -0.3
+ 498010p 0.9
+ 500000p 0.9
+ 500010p -0.3
+ 502000p -0.3
+ 502010p 0.9
+ 504000p 0.9
+ 504010p -0.3
+ 506000p -0.3
+ 506010p 0.9
+ 508000p 0.9
+ 508010p -0.3
+ 510000p -0.3
+ 510010p 0.9
+ 512000p 0.9
+ 512010p -0.3
+ 514000p -0.3
+ 514010p 0.9
+ 516000p 0.9
+ 516010p -0.3
+ 518000p -0.3
+ 518010p 0.9
+ 520000p 0.9
+ 520010p -0.3
+ 522000p -0.3
+ 522010p 0.9
+ 524000p 0.9
+ 524010p -0.3
+ 526000p -0.3
+ 526010p 0.9
+ 528000p 0.9
+ 528010p -0.3
+ 530000p -0.3
+ 530010p 0.9
+ 532000p 0.9
+ 532010p -0.3
+ 534000p -0.3
+ 534010p 0.9
+ 536000p 0.9
+ 536010p -0.3
+ 538000p -0.3
+ 538010p 0.9
+ 540000p 0.9
+ 540010p -0.3
+ 542000p -0.3
+ 542010p 0.9
+ 544000p 0.9
+ 544010p -0.3
+ 546000p -0.3
+ 546010p 0.9
+ 548000p 0.9
+ 548010p -0.3
+ 550000p -0.3
+ 550010p 0.9
+ 552000p 0.9
+ 552010p -0.3
+ 554000p -0.3
+ 554010p 0.9
+ 556000p 0.9
+ 556010p -0.3
+ 558000p -0.3
+ 558010p 0.9
+ 560000p 0.9
+ 560010p -0.3
+ 562000p -0.3
+ 562010p 0.9
+ 564000p 0.9
+ 564010p -0.3
+ 566000p -0.3
+ 566010p 0.9
+ 568000p 0.9
+ 568010p -0.3
+ 570000p -0.3
+ 570010p 0.9
+ 572000p 0.9
+ 572010p -0.3
+ 574000p -0.3
+ 574010p 0.9
+ 576000p 0.9
+ 576010p -0.3
+ 578000p -0.3
+ 578010p 0.9
+ 580000p 0.9
+ 580010p -0.3
+ 582000p -0.3
+ 582010p 0.9
+ 584000p 0.9
+ 584010p -0.3
+ 586000p -0.3
+ 586010p 0.9
+ 588000p 0.9
+ 588010p -0.3
+ 590000p -0.3
+ 590010p 0.9
+ 592000p 0.9
+ 592010p -0.3
+ 594000p -0.3
+ 594010p 0.9
+ 596000p 0.9
+ 596010p -0.3
+ 598000p -0.3
+ 598010p 0.9
+ 600000p 0.9
+ 600010p -0.3
+ 602000p -0.3
+ 602010p 0.9
+ 604000p 0.9
+ 604010p -0.3
+ 606000p -0.3
+ 606010p 0.9
+ 608000p 0.9
+ 608010p -0.3
+ 610000p -0.3
+ 610010p 0.9
+ 612000p 0.9
+ 612010p -0.3
+ 614000p -0.3
+ 614010p 0.9
+ 616000p 0.9
+ 616010p -0.3
+ 618000p -0.3
+ 618010p 0.9
+ 620000p 0.9
+ 620010p -0.3
+ 622000p -0.3
+ 622010p 0.9
+ 624000p 0.9
+ 624010p -0.3
+ 626000p -0.3
+ 626010p 0.9
+ 628000p 0.9
+ 628010p -0.3
+ 630000p -0.3
+ 630010p 0.9
+ 632000p 0.9
+ 632010p -0.3
+ 634000p -0.3
+ 634010p 0.9
+ 636000p 0.9
+ 636010p -0.3
+ 638000p -0.3
+ 638010p 0.9
+ 640000p 0.9
+ 640010p -0.3
+ 642000p -0.3
+ 642010p 0.9
+ 644000p 0.9
+ 644010p -0.3
+ 646000p -0.3
+ 646010p 0.9
+ 648000p 0.9
+ 648010p -0.3
+ 650000p -0.3
+ 650010p 0.9
+ 652000p 0.9
+ 652010p -0.3
+ 654000p -0.3
+ 654010p 0.9
+ 656000p 0.9
+ 656010p -0.3
+ 658000p -0.3
+ 658010p 0.9
+ 660000p 0.9
+ 660010p -0.3
+ 662000p -0.3
+ 662010p 0.9
+ 664000p 0.9
+ 664010p -0.3
+ 666000p -0.3
+ 666010p 0.9
+ 668000p 0.9
+ 668010p -0.3
+ 670000p -0.3
+ 670010p 0.9
+ 672000p 0.9
+ 672010p -0.3
+ 674000p -0.3
+ 674010p 0.9
+ 676000p 0.9
+ 676010p -0.3
+ 678000p -0.3
+ 678010p 0.9
+ 680000p 0.9
+ 680010p -0.3
+ 682000p -0.3
+ 682010p 0.9
+ 684000p 0.9
+ 684010p -0.3
+ 686000p -0.3
+ 686010p 0.9
+ 688000p 0.9
+ 688010p -0.3
+ 690000p -0.3
+ 690010p 0.9
+ 692000p 0.9
+ 692010p -0.3
+ 694000p -0.3
+ 694010p 0.9
+ 696000p 0.9
+ 696010p -0.3
+ 698000p -0.3
+ 698010p 0.9
+ 700000p 0.9
+ 700010p -0.3
+ 702000p -0.3
+ 702010p 0.9
+ 704000p 0.9
+ 704010p -0.3
+ 706000p -0.3
+ 706010p 0.9
+ 708000p 0.9
+ 708010p -0.3
+ 710000p -0.3
+ 710010p 0.9
+ 712000p 0.9
+ 712010p -0.3
+ 714000p -0.3
+ 714010p 0.9
+ 716000p 0.9
+ 716010p -0.3
+ 718000p -0.3
+ 718010p 0.9
+ 720000p 0.9
+ 720010p -0.3
+ 722000p -0.3
+ 722010p 0.9
+ 724000p 0.9
+ 724010p -0.3
+ 726000p -0.3
+ 726010p 0.9
+ 728000p 0.9
+ 728010p -0.3
+ 730000p -0.3
+ 730010p 0.9
+ 732000p 0.9
+ 732010p -0.3
+ 734000p -0.3
+ 734010p 0.9
+ 736000p 0.9
+ 736010p -0.3
+ 738000p -0.3
+ 738010p 0.9
+ 740000p 0.9
+ 740010p -0.3
+ 742000p -0.3
+ 742010p 0.9
+ 744000p 0.9
+ 744010p -0.3
+ 746000p -0.3
+ 746010p 0.9
+ 748000p 0.9
+ 748010p -0.3
+ 750000p -0.3
+ 750010p 0.9
+ 752000p 0.9
+ 752010p -0.3
+ 754000p -0.3
+ 754010p 0.9
+ 756000p 0.9
+ 756010p -0.3
+ 758000p -0.3
+ 758010p 0.9
+ 760000p 0.9
+ 760010p -0.3
+ 762000p -0.3
+ 762010p 0.9
+ 764000p 0.9
+ 764010p -0.3
+ 766000p -0.3
+ 766010p 0.9
+ 768000p 0.9
+ 768010p -0.3
+ 770000p -0.3
+ 770010p 0.9
+ 772000p 0.9
+ 772010p -0.3
+ 774000p -0.3
+ 774010p 0.9
+ 776000p 0.9
+ 776010p -0.3
+ 778000p -0.3
+ 778010p 0.9
+ 780000p 0.9
+ 780010p -0.3
+ 782000p -0.3
+ 782010p 0.9
+ 784000p 0.9
+ 784010p -0.3
+ 786000p -0.3
+ 786010p 0.9
+ 788000p 0.9
+ 788010p -0.3
+ 790000p -0.3
+ 790010p 0.9
+ 792000p 0.9
+ 792010p -0.3
+ 794000p -0.3
+ 794010p 0.9
+ 796000p 0.9
+ 796010p -0.3
+ 798000p -0.3
+ 798010p 0.9
+ 800000p 0.9
+ 800010p -0.3
+ 802000p -0.3
+ 802010p 0.9
+ 804000p 0.9
+ 804010p -0.3
+ 806000p -0.3
+ 806010p 0.9
+ 808000p 0.9
+ 808010p -0.3
+ 810000p -0.3
+ 810010p 0.9
+ 812000p 0.9
+ 812010p -0.3
+ 814000p -0.3
+ 814010p 0.9
+ 816000p 0.9
+ 816010p -0.3
+ 818000p -0.3
+ 818010p 0.9
+ 820000p 0.9
+ 820010p -0.3
+ 822000p -0.3
+ 822010p 0.9
+ 824000p 0.9
+ 824010p -0.3
+ 826000p -0.3
+ 826010p 0.9
+ 828000p 0.9
+ 828010p -0.3
+ 830000p -0.3
+ 830010p 0.9
+ 832000p 0.9
+ 832010p -0.3
+ 834000p -0.3
+ 834010p 0.9
+ 836000p 0.9
+ 836010p -0.3
+ 838000p -0.3
+ 838010p 0.9
+ 840000p 0.9
+ 840010p -0.3
+ 842000p -0.3
+ 842010p 0.9
+ 844000p 0.9
+ 844010p -0.3
+ 846000p -0.3
+ 846010p 0.9
+ 848000p 0.9
+ 848010p -0.3
+ 850000p -0.3
+ 850010p 0.9
+ 852000p 0.9
+ 852010p -0.3
+ 854000p -0.3
+ 854010p 0.9
+ 856000p 0.9
+ 856010p -0.3
+ 858000p -0.3
+ 858010p 0.9
+ 860000p 0.9
+ 860010p -0.3
+ 862000p -0.3
+ 862010p 0.9
+ 864000p 0.9
+ 864010p -0.3
+ 866000p -0.3
+ 866010p 0.9
+ 868000p 0.9
+ 868010p -0.3
+ 870000p -0.3
+ 870010p 0.9
+ 872000p 0.9
+ 872010p -0.3
+ 874000p -0.3
+ 874010p 0.9
+ 876000p 0.9
+ 876010p -0.3
+ 878000p -0.3
+ 878010p 0.9
+ 880000p 0.9
+ 880010p -0.3
+ 882000p -0.3
+ 882010p 0.9
+ 884000p 0.9
+ 884010p -0.3
+ 886000p -0.3
+ 886010p 0.9
+ 888000p 0.9
+ 888010p -0.3
+ 890000p -0.3
+ 890010p 0.9
+ 892000p 0.9
+ 892010p -0.3
+ 894000p -0.3
+ 894010p 0.9
+ 896000p 0.9
+ 896010p -0.3
+ 898000p -0.3
+ 898010p 0.9
+ 900000p 0.9
+ 900010p -0.3
+ 902000p -0.3
+ 902010p 0.9
+ 904000p 0.9
+ 904010p -0.3
+ 906000p -0.3
+ 906010p 0.9
+ 908000p 0.9
+ 908010p -0.3
+ 910000p -0.3
+ 910010p 0.9
+ 912000p 0.9
+ 912010p -0.3
+ 914000p -0.3
+ 914010p 0.9
+ 916000p 0.9
+ 916010p -0.3
+ 918000p -0.3
+ 918010p 0.9
+ 920000p 0.9
+ 920010p -0.3
+ 922000p -0.3
+ 922010p 0.9
+ 924000p 0.9
+ 924010p -0.3
+ 926000p -0.3
+ 926010p 0.9
+ 928000p 0.9
+ 928010p -0.3
+ 930000p -0.3
+ 930010p 0.9
+ 932000p 0.9
+ 932010p -0.3
+ 934000p -0.3
+ 934010p 0.9
+ 936000p 0.9
+ 936010p -0.3
+ 938000p -0.3
+ 938010p 0.9
+ 940000p 0.9
+ 940010p -0.3
+ 942000p -0.3
+ 942010p 0.9
+ 944000p 0.9
+ 944010p -0.3
+ 946000p -0.3
+ 946010p 0.9
+ 948000p 0.9
+ 948010p -0.3
+ 950000p -0.3
+ 950010p 0.9
+ 952000p 0.9
+ 952010p -0.3
+ 954000p -0.3
+ 954010p 0.9
+ 956000p 0.9
+ 956010p -0.3
+ 958000p -0.3
+ 958010p 0.9
+ 960000p 0.9
+ 960010p -0.3
+ 962000p -0.3
+ 962010p 0.9
+ 964000p 0.9
+ 964010p -0.3
+ 966000p -0.3
+ 966010p 0.9
+ 968000p 0.9
+ 968010p -0.3
+ 970000p -0.3
+ 970010p 0.9
+ 972000p 0.9
+ 972010p -0.3
+ 974000p -0.3
+ 974010p 0.9
+ 976000p 0.9
+ 976010p -0.3
+ 978000p -0.3
+ 978010p 0.9
+ 980000p 0.9
+ 980010p -0.3
+ 982000p -0.3
+ 982010p 0.9
+ 984000p 0.9
+ 984010p -0.3
+ 986000p -0.3
+ 986010p 0.9
+ 988000p 0.9
+ 988010p -0.3
+ 990000p -0.3
+ 990010p 0.9
+ 992000p 0.9
+ 992010p -0.3
+ 994000p -0.3
+ 994010p 0.9
+ 996000p 0.9
+ 996010p -0.3
+ 998000p -0.3
+ 998010p 0.9
+ 1000000p 0.9
+ 1000010p -0.3
+ 1002000p -0.3
+ 1002010p 0.9
+ 1004000p 0.9
+ 1004010p -0.3
+ 1006000p -0.3
+ 1006010p 0.9
+ 1008000p 0.9
+ 1008010p -0.3
+ 1010000p -0.3
+ 1010010p 0.9
+ 1012000p 0.9
+ 1012010p -0.3
+ 1014000p -0.3
+ 1014010p 0.9
+ 1016000p 0.9
+ 1016010p -0.3
+ 1018000p -0.3
+ 1018010p 0.9
+ 1020000p 0.9
+ 1020010p -0.3
+ 1022000p -0.3
+ 1022010p 0.9
+ 1024000p 0.9
+ 1024010p -0.3
+ 1026000p -0.3
+ 1026010p 0.9
+ 1028000p 0.9
+ 1028010p -0.3
+ 1030000p -0.3
+ 1030010p 0.9
+ 1032000p 0.9
+ 1032010p -0.3
+ 1034000p -0.3
+ 1034010p 0.9
+ 1036000p 0.9
+ 1036010p -0.3
+ 1038000p -0.3
+ 1038010p 0.9
+ 1040000p 0.9
+ 1040010p -0.3
+ 1042000p -0.3
+ 1042010p 0.9
+ 1044000p 0.9
+ 1044010p -0.3
+ 1046000p -0.3
+ 1046010p 0.9
+ 1048000p 0.9
+ 1048010p -0.3
+ 1050000p -0.3
+ 1050010p 0.9
+ 1052000p 0.9
+ 1052010p -0.3
+ 1054000p -0.3
+ 1054010p 0.9
+ 1056000p 0.9
+ 1056010p -0.3
+ 1058000p -0.3
+ 1058010p 0.9
+ 1060000p 0.9
+ 1060010p -0.3
+ 1062000p -0.3
+ 1062010p 0.9
+ 1064000p 0.9
+ 1064010p -0.3
+ 1066000p -0.3
+ 1066010p 0.9
+ 1068000p 0.9
+ 1068010p -0.3
+ 1070000p -0.3
+ 1070010p 0.9
+ 1072000p 0.9
+ 1072010p -0.3
+ 1074000p -0.3
+ 1074010p 0.9
+ 1076000p 0.9
+ 1076010p -0.3
+ 1078000p -0.3
+ 1078010p 0.9
+ 1080000p 0.9
+ 1080010p -0.3
+ 1082000p -0.3
+ 1082010p 0.9
+ 1084000p 0.9
+ 1084010p -0.3
+ 1086000p -0.3
+ 1086010p 0.9
+ 1088000p 0.9
+ 1088010p -0.3
+ 1090000p -0.3
+ 1090010p 0.9
+ 1092000p 0.9
+ 1092010p -0.3
+ 1094000p -0.3
+ 1094010p 0.9
+ 1096000p 0.9
+ 1096010p -0.3
+ 1098000p -0.3
+ 1098010p 0.9
+ 1100000p 0.9
+ 1100010p -0.3
+ 1102000p -0.3
+ 1102010p 0.9
+ 1104000p 0.9
+ 1104010p -0.3
+ 1106000p -0.3
+ 1106010p 0.9
+ 1108000p 0.9
+ 1108010p -0.3
+ 1110000p -0.3
+ 1110010p 0.9
+ 1112000p 0.9
+ 1112010p -0.3
+ 1114000p -0.3
+ 1114010p 0.9
+ 1116000p 0.9
+ 1116010p -0.3
+ 1118000p -0.3
+ 1118010p 0.9
+ 1120000p 0.9
+ 1120010p -0.3
+ 1122000p -0.3
+ 1122010p 0.9
+ 1124000p 0.9
+ 1124010p -0.3
+ 1126000p -0.3
+ 1126010p 0.9
+ 1128000p 0.9
+ 1128010p -0.3
+ 1130000p -0.3
+ 1130010p 0.9
+ 1132000p 0.9
+ 1132010p -0.3
+ 1134000p -0.3
+ 1134010p 0.9
+ 1136000p 0.9
+ 1136010p -0.3
+ 1138000p -0.3
+ 1138010p 0.9
+ 1140000p 0.9
+ 1140010p -0.3
+ 1142000p -0.3
+ 1142010p 0.9
+ 1144000p 0.9
+ 1144010p -0.3
+ 1146000p -0.3
+ 1146010p 0.9
+ 1148000p 0.9
+ 1148010p -0.3
+ 1150000p -0.3
+ 1150010p 0.9
+ 1152000p 0.9
+ 1152010p -0.3
+ 1154000p -0.3
+ 1154010p 0.9
+ 1156000p 0.9
+ 1156010p -0.3
+ 1158000p -0.3
+ 1158010p 0.9
+ 1160000p 0.9
+ 1160010p -0.3
+ 1162000p -0.3
+ 1162010p 0.9
+ 1164000p 0.9
+ 1164010p -0.3
+ 1166000p -0.3
+ 1166010p 0.9
+ 1168000p 0.9
+ 1168010p -0.3
+ 1170000p -0.3
+ 1170010p 0.9
+ 1172000p 0.9
+ 1172010p -0.3
+ 1174000p -0.3
+ 1174010p 0.9
+ 1176000p 0.9
+ 1176010p -0.3
+ 1178000p -0.3
+ 1178010p 0.9
+ 1180000p 0.9
+ 1180010p -0.3
+ 1182000p -0.3
+ 1182010p 0.9
+ 1184000p 0.9
+ 1184010p -0.3
+ 1186000p -0.3
+ 1186010p 0.9
+ 1188000p 0.9
+ 1188010p -0.3
+ 1190000p -0.3
+ 1190010p 0.9
+ 1192000p 0.9
+ 1192010p -0.3
+ 1194000p -0.3
+ 1194010p 0.9
+ 1196000p 0.9
+ 1196010p -0.3
+ 1198000p -0.3
+ 1198010p 0.9
+ 1200000p 0.9
+ 1200010p -0.3
+ 1202000p -0.3
+ 1202010p 0.9
+ 1204000p 0.9
+ 1204010p -0.3
+ 1206000p -0.3
+ 1206010p 0.9
+ 1208000p 0.9
+ 1208010p -0.3
+ 1210000p -0.3
+ 1210010p 0.9
+ 1212000p 0.9
+ 1212010p -0.3
+ 1214000p -0.3
+ 1214010p 0.9
+ 1216000p 0.9
+ 1216010p -0.3
+ 1218000p -0.3
+ 1218010p 0.9
+ 1220000p 0.9
+ 1220010p -0.3
+ 1222000p -0.3
+ 1222010p 0.9
+ 1224000p 0.9
+ 1224010p -0.3
+ 1226000p -0.3
+ 1226010p 0.9
+ 1228000p 0.9
+ 1228010p -0.3
+ 1230000p -0.3
+ 1230010p 0.9
+ 1232000p 0.9
+ 1232010p -0.3
+ 1234000p -0.3
+ 1234010p 0.9
+ 1236000p 0.9
+ 1236010p -0.3
+ 1238000p -0.3
+ 1238010p 0.9
+ 1240000p 0.9
+ 1240010p -0.3
+ 1242000p -0.3
+ 1242010p 0.9
+ 1244000p 0.9
+ 1244010p -0.3
+ 1246000p -0.3
+ 1246010p 0.9
+ 1248000p 0.9
+ 1248010p -0.3
+ 1250000p -0.3
+ 1250010p 0.9
+ 1252000p 0.9
+ 1252010p -0.3
+ 1254000p -0.3
+ 1254010p 0.9
+ 1256000p 0.9
+ 1256010p -0.3
+ 1258000p -0.3
+ 1258010p 0.9
+ 1260000p 0.9
+ 1260010p -0.3
+ 1262000p -0.3
+ 1262010p 0.9
+ 1264000p 0.9
+ 1264010p -0.3
+ 1266000p -0.3
+ 1266010p 0.9
+ 1268000p 0.9
+ 1268010p -0.3
+ 1270000p -0.3
+ 1270010p 0.9
+ 1272000p 0.9
+ 1272010p -0.3
+ 1274000p -0.3
+ 1274010p 0.9
+ 1276000p 0.9
+ 1276010p -0.3
+ 1278000p -0.3
+ 1278010p 0.9
+ 1280000p 0.9
+ 1280010p -0.3
+ 1282000p -0.3
+ 1282010p 0.9
+ 1284000p 0.9
+ 1284010p -0.3
+ 1286000p -0.3
+ 1286010p 0.9
+ 1288000p 0.9
+ 1288010p -0.3
+ 1290000p -0.3
+ 1290010p 0.9
+ 1292000p 0.9
+ 1292010p -0.3
+ 1294000p -0.3
+ 1294010p 0.9
+ 1296000p 0.9
+ 1296010p -0.3
+ 1298000p -0.3
+ 1298010p 0.9
+ 1300000p 0.9
+ 1300010p -0.3
+ 1302000p -0.3
+ 1302010p 0.9
+ 1304000p 0.9
+ 1304010p -0.3
+ 1306000p -0.3
+ 1306010p 0.9
+ 1308000p 0.9
+ 1308010p -0.3
+ 1310000p -0.3
+ 1310010p 0.9
+ 1312000p 0.9
+ 1312010p -0.3
+ 1314000p -0.3
+ 1314010p 0.9
+ 1316000p 0.9
+ 1316010p -0.3
+ 1318000p -0.3
+ 1318010p 0.9
+ 1320000p 0.9
+ 1320010p -0.3
+ 1322000p -0.3
+ 1322010p 0.9
+ 1324000p 0.9
+ 1324010p -0.3
+ 1326000p -0.3
+ 1326010p 0.9
+ 1328000p 0.9
+ 1328010p -0.3
+ 1330000p -0.3
+ 1330010p 0.9
+ 1332000p 0.9
+ 1332010p -0.3
+ 1334000p -0.3
+ 1334010p 0.9
+ 1336000p 0.9
+ 1336010p -0.3
+ 1338000p -0.3
+ 1338010p 0.9
+ 1340000p 0.9
+ 1340010p -0.3
+ 1342000p -0.3
+ 1342010p 0.9
+ 1344000p 0.9
+ 1344010p -0.3
+ 1346000p -0.3
+ 1346010p 0.9
+ 1348000p 0.9
+ 1348010p -0.3
+ 1350000p -0.3
+ 1350010p 0.9
+ 1352000p 0.9
+ 1352010p -0.3
+ 1354000p -0.3
+ 1354010p 0.9
+ 1356000p 0.9
+ 1356010p -0.3
+ 1358000p -0.3
+ 1358010p 0.9
+ 1360000p 0.9
+ 1360010p -0.3
+ 1362000p -0.3
+ 1362010p 0.9
+ 1364000p 0.9
+ 1364010p -0.3
+ 1366000p -0.3
+ 1366010p 0.9
+ 1368000p 0.9
+ 1368010p -0.3
+ 1370000p -0.3
+ 1370010p 0.9
+ 1372000p 0.9
+ 1372010p -0.3
+ 1374000p -0.3
+ 1374010p 0.9
+ 1376000p 0.9
+ 1376010p -0.3
+ 1378000p -0.3
+ 1378010p 0.9
+ 1380000p 0.9
+ 1380010p -0.3
+ 1382000p -0.3
+ 1382010p 0.9
+ 1384000p 0.9
+ 1384010p -0.3
+ 1386000p -0.3
+ 1386010p 0.9
+ 1388000p 0.9
+ 1388010p -0.3
+ 1390000p -0.3
+ 1390010p 0.9
+ 1392000p 0.9
+ 1392010p -0.3
+ 1394000p -0.3
+ 1394010p 0.9
+ 1396000p 0.9
+ 1396010p -0.3
+ 1398000p -0.3
+ 1398010p 0.9
+ 1400000p 0.9
+ 1400010p -0.3
+ 1402000p -0.3
+ 1402010p 0.9
+ 1404000p 0.9
+ 1404010p -0.3
+ 1406000p -0.3
+ 1406010p 0.9
+ 1408000p 0.9
+ 1408010p -0.3
+ 1410000p -0.3
+ 1410010p 0.9
+ 1412000p 0.9
+ 1412010p -0.3
+ 1414000p -0.3
+ 1414010p 0.9
+ 1416000p 0.9
+ 1416010p -0.3
+ 1418000p -0.3
+ 1418010p 0.9
+ 1420000p 0.9
+ 1420010p -0.3
+ 1422000p -0.3
+ 1422010p 0.9
+ 1424000p 0.9
+ 1424010p -0.3
+ 1426000p -0.3
+ 1426010p 0.9
+ 1428000p 0.9
+ 1428010p -0.3
+ 1430000p -0.3
+ 1430010p 0.9
+ 1432000p 0.9
+ 1432010p -0.3
+ 1434000p -0.3
+ 1434010p 0.9
+ 1436000p 0.9
+ 1436010p -0.3
+ 1438000p -0.3
+ 1438010p 0.9
+ 1440000p 0.9
+ 1440010p -0.3
+ 1442000p -0.3
+ 1442010p 0.9
+ 1444000p 0.9
+ 1444010p -0.3
+ 1446000p -0.3
+ 1446010p 0.9
+ 1448000p 0.9
+ 1448010p -0.3
+ 1450000p -0.3
+ 1450010p 0.9
+ 1452000p 0.9
+ 1452010p -0.3
+ 1454000p -0.3
+ 1454010p 0.9
+ 1456000p 0.9
+ 1456010p -0.3
+ 1458000p -0.3
+ 1458010p 0.9
+ 1460000p 0.9
+ 1460010p -0.3
+ 1462000p -0.3
+ 1462010p 0.9
+ 1464000p 0.9
+ 1464010p -0.3
+ 1466000p -0.3
+ 1466010p 0.9
+ 1468000p 0.9
+ 1468010p -0.3
+ 1470000p -0.3
+ 1470010p 0.9
+ 1472000p 0.9
+ 1472010p -0.3
+ 1474000p -0.3
+ 1474010p 0.9
+ 1476000p 0.9
+ 1476010p -0.3
+ 1478000p -0.3
+ 1478010p 0.9
+ 1480000p 0.9
+ 1480010p -0.3
+ 1482000p -0.3
+ 1482010p 0.9
+ 1484000p 0.9
+ 1484010p -0.3
+ 1486000p -0.3
+ 1486010p 0.9
+ 1488000p 0.9
+ 1488010p -0.3
+ 1490000p -0.3
+ 1490010p 0.9
+ 1492000p 0.9
+ 1492010p -0.3
+ 1494000p -0.3
+ 1494010p 0.9
+ 1496000p 0.9
+ 1496010p -0.3
+ 1498000p -0.3
+ 1498010p 0.9
+ 1500000p 0.9
+ 1500010p -0.3
+ 1502000p -0.3
+ 1502010p 0.9
+ 1504000p 0.9
+ 1504010p -0.3
+ 1506000p -0.3
+ 1506010p 0.9
+ 1508000p 0.9
+ 1508010p -0.3
+ 1510000p -0.3
+ 1510010p 0.9
+ 1512000p 0.9
+ 1512010p -0.3
+ 1514000p -0.3
+ 1514010p 0.9
+ 1516000p 0.9
+ 1516010p -0.3
+ 1518000p -0.3
+ 1518010p 0.9
+ 1520000p 0.9
+ 1520010p -0.3
+ 1522000p -0.3
+ 1522010p 0.9
+ 1524000p 0.9
+ 1524010p -0.3
+ 1526000p -0.3
+ 1526010p 0.9
+ 1528000p 0.9
+ 1528010p -0.3
+ 1530000p -0.3
+ 1530010p 0.9
+ 1532000p 0.9
+ 1532010p -0.3
+ 1534000p -0.3
+ 1534010p 0.9
+ 1536000p 0.9
+ 1536010p -0.3
+ 1538000p -0.3
+ 1538010p 0.9
+ 1540000p 0.9
+ 1540010p -0.3
+ 1542000p -0.3
+ 1542010p 0.9
+ 1544000p 0.9
+ 1544010p -0.3
+ 1546000p -0.3
+ 1546010p 0.9
+ 1548000p 0.9
+ 1548010p -0.3
+ 1550000p -0.3
+ 1550010p 0.9
+ 1552000p 0.9
+ 1552010p -0.3
+ 1554000p -0.3
+ 1554010p 0.9
+ 1556000p 0.9
+ 1556010p -0.3
+ 1558000p -0.3
+ 1558010p 0.9
+ 1560000p 0.9
+ 1560010p -0.3
+ 1562000p -0.3
+ 1562010p 0.9
+ 1564000p 0.9
+ 1564010p -0.3
+ 1566000p -0.3
+ 1566010p 0.9
+ 1568000p 0.9
+ 1568010p -0.3
+ 1570000p -0.3
+ 1570010p 0.9
+ 1572000p 0.9
+ 1572010p -0.3
+ 1574000p -0.3
+ 1574010p 0.9
+ 1576000p 0.9
+ 1576010p -0.3
+ 1578000p -0.3
+ 1578010p 0.9
+ 1580000p 0.9
+ 1580010p -0.3
+ 1582000p -0.3
+ 1582010p 0.9
+ 1584000p 0.9
+ 1584010p -0.3
+ 1586000p -0.3
+ 1586010p 0.9
+ 1588000p 0.9
+ 1588010p -0.3
+ 1590000p -0.3
+ 1590010p 0.9
+ 1592000p 0.9
+ 1592010p -0.3
+ 1594000p -0.3
+ 1594010p 0.9
+ 1596000p 0.9
+ 1596010p -0.3
+ 1598000p -0.3
+ 1598010p 0.9
+ 1600000p 0.9
+ 1600010p -0.3
+ 1602000p -0.3
+ 1602010p 0.9
+ 1604000p 0.9
+ 1604010p -0.3
+ 1606000p -0.3
+ 1606010p 0.9
+ 1608000p 0.9
+ 1608010p -0.3
+ 1610000p -0.3
+ 1610010p 0.9
+ 1612000p 0.9
+ 1612010p -0.3
+ 1614000p -0.3
+ 1614010p 0.9
+ 1616000p 0.9
+ 1616010p -0.3
+ 1618000p -0.3
+ 1618010p 0.9
+ 1620000p 0.9
+ 1620010p -0.3
+ 1622000p -0.3
+ 1622010p 0.9
+ 1624000p 0.9
+ 1624010p -0.3
+ 1626000p -0.3
+ 1626010p 0.9
+ 1628000p 0.9
+ 1628010p -0.3
+ 1630000p -0.3
+ 1630010p 0.9
+ 1632000p 0.9
+ 1632010p -0.3
+ 1634000p -0.3
+ 1634010p 0.9
+ 1636000p 0.9
+ 1636010p -0.3
+ 1638000p -0.3
+ 1638010p 0.9
+ 1640000p 0.9
+ 1640010p -0.3
+ 1642000p -0.3
+ 1642010p 0.9
+ 1644000p 0.9
+ 1644010p -0.3
+ 1646000p -0.3
+ 1646010p 0.9
+ 1648000p 0.9
+ 1648010p -0.3
+ 1650000p -0.3
+ 1650010p 0.9
+ 1652000p 0.9
+ 1652010p -0.3
+ 1654000p -0.3
+ 1654010p 0.9
+ 1656000p 0.9
+ 1656010p -0.3
+ 1658000p -0.3
+ 1658010p 0.9
+ 1660000p 0.9
+ 1660010p -0.3
+ 1662000p -0.3
+ 1662010p 0.9
+ 1664000p 0.9
+ 1664010p -0.3
+ 1666000p -0.3
+ 1666010p 0.9
+ 1668000p 0.9
+ 1668010p -0.3
+ 1670000p -0.3
+ 1670010p 0.9
+ 1672000p 0.9
+ 1672010p -0.3
+ 1674000p -0.3
+ 1674010p 0.9
+ 1676000p 0.9
+ 1676010p -0.3
+ 1678000p -0.3
+ 1678010p 0.9
+ 1680000p 0.9
+ 1680010p -0.3
+ 1682000p -0.3
+ 1682010p 0.9
+ 1684000p 0.9
+ 1684010p -0.3
+ 1686000p -0.3
+ 1686010p 0.9
+ 1688000p 0.9
+ 1688010p -0.3
+ 1690000p -0.3
+ 1690010p 0.9
+ 1692000p 0.9
+ 1692010p -0.3
+ 1694000p -0.3
+ 1694010p 0.9
+ 1696000p 0.9
+ 1696010p -0.3
+ 1698000p -0.3
+ 1698010p 0.9
+ 1700000p 0.9
+ 1700010p -0.3
+ 1702000p -0.3
+ 1702010p 0.9
+ 1704000p 0.9
+ 1704010p -0.3
+ 1706000p -0.3
+ 1706010p 0.9
+ 1708000p 0.9
+ 1708010p -0.3
+ 1710000p -0.3
+ 1710010p 0.9
+ 1712000p 0.9
+ 1712010p -0.3
+ 1714000p -0.3
+ 1714010p 0.9
+ 1716000p 0.9
+ 1716010p -0.3
+ 1718000p -0.3
+ 1718010p 0.9
+ 1720000p 0.9
+ 1720010p -0.3
+ 1722000p -0.3
+ 1722010p 0.9
+ 1724000p 0.9
+ 1724010p -0.3
+ 1726000p -0.3
+ 1726010p 0.9
+ 1728000p 0.9
+ 1728010p -0.3
+ 1730000p -0.3
+ 1730010p 0.9
+ 1732000p 0.9
+ 1732010p -0.3
+ 1734000p -0.3
+ 1734010p 0.9
+ 1736000p 0.9
+ 1736010p -0.3
+ 1738000p -0.3
+ 1738010p 0.9
+ 1740000p 0.9
+ 1740010p -0.3
+ 1742000p -0.3
+ 1742010p 0.9
+ 1744000p 0.9
+ 1744010p -0.3
+ 1746000p -0.3
+ 1746010p 0.9
+ 1748000p 0.9
+ 1748010p -0.3
+ 1750000p -0.3
+ 1750010p 0.9
+ 1752000p 0.9
+ 1752010p -0.3
+ 1754000p -0.3
+ 1754010p 0.9
+ 1756000p 0.9
+ 1756010p -0.3
+ 1758000p -0.3
+ 1758010p 0.9
+ 1760000p 0.9
+ 1760010p -0.3
+ 1762000p -0.3
+ 1762010p 0.9
+ 1764000p 0.9
+ 1764010p -0.3
+ 1766000p -0.3
+ 1766010p 0.9
+ 1768000p 0.9
+ 1768010p -0.3
+ 1770000p -0.3
+ 1770010p 0.9
+ 1772000p 0.9
+ 1772010p -0.3
+ 1774000p -0.3
+ 1774010p 0.9
+ 1776000p 0.9
+ 1776010p -0.3
+ 1778000p -0.3
+ 1778010p 0.9
+ 1780000p 0.9
+ 1780010p -0.3
+ 1782000p -0.3
+ 1782010p 0.9
+ 1784000p 0.9
+ 1784010p -0.3
+ 1786000p -0.3
+ 1786010p 0.9
+ 1788000p 0.9
+ 1788010p -0.3
+ 1790000p -0.3
+ 1790010p 0.9
+ 1792000p 0.9
+ 1792010p -0.3
+ 1794000p -0.3
+ 1794010p 0.9
+ 1796000p 0.9
+ 1796010p -0.3
+ 1798000p -0.3
+ 1798010p 0.9
+ 1800000p 0.9
+ 1800010p -0.3
+ 1802000p -0.3
+ 1802010p 0.9
+ 1804000p 0.9
+ 1804010p -0.3
+ 1806000p -0.3
+ 1806010p 0.9
+ 1808000p 0.9
+ 1808010p -0.3
+ 1810000p -0.3
+ 1810010p 0.9
+ 1812000p 0.9
+ 1812010p -0.3
+ 1814000p -0.3
+ 1814010p 0.9
+ 1816000p 0.9
+ 1816010p -0.3
+ 1818000p -0.3
+ 1818010p 0.9
+ 1820000p 0.9
+ 1820010p -0.3
+ 1822000p -0.3
+ 1822010p 0.9
+ 1824000p 0.9
+ 1824010p -0.3
+ 1826000p -0.3
+ 1826010p 0.9
+ 1828000p 0.9
+ 1828010p -0.3
+ 1830000p -0.3
+ 1830010p 0.9
+ 1832000p 0.9
+ 1832010p -0.3
+ 1834000p -0.3
+ 1834010p 0.9
+ 1836000p 0.9
+ 1836010p -0.3
+ 1838000p -0.3
+ 1838010p 0.9
+ 1840000p 0.9
+ 1840010p -0.3
+ 1842000p -0.3
+ 1842010p 0.9
+ 1844000p 0.9
+ 1844010p -0.3
+ 1846000p -0.3
+ 1846010p 0.9
+ 1848000p 0.9
+ 1848010p -0.3
+ 1850000p -0.3
+ 1850010p 0.9
+ 1852000p 0.9
+ 1852010p -0.3
+ 1854000p -0.3
+ 1854010p 0.9
+ 1856000p 0.9
+ 1856010p -0.3
+ 1858000p -0.3
+ 1858010p 0.9
+ 1860000p 0.9
+ 1860010p -0.3
+ 1862000p -0.3
+ 1862010p 0.9
+ 1864000p 0.9
+ 1864010p -0.3
+ 1866000p -0.3
+ 1866010p 0.9
+ 1868000p 0.9
+ 1868010p -0.3
+ 1870000p -0.3
+ 1870010p 0.9
+ 1872000p 0.9
+ 1872010p -0.3
+ 1874000p -0.3
+ 1874010p 0.9
+ 1876000p 0.9
+ 1876010p -0.3
+ 1878000p -0.3
+ 1878010p 0.9
+ 1880000p 0.9
+ 1880010p -0.3
+ 1882000p -0.3
+ 1882010p 0.9
+ 1884000p 0.9
+ 1884010p -0.3
+ 1886000p -0.3
+ 1886010p 0.9
+ 1888000p 0.9
+ 1888010p -0.3
+ 1890000p -0.3
+ 1890010p 0.9
+ 1892000p 0.9
+ 1892010p -0.3
+ 1894000p -0.3
+ 1894010p 0.9
+ 1896000p 0.9
+ 1896010p -0.3
+ 1898000p -0.3
+ 1898010p 0.9
+ 1900000p 0.9
+ 1900010p -0.3
+ 1902000p -0.3
+ 1902010p 0.9
+ 1904000p 0.9
+ 1904010p -0.3
+ 1906000p -0.3
+ 1906010p 0.9
+ 1908000p 0.9
+ 1908010p -0.3
+ 1910000p -0.3
+ 1910010p 0.9
+ 1912000p 0.9
+ 1912010p -0.3
+ 1914000p -0.3
+ 1914010p 0.9
+ 1916000p 0.9
+ 1916010p -0.3
+ 1918000p -0.3
+ 1918010p 0.9
+ 1920000p 0.9
+ 1920010p -0.3
+ 1922000p -0.3
+ 1922010p 0.9
+ 1924000p 0.9
+ 1924010p -0.3
+ 1926000p -0.3
+ 1926010p 0.9
+ 1928000p 0.9
+ 1928010p -0.3
+ 1930000p -0.3
+ 1930010p 0.9
+ 1932000p 0.9
+ 1932010p -0.3
+ 1934000p -0.3
+ 1934010p 0.9
+ 1936000p 0.9
+ 1936010p -0.3
+ 1938000p -0.3
+ 1938010p 0.9
+ 1940000p 0.9
+ 1940010p -0.3
+ 1942000p -0.3
+ 1942010p 0.9
+ 1944000p 0.9
+ 1944010p -0.3
+ 1946000p -0.3
+ 1946010p 0.9
+ 1948000p 0.9
+ 1948010p -0.3
+ 1950000p -0.3
+ 1950010p 0.9
+ 1952000p 0.9
+ 1952010p -0.3
+ 1954000p -0.3
+ 1954010p 0.9
+ 1956000p 0.9
+ 1956010p -0.3
+ 1958000p -0.3
+ 1958010p 0.9
+ 1960000p 0.9
+ 1960010p -0.3
+ 1962000p -0.3
+ 1962010p 0.9
+ 1964000p 0.9
+ 1964010p -0.3
+ 1966000p -0.3
+ 1966010p 0.9
+ 1968000p 0.9
+ 1968010p -0.3
+ 1970000p -0.3
+ 1970010p 0.9
+ 1972000p 0.9
+ 1972010p -0.3
+ 1974000p -0.3
+ 1974010p 0.9
+ 1976000p 0.9
+ 1976010p -0.3
+ 1978000p -0.3
+ 1978010p 0.9
+ 1980000p 0.9
+ 1980010p -0.3
+ 1982000p -0.3
+ 1982010p 0.9
+ 1984000p 0.9
+ 1984010p -0.3
+ 1986000p -0.3
+ 1986010p 0.9
+ 1988000p 0.9
+ 1988010p -0.3
+ 1990000p -0.3
+ 1990010p 0.9
+ 1992000p 0.9
+ 1992010p -0.3
+ 1994000p -0.3
+ 1994010p 0.9
+ 1996000p 0.9
+ 1996010p -0.3
+ 1998000p -0.3
+ 1998010p 0.9
+ 2000000p 0.9
+ 2000010p -0.3
+ 2002000p -0.3
+ 2002010p 0.9
+ 2004000p 0.9
+ 2004010p -0.3
+ 2006000p -0.3
+ 2006010p 0.9
+ 2008000p 0.9
+ 2008010p -0.3
+ 2010000p -0.3
+ 2010010p 0.9
+ 2012000p 0.9
+ 2012010p -0.3
+ 2014000p -0.3
+ 2014010p 0.9
+ 2016000p 0.9
+ 2016010p -0.3
+ 2018000p -0.3
+ 2018010p 0.9
+ 2020000p 0.9
+ 2020010p -0.3
+ 2022000p -0.3
+ 2022010p 0.9
+ 2024000p 0.9
+ 2024010p -0.3
+ 2026000p -0.3
+ 2026010p 0.9
+ 2028000p 0.9
+ 2028010p -0.3
+ 2030000p -0.3
+ 2030010p 0.9
+ 2032000p 0.9
+ 2032010p -0.3
+ 2034000p -0.3
+ 2034010p 0.9
+ 2036000p 0.9
+ 2036010p -0.3
+ 2038000p -0.3
+ 2038010p 0.9
+ 2040000p 0.9
+ 2040010p -0.3
+ 2042000p -0.3
+ 2042010p 0.9
+ 2044000p 0.9
+ 2044010p -0.3
+ 2046000p -0.3
+ 2046010p 0.9
+ 2048000p 0.9
+ 2048010p -0.3
+ \]
V_data_19 (Data\\<19\\> gnd!) vsource type=pwl wave=\[
+ 0    0.9
+ 2000p 0.9
+ 2010p -0.3
+ 4000p -0.3
+ 4010p 0.9
+ 6000p 0.9
+ 6010p -0.3
+ 8000p -0.3
+ 8010p 0.9
+ 10000p 0.9
+ 10010p -0.3
+ 12000p -0.3
+ 12010p 0.9
+ 14000p 0.9
+ 14010p -0.3
+ 16000p -0.3
+ 16010p 0.9
+ 18000p 0.9
+ 18010p -0.3
+ 20000p -0.3
+ 20010p 0.9
+ 22000p 0.9
+ 22010p -0.3
+ 24000p -0.3
+ 24010p 0.9
+ 26000p 0.9
+ 26010p -0.3
+ 28000p -0.3
+ 28010p 0.9
+ 30000p 0.9
+ 30010p -0.3
+ 32000p -0.3
+ 32010p 0.9
+ 34000p 0.9
+ 34010p -0.3
+ 36000p -0.3
+ 36010p 0.9
+ 38000p 0.9
+ 38010p -0.3
+ 40000p -0.3
+ 40010p 0.9
+ 42000p 0.9
+ 42010p -0.3
+ 44000p -0.3
+ 44010p 0.9
+ 46000p 0.9
+ 46010p -0.3
+ 48000p -0.3
+ 48010p 0.9
+ 50000p 0.9
+ 50010p -0.3
+ 52000p -0.3
+ 52010p 0.9
+ 54000p 0.9
+ 54010p -0.3
+ 56000p -0.3
+ 56010p 0.9
+ 58000p 0.9
+ 58010p -0.3
+ 60000p -0.3
+ 60010p 0.9
+ 62000p 0.9
+ 62010p -0.3
+ 64000p -0.3
+ 64010p 0.9
+ 66000p 0.9
+ 66010p -0.3
+ 68000p -0.3
+ 68010p 0.9
+ 70000p 0.9
+ 70010p -0.3
+ 72000p -0.3
+ 72010p 0.9
+ 74000p 0.9
+ 74010p -0.3
+ 76000p -0.3
+ 76010p 0.9
+ 78000p 0.9
+ 78010p -0.3
+ 80000p -0.3
+ 80010p 0.9
+ 82000p 0.9
+ 82010p -0.3
+ 84000p -0.3
+ 84010p 0.9
+ 86000p 0.9
+ 86010p -0.3
+ 88000p -0.3
+ 88010p 0.9
+ 90000p 0.9
+ 90010p -0.3
+ 92000p -0.3
+ 92010p 0.9
+ 94000p 0.9
+ 94010p -0.3
+ 96000p -0.3
+ 96010p 0.9
+ 98000p 0.9
+ 98010p -0.3
+ 100000p -0.3
+ 100010p 0.9
+ 102000p 0.9
+ 102010p -0.3
+ 104000p -0.3
+ 104010p 0.9
+ 106000p 0.9
+ 106010p -0.3
+ 108000p -0.3
+ 108010p 0.9
+ 110000p 0.9
+ 110010p -0.3
+ 112000p -0.3
+ 112010p 0.9
+ 114000p 0.9
+ 114010p -0.3
+ 116000p -0.3
+ 116010p 0.9
+ 118000p 0.9
+ 118010p -0.3
+ 120000p -0.3
+ 120010p 0.9
+ 122000p 0.9
+ 122010p -0.3
+ 124000p -0.3
+ 124010p 0.9
+ 126000p 0.9
+ 126010p -0.3
+ 128000p -0.3
+ 128010p 0.9
+ 130000p 0.9
+ 130010p -0.3
+ 132000p -0.3
+ 132010p 0.9
+ 134000p 0.9
+ 134010p -0.3
+ 136000p -0.3
+ 136010p 0.9
+ 138000p 0.9
+ 138010p -0.3
+ 140000p -0.3
+ 140010p 0.9
+ 142000p 0.9
+ 142010p -0.3
+ 144000p -0.3
+ 144010p 0.9
+ 146000p 0.9
+ 146010p -0.3
+ 148000p -0.3
+ 148010p 0.9
+ 150000p 0.9
+ 150010p -0.3
+ 152000p -0.3
+ 152010p 0.9
+ 154000p 0.9
+ 154010p -0.3
+ 156000p -0.3
+ 156010p 0.9
+ 158000p 0.9
+ 158010p -0.3
+ 160000p -0.3
+ 160010p 0.9
+ 162000p 0.9
+ 162010p -0.3
+ 164000p -0.3
+ 164010p 0.9
+ 166000p 0.9
+ 166010p -0.3
+ 168000p -0.3
+ 168010p 0.9
+ 170000p 0.9
+ 170010p -0.3
+ 172000p -0.3
+ 172010p 0.9
+ 174000p 0.9
+ 174010p -0.3
+ 176000p -0.3
+ 176010p 0.9
+ 178000p 0.9
+ 178010p -0.3
+ 180000p -0.3
+ 180010p 0.9
+ 182000p 0.9
+ 182010p -0.3
+ 184000p -0.3
+ 184010p 0.9
+ 186000p 0.9
+ 186010p -0.3
+ 188000p -0.3
+ 188010p 0.9
+ 190000p 0.9
+ 190010p -0.3
+ 192000p -0.3
+ 192010p 0.9
+ 194000p 0.9
+ 194010p -0.3
+ 196000p -0.3
+ 196010p 0.9
+ 198000p 0.9
+ 198010p -0.3
+ 200000p -0.3
+ 200010p 0.9
+ 202000p 0.9
+ 202010p -0.3
+ 204000p -0.3
+ 204010p 0.9
+ 206000p 0.9
+ 206010p -0.3
+ 208000p -0.3
+ 208010p 0.9
+ 210000p 0.9
+ 210010p -0.3
+ 212000p -0.3
+ 212010p 0.9
+ 214000p 0.9
+ 214010p -0.3
+ 216000p -0.3
+ 216010p 0.9
+ 218000p 0.9
+ 218010p -0.3
+ 220000p -0.3
+ 220010p 0.9
+ 222000p 0.9
+ 222010p -0.3
+ 224000p -0.3
+ 224010p 0.9
+ 226000p 0.9
+ 226010p -0.3
+ 228000p -0.3
+ 228010p 0.9
+ 230000p 0.9
+ 230010p -0.3
+ 232000p -0.3
+ 232010p 0.9
+ 234000p 0.9
+ 234010p -0.3
+ 236000p -0.3
+ 236010p 0.9
+ 238000p 0.9
+ 238010p -0.3
+ 240000p -0.3
+ 240010p 0.9
+ 242000p 0.9
+ 242010p -0.3
+ 244000p -0.3
+ 244010p 0.9
+ 246000p 0.9
+ 246010p -0.3
+ 248000p -0.3
+ 248010p 0.9
+ 250000p 0.9
+ 250010p -0.3
+ 252000p -0.3
+ 252010p 0.9
+ 254000p 0.9
+ 254010p -0.3
+ 256000p -0.3
+ 256010p 0.9
+ 258000p 0.9
+ 258010p -0.3
+ 260000p -0.3
+ 260010p 0.9
+ 262000p 0.9
+ 262010p -0.3
+ 264000p -0.3
+ 264010p 0.9
+ 266000p 0.9
+ 266010p -0.3
+ 268000p -0.3
+ 268010p 0.9
+ 270000p 0.9
+ 270010p -0.3
+ 272000p -0.3
+ 272010p 0.9
+ 274000p 0.9
+ 274010p -0.3
+ 276000p -0.3
+ 276010p 0.9
+ 278000p 0.9
+ 278010p -0.3
+ 280000p -0.3
+ 280010p 0.9
+ 282000p 0.9
+ 282010p -0.3
+ 284000p -0.3
+ 284010p 0.9
+ 286000p 0.9
+ 286010p -0.3
+ 288000p -0.3
+ 288010p 0.9
+ 290000p 0.9
+ 290010p -0.3
+ 292000p -0.3
+ 292010p 0.9
+ 294000p 0.9
+ 294010p -0.3
+ 296000p -0.3
+ 296010p 0.9
+ 298000p 0.9
+ 298010p -0.3
+ 300000p -0.3
+ 300010p 0.9
+ 302000p 0.9
+ 302010p -0.3
+ 304000p -0.3
+ 304010p 0.9
+ 306000p 0.9
+ 306010p -0.3
+ 308000p -0.3
+ 308010p 0.9
+ 310000p 0.9
+ 310010p -0.3
+ 312000p -0.3
+ 312010p 0.9
+ 314000p 0.9
+ 314010p -0.3
+ 316000p -0.3
+ 316010p 0.9
+ 318000p 0.9
+ 318010p -0.3
+ 320000p -0.3
+ 320010p 0.9
+ 322000p 0.9
+ 322010p -0.3
+ 324000p -0.3
+ 324010p 0.9
+ 326000p 0.9
+ 326010p -0.3
+ 328000p -0.3
+ 328010p 0.9
+ 330000p 0.9
+ 330010p -0.3
+ 332000p -0.3
+ 332010p 0.9
+ 334000p 0.9
+ 334010p -0.3
+ 336000p -0.3
+ 336010p 0.9
+ 338000p 0.9
+ 338010p -0.3
+ 340000p -0.3
+ 340010p 0.9
+ 342000p 0.9
+ 342010p -0.3
+ 344000p -0.3
+ 344010p 0.9
+ 346000p 0.9
+ 346010p -0.3
+ 348000p -0.3
+ 348010p 0.9
+ 350000p 0.9
+ 350010p -0.3
+ 352000p -0.3
+ 352010p 0.9
+ 354000p 0.9
+ 354010p -0.3
+ 356000p -0.3
+ 356010p 0.9
+ 358000p 0.9
+ 358010p -0.3
+ 360000p -0.3
+ 360010p 0.9
+ 362000p 0.9
+ 362010p -0.3
+ 364000p -0.3
+ 364010p 0.9
+ 366000p 0.9
+ 366010p -0.3
+ 368000p -0.3
+ 368010p 0.9
+ 370000p 0.9
+ 370010p -0.3
+ 372000p -0.3
+ 372010p 0.9
+ 374000p 0.9
+ 374010p -0.3
+ 376000p -0.3
+ 376010p 0.9
+ 378000p 0.9
+ 378010p -0.3
+ 380000p -0.3
+ 380010p 0.9
+ 382000p 0.9
+ 382010p -0.3
+ 384000p -0.3
+ 384010p 0.9
+ 386000p 0.9
+ 386010p -0.3
+ 388000p -0.3
+ 388010p 0.9
+ 390000p 0.9
+ 390010p -0.3
+ 392000p -0.3
+ 392010p 0.9
+ 394000p 0.9
+ 394010p -0.3
+ 396000p -0.3
+ 396010p 0.9
+ 398000p 0.9
+ 398010p -0.3
+ 400000p -0.3
+ 400010p 0.9
+ 402000p 0.9
+ 402010p -0.3
+ 404000p -0.3
+ 404010p 0.9
+ 406000p 0.9
+ 406010p -0.3
+ 408000p -0.3
+ 408010p 0.9
+ 410000p 0.9
+ 410010p -0.3
+ 412000p -0.3
+ 412010p 0.9
+ 414000p 0.9
+ 414010p -0.3
+ 416000p -0.3
+ 416010p 0.9
+ 418000p 0.9
+ 418010p -0.3
+ 420000p -0.3
+ 420010p 0.9
+ 422000p 0.9
+ 422010p -0.3
+ 424000p -0.3
+ 424010p 0.9
+ 426000p 0.9
+ 426010p -0.3
+ 428000p -0.3
+ 428010p 0.9
+ 430000p 0.9
+ 430010p -0.3
+ 432000p -0.3
+ 432010p 0.9
+ 434000p 0.9
+ 434010p -0.3
+ 436000p -0.3
+ 436010p 0.9
+ 438000p 0.9
+ 438010p -0.3
+ 440000p -0.3
+ 440010p 0.9
+ 442000p 0.9
+ 442010p -0.3
+ 444000p -0.3
+ 444010p 0.9
+ 446000p 0.9
+ 446010p -0.3
+ 448000p -0.3
+ 448010p 0.9
+ 450000p 0.9
+ 450010p -0.3
+ 452000p -0.3
+ 452010p 0.9
+ 454000p 0.9
+ 454010p -0.3
+ 456000p -0.3
+ 456010p 0.9
+ 458000p 0.9
+ 458010p -0.3
+ 460000p -0.3
+ 460010p 0.9
+ 462000p 0.9
+ 462010p -0.3
+ 464000p -0.3
+ 464010p 0.9
+ 466000p 0.9
+ 466010p -0.3
+ 468000p -0.3
+ 468010p 0.9
+ 470000p 0.9
+ 470010p -0.3
+ 472000p -0.3
+ 472010p 0.9
+ 474000p 0.9
+ 474010p -0.3
+ 476000p -0.3
+ 476010p 0.9
+ 478000p 0.9
+ 478010p -0.3
+ 480000p -0.3
+ 480010p 0.9
+ 482000p 0.9
+ 482010p -0.3
+ 484000p -0.3
+ 484010p 0.9
+ 486000p 0.9
+ 486010p -0.3
+ 488000p -0.3
+ 488010p 0.9
+ 490000p 0.9
+ 490010p -0.3
+ 492000p -0.3
+ 492010p 0.9
+ 494000p 0.9
+ 494010p -0.3
+ 496000p -0.3
+ 496010p 0.9
+ 498000p 0.9
+ 498010p -0.3
+ 500000p -0.3
+ 500010p 0.9
+ 502000p 0.9
+ 502010p -0.3
+ 504000p -0.3
+ 504010p 0.9
+ 506000p 0.9
+ 506010p -0.3
+ 508000p -0.3
+ 508010p 0.9
+ 510000p 0.9
+ 510010p -0.3
+ 512000p -0.3
+ 512010p 0.9
+ 514000p 0.9
+ 514010p -0.3
+ 516000p -0.3
+ 516010p 0.9
+ 518000p 0.9
+ 518010p -0.3
+ 520000p -0.3
+ 520010p 0.9
+ 522000p 0.9
+ 522010p -0.3
+ 524000p -0.3
+ 524010p 0.9
+ 526000p 0.9
+ 526010p -0.3
+ 528000p -0.3
+ 528010p 0.9
+ 530000p 0.9
+ 530010p -0.3
+ 532000p -0.3
+ 532010p 0.9
+ 534000p 0.9
+ 534010p -0.3
+ 536000p -0.3
+ 536010p 0.9
+ 538000p 0.9
+ 538010p -0.3
+ 540000p -0.3
+ 540010p 0.9
+ 542000p 0.9
+ 542010p -0.3
+ 544000p -0.3
+ 544010p 0.9
+ 546000p 0.9
+ 546010p -0.3
+ 548000p -0.3
+ 548010p 0.9
+ 550000p 0.9
+ 550010p -0.3
+ 552000p -0.3
+ 552010p 0.9
+ 554000p 0.9
+ 554010p -0.3
+ 556000p -0.3
+ 556010p 0.9
+ 558000p 0.9
+ 558010p -0.3
+ 560000p -0.3
+ 560010p 0.9
+ 562000p 0.9
+ 562010p -0.3
+ 564000p -0.3
+ 564010p 0.9
+ 566000p 0.9
+ 566010p -0.3
+ 568000p -0.3
+ 568010p 0.9
+ 570000p 0.9
+ 570010p -0.3
+ 572000p -0.3
+ 572010p 0.9
+ 574000p 0.9
+ 574010p -0.3
+ 576000p -0.3
+ 576010p 0.9
+ 578000p 0.9
+ 578010p -0.3
+ 580000p -0.3
+ 580010p 0.9
+ 582000p 0.9
+ 582010p -0.3
+ 584000p -0.3
+ 584010p 0.9
+ 586000p 0.9
+ 586010p -0.3
+ 588000p -0.3
+ 588010p 0.9
+ 590000p 0.9
+ 590010p -0.3
+ 592000p -0.3
+ 592010p 0.9
+ 594000p 0.9
+ 594010p -0.3
+ 596000p -0.3
+ 596010p 0.9
+ 598000p 0.9
+ 598010p -0.3
+ 600000p -0.3
+ 600010p 0.9
+ 602000p 0.9
+ 602010p -0.3
+ 604000p -0.3
+ 604010p 0.9
+ 606000p 0.9
+ 606010p -0.3
+ 608000p -0.3
+ 608010p 0.9
+ 610000p 0.9
+ 610010p -0.3
+ 612000p -0.3
+ 612010p 0.9
+ 614000p 0.9
+ 614010p -0.3
+ 616000p -0.3
+ 616010p 0.9
+ 618000p 0.9
+ 618010p -0.3
+ 620000p -0.3
+ 620010p 0.9
+ 622000p 0.9
+ 622010p -0.3
+ 624000p -0.3
+ 624010p 0.9
+ 626000p 0.9
+ 626010p -0.3
+ 628000p -0.3
+ 628010p 0.9
+ 630000p 0.9
+ 630010p -0.3
+ 632000p -0.3
+ 632010p 0.9
+ 634000p 0.9
+ 634010p -0.3
+ 636000p -0.3
+ 636010p 0.9
+ 638000p 0.9
+ 638010p -0.3
+ 640000p -0.3
+ 640010p 0.9
+ 642000p 0.9
+ 642010p -0.3
+ 644000p -0.3
+ 644010p 0.9
+ 646000p 0.9
+ 646010p -0.3
+ 648000p -0.3
+ 648010p 0.9
+ 650000p 0.9
+ 650010p -0.3
+ 652000p -0.3
+ 652010p 0.9
+ 654000p 0.9
+ 654010p -0.3
+ 656000p -0.3
+ 656010p 0.9
+ 658000p 0.9
+ 658010p -0.3
+ 660000p -0.3
+ 660010p 0.9
+ 662000p 0.9
+ 662010p -0.3
+ 664000p -0.3
+ 664010p 0.9
+ 666000p 0.9
+ 666010p -0.3
+ 668000p -0.3
+ 668010p 0.9
+ 670000p 0.9
+ 670010p -0.3
+ 672000p -0.3
+ 672010p 0.9
+ 674000p 0.9
+ 674010p -0.3
+ 676000p -0.3
+ 676010p 0.9
+ 678000p 0.9
+ 678010p -0.3
+ 680000p -0.3
+ 680010p 0.9
+ 682000p 0.9
+ 682010p -0.3
+ 684000p -0.3
+ 684010p 0.9
+ 686000p 0.9
+ 686010p -0.3
+ 688000p -0.3
+ 688010p 0.9
+ 690000p 0.9
+ 690010p -0.3
+ 692000p -0.3
+ 692010p 0.9
+ 694000p 0.9
+ 694010p -0.3
+ 696000p -0.3
+ 696010p 0.9
+ 698000p 0.9
+ 698010p -0.3
+ 700000p -0.3
+ 700010p 0.9
+ 702000p 0.9
+ 702010p -0.3
+ 704000p -0.3
+ 704010p 0.9
+ 706000p 0.9
+ 706010p -0.3
+ 708000p -0.3
+ 708010p 0.9
+ 710000p 0.9
+ 710010p -0.3
+ 712000p -0.3
+ 712010p 0.9
+ 714000p 0.9
+ 714010p -0.3
+ 716000p -0.3
+ 716010p 0.9
+ 718000p 0.9
+ 718010p -0.3
+ 720000p -0.3
+ 720010p 0.9
+ 722000p 0.9
+ 722010p -0.3
+ 724000p -0.3
+ 724010p 0.9
+ 726000p 0.9
+ 726010p -0.3
+ 728000p -0.3
+ 728010p 0.9
+ 730000p 0.9
+ 730010p -0.3
+ 732000p -0.3
+ 732010p 0.9
+ 734000p 0.9
+ 734010p -0.3
+ 736000p -0.3
+ 736010p 0.9
+ 738000p 0.9
+ 738010p -0.3
+ 740000p -0.3
+ 740010p 0.9
+ 742000p 0.9
+ 742010p -0.3
+ 744000p -0.3
+ 744010p 0.9
+ 746000p 0.9
+ 746010p -0.3
+ 748000p -0.3
+ 748010p 0.9
+ 750000p 0.9
+ 750010p -0.3
+ 752000p -0.3
+ 752010p 0.9
+ 754000p 0.9
+ 754010p -0.3
+ 756000p -0.3
+ 756010p 0.9
+ 758000p 0.9
+ 758010p -0.3
+ 760000p -0.3
+ 760010p 0.9
+ 762000p 0.9
+ 762010p -0.3
+ 764000p -0.3
+ 764010p 0.9
+ 766000p 0.9
+ 766010p -0.3
+ 768000p -0.3
+ 768010p 0.9
+ 770000p 0.9
+ 770010p -0.3
+ 772000p -0.3
+ 772010p 0.9
+ 774000p 0.9
+ 774010p -0.3
+ 776000p -0.3
+ 776010p 0.9
+ 778000p 0.9
+ 778010p -0.3
+ 780000p -0.3
+ 780010p 0.9
+ 782000p 0.9
+ 782010p -0.3
+ 784000p -0.3
+ 784010p 0.9
+ 786000p 0.9
+ 786010p -0.3
+ 788000p -0.3
+ 788010p 0.9
+ 790000p 0.9
+ 790010p -0.3
+ 792000p -0.3
+ 792010p 0.9
+ 794000p 0.9
+ 794010p -0.3
+ 796000p -0.3
+ 796010p 0.9
+ 798000p 0.9
+ 798010p -0.3
+ 800000p -0.3
+ 800010p 0.9
+ 802000p 0.9
+ 802010p -0.3
+ 804000p -0.3
+ 804010p 0.9
+ 806000p 0.9
+ 806010p -0.3
+ 808000p -0.3
+ 808010p 0.9
+ 810000p 0.9
+ 810010p -0.3
+ 812000p -0.3
+ 812010p 0.9
+ 814000p 0.9
+ 814010p -0.3
+ 816000p -0.3
+ 816010p 0.9
+ 818000p 0.9
+ 818010p -0.3
+ 820000p -0.3
+ 820010p 0.9
+ 822000p 0.9
+ 822010p -0.3
+ 824000p -0.3
+ 824010p 0.9
+ 826000p 0.9
+ 826010p -0.3
+ 828000p -0.3
+ 828010p 0.9
+ 830000p 0.9
+ 830010p -0.3
+ 832000p -0.3
+ 832010p 0.9
+ 834000p 0.9
+ 834010p -0.3
+ 836000p -0.3
+ 836010p 0.9
+ 838000p 0.9
+ 838010p -0.3
+ 840000p -0.3
+ 840010p 0.9
+ 842000p 0.9
+ 842010p -0.3
+ 844000p -0.3
+ 844010p 0.9
+ 846000p 0.9
+ 846010p -0.3
+ 848000p -0.3
+ 848010p 0.9
+ 850000p 0.9
+ 850010p -0.3
+ 852000p -0.3
+ 852010p 0.9
+ 854000p 0.9
+ 854010p -0.3
+ 856000p -0.3
+ 856010p 0.9
+ 858000p 0.9
+ 858010p -0.3
+ 860000p -0.3
+ 860010p 0.9
+ 862000p 0.9
+ 862010p -0.3
+ 864000p -0.3
+ 864010p 0.9
+ 866000p 0.9
+ 866010p -0.3
+ 868000p -0.3
+ 868010p 0.9
+ 870000p 0.9
+ 870010p -0.3
+ 872000p -0.3
+ 872010p 0.9
+ 874000p 0.9
+ 874010p -0.3
+ 876000p -0.3
+ 876010p 0.9
+ 878000p 0.9
+ 878010p -0.3
+ 880000p -0.3
+ 880010p 0.9
+ 882000p 0.9
+ 882010p -0.3
+ 884000p -0.3
+ 884010p 0.9
+ 886000p 0.9
+ 886010p -0.3
+ 888000p -0.3
+ 888010p 0.9
+ 890000p 0.9
+ 890010p -0.3
+ 892000p -0.3
+ 892010p 0.9
+ 894000p 0.9
+ 894010p -0.3
+ 896000p -0.3
+ 896010p 0.9
+ 898000p 0.9
+ 898010p -0.3
+ 900000p -0.3
+ 900010p 0.9
+ 902000p 0.9
+ 902010p -0.3
+ 904000p -0.3
+ 904010p 0.9
+ 906000p 0.9
+ 906010p -0.3
+ 908000p -0.3
+ 908010p 0.9
+ 910000p 0.9
+ 910010p -0.3
+ 912000p -0.3
+ 912010p 0.9
+ 914000p 0.9
+ 914010p -0.3
+ 916000p -0.3
+ 916010p 0.9
+ 918000p 0.9
+ 918010p -0.3
+ 920000p -0.3
+ 920010p 0.9
+ 922000p 0.9
+ 922010p -0.3
+ 924000p -0.3
+ 924010p 0.9
+ 926000p 0.9
+ 926010p -0.3
+ 928000p -0.3
+ 928010p 0.9
+ 930000p 0.9
+ 930010p -0.3
+ 932000p -0.3
+ 932010p 0.9
+ 934000p 0.9
+ 934010p -0.3
+ 936000p -0.3
+ 936010p 0.9
+ 938000p 0.9
+ 938010p -0.3
+ 940000p -0.3
+ 940010p 0.9
+ 942000p 0.9
+ 942010p -0.3
+ 944000p -0.3
+ 944010p 0.9
+ 946000p 0.9
+ 946010p -0.3
+ 948000p -0.3
+ 948010p 0.9
+ 950000p 0.9
+ 950010p -0.3
+ 952000p -0.3
+ 952010p 0.9
+ 954000p 0.9
+ 954010p -0.3
+ 956000p -0.3
+ 956010p 0.9
+ 958000p 0.9
+ 958010p -0.3
+ 960000p -0.3
+ 960010p 0.9
+ 962000p 0.9
+ 962010p -0.3
+ 964000p -0.3
+ 964010p 0.9
+ 966000p 0.9
+ 966010p -0.3
+ 968000p -0.3
+ 968010p 0.9
+ 970000p 0.9
+ 970010p -0.3
+ 972000p -0.3
+ 972010p 0.9
+ 974000p 0.9
+ 974010p -0.3
+ 976000p -0.3
+ 976010p 0.9
+ 978000p 0.9
+ 978010p -0.3
+ 980000p -0.3
+ 980010p 0.9
+ 982000p 0.9
+ 982010p -0.3
+ 984000p -0.3
+ 984010p 0.9
+ 986000p 0.9
+ 986010p -0.3
+ 988000p -0.3
+ 988010p 0.9
+ 990000p 0.9
+ 990010p -0.3
+ 992000p -0.3
+ 992010p 0.9
+ 994000p 0.9
+ 994010p -0.3
+ 996000p -0.3
+ 996010p 0.9
+ 998000p 0.9
+ 998010p -0.3
+ 1000000p -0.3
+ 1000010p 0.9
+ 1002000p 0.9
+ 1002010p -0.3
+ 1004000p -0.3
+ 1004010p 0.9
+ 1006000p 0.9
+ 1006010p -0.3
+ 1008000p -0.3
+ 1008010p 0.9
+ 1010000p 0.9
+ 1010010p -0.3
+ 1012000p -0.3
+ 1012010p 0.9
+ 1014000p 0.9
+ 1014010p -0.3
+ 1016000p -0.3
+ 1016010p 0.9
+ 1018000p 0.9
+ 1018010p -0.3
+ 1020000p -0.3
+ 1020010p 0.9
+ 1022000p 0.9
+ 1022010p -0.3
+ 1024000p -0.3
+ 1024010p 0.9
+ 1026000p 0.9
+ 1026010p -0.3
+ 1028000p -0.3
+ 1028010p 0.9
+ 1030000p 0.9
+ 1030010p -0.3
+ 1032000p -0.3
+ 1032010p 0.9
+ 1034000p 0.9
+ 1034010p -0.3
+ 1036000p -0.3
+ 1036010p 0.9
+ 1038000p 0.9
+ 1038010p -0.3
+ 1040000p -0.3
+ 1040010p 0.9
+ 1042000p 0.9
+ 1042010p -0.3
+ 1044000p -0.3
+ 1044010p 0.9
+ 1046000p 0.9
+ 1046010p -0.3
+ 1048000p -0.3
+ 1048010p 0.9
+ 1050000p 0.9
+ 1050010p -0.3
+ 1052000p -0.3
+ 1052010p 0.9
+ 1054000p 0.9
+ 1054010p -0.3
+ 1056000p -0.3
+ 1056010p 0.9
+ 1058000p 0.9
+ 1058010p -0.3
+ 1060000p -0.3
+ 1060010p 0.9
+ 1062000p 0.9
+ 1062010p -0.3
+ 1064000p -0.3
+ 1064010p 0.9
+ 1066000p 0.9
+ 1066010p -0.3
+ 1068000p -0.3
+ 1068010p 0.9
+ 1070000p 0.9
+ 1070010p -0.3
+ 1072000p -0.3
+ 1072010p 0.9
+ 1074000p 0.9
+ 1074010p -0.3
+ 1076000p -0.3
+ 1076010p 0.9
+ 1078000p 0.9
+ 1078010p -0.3
+ 1080000p -0.3
+ 1080010p 0.9
+ 1082000p 0.9
+ 1082010p -0.3
+ 1084000p -0.3
+ 1084010p 0.9
+ 1086000p 0.9
+ 1086010p -0.3
+ 1088000p -0.3
+ 1088010p 0.9
+ 1090000p 0.9
+ 1090010p -0.3
+ 1092000p -0.3
+ 1092010p 0.9
+ 1094000p 0.9
+ 1094010p -0.3
+ 1096000p -0.3
+ 1096010p 0.9
+ 1098000p 0.9
+ 1098010p -0.3
+ 1100000p -0.3
+ 1100010p 0.9
+ 1102000p 0.9
+ 1102010p -0.3
+ 1104000p -0.3
+ 1104010p 0.9
+ 1106000p 0.9
+ 1106010p -0.3
+ 1108000p -0.3
+ 1108010p 0.9
+ 1110000p 0.9
+ 1110010p -0.3
+ 1112000p -0.3
+ 1112010p 0.9
+ 1114000p 0.9
+ 1114010p -0.3
+ 1116000p -0.3
+ 1116010p 0.9
+ 1118000p 0.9
+ 1118010p -0.3
+ 1120000p -0.3
+ 1120010p 0.9
+ 1122000p 0.9
+ 1122010p -0.3
+ 1124000p -0.3
+ 1124010p 0.9
+ 1126000p 0.9
+ 1126010p -0.3
+ 1128000p -0.3
+ 1128010p 0.9
+ 1130000p 0.9
+ 1130010p -0.3
+ 1132000p -0.3
+ 1132010p 0.9
+ 1134000p 0.9
+ 1134010p -0.3
+ 1136000p -0.3
+ 1136010p 0.9
+ 1138000p 0.9
+ 1138010p -0.3
+ 1140000p -0.3
+ 1140010p 0.9
+ 1142000p 0.9
+ 1142010p -0.3
+ 1144000p -0.3
+ 1144010p 0.9
+ 1146000p 0.9
+ 1146010p -0.3
+ 1148000p -0.3
+ 1148010p 0.9
+ 1150000p 0.9
+ 1150010p -0.3
+ 1152000p -0.3
+ 1152010p 0.9
+ 1154000p 0.9
+ 1154010p -0.3
+ 1156000p -0.3
+ 1156010p 0.9
+ 1158000p 0.9
+ 1158010p -0.3
+ 1160000p -0.3
+ 1160010p 0.9
+ 1162000p 0.9
+ 1162010p -0.3
+ 1164000p -0.3
+ 1164010p 0.9
+ 1166000p 0.9
+ 1166010p -0.3
+ 1168000p -0.3
+ 1168010p 0.9
+ 1170000p 0.9
+ 1170010p -0.3
+ 1172000p -0.3
+ 1172010p 0.9
+ 1174000p 0.9
+ 1174010p -0.3
+ 1176000p -0.3
+ 1176010p 0.9
+ 1178000p 0.9
+ 1178010p -0.3
+ 1180000p -0.3
+ 1180010p 0.9
+ 1182000p 0.9
+ 1182010p -0.3
+ 1184000p -0.3
+ 1184010p 0.9
+ 1186000p 0.9
+ 1186010p -0.3
+ 1188000p -0.3
+ 1188010p 0.9
+ 1190000p 0.9
+ 1190010p -0.3
+ 1192000p -0.3
+ 1192010p 0.9
+ 1194000p 0.9
+ 1194010p -0.3
+ 1196000p -0.3
+ 1196010p 0.9
+ 1198000p 0.9
+ 1198010p -0.3
+ 1200000p -0.3
+ 1200010p 0.9
+ 1202000p 0.9
+ 1202010p -0.3
+ 1204000p -0.3
+ 1204010p 0.9
+ 1206000p 0.9
+ 1206010p -0.3
+ 1208000p -0.3
+ 1208010p 0.9
+ 1210000p 0.9
+ 1210010p -0.3
+ 1212000p -0.3
+ 1212010p 0.9
+ 1214000p 0.9
+ 1214010p -0.3
+ 1216000p -0.3
+ 1216010p 0.9
+ 1218000p 0.9
+ 1218010p -0.3
+ 1220000p -0.3
+ 1220010p 0.9
+ 1222000p 0.9
+ 1222010p -0.3
+ 1224000p -0.3
+ 1224010p 0.9
+ 1226000p 0.9
+ 1226010p -0.3
+ 1228000p -0.3
+ 1228010p 0.9
+ 1230000p 0.9
+ 1230010p -0.3
+ 1232000p -0.3
+ 1232010p 0.9
+ 1234000p 0.9
+ 1234010p -0.3
+ 1236000p -0.3
+ 1236010p 0.9
+ 1238000p 0.9
+ 1238010p -0.3
+ 1240000p -0.3
+ 1240010p 0.9
+ 1242000p 0.9
+ 1242010p -0.3
+ 1244000p -0.3
+ 1244010p 0.9
+ 1246000p 0.9
+ 1246010p -0.3
+ 1248000p -0.3
+ 1248010p 0.9
+ 1250000p 0.9
+ 1250010p -0.3
+ 1252000p -0.3
+ 1252010p 0.9
+ 1254000p 0.9
+ 1254010p -0.3
+ 1256000p -0.3
+ 1256010p 0.9
+ 1258000p 0.9
+ 1258010p -0.3
+ 1260000p -0.3
+ 1260010p 0.9
+ 1262000p 0.9
+ 1262010p -0.3
+ 1264000p -0.3
+ 1264010p 0.9
+ 1266000p 0.9
+ 1266010p -0.3
+ 1268000p -0.3
+ 1268010p 0.9
+ 1270000p 0.9
+ 1270010p -0.3
+ 1272000p -0.3
+ 1272010p 0.9
+ 1274000p 0.9
+ 1274010p -0.3
+ 1276000p -0.3
+ 1276010p 0.9
+ 1278000p 0.9
+ 1278010p -0.3
+ 1280000p -0.3
+ 1280010p 0.9
+ 1282000p 0.9
+ 1282010p -0.3
+ 1284000p -0.3
+ 1284010p 0.9
+ 1286000p 0.9
+ 1286010p -0.3
+ 1288000p -0.3
+ 1288010p 0.9
+ 1290000p 0.9
+ 1290010p -0.3
+ 1292000p -0.3
+ 1292010p 0.9
+ 1294000p 0.9
+ 1294010p -0.3
+ 1296000p -0.3
+ 1296010p 0.9
+ 1298000p 0.9
+ 1298010p -0.3
+ 1300000p -0.3
+ 1300010p 0.9
+ 1302000p 0.9
+ 1302010p -0.3
+ 1304000p -0.3
+ 1304010p 0.9
+ 1306000p 0.9
+ 1306010p -0.3
+ 1308000p -0.3
+ 1308010p 0.9
+ 1310000p 0.9
+ 1310010p -0.3
+ 1312000p -0.3
+ 1312010p 0.9
+ 1314000p 0.9
+ 1314010p -0.3
+ 1316000p -0.3
+ 1316010p 0.9
+ 1318000p 0.9
+ 1318010p -0.3
+ 1320000p -0.3
+ 1320010p 0.9
+ 1322000p 0.9
+ 1322010p -0.3
+ 1324000p -0.3
+ 1324010p 0.9
+ 1326000p 0.9
+ 1326010p -0.3
+ 1328000p -0.3
+ 1328010p 0.9
+ 1330000p 0.9
+ 1330010p -0.3
+ 1332000p -0.3
+ 1332010p 0.9
+ 1334000p 0.9
+ 1334010p -0.3
+ 1336000p -0.3
+ 1336010p 0.9
+ 1338000p 0.9
+ 1338010p -0.3
+ 1340000p -0.3
+ 1340010p 0.9
+ 1342000p 0.9
+ 1342010p -0.3
+ 1344000p -0.3
+ 1344010p 0.9
+ 1346000p 0.9
+ 1346010p -0.3
+ 1348000p -0.3
+ 1348010p 0.9
+ 1350000p 0.9
+ 1350010p -0.3
+ 1352000p -0.3
+ 1352010p 0.9
+ 1354000p 0.9
+ 1354010p -0.3
+ 1356000p -0.3
+ 1356010p 0.9
+ 1358000p 0.9
+ 1358010p -0.3
+ 1360000p -0.3
+ 1360010p 0.9
+ 1362000p 0.9
+ 1362010p -0.3
+ 1364000p -0.3
+ 1364010p 0.9
+ 1366000p 0.9
+ 1366010p -0.3
+ 1368000p -0.3
+ 1368010p 0.9
+ 1370000p 0.9
+ 1370010p -0.3
+ 1372000p -0.3
+ 1372010p 0.9
+ 1374000p 0.9
+ 1374010p -0.3
+ 1376000p -0.3
+ 1376010p 0.9
+ 1378000p 0.9
+ 1378010p -0.3
+ 1380000p -0.3
+ 1380010p 0.9
+ 1382000p 0.9
+ 1382010p -0.3
+ 1384000p -0.3
+ 1384010p 0.9
+ 1386000p 0.9
+ 1386010p -0.3
+ 1388000p -0.3
+ 1388010p 0.9
+ 1390000p 0.9
+ 1390010p -0.3
+ 1392000p -0.3
+ 1392010p 0.9
+ 1394000p 0.9
+ 1394010p -0.3
+ 1396000p -0.3
+ 1396010p 0.9
+ 1398000p 0.9
+ 1398010p -0.3
+ 1400000p -0.3
+ 1400010p 0.9
+ 1402000p 0.9
+ 1402010p -0.3
+ 1404000p -0.3
+ 1404010p 0.9
+ 1406000p 0.9
+ 1406010p -0.3
+ 1408000p -0.3
+ 1408010p 0.9
+ 1410000p 0.9
+ 1410010p -0.3
+ 1412000p -0.3
+ 1412010p 0.9
+ 1414000p 0.9
+ 1414010p -0.3
+ 1416000p -0.3
+ 1416010p 0.9
+ 1418000p 0.9
+ 1418010p -0.3
+ 1420000p -0.3
+ 1420010p 0.9
+ 1422000p 0.9
+ 1422010p -0.3
+ 1424000p -0.3
+ 1424010p 0.9
+ 1426000p 0.9
+ 1426010p -0.3
+ 1428000p -0.3
+ 1428010p 0.9
+ 1430000p 0.9
+ 1430010p -0.3
+ 1432000p -0.3
+ 1432010p 0.9
+ 1434000p 0.9
+ 1434010p -0.3
+ 1436000p -0.3
+ 1436010p 0.9
+ 1438000p 0.9
+ 1438010p -0.3
+ 1440000p -0.3
+ 1440010p 0.9
+ 1442000p 0.9
+ 1442010p -0.3
+ 1444000p -0.3
+ 1444010p 0.9
+ 1446000p 0.9
+ 1446010p -0.3
+ 1448000p -0.3
+ 1448010p 0.9
+ 1450000p 0.9
+ 1450010p -0.3
+ 1452000p -0.3
+ 1452010p 0.9
+ 1454000p 0.9
+ 1454010p -0.3
+ 1456000p -0.3
+ 1456010p 0.9
+ 1458000p 0.9
+ 1458010p -0.3
+ 1460000p -0.3
+ 1460010p 0.9
+ 1462000p 0.9
+ 1462010p -0.3
+ 1464000p -0.3
+ 1464010p 0.9
+ 1466000p 0.9
+ 1466010p -0.3
+ 1468000p -0.3
+ 1468010p 0.9
+ 1470000p 0.9
+ 1470010p -0.3
+ 1472000p -0.3
+ 1472010p 0.9
+ 1474000p 0.9
+ 1474010p -0.3
+ 1476000p -0.3
+ 1476010p 0.9
+ 1478000p 0.9
+ 1478010p -0.3
+ 1480000p -0.3
+ 1480010p 0.9
+ 1482000p 0.9
+ 1482010p -0.3
+ 1484000p -0.3
+ 1484010p 0.9
+ 1486000p 0.9
+ 1486010p -0.3
+ 1488000p -0.3
+ 1488010p 0.9
+ 1490000p 0.9
+ 1490010p -0.3
+ 1492000p -0.3
+ 1492010p 0.9
+ 1494000p 0.9
+ 1494010p -0.3
+ 1496000p -0.3
+ 1496010p 0.9
+ 1498000p 0.9
+ 1498010p -0.3
+ 1500000p -0.3
+ 1500010p 0.9
+ 1502000p 0.9
+ 1502010p -0.3
+ 1504000p -0.3
+ 1504010p 0.9
+ 1506000p 0.9
+ 1506010p -0.3
+ 1508000p -0.3
+ 1508010p 0.9
+ 1510000p 0.9
+ 1510010p -0.3
+ 1512000p -0.3
+ 1512010p 0.9
+ 1514000p 0.9
+ 1514010p -0.3
+ 1516000p -0.3
+ 1516010p 0.9
+ 1518000p 0.9
+ 1518010p -0.3
+ 1520000p -0.3
+ 1520010p 0.9
+ 1522000p 0.9
+ 1522010p -0.3
+ 1524000p -0.3
+ 1524010p 0.9
+ 1526000p 0.9
+ 1526010p -0.3
+ 1528000p -0.3
+ 1528010p 0.9
+ 1530000p 0.9
+ 1530010p -0.3
+ 1532000p -0.3
+ 1532010p 0.9
+ 1534000p 0.9
+ 1534010p -0.3
+ 1536000p -0.3
+ 1536010p 0.9
+ 1538000p 0.9
+ 1538010p -0.3
+ 1540000p -0.3
+ 1540010p 0.9
+ 1542000p 0.9
+ 1542010p -0.3
+ 1544000p -0.3
+ 1544010p 0.9
+ 1546000p 0.9
+ 1546010p -0.3
+ 1548000p -0.3
+ 1548010p 0.9
+ 1550000p 0.9
+ 1550010p -0.3
+ 1552000p -0.3
+ 1552010p 0.9
+ 1554000p 0.9
+ 1554010p -0.3
+ 1556000p -0.3
+ 1556010p 0.9
+ 1558000p 0.9
+ 1558010p -0.3
+ 1560000p -0.3
+ 1560010p 0.9
+ 1562000p 0.9
+ 1562010p -0.3
+ 1564000p -0.3
+ 1564010p 0.9
+ 1566000p 0.9
+ 1566010p -0.3
+ 1568000p -0.3
+ 1568010p 0.9
+ 1570000p 0.9
+ 1570010p -0.3
+ 1572000p -0.3
+ 1572010p 0.9
+ 1574000p 0.9
+ 1574010p -0.3
+ 1576000p -0.3
+ 1576010p 0.9
+ 1578000p 0.9
+ 1578010p -0.3
+ 1580000p -0.3
+ 1580010p 0.9
+ 1582000p 0.9
+ 1582010p -0.3
+ 1584000p -0.3
+ 1584010p 0.9
+ 1586000p 0.9
+ 1586010p -0.3
+ 1588000p -0.3
+ 1588010p 0.9
+ 1590000p 0.9
+ 1590010p -0.3
+ 1592000p -0.3
+ 1592010p 0.9
+ 1594000p 0.9
+ 1594010p -0.3
+ 1596000p -0.3
+ 1596010p 0.9
+ 1598000p 0.9
+ 1598010p -0.3
+ 1600000p -0.3
+ 1600010p 0.9
+ 1602000p 0.9
+ 1602010p -0.3
+ 1604000p -0.3
+ 1604010p 0.9
+ 1606000p 0.9
+ 1606010p -0.3
+ 1608000p -0.3
+ 1608010p 0.9
+ 1610000p 0.9
+ 1610010p -0.3
+ 1612000p -0.3
+ 1612010p 0.9
+ 1614000p 0.9
+ 1614010p -0.3
+ 1616000p -0.3
+ 1616010p 0.9
+ 1618000p 0.9
+ 1618010p -0.3
+ 1620000p -0.3
+ 1620010p 0.9
+ 1622000p 0.9
+ 1622010p -0.3
+ 1624000p -0.3
+ 1624010p 0.9
+ 1626000p 0.9
+ 1626010p -0.3
+ 1628000p -0.3
+ 1628010p 0.9
+ 1630000p 0.9
+ 1630010p -0.3
+ 1632000p -0.3
+ 1632010p 0.9
+ 1634000p 0.9
+ 1634010p -0.3
+ 1636000p -0.3
+ 1636010p 0.9
+ 1638000p 0.9
+ 1638010p -0.3
+ 1640000p -0.3
+ 1640010p 0.9
+ 1642000p 0.9
+ 1642010p -0.3
+ 1644000p -0.3
+ 1644010p 0.9
+ 1646000p 0.9
+ 1646010p -0.3
+ 1648000p -0.3
+ 1648010p 0.9
+ 1650000p 0.9
+ 1650010p -0.3
+ 1652000p -0.3
+ 1652010p 0.9
+ 1654000p 0.9
+ 1654010p -0.3
+ 1656000p -0.3
+ 1656010p 0.9
+ 1658000p 0.9
+ 1658010p -0.3
+ 1660000p -0.3
+ 1660010p 0.9
+ 1662000p 0.9
+ 1662010p -0.3
+ 1664000p -0.3
+ 1664010p 0.9
+ 1666000p 0.9
+ 1666010p -0.3
+ 1668000p -0.3
+ 1668010p 0.9
+ 1670000p 0.9
+ 1670010p -0.3
+ 1672000p -0.3
+ 1672010p 0.9
+ 1674000p 0.9
+ 1674010p -0.3
+ 1676000p -0.3
+ 1676010p 0.9
+ 1678000p 0.9
+ 1678010p -0.3
+ 1680000p -0.3
+ 1680010p 0.9
+ 1682000p 0.9
+ 1682010p -0.3
+ 1684000p -0.3
+ 1684010p 0.9
+ 1686000p 0.9
+ 1686010p -0.3
+ 1688000p -0.3
+ 1688010p 0.9
+ 1690000p 0.9
+ 1690010p -0.3
+ 1692000p -0.3
+ 1692010p 0.9
+ 1694000p 0.9
+ 1694010p -0.3
+ 1696000p -0.3
+ 1696010p 0.9
+ 1698000p 0.9
+ 1698010p -0.3
+ 1700000p -0.3
+ 1700010p 0.9
+ 1702000p 0.9
+ 1702010p -0.3
+ 1704000p -0.3
+ 1704010p 0.9
+ 1706000p 0.9
+ 1706010p -0.3
+ 1708000p -0.3
+ 1708010p 0.9
+ 1710000p 0.9
+ 1710010p -0.3
+ 1712000p -0.3
+ 1712010p 0.9
+ 1714000p 0.9
+ 1714010p -0.3
+ 1716000p -0.3
+ 1716010p 0.9
+ 1718000p 0.9
+ 1718010p -0.3
+ 1720000p -0.3
+ 1720010p 0.9
+ 1722000p 0.9
+ 1722010p -0.3
+ 1724000p -0.3
+ 1724010p 0.9
+ 1726000p 0.9
+ 1726010p -0.3
+ 1728000p -0.3
+ 1728010p 0.9
+ 1730000p 0.9
+ 1730010p -0.3
+ 1732000p -0.3
+ 1732010p 0.9
+ 1734000p 0.9
+ 1734010p -0.3
+ 1736000p -0.3
+ 1736010p 0.9
+ 1738000p 0.9
+ 1738010p -0.3
+ 1740000p -0.3
+ 1740010p 0.9
+ 1742000p 0.9
+ 1742010p -0.3
+ 1744000p -0.3
+ 1744010p 0.9
+ 1746000p 0.9
+ 1746010p -0.3
+ 1748000p -0.3
+ 1748010p 0.9
+ 1750000p 0.9
+ 1750010p -0.3
+ 1752000p -0.3
+ 1752010p 0.9
+ 1754000p 0.9
+ 1754010p -0.3
+ 1756000p -0.3
+ 1756010p 0.9
+ 1758000p 0.9
+ 1758010p -0.3
+ 1760000p -0.3
+ 1760010p 0.9
+ 1762000p 0.9
+ 1762010p -0.3
+ 1764000p -0.3
+ 1764010p 0.9
+ 1766000p 0.9
+ 1766010p -0.3
+ 1768000p -0.3
+ 1768010p 0.9
+ 1770000p 0.9
+ 1770010p -0.3
+ 1772000p -0.3
+ 1772010p 0.9
+ 1774000p 0.9
+ 1774010p -0.3
+ 1776000p -0.3
+ 1776010p 0.9
+ 1778000p 0.9
+ 1778010p -0.3
+ 1780000p -0.3
+ 1780010p 0.9
+ 1782000p 0.9
+ 1782010p -0.3
+ 1784000p -0.3
+ 1784010p 0.9
+ 1786000p 0.9
+ 1786010p -0.3
+ 1788000p -0.3
+ 1788010p 0.9
+ 1790000p 0.9
+ 1790010p -0.3
+ 1792000p -0.3
+ 1792010p 0.9
+ 1794000p 0.9
+ 1794010p -0.3
+ 1796000p -0.3
+ 1796010p 0.9
+ 1798000p 0.9
+ 1798010p -0.3
+ 1800000p -0.3
+ 1800010p 0.9
+ 1802000p 0.9
+ 1802010p -0.3
+ 1804000p -0.3
+ 1804010p 0.9
+ 1806000p 0.9
+ 1806010p -0.3
+ 1808000p -0.3
+ 1808010p 0.9
+ 1810000p 0.9
+ 1810010p -0.3
+ 1812000p -0.3
+ 1812010p 0.9
+ 1814000p 0.9
+ 1814010p -0.3
+ 1816000p -0.3
+ 1816010p 0.9
+ 1818000p 0.9
+ 1818010p -0.3
+ 1820000p -0.3
+ 1820010p 0.9
+ 1822000p 0.9
+ 1822010p -0.3
+ 1824000p -0.3
+ 1824010p 0.9
+ 1826000p 0.9
+ 1826010p -0.3
+ 1828000p -0.3
+ 1828010p 0.9
+ 1830000p 0.9
+ 1830010p -0.3
+ 1832000p -0.3
+ 1832010p 0.9
+ 1834000p 0.9
+ 1834010p -0.3
+ 1836000p -0.3
+ 1836010p 0.9
+ 1838000p 0.9
+ 1838010p -0.3
+ 1840000p -0.3
+ 1840010p 0.9
+ 1842000p 0.9
+ 1842010p -0.3
+ 1844000p -0.3
+ 1844010p 0.9
+ 1846000p 0.9
+ 1846010p -0.3
+ 1848000p -0.3
+ 1848010p 0.9
+ 1850000p 0.9
+ 1850010p -0.3
+ 1852000p -0.3
+ 1852010p 0.9
+ 1854000p 0.9
+ 1854010p -0.3
+ 1856000p -0.3
+ 1856010p 0.9
+ 1858000p 0.9
+ 1858010p -0.3
+ 1860000p -0.3
+ 1860010p 0.9
+ 1862000p 0.9
+ 1862010p -0.3
+ 1864000p -0.3
+ 1864010p 0.9
+ 1866000p 0.9
+ 1866010p -0.3
+ 1868000p -0.3
+ 1868010p 0.9
+ 1870000p 0.9
+ 1870010p -0.3
+ 1872000p -0.3
+ 1872010p 0.9
+ 1874000p 0.9
+ 1874010p -0.3
+ 1876000p -0.3
+ 1876010p 0.9
+ 1878000p 0.9
+ 1878010p -0.3
+ 1880000p -0.3
+ 1880010p 0.9
+ 1882000p 0.9
+ 1882010p -0.3
+ 1884000p -0.3
+ 1884010p 0.9
+ 1886000p 0.9
+ 1886010p -0.3
+ 1888000p -0.3
+ 1888010p 0.9
+ 1890000p 0.9
+ 1890010p -0.3
+ 1892000p -0.3
+ 1892010p 0.9
+ 1894000p 0.9
+ 1894010p -0.3
+ 1896000p -0.3
+ 1896010p 0.9
+ 1898000p 0.9
+ 1898010p -0.3
+ 1900000p -0.3
+ 1900010p 0.9
+ 1902000p 0.9
+ 1902010p -0.3
+ 1904000p -0.3
+ 1904010p 0.9
+ 1906000p 0.9
+ 1906010p -0.3
+ 1908000p -0.3
+ 1908010p 0.9
+ 1910000p 0.9
+ 1910010p -0.3
+ 1912000p -0.3
+ 1912010p 0.9
+ 1914000p 0.9
+ 1914010p -0.3
+ 1916000p -0.3
+ 1916010p 0.9
+ 1918000p 0.9
+ 1918010p -0.3
+ 1920000p -0.3
+ 1920010p 0.9
+ 1922000p 0.9
+ 1922010p -0.3
+ 1924000p -0.3
+ 1924010p 0.9
+ 1926000p 0.9
+ 1926010p -0.3
+ 1928000p -0.3
+ 1928010p 0.9
+ 1930000p 0.9
+ 1930010p -0.3
+ 1932000p -0.3
+ 1932010p 0.9
+ 1934000p 0.9
+ 1934010p -0.3
+ 1936000p -0.3
+ 1936010p 0.9
+ 1938000p 0.9
+ 1938010p -0.3
+ 1940000p -0.3
+ 1940010p 0.9
+ 1942000p 0.9
+ 1942010p -0.3
+ 1944000p -0.3
+ 1944010p 0.9
+ 1946000p 0.9
+ 1946010p -0.3
+ 1948000p -0.3
+ 1948010p 0.9
+ 1950000p 0.9
+ 1950010p -0.3
+ 1952000p -0.3
+ 1952010p 0.9
+ 1954000p 0.9
+ 1954010p -0.3
+ 1956000p -0.3
+ 1956010p 0.9
+ 1958000p 0.9
+ 1958010p -0.3
+ 1960000p -0.3
+ 1960010p 0.9
+ 1962000p 0.9
+ 1962010p -0.3
+ 1964000p -0.3
+ 1964010p 0.9
+ 1966000p 0.9
+ 1966010p -0.3
+ 1968000p -0.3
+ 1968010p 0.9
+ 1970000p 0.9
+ 1970010p -0.3
+ 1972000p -0.3
+ 1972010p 0.9
+ 1974000p 0.9
+ 1974010p -0.3
+ 1976000p -0.3
+ 1976010p 0.9
+ 1978000p 0.9
+ 1978010p -0.3
+ 1980000p -0.3
+ 1980010p 0.9
+ 1982000p 0.9
+ 1982010p -0.3
+ 1984000p -0.3
+ 1984010p 0.9
+ 1986000p 0.9
+ 1986010p -0.3
+ 1988000p -0.3
+ 1988010p 0.9
+ 1990000p 0.9
+ 1990010p -0.3
+ 1992000p -0.3
+ 1992010p 0.9
+ 1994000p 0.9
+ 1994010p -0.3
+ 1996000p -0.3
+ 1996010p 0.9
+ 1998000p 0.9
+ 1998010p -0.3
+ 2000000p -0.3
+ 2000010p 0.9
+ 2002000p 0.9
+ 2002010p -0.3
+ 2004000p -0.3
+ 2004010p 0.9
+ 2006000p 0.9
+ 2006010p -0.3
+ 2008000p -0.3
+ 2008010p 0.9
+ 2010000p 0.9
+ 2010010p -0.3
+ 2012000p -0.3
+ 2012010p 0.9
+ 2014000p 0.9
+ 2014010p -0.3
+ 2016000p -0.3
+ 2016010p 0.9
+ 2018000p 0.9
+ 2018010p -0.3
+ 2020000p -0.3
+ 2020010p 0.9
+ 2022000p 0.9
+ 2022010p -0.3
+ 2024000p -0.3
+ 2024010p 0.9
+ 2026000p 0.9
+ 2026010p -0.3
+ 2028000p -0.3
+ 2028010p 0.9
+ 2030000p 0.9
+ 2030010p -0.3
+ 2032000p -0.3
+ 2032010p 0.9
+ 2034000p 0.9
+ 2034010p -0.3
+ 2036000p -0.3
+ 2036010p 0.9
+ 2038000p 0.9
+ 2038010p -0.3
+ 2040000p -0.3
+ 2040010p 0.9
+ 2042000p 0.9
+ 2042010p -0.3
+ 2044000p -0.3
+ 2044010p 0.9
+ 2046000p 0.9
+ 2046010p -0.3
+ 2048000p -0.3
+ 2048010p 0.9
+ \]
V_data_bar_19 (Data_bar\\<19\\> gnd!) vsource type=pwl wave=\[
+ 0    -0.3
+ 2000p -0.3
+ 2010p 0.9
+ 4000p 0.9
+ 4010p -0.3
+ 6000p -0.3
+ 6010p 0.9
+ 8000p 0.9
+ 8010p -0.3
+ 10000p -0.3
+ 10010p 0.9
+ 12000p 0.9
+ 12010p -0.3
+ 14000p -0.3
+ 14010p 0.9
+ 16000p 0.9
+ 16010p -0.3
+ 18000p -0.3
+ 18010p 0.9
+ 20000p 0.9
+ 20010p -0.3
+ 22000p -0.3
+ 22010p 0.9
+ 24000p 0.9
+ 24010p -0.3
+ 26000p -0.3
+ 26010p 0.9
+ 28000p 0.9
+ 28010p -0.3
+ 30000p -0.3
+ 30010p 0.9
+ 32000p 0.9
+ 32010p -0.3
+ 34000p -0.3
+ 34010p 0.9
+ 36000p 0.9
+ 36010p -0.3
+ 38000p -0.3
+ 38010p 0.9
+ 40000p 0.9
+ 40010p -0.3
+ 42000p -0.3
+ 42010p 0.9
+ 44000p 0.9
+ 44010p -0.3
+ 46000p -0.3
+ 46010p 0.9
+ 48000p 0.9
+ 48010p -0.3
+ 50000p -0.3
+ 50010p 0.9
+ 52000p 0.9
+ 52010p -0.3
+ 54000p -0.3
+ 54010p 0.9
+ 56000p 0.9
+ 56010p -0.3
+ 58000p -0.3
+ 58010p 0.9
+ 60000p 0.9
+ 60010p -0.3
+ 62000p -0.3
+ 62010p 0.9
+ 64000p 0.9
+ 64010p -0.3
+ 66000p -0.3
+ 66010p 0.9
+ 68000p 0.9
+ 68010p -0.3
+ 70000p -0.3
+ 70010p 0.9
+ 72000p 0.9
+ 72010p -0.3
+ 74000p -0.3
+ 74010p 0.9
+ 76000p 0.9
+ 76010p -0.3
+ 78000p -0.3
+ 78010p 0.9
+ 80000p 0.9
+ 80010p -0.3
+ 82000p -0.3
+ 82010p 0.9
+ 84000p 0.9
+ 84010p -0.3
+ 86000p -0.3
+ 86010p 0.9
+ 88000p 0.9
+ 88010p -0.3
+ 90000p -0.3
+ 90010p 0.9
+ 92000p 0.9
+ 92010p -0.3
+ 94000p -0.3
+ 94010p 0.9
+ 96000p 0.9
+ 96010p -0.3
+ 98000p -0.3
+ 98010p 0.9
+ 100000p 0.9
+ 100010p -0.3
+ 102000p -0.3
+ 102010p 0.9
+ 104000p 0.9
+ 104010p -0.3
+ 106000p -0.3
+ 106010p 0.9
+ 108000p 0.9
+ 108010p -0.3
+ 110000p -0.3
+ 110010p 0.9
+ 112000p 0.9
+ 112010p -0.3
+ 114000p -0.3
+ 114010p 0.9
+ 116000p 0.9
+ 116010p -0.3
+ 118000p -0.3
+ 118010p 0.9
+ 120000p 0.9
+ 120010p -0.3
+ 122000p -0.3
+ 122010p 0.9
+ 124000p 0.9
+ 124010p -0.3
+ 126000p -0.3
+ 126010p 0.9
+ 128000p 0.9
+ 128010p -0.3
+ 130000p -0.3
+ 130010p 0.9
+ 132000p 0.9
+ 132010p -0.3
+ 134000p -0.3
+ 134010p 0.9
+ 136000p 0.9
+ 136010p -0.3
+ 138000p -0.3
+ 138010p 0.9
+ 140000p 0.9
+ 140010p -0.3
+ 142000p -0.3
+ 142010p 0.9
+ 144000p 0.9
+ 144010p -0.3
+ 146000p -0.3
+ 146010p 0.9
+ 148000p 0.9
+ 148010p -0.3
+ 150000p -0.3
+ 150010p 0.9
+ 152000p 0.9
+ 152010p -0.3
+ 154000p -0.3
+ 154010p 0.9
+ 156000p 0.9
+ 156010p -0.3
+ 158000p -0.3
+ 158010p 0.9
+ 160000p 0.9
+ 160010p -0.3
+ 162000p -0.3
+ 162010p 0.9
+ 164000p 0.9
+ 164010p -0.3
+ 166000p -0.3
+ 166010p 0.9
+ 168000p 0.9
+ 168010p -0.3
+ 170000p -0.3
+ 170010p 0.9
+ 172000p 0.9
+ 172010p -0.3
+ 174000p -0.3
+ 174010p 0.9
+ 176000p 0.9
+ 176010p -0.3
+ 178000p -0.3
+ 178010p 0.9
+ 180000p 0.9
+ 180010p -0.3
+ 182000p -0.3
+ 182010p 0.9
+ 184000p 0.9
+ 184010p -0.3
+ 186000p -0.3
+ 186010p 0.9
+ 188000p 0.9
+ 188010p -0.3
+ 190000p -0.3
+ 190010p 0.9
+ 192000p 0.9
+ 192010p -0.3
+ 194000p -0.3
+ 194010p 0.9
+ 196000p 0.9
+ 196010p -0.3
+ 198000p -0.3
+ 198010p 0.9
+ 200000p 0.9
+ 200010p -0.3
+ 202000p -0.3
+ 202010p 0.9
+ 204000p 0.9
+ 204010p -0.3
+ 206000p -0.3
+ 206010p 0.9
+ 208000p 0.9
+ 208010p -0.3
+ 210000p -0.3
+ 210010p 0.9
+ 212000p 0.9
+ 212010p -0.3
+ 214000p -0.3
+ 214010p 0.9
+ 216000p 0.9
+ 216010p -0.3
+ 218000p -0.3
+ 218010p 0.9
+ 220000p 0.9
+ 220010p -0.3
+ 222000p -0.3
+ 222010p 0.9
+ 224000p 0.9
+ 224010p -0.3
+ 226000p -0.3
+ 226010p 0.9
+ 228000p 0.9
+ 228010p -0.3
+ 230000p -0.3
+ 230010p 0.9
+ 232000p 0.9
+ 232010p -0.3
+ 234000p -0.3
+ 234010p 0.9
+ 236000p 0.9
+ 236010p -0.3
+ 238000p -0.3
+ 238010p 0.9
+ 240000p 0.9
+ 240010p -0.3
+ 242000p -0.3
+ 242010p 0.9
+ 244000p 0.9
+ 244010p -0.3
+ 246000p -0.3
+ 246010p 0.9
+ 248000p 0.9
+ 248010p -0.3
+ 250000p -0.3
+ 250010p 0.9
+ 252000p 0.9
+ 252010p -0.3
+ 254000p -0.3
+ 254010p 0.9
+ 256000p 0.9
+ 256010p -0.3
+ 258000p -0.3
+ 258010p 0.9
+ 260000p 0.9
+ 260010p -0.3
+ 262000p -0.3
+ 262010p 0.9
+ 264000p 0.9
+ 264010p -0.3
+ 266000p -0.3
+ 266010p 0.9
+ 268000p 0.9
+ 268010p -0.3
+ 270000p -0.3
+ 270010p 0.9
+ 272000p 0.9
+ 272010p -0.3
+ 274000p -0.3
+ 274010p 0.9
+ 276000p 0.9
+ 276010p -0.3
+ 278000p -0.3
+ 278010p 0.9
+ 280000p 0.9
+ 280010p -0.3
+ 282000p -0.3
+ 282010p 0.9
+ 284000p 0.9
+ 284010p -0.3
+ 286000p -0.3
+ 286010p 0.9
+ 288000p 0.9
+ 288010p -0.3
+ 290000p -0.3
+ 290010p 0.9
+ 292000p 0.9
+ 292010p -0.3
+ 294000p -0.3
+ 294010p 0.9
+ 296000p 0.9
+ 296010p -0.3
+ 298000p -0.3
+ 298010p 0.9
+ 300000p 0.9
+ 300010p -0.3
+ 302000p -0.3
+ 302010p 0.9
+ 304000p 0.9
+ 304010p -0.3
+ 306000p -0.3
+ 306010p 0.9
+ 308000p 0.9
+ 308010p -0.3
+ 310000p -0.3
+ 310010p 0.9
+ 312000p 0.9
+ 312010p -0.3
+ 314000p -0.3
+ 314010p 0.9
+ 316000p 0.9
+ 316010p -0.3
+ 318000p -0.3
+ 318010p 0.9
+ 320000p 0.9
+ 320010p -0.3
+ 322000p -0.3
+ 322010p 0.9
+ 324000p 0.9
+ 324010p -0.3
+ 326000p -0.3
+ 326010p 0.9
+ 328000p 0.9
+ 328010p -0.3
+ 330000p -0.3
+ 330010p 0.9
+ 332000p 0.9
+ 332010p -0.3
+ 334000p -0.3
+ 334010p 0.9
+ 336000p 0.9
+ 336010p -0.3
+ 338000p -0.3
+ 338010p 0.9
+ 340000p 0.9
+ 340010p -0.3
+ 342000p -0.3
+ 342010p 0.9
+ 344000p 0.9
+ 344010p -0.3
+ 346000p -0.3
+ 346010p 0.9
+ 348000p 0.9
+ 348010p -0.3
+ 350000p -0.3
+ 350010p 0.9
+ 352000p 0.9
+ 352010p -0.3
+ 354000p -0.3
+ 354010p 0.9
+ 356000p 0.9
+ 356010p -0.3
+ 358000p -0.3
+ 358010p 0.9
+ 360000p 0.9
+ 360010p -0.3
+ 362000p -0.3
+ 362010p 0.9
+ 364000p 0.9
+ 364010p -0.3
+ 366000p -0.3
+ 366010p 0.9
+ 368000p 0.9
+ 368010p -0.3
+ 370000p -0.3
+ 370010p 0.9
+ 372000p 0.9
+ 372010p -0.3
+ 374000p -0.3
+ 374010p 0.9
+ 376000p 0.9
+ 376010p -0.3
+ 378000p -0.3
+ 378010p 0.9
+ 380000p 0.9
+ 380010p -0.3
+ 382000p -0.3
+ 382010p 0.9
+ 384000p 0.9
+ 384010p -0.3
+ 386000p -0.3
+ 386010p 0.9
+ 388000p 0.9
+ 388010p -0.3
+ 390000p -0.3
+ 390010p 0.9
+ 392000p 0.9
+ 392010p -0.3
+ 394000p -0.3
+ 394010p 0.9
+ 396000p 0.9
+ 396010p -0.3
+ 398000p -0.3
+ 398010p 0.9
+ 400000p 0.9
+ 400010p -0.3
+ 402000p -0.3
+ 402010p 0.9
+ 404000p 0.9
+ 404010p -0.3
+ 406000p -0.3
+ 406010p 0.9
+ 408000p 0.9
+ 408010p -0.3
+ 410000p -0.3
+ 410010p 0.9
+ 412000p 0.9
+ 412010p -0.3
+ 414000p -0.3
+ 414010p 0.9
+ 416000p 0.9
+ 416010p -0.3
+ 418000p -0.3
+ 418010p 0.9
+ 420000p 0.9
+ 420010p -0.3
+ 422000p -0.3
+ 422010p 0.9
+ 424000p 0.9
+ 424010p -0.3
+ 426000p -0.3
+ 426010p 0.9
+ 428000p 0.9
+ 428010p -0.3
+ 430000p -0.3
+ 430010p 0.9
+ 432000p 0.9
+ 432010p -0.3
+ 434000p -0.3
+ 434010p 0.9
+ 436000p 0.9
+ 436010p -0.3
+ 438000p -0.3
+ 438010p 0.9
+ 440000p 0.9
+ 440010p -0.3
+ 442000p -0.3
+ 442010p 0.9
+ 444000p 0.9
+ 444010p -0.3
+ 446000p -0.3
+ 446010p 0.9
+ 448000p 0.9
+ 448010p -0.3
+ 450000p -0.3
+ 450010p 0.9
+ 452000p 0.9
+ 452010p -0.3
+ 454000p -0.3
+ 454010p 0.9
+ 456000p 0.9
+ 456010p -0.3
+ 458000p -0.3
+ 458010p 0.9
+ 460000p 0.9
+ 460010p -0.3
+ 462000p -0.3
+ 462010p 0.9
+ 464000p 0.9
+ 464010p -0.3
+ 466000p -0.3
+ 466010p 0.9
+ 468000p 0.9
+ 468010p -0.3
+ 470000p -0.3
+ 470010p 0.9
+ 472000p 0.9
+ 472010p -0.3
+ 474000p -0.3
+ 474010p 0.9
+ 476000p 0.9
+ 476010p -0.3
+ 478000p -0.3
+ 478010p 0.9
+ 480000p 0.9
+ 480010p -0.3
+ 482000p -0.3
+ 482010p 0.9
+ 484000p 0.9
+ 484010p -0.3
+ 486000p -0.3
+ 486010p 0.9
+ 488000p 0.9
+ 488010p -0.3
+ 490000p -0.3
+ 490010p 0.9
+ 492000p 0.9
+ 492010p -0.3
+ 494000p -0.3
+ 494010p 0.9
+ 496000p 0.9
+ 496010p -0.3
+ 498000p -0.3
+ 498010p 0.9
+ 500000p 0.9
+ 500010p -0.3
+ 502000p -0.3
+ 502010p 0.9
+ 504000p 0.9
+ 504010p -0.3
+ 506000p -0.3
+ 506010p 0.9
+ 508000p 0.9
+ 508010p -0.3
+ 510000p -0.3
+ 510010p 0.9
+ 512000p 0.9
+ 512010p -0.3
+ 514000p -0.3
+ 514010p 0.9
+ 516000p 0.9
+ 516010p -0.3
+ 518000p -0.3
+ 518010p 0.9
+ 520000p 0.9
+ 520010p -0.3
+ 522000p -0.3
+ 522010p 0.9
+ 524000p 0.9
+ 524010p -0.3
+ 526000p -0.3
+ 526010p 0.9
+ 528000p 0.9
+ 528010p -0.3
+ 530000p -0.3
+ 530010p 0.9
+ 532000p 0.9
+ 532010p -0.3
+ 534000p -0.3
+ 534010p 0.9
+ 536000p 0.9
+ 536010p -0.3
+ 538000p -0.3
+ 538010p 0.9
+ 540000p 0.9
+ 540010p -0.3
+ 542000p -0.3
+ 542010p 0.9
+ 544000p 0.9
+ 544010p -0.3
+ 546000p -0.3
+ 546010p 0.9
+ 548000p 0.9
+ 548010p -0.3
+ 550000p -0.3
+ 550010p 0.9
+ 552000p 0.9
+ 552010p -0.3
+ 554000p -0.3
+ 554010p 0.9
+ 556000p 0.9
+ 556010p -0.3
+ 558000p -0.3
+ 558010p 0.9
+ 560000p 0.9
+ 560010p -0.3
+ 562000p -0.3
+ 562010p 0.9
+ 564000p 0.9
+ 564010p -0.3
+ 566000p -0.3
+ 566010p 0.9
+ 568000p 0.9
+ 568010p -0.3
+ 570000p -0.3
+ 570010p 0.9
+ 572000p 0.9
+ 572010p -0.3
+ 574000p -0.3
+ 574010p 0.9
+ 576000p 0.9
+ 576010p -0.3
+ 578000p -0.3
+ 578010p 0.9
+ 580000p 0.9
+ 580010p -0.3
+ 582000p -0.3
+ 582010p 0.9
+ 584000p 0.9
+ 584010p -0.3
+ 586000p -0.3
+ 586010p 0.9
+ 588000p 0.9
+ 588010p -0.3
+ 590000p -0.3
+ 590010p 0.9
+ 592000p 0.9
+ 592010p -0.3
+ 594000p -0.3
+ 594010p 0.9
+ 596000p 0.9
+ 596010p -0.3
+ 598000p -0.3
+ 598010p 0.9
+ 600000p 0.9
+ 600010p -0.3
+ 602000p -0.3
+ 602010p 0.9
+ 604000p 0.9
+ 604010p -0.3
+ 606000p -0.3
+ 606010p 0.9
+ 608000p 0.9
+ 608010p -0.3
+ 610000p -0.3
+ 610010p 0.9
+ 612000p 0.9
+ 612010p -0.3
+ 614000p -0.3
+ 614010p 0.9
+ 616000p 0.9
+ 616010p -0.3
+ 618000p -0.3
+ 618010p 0.9
+ 620000p 0.9
+ 620010p -0.3
+ 622000p -0.3
+ 622010p 0.9
+ 624000p 0.9
+ 624010p -0.3
+ 626000p -0.3
+ 626010p 0.9
+ 628000p 0.9
+ 628010p -0.3
+ 630000p -0.3
+ 630010p 0.9
+ 632000p 0.9
+ 632010p -0.3
+ 634000p -0.3
+ 634010p 0.9
+ 636000p 0.9
+ 636010p -0.3
+ 638000p -0.3
+ 638010p 0.9
+ 640000p 0.9
+ 640010p -0.3
+ 642000p -0.3
+ 642010p 0.9
+ 644000p 0.9
+ 644010p -0.3
+ 646000p -0.3
+ 646010p 0.9
+ 648000p 0.9
+ 648010p -0.3
+ 650000p -0.3
+ 650010p 0.9
+ 652000p 0.9
+ 652010p -0.3
+ 654000p -0.3
+ 654010p 0.9
+ 656000p 0.9
+ 656010p -0.3
+ 658000p -0.3
+ 658010p 0.9
+ 660000p 0.9
+ 660010p -0.3
+ 662000p -0.3
+ 662010p 0.9
+ 664000p 0.9
+ 664010p -0.3
+ 666000p -0.3
+ 666010p 0.9
+ 668000p 0.9
+ 668010p -0.3
+ 670000p -0.3
+ 670010p 0.9
+ 672000p 0.9
+ 672010p -0.3
+ 674000p -0.3
+ 674010p 0.9
+ 676000p 0.9
+ 676010p -0.3
+ 678000p -0.3
+ 678010p 0.9
+ 680000p 0.9
+ 680010p -0.3
+ 682000p -0.3
+ 682010p 0.9
+ 684000p 0.9
+ 684010p -0.3
+ 686000p -0.3
+ 686010p 0.9
+ 688000p 0.9
+ 688010p -0.3
+ 690000p -0.3
+ 690010p 0.9
+ 692000p 0.9
+ 692010p -0.3
+ 694000p -0.3
+ 694010p 0.9
+ 696000p 0.9
+ 696010p -0.3
+ 698000p -0.3
+ 698010p 0.9
+ 700000p 0.9
+ 700010p -0.3
+ 702000p -0.3
+ 702010p 0.9
+ 704000p 0.9
+ 704010p -0.3
+ 706000p -0.3
+ 706010p 0.9
+ 708000p 0.9
+ 708010p -0.3
+ 710000p -0.3
+ 710010p 0.9
+ 712000p 0.9
+ 712010p -0.3
+ 714000p -0.3
+ 714010p 0.9
+ 716000p 0.9
+ 716010p -0.3
+ 718000p -0.3
+ 718010p 0.9
+ 720000p 0.9
+ 720010p -0.3
+ 722000p -0.3
+ 722010p 0.9
+ 724000p 0.9
+ 724010p -0.3
+ 726000p -0.3
+ 726010p 0.9
+ 728000p 0.9
+ 728010p -0.3
+ 730000p -0.3
+ 730010p 0.9
+ 732000p 0.9
+ 732010p -0.3
+ 734000p -0.3
+ 734010p 0.9
+ 736000p 0.9
+ 736010p -0.3
+ 738000p -0.3
+ 738010p 0.9
+ 740000p 0.9
+ 740010p -0.3
+ 742000p -0.3
+ 742010p 0.9
+ 744000p 0.9
+ 744010p -0.3
+ 746000p -0.3
+ 746010p 0.9
+ 748000p 0.9
+ 748010p -0.3
+ 750000p -0.3
+ 750010p 0.9
+ 752000p 0.9
+ 752010p -0.3
+ 754000p -0.3
+ 754010p 0.9
+ 756000p 0.9
+ 756010p -0.3
+ 758000p -0.3
+ 758010p 0.9
+ 760000p 0.9
+ 760010p -0.3
+ 762000p -0.3
+ 762010p 0.9
+ 764000p 0.9
+ 764010p -0.3
+ 766000p -0.3
+ 766010p 0.9
+ 768000p 0.9
+ 768010p -0.3
+ 770000p -0.3
+ 770010p 0.9
+ 772000p 0.9
+ 772010p -0.3
+ 774000p -0.3
+ 774010p 0.9
+ 776000p 0.9
+ 776010p -0.3
+ 778000p -0.3
+ 778010p 0.9
+ 780000p 0.9
+ 780010p -0.3
+ 782000p -0.3
+ 782010p 0.9
+ 784000p 0.9
+ 784010p -0.3
+ 786000p -0.3
+ 786010p 0.9
+ 788000p 0.9
+ 788010p -0.3
+ 790000p -0.3
+ 790010p 0.9
+ 792000p 0.9
+ 792010p -0.3
+ 794000p -0.3
+ 794010p 0.9
+ 796000p 0.9
+ 796010p -0.3
+ 798000p -0.3
+ 798010p 0.9
+ 800000p 0.9
+ 800010p -0.3
+ 802000p -0.3
+ 802010p 0.9
+ 804000p 0.9
+ 804010p -0.3
+ 806000p -0.3
+ 806010p 0.9
+ 808000p 0.9
+ 808010p -0.3
+ 810000p -0.3
+ 810010p 0.9
+ 812000p 0.9
+ 812010p -0.3
+ 814000p -0.3
+ 814010p 0.9
+ 816000p 0.9
+ 816010p -0.3
+ 818000p -0.3
+ 818010p 0.9
+ 820000p 0.9
+ 820010p -0.3
+ 822000p -0.3
+ 822010p 0.9
+ 824000p 0.9
+ 824010p -0.3
+ 826000p -0.3
+ 826010p 0.9
+ 828000p 0.9
+ 828010p -0.3
+ 830000p -0.3
+ 830010p 0.9
+ 832000p 0.9
+ 832010p -0.3
+ 834000p -0.3
+ 834010p 0.9
+ 836000p 0.9
+ 836010p -0.3
+ 838000p -0.3
+ 838010p 0.9
+ 840000p 0.9
+ 840010p -0.3
+ 842000p -0.3
+ 842010p 0.9
+ 844000p 0.9
+ 844010p -0.3
+ 846000p -0.3
+ 846010p 0.9
+ 848000p 0.9
+ 848010p -0.3
+ 850000p -0.3
+ 850010p 0.9
+ 852000p 0.9
+ 852010p -0.3
+ 854000p -0.3
+ 854010p 0.9
+ 856000p 0.9
+ 856010p -0.3
+ 858000p -0.3
+ 858010p 0.9
+ 860000p 0.9
+ 860010p -0.3
+ 862000p -0.3
+ 862010p 0.9
+ 864000p 0.9
+ 864010p -0.3
+ 866000p -0.3
+ 866010p 0.9
+ 868000p 0.9
+ 868010p -0.3
+ 870000p -0.3
+ 870010p 0.9
+ 872000p 0.9
+ 872010p -0.3
+ 874000p -0.3
+ 874010p 0.9
+ 876000p 0.9
+ 876010p -0.3
+ 878000p -0.3
+ 878010p 0.9
+ 880000p 0.9
+ 880010p -0.3
+ 882000p -0.3
+ 882010p 0.9
+ 884000p 0.9
+ 884010p -0.3
+ 886000p -0.3
+ 886010p 0.9
+ 888000p 0.9
+ 888010p -0.3
+ 890000p -0.3
+ 890010p 0.9
+ 892000p 0.9
+ 892010p -0.3
+ 894000p -0.3
+ 894010p 0.9
+ 896000p 0.9
+ 896010p -0.3
+ 898000p -0.3
+ 898010p 0.9
+ 900000p 0.9
+ 900010p -0.3
+ 902000p -0.3
+ 902010p 0.9
+ 904000p 0.9
+ 904010p -0.3
+ 906000p -0.3
+ 906010p 0.9
+ 908000p 0.9
+ 908010p -0.3
+ 910000p -0.3
+ 910010p 0.9
+ 912000p 0.9
+ 912010p -0.3
+ 914000p -0.3
+ 914010p 0.9
+ 916000p 0.9
+ 916010p -0.3
+ 918000p -0.3
+ 918010p 0.9
+ 920000p 0.9
+ 920010p -0.3
+ 922000p -0.3
+ 922010p 0.9
+ 924000p 0.9
+ 924010p -0.3
+ 926000p -0.3
+ 926010p 0.9
+ 928000p 0.9
+ 928010p -0.3
+ 930000p -0.3
+ 930010p 0.9
+ 932000p 0.9
+ 932010p -0.3
+ 934000p -0.3
+ 934010p 0.9
+ 936000p 0.9
+ 936010p -0.3
+ 938000p -0.3
+ 938010p 0.9
+ 940000p 0.9
+ 940010p -0.3
+ 942000p -0.3
+ 942010p 0.9
+ 944000p 0.9
+ 944010p -0.3
+ 946000p -0.3
+ 946010p 0.9
+ 948000p 0.9
+ 948010p -0.3
+ 950000p -0.3
+ 950010p 0.9
+ 952000p 0.9
+ 952010p -0.3
+ 954000p -0.3
+ 954010p 0.9
+ 956000p 0.9
+ 956010p -0.3
+ 958000p -0.3
+ 958010p 0.9
+ 960000p 0.9
+ 960010p -0.3
+ 962000p -0.3
+ 962010p 0.9
+ 964000p 0.9
+ 964010p -0.3
+ 966000p -0.3
+ 966010p 0.9
+ 968000p 0.9
+ 968010p -0.3
+ 970000p -0.3
+ 970010p 0.9
+ 972000p 0.9
+ 972010p -0.3
+ 974000p -0.3
+ 974010p 0.9
+ 976000p 0.9
+ 976010p -0.3
+ 978000p -0.3
+ 978010p 0.9
+ 980000p 0.9
+ 980010p -0.3
+ 982000p -0.3
+ 982010p 0.9
+ 984000p 0.9
+ 984010p -0.3
+ 986000p -0.3
+ 986010p 0.9
+ 988000p 0.9
+ 988010p -0.3
+ 990000p -0.3
+ 990010p 0.9
+ 992000p 0.9
+ 992010p -0.3
+ 994000p -0.3
+ 994010p 0.9
+ 996000p 0.9
+ 996010p -0.3
+ 998000p -0.3
+ 998010p 0.9
+ 1000000p 0.9
+ 1000010p -0.3
+ 1002000p -0.3
+ 1002010p 0.9
+ 1004000p 0.9
+ 1004010p -0.3
+ 1006000p -0.3
+ 1006010p 0.9
+ 1008000p 0.9
+ 1008010p -0.3
+ 1010000p -0.3
+ 1010010p 0.9
+ 1012000p 0.9
+ 1012010p -0.3
+ 1014000p -0.3
+ 1014010p 0.9
+ 1016000p 0.9
+ 1016010p -0.3
+ 1018000p -0.3
+ 1018010p 0.9
+ 1020000p 0.9
+ 1020010p -0.3
+ 1022000p -0.3
+ 1022010p 0.9
+ 1024000p 0.9
+ 1024010p -0.3
+ 1026000p -0.3
+ 1026010p 0.9
+ 1028000p 0.9
+ 1028010p -0.3
+ 1030000p -0.3
+ 1030010p 0.9
+ 1032000p 0.9
+ 1032010p -0.3
+ 1034000p -0.3
+ 1034010p 0.9
+ 1036000p 0.9
+ 1036010p -0.3
+ 1038000p -0.3
+ 1038010p 0.9
+ 1040000p 0.9
+ 1040010p -0.3
+ 1042000p -0.3
+ 1042010p 0.9
+ 1044000p 0.9
+ 1044010p -0.3
+ 1046000p -0.3
+ 1046010p 0.9
+ 1048000p 0.9
+ 1048010p -0.3
+ 1050000p -0.3
+ 1050010p 0.9
+ 1052000p 0.9
+ 1052010p -0.3
+ 1054000p -0.3
+ 1054010p 0.9
+ 1056000p 0.9
+ 1056010p -0.3
+ 1058000p -0.3
+ 1058010p 0.9
+ 1060000p 0.9
+ 1060010p -0.3
+ 1062000p -0.3
+ 1062010p 0.9
+ 1064000p 0.9
+ 1064010p -0.3
+ 1066000p -0.3
+ 1066010p 0.9
+ 1068000p 0.9
+ 1068010p -0.3
+ 1070000p -0.3
+ 1070010p 0.9
+ 1072000p 0.9
+ 1072010p -0.3
+ 1074000p -0.3
+ 1074010p 0.9
+ 1076000p 0.9
+ 1076010p -0.3
+ 1078000p -0.3
+ 1078010p 0.9
+ 1080000p 0.9
+ 1080010p -0.3
+ 1082000p -0.3
+ 1082010p 0.9
+ 1084000p 0.9
+ 1084010p -0.3
+ 1086000p -0.3
+ 1086010p 0.9
+ 1088000p 0.9
+ 1088010p -0.3
+ 1090000p -0.3
+ 1090010p 0.9
+ 1092000p 0.9
+ 1092010p -0.3
+ 1094000p -0.3
+ 1094010p 0.9
+ 1096000p 0.9
+ 1096010p -0.3
+ 1098000p -0.3
+ 1098010p 0.9
+ 1100000p 0.9
+ 1100010p -0.3
+ 1102000p -0.3
+ 1102010p 0.9
+ 1104000p 0.9
+ 1104010p -0.3
+ 1106000p -0.3
+ 1106010p 0.9
+ 1108000p 0.9
+ 1108010p -0.3
+ 1110000p -0.3
+ 1110010p 0.9
+ 1112000p 0.9
+ 1112010p -0.3
+ 1114000p -0.3
+ 1114010p 0.9
+ 1116000p 0.9
+ 1116010p -0.3
+ 1118000p -0.3
+ 1118010p 0.9
+ 1120000p 0.9
+ 1120010p -0.3
+ 1122000p -0.3
+ 1122010p 0.9
+ 1124000p 0.9
+ 1124010p -0.3
+ 1126000p -0.3
+ 1126010p 0.9
+ 1128000p 0.9
+ 1128010p -0.3
+ 1130000p -0.3
+ 1130010p 0.9
+ 1132000p 0.9
+ 1132010p -0.3
+ 1134000p -0.3
+ 1134010p 0.9
+ 1136000p 0.9
+ 1136010p -0.3
+ 1138000p -0.3
+ 1138010p 0.9
+ 1140000p 0.9
+ 1140010p -0.3
+ 1142000p -0.3
+ 1142010p 0.9
+ 1144000p 0.9
+ 1144010p -0.3
+ 1146000p -0.3
+ 1146010p 0.9
+ 1148000p 0.9
+ 1148010p -0.3
+ 1150000p -0.3
+ 1150010p 0.9
+ 1152000p 0.9
+ 1152010p -0.3
+ 1154000p -0.3
+ 1154010p 0.9
+ 1156000p 0.9
+ 1156010p -0.3
+ 1158000p -0.3
+ 1158010p 0.9
+ 1160000p 0.9
+ 1160010p -0.3
+ 1162000p -0.3
+ 1162010p 0.9
+ 1164000p 0.9
+ 1164010p -0.3
+ 1166000p -0.3
+ 1166010p 0.9
+ 1168000p 0.9
+ 1168010p -0.3
+ 1170000p -0.3
+ 1170010p 0.9
+ 1172000p 0.9
+ 1172010p -0.3
+ 1174000p -0.3
+ 1174010p 0.9
+ 1176000p 0.9
+ 1176010p -0.3
+ 1178000p -0.3
+ 1178010p 0.9
+ 1180000p 0.9
+ 1180010p -0.3
+ 1182000p -0.3
+ 1182010p 0.9
+ 1184000p 0.9
+ 1184010p -0.3
+ 1186000p -0.3
+ 1186010p 0.9
+ 1188000p 0.9
+ 1188010p -0.3
+ 1190000p -0.3
+ 1190010p 0.9
+ 1192000p 0.9
+ 1192010p -0.3
+ 1194000p -0.3
+ 1194010p 0.9
+ 1196000p 0.9
+ 1196010p -0.3
+ 1198000p -0.3
+ 1198010p 0.9
+ 1200000p 0.9
+ 1200010p -0.3
+ 1202000p -0.3
+ 1202010p 0.9
+ 1204000p 0.9
+ 1204010p -0.3
+ 1206000p -0.3
+ 1206010p 0.9
+ 1208000p 0.9
+ 1208010p -0.3
+ 1210000p -0.3
+ 1210010p 0.9
+ 1212000p 0.9
+ 1212010p -0.3
+ 1214000p -0.3
+ 1214010p 0.9
+ 1216000p 0.9
+ 1216010p -0.3
+ 1218000p -0.3
+ 1218010p 0.9
+ 1220000p 0.9
+ 1220010p -0.3
+ 1222000p -0.3
+ 1222010p 0.9
+ 1224000p 0.9
+ 1224010p -0.3
+ 1226000p -0.3
+ 1226010p 0.9
+ 1228000p 0.9
+ 1228010p -0.3
+ 1230000p -0.3
+ 1230010p 0.9
+ 1232000p 0.9
+ 1232010p -0.3
+ 1234000p -0.3
+ 1234010p 0.9
+ 1236000p 0.9
+ 1236010p -0.3
+ 1238000p -0.3
+ 1238010p 0.9
+ 1240000p 0.9
+ 1240010p -0.3
+ 1242000p -0.3
+ 1242010p 0.9
+ 1244000p 0.9
+ 1244010p -0.3
+ 1246000p -0.3
+ 1246010p 0.9
+ 1248000p 0.9
+ 1248010p -0.3
+ 1250000p -0.3
+ 1250010p 0.9
+ 1252000p 0.9
+ 1252010p -0.3
+ 1254000p -0.3
+ 1254010p 0.9
+ 1256000p 0.9
+ 1256010p -0.3
+ 1258000p -0.3
+ 1258010p 0.9
+ 1260000p 0.9
+ 1260010p -0.3
+ 1262000p -0.3
+ 1262010p 0.9
+ 1264000p 0.9
+ 1264010p -0.3
+ 1266000p -0.3
+ 1266010p 0.9
+ 1268000p 0.9
+ 1268010p -0.3
+ 1270000p -0.3
+ 1270010p 0.9
+ 1272000p 0.9
+ 1272010p -0.3
+ 1274000p -0.3
+ 1274010p 0.9
+ 1276000p 0.9
+ 1276010p -0.3
+ 1278000p -0.3
+ 1278010p 0.9
+ 1280000p 0.9
+ 1280010p -0.3
+ 1282000p -0.3
+ 1282010p 0.9
+ 1284000p 0.9
+ 1284010p -0.3
+ 1286000p -0.3
+ 1286010p 0.9
+ 1288000p 0.9
+ 1288010p -0.3
+ 1290000p -0.3
+ 1290010p 0.9
+ 1292000p 0.9
+ 1292010p -0.3
+ 1294000p -0.3
+ 1294010p 0.9
+ 1296000p 0.9
+ 1296010p -0.3
+ 1298000p -0.3
+ 1298010p 0.9
+ 1300000p 0.9
+ 1300010p -0.3
+ 1302000p -0.3
+ 1302010p 0.9
+ 1304000p 0.9
+ 1304010p -0.3
+ 1306000p -0.3
+ 1306010p 0.9
+ 1308000p 0.9
+ 1308010p -0.3
+ 1310000p -0.3
+ 1310010p 0.9
+ 1312000p 0.9
+ 1312010p -0.3
+ 1314000p -0.3
+ 1314010p 0.9
+ 1316000p 0.9
+ 1316010p -0.3
+ 1318000p -0.3
+ 1318010p 0.9
+ 1320000p 0.9
+ 1320010p -0.3
+ 1322000p -0.3
+ 1322010p 0.9
+ 1324000p 0.9
+ 1324010p -0.3
+ 1326000p -0.3
+ 1326010p 0.9
+ 1328000p 0.9
+ 1328010p -0.3
+ 1330000p -0.3
+ 1330010p 0.9
+ 1332000p 0.9
+ 1332010p -0.3
+ 1334000p -0.3
+ 1334010p 0.9
+ 1336000p 0.9
+ 1336010p -0.3
+ 1338000p -0.3
+ 1338010p 0.9
+ 1340000p 0.9
+ 1340010p -0.3
+ 1342000p -0.3
+ 1342010p 0.9
+ 1344000p 0.9
+ 1344010p -0.3
+ 1346000p -0.3
+ 1346010p 0.9
+ 1348000p 0.9
+ 1348010p -0.3
+ 1350000p -0.3
+ 1350010p 0.9
+ 1352000p 0.9
+ 1352010p -0.3
+ 1354000p -0.3
+ 1354010p 0.9
+ 1356000p 0.9
+ 1356010p -0.3
+ 1358000p -0.3
+ 1358010p 0.9
+ 1360000p 0.9
+ 1360010p -0.3
+ 1362000p -0.3
+ 1362010p 0.9
+ 1364000p 0.9
+ 1364010p -0.3
+ 1366000p -0.3
+ 1366010p 0.9
+ 1368000p 0.9
+ 1368010p -0.3
+ 1370000p -0.3
+ 1370010p 0.9
+ 1372000p 0.9
+ 1372010p -0.3
+ 1374000p -0.3
+ 1374010p 0.9
+ 1376000p 0.9
+ 1376010p -0.3
+ 1378000p -0.3
+ 1378010p 0.9
+ 1380000p 0.9
+ 1380010p -0.3
+ 1382000p -0.3
+ 1382010p 0.9
+ 1384000p 0.9
+ 1384010p -0.3
+ 1386000p -0.3
+ 1386010p 0.9
+ 1388000p 0.9
+ 1388010p -0.3
+ 1390000p -0.3
+ 1390010p 0.9
+ 1392000p 0.9
+ 1392010p -0.3
+ 1394000p -0.3
+ 1394010p 0.9
+ 1396000p 0.9
+ 1396010p -0.3
+ 1398000p -0.3
+ 1398010p 0.9
+ 1400000p 0.9
+ 1400010p -0.3
+ 1402000p -0.3
+ 1402010p 0.9
+ 1404000p 0.9
+ 1404010p -0.3
+ 1406000p -0.3
+ 1406010p 0.9
+ 1408000p 0.9
+ 1408010p -0.3
+ 1410000p -0.3
+ 1410010p 0.9
+ 1412000p 0.9
+ 1412010p -0.3
+ 1414000p -0.3
+ 1414010p 0.9
+ 1416000p 0.9
+ 1416010p -0.3
+ 1418000p -0.3
+ 1418010p 0.9
+ 1420000p 0.9
+ 1420010p -0.3
+ 1422000p -0.3
+ 1422010p 0.9
+ 1424000p 0.9
+ 1424010p -0.3
+ 1426000p -0.3
+ 1426010p 0.9
+ 1428000p 0.9
+ 1428010p -0.3
+ 1430000p -0.3
+ 1430010p 0.9
+ 1432000p 0.9
+ 1432010p -0.3
+ 1434000p -0.3
+ 1434010p 0.9
+ 1436000p 0.9
+ 1436010p -0.3
+ 1438000p -0.3
+ 1438010p 0.9
+ 1440000p 0.9
+ 1440010p -0.3
+ 1442000p -0.3
+ 1442010p 0.9
+ 1444000p 0.9
+ 1444010p -0.3
+ 1446000p -0.3
+ 1446010p 0.9
+ 1448000p 0.9
+ 1448010p -0.3
+ 1450000p -0.3
+ 1450010p 0.9
+ 1452000p 0.9
+ 1452010p -0.3
+ 1454000p -0.3
+ 1454010p 0.9
+ 1456000p 0.9
+ 1456010p -0.3
+ 1458000p -0.3
+ 1458010p 0.9
+ 1460000p 0.9
+ 1460010p -0.3
+ 1462000p -0.3
+ 1462010p 0.9
+ 1464000p 0.9
+ 1464010p -0.3
+ 1466000p -0.3
+ 1466010p 0.9
+ 1468000p 0.9
+ 1468010p -0.3
+ 1470000p -0.3
+ 1470010p 0.9
+ 1472000p 0.9
+ 1472010p -0.3
+ 1474000p -0.3
+ 1474010p 0.9
+ 1476000p 0.9
+ 1476010p -0.3
+ 1478000p -0.3
+ 1478010p 0.9
+ 1480000p 0.9
+ 1480010p -0.3
+ 1482000p -0.3
+ 1482010p 0.9
+ 1484000p 0.9
+ 1484010p -0.3
+ 1486000p -0.3
+ 1486010p 0.9
+ 1488000p 0.9
+ 1488010p -0.3
+ 1490000p -0.3
+ 1490010p 0.9
+ 1492000p 0.9
+ 1492010p -0.3
+ 1494000p -0.3
+ 1494010p 0.9
+ 1496000p 0.9
+ 1496010p -0.3
+ 1498000p -0.3
+ 1498010p 0.9
+ 1500000p 0.9
+ 1500010p -0.3
+ 1502000p -0.3
+ 1502010p 0.9
+ 1504000p 0.9
+ 1504010p -0.3
+ 1506000p -0.3
+ 1506010p 0.9
+ 1508000p 0.9
+ 1508010p -0.3
+ 1510000p -0.3
+ 1510010p 0.9
+ 1512000p 0.9
+ 1512010p -0.3
+ 1514000p -0.3
+ 1514010p 0.9
+ 1516000p 0.9
+ 1516010p -0.3
+ 1518000p -0.3
+ 1518010p 0.9
+ 1520000p 0.9
+ 1520010p -0.3
+ 1522000p -0.3
+ 1522010p 0.9
+ 1524000p 0.9
+ 1524010p -0.3
+ 1526000p -0.3
+ 1526010p 0.9
+ 1528000p 0.9
+ 1528010p -0.3
+ 1530000p -0.3
+ 1530010p 0.9
+ 1532000p 0.9
+ 1532010p -0.3
+ 1534000p -0.3
+ 1534010p 0.9
+ 1536000p 0.9
+ 1536010p -0.3
+ 1538000p -0.3
+ 1538010p 0.9
+ 1540000p 0.9
+ 1540010p -0.3
+ 1542000p -0.3
+ 1542010p 0.9
+ 1544000p 0.9
+ 1544010p -0.3
+ 1546000p -0.3
+ 1546010p 0.9
+ 1548000p 0.9
+ 1548010p -0.3
+ 1550000p -0.3
+ 1550010p 0.9
+ 1552000p 0.9
+ 1552010p -0.3
+ 1554000p -0.3
+ 1554010p 0.9
+ 1556000p 0.9
+ 1556010p -0.3
+ 1558000p -0.3
+ 1558010p 0.9
+ 1560000p 0.9
+ 1560010p -0.3
+ 1562000p -0.3
+ 1562010p 0.9
+ 1564000p 0.9
+ 1564010p -0.3
+ 1566000p -0.3
+ 1566010p 0.9
+ 1568000p 0.9
+ 1568010p -0.3
+ 1570000p -0.3
+ 1570010p 0.9
+ 1572000p 0.9
+ 1572010p -0.3
+ 1574000p -0.3
+ 1574010p 0.9
+ 1576000p 0.9
+ 1576010p -0.3
+ 1578000p -0.3
+ 1578010p 0.9
+ 1580000p 0.9
+ 1580010p -0.3
+ 1582000p -0.3
+ 1582010p 0.9
+ 1584000p 0.9
+ 1584010p -0.3
+ 1586000p -0.3
+ 1586010p 0.9
+ 1588000p 0.9
+ 1588010p -0.3
+ 1590000p -0.3
+ 1590010p 0.9
+ 1592000p 0.9
+ 1592010p -0.3
+ 1594000p -0.3
+ 1594010p 0.9
+ 1596000p 0.9
+ 1596010p -0.3
+ 1598000p -0.3
+ 1598010p 0.9
+ 1600000p 0.9
+ 1600010p -0.3
+ 1602000p -0.3
+ 1602010p 0.9
+ 1604000p 0.9
+ 1604010p -0.3
+ 1606000p -0.3
+ 1606010p 0.9
+ 1608000p 0.9
+ 1608010p -0.3
+ 1610000p -0.3
+ 1610010p 0.9
+ 1612000p 0.9
+ 1612010p -0.3
+ 1614000p -0.3
+ 1614010p 0.9
+ 1616000p 0.9
+ 1616010p -0.3
+ 1618000p -0.3
+ 1618010p 0.9
+ 1620000p 0.9
+ 1620010p -0.3
+ 1622000p -0.3
+ 1622010p 0.9
+ 1624000p 0.9
+ 1624010p -0.3
+ 1626000p -0.3
+ 1626010p 0.9
+ 1628000p 0.9
+ 1628010p -0.3
+ 1630000p -0.3
+ 1630010p 0.9
+ 1632000p 0.9
+ 1632010p -0.3
+ 1634000p -0.3
+ 1634010p 0.9
+ 1636000p 0.9
+ 1636010p -0.3
+ 1638000p -0.3
+ 1638010p 0.9
+ 1640000p 0.9
+ 1640010p -0.3
+ 1642000p -0.3
+ 1642010p 0.9
+ 1644000p 0.9
+ 1644010p -0.3
+ 1646000p -0.3
+ 1646010p 0.9
+ 1648000p 0.9
+ 1648010p -0.3
+ 1650000p -0.3
+ 1650010p 0.9
+ 1652000p 0.9
+ 1652010p -0.3
+ 1654000p -0.3
+ 1654010p 0.9
+ 1656000p 0.9
+ 1656010p -0.3
+ 1658000p -0.3
+ 1658010p 0.9
+ 1660000p 0.9
+ 1660010p -0.3
+ 1662000p -0.3
+ 1662010p 0.9
+ 1664000p 0.9
+ 1664010p -0.3
+ 1666000p -0.3
+ 1666010p 0.9
+ 1668000p 0.9
+ 1668010p -0.3
+ 1670000p -0.3
+ 1670010p 0.9
+ 1672000p 0.9
+ 1672010p -0.3
+ 1674000p -0.3
+ 1674010p 0.9
+ 1676000p 0.9
+ 1676010p -0.3
+ 1678000p -0.3
+ 1678010p 0.9
+ 1680000p 0.9
+ 1680010p -0.3
+ 1682000p -0.3
+ 1682010p 0.9
+ 1684000p 0.9
+ 1684010p -0.3
+ 1686000p -0.3
+ 1686010p 0.9
+ 1688000p 0.9
+ 1688010p -0.3
+ 1690000p -0.3
+ 1690010p 0.9
+ 1692000p 0.9
+ 1692010p -0.3
+ 1694000p -0.3
+ 1694010p 0.9
+ 1696000p 0.9
+ 1696010p -0.3
+ 1698000p -0.3
+ 1698010p 0.9
+ 1700000p 0.9
+ 1700010p -0.3
+ 1702000p -0.3
+ 1702010p 0.9
+ 1704000p 0.9
+ 1704010p -0.3
+ 1706000p -0.3
+ 1706010p 0.9
+ 1708000p 0.9
+ 1708010p -0.3
+ 1710000p -0.3
+ 1710010p 0.9
+ 1712000p 0.9
+ 1712010p -0.3
+ 1714000p -0.3
+ 1714010p 0.9
+ 1716000p 0.9
+ 1716010p -0.3
+ 1718000p -0.3
+ 1718010p 0.9
+ 1720000p 0.9
+ 1720010p -0.3
+ 1722000p -0.3
+ 1722010p 0.9
+ 1724000p 0.9
+ 1724010p -0.3
+ 1726000p -0.3
+ 1726010p 0.9
+ 1728000p 0.9
+ 1728010p -0.3
+ 1730000p -0.3
+ 1730010p 0.9
+ 1732000p 0.9
+ 1732010p -0.3
+ 1734000p -0.3
+ 1734010p 0.9
+ 1736000p 0.9
+ 1736010p -0.3
+ 1738000p -0.3
+ 1738010p 0.9
+ 1740000p 0.9
+ 1740010p -0.3
+ 1742000p -0.3
+ 1742010p 0.9
+ 1744000p 0.9
+ 1744010p -0.3
+ 1746000p -0.3
+ 1746010p 0.9
+ 1748000p 0.9
+ 1748010p -0.3
+ 1750000p -0.3
+ 1750010p 0.9
+ 1752000p 0.9
+ 1752010p -0.3
+ 1754000p -0.3
+ 1754010p 0.9
+ 1756000p 0.9
+ 1756010p -0.3
+ 1758000p -0.3
+ 1758010p 0.9
+ 1760000p 0.9
+ 1760010p -0.3
+ 1762000p -0.3
+ 1762010p 0.9
+ 1764000p 0.9
+ 1764010p -0.3
+ 1766000p -0.3
+ 1766010p 0.9
+ 1768000p 0.9
+ 1768010p -0.3
+ 1770000p -0.3
+ 1770010p 0.9
+ 1772000p 0.9
+ 1772010p -0.3
+ 1774000p -0.3
+ 1774010p 0.9
+ 1776000p 0.9
+ 1776010p -0.3
+ 1778000p -0.3
+ 1778010p 0.9
+ 1780000p 0.9
+ 1780010p -0.3
+ 1782000p -0.3
+ 1782010p 0.9
+ 1784000p 0.9
+ 1784010p -0.3
+ 1786000p -0.3
+ 1786010p 0.9
+ 1788000p 0.9
+ 1788010p -0.3
+ 1790000p -0.3
+ 1790010p 0.9
+ 1792000p 0.9
+ 1792010p -0.3
+ 1794000p -0.3
+ 1794010p 0.9
+ 1796000p 0.9
+ 1796010p -0.3
+ 1798000p -0.3
+ 1798010p 0.9
+ 1800000p 0.9
+ 1800010p -0.3
+ 1802000p -0.3
+ 1802010p 0.9
+ 1804000p 0.9
+ 1804010p -0.3
+ 1806000p -0.3
+ 1806010p 0.9
+ 1808000p 0.9
+ 1808010p -0.3
+ 1810000p -0.3
+ 1810010p 0.9
+ 1812000p 0.9
+ 1812010p -0.3
+ 1814000p -0.3
+ 1814010p 0.9
+ 1816000p 0.9
+ 1816010p -0.3
+ 1818000p -0.3
+ 1818010p 0.9
+ 1820000p 0.9
+ 1820010p -0.3
+ 1822000p -0.3
+ 1822010p 0.9
+ 1824000p 0.9
+ 1824010p -0.3
+ 1826000p -0.3
+ 1826010p 0.9
+ 1828000p 0.9
+ 1828010p -0.3
+ 1830000p -0.3
+ 1830010p 0.9
+ 1832000p 0.9
+ 1832010p -0.3
+ 1834000p -0.3
+ 1834010p 0.9
+ 1836000p 0.9
+ 1836010p -0.3
+ 1838000p -0.3
+ 1838010p 0.9
+ 1840000p 0.9
+ 1840010p -0.3
+ 1842000p -0.3
+ 1842010p 0.9
+ 1844000p 0.9
+ 1844010p -0.3
+ 1846000p -0.3
+ 1846010p 0.9
+ 1848000p 0.9
+ 1848010p -0.3
+ 1850000p -0.3
+ 1850010p 0.9
+ 1852000p 0.9
+ 1852010p -0.3
+ 1854000p -0.3
+ 1854010p 0.9
+ 1856000p 0.9
+ 1856010p -0.3
+ 1858000p -0.3
+ 1858010p 0.9
+ 1860000p 0.9
+ 1860010p -0.3
+ 1862000p -0.3
+ 1862010p 0.9
+ 1864000p 0.9
+ 1864010p -0.3
+ 1866000p -0.3
+ 1866010p 0.9
+ 1868000p 0.9
+ 1868010p -0.3
+ 1870000p -0.3
+ 1870010p 0.9
+ 1872000p 0.9
+ 1872010p -0.3
+ 1874000p -0.3
+ 1874010p 0.9
+ 1876000p 0.9
+ 1876010p -0.3
+ 1878000p -0.3
+ 1878010p 0.9
+ 1880000p 0.9
+ 1880010p -0.3
+ 1882000p -0.3
+ 1882010p 0.9
+ 1884000p 0.9
+ 1884010p -0.3
+ 1886000p -0.3
+ 1886010p 0.9
+ 1888000p 0.9
+ 1888010p -0.3
+ 1890000p -0.3
+ 1890010p 0.9
+ 1892000p 0.9
+ 1892010p -0.3
+ 1894000p -0.3
+ 1894010p 0.9
+ 1896000p 0.9
+ 1896010p -0.3
+ 1898000p -0.3
+ 1898010p 0.9
+ 1900000p 0.9
+ 1900010p -0.3
+ 1902000p -0.3
+ 1902010p 0.9
+ 1904000p 0.9
+ 1904010p -0.3
+ 1906000p -0.3
+ 1906010p 0.9
+ 1908000p 0.9
+ 1908010p -0.3
+ 1910000p -0.3
+ 1910010p 0.9
+ 1912000p 0.9
+ 1912010p -0.3
+ 1914000p -0.3
+ 1914010p 0.9
+ 1916000p 0.9
+ 1916010p -0.3
+ 1918000p -0.3
+ 1918010p 0.9
+ 1920000p 0.9
+ 1920010p -0.3
+ 1922000p -0.3
+ 1922010p 0.9
+ 1924000p 0.9
+ 1924010p -0.3
+ 1926000p -0.3
+ 1926010p 0.9
+ 1928000p 0.9
+ 1928010p -0.3
+ 1930000p -0.3
+ 1930010p 0.9
+ 1932000p 0.9
+ 1932010p -0.3
+ 1934000p -0.3
+ 1934010p 0.9
+ 1936000p 0.9
+ 1936010p -0.3
+ 1938000p -0.3
+ 1938010p 0.9
+ 1940000p 0.9
+ 1940010p -0.3
+ 1942000p -0.3
+ 1942010p 0.9
+ 1944000p 0.9
+ 1944010p -0.3
+ 1946000p -0.3
+ 1946010p 0.9
+ 1948000p 0.9
+ 1948010p -0.3
+ 1950000p -0.3
+ 1950010p 0.9
+ 1952000p 0.9
+ 1952010p -0.3
+ 1954000p -0.3
+ 1954010p 0.9
+ 1956000p 0.9
+ 1956010p -0.3
+ 1958000p -0.3
+ 1958010p 0.9
+ 1960000p 0.9
+ 1960010p -0.3
+ 1962000p -0.3
+ 1962010p 0.9
+ 1964000p 0.9
+ 1964010p -0.3
+ 1966000p -0.3
+ 1966010p 0.9
+ 1968000p 0.9
+ 1968010p -0.3
+ 1970000p -0.3
+ 1970010p 0.9
+ 1972000p 0.9
+ 1972010p -0.3
+ 1974000p -0.3
+ 1974010p 0.9
+ 1976000p 0.9
+ 1976010p -0.3
+ 1978000p -0.3
+ 1978010p 0.9
+ 1980000p 0.9
+ 1980010p -0.3
+ 1982000p -0.3
+ 1982010p 0.9
+ 1984000p 0.9
+ 1984010p -0.3
+ 1986000p -0.3
+ 1986010p 0.9
+ 1988000p 0.9
+ 1988010p -0.3
+ 1990000p -0.3
+ 1990010p 0.9
+ 1992000p 0.9
+ 1992010p -0.3
+ 1994000p -0.3
+ 1994010p 0.9
+ 1996000p 0.9
+ 1996010p -0.3
+ 1998000p -0.3
+ 1998010p 0.9
+ 2000000p 0.9
+ 2000010p -0.3
+ 2002000p -0.3
+ 2002010p 0.9
+ 2004000p 0.9
+ 2004010p -0.3
+ 2006000p -0.3
+ 2006010p 0.9
+ 2008000p 0.9
+ 2008010p -0.3
+ 2010000p -0.3
+ 2010010p 0.9
+ 2012000p 0.9
+ 2012010p -0.3
+ 2014000p -0.3
+ 2014010p 0.9
+ 2016000p 0.9
+ 2016010p -0.3
+ 2018000p -0.3
+ 2018010p 0.9
+ 2020000p 0.9
+ 2020010p -0.3
+ 2022000p -0.3
+ 2022010p 0.9
+ 2024000p 0.9
+ 2024010p -0.3
+ 2026000p -0.3
+ 2026010p 0.9
+ 2028000p 0.9
+ 2028010p -0.3
+ 2030000p -0.3
+ 2030010p 0.9
+ 2032000p 0.9
+ 2032010p -0.3
+ 2034000p -0.3
+ 2034010p 0.9
+ 2036000p 0.9
+ 2036010p -0.3
+ 2038000p -0.3
+ 2038010p 0.9
+ 2040000p 0.9
+ 2040010p -0.3
+ 2042000p -0.3
+ 2042010p 0.9
+ 2044000p 0.9
+ 2044010p -0.3
+ 2046000p -0.3
+ 2046010p 0.9
+ 2048000p 0.9
+ 2048010p -0.3
+ \]
V_data_20 (Data\\<20\\> gnd!) vsource type=pwl wave=\[
+ 0    0.9
+ 2000p 0.9
+ 2010p -0.3
+ 4000p -0.3
+ 4010p 0.9
+ 6000p 0.9
+ 6010p -0.3
+ 8000p -0.3
+ 8010p 0.9
+ 10000p 0.9
+ 10010p -0.3
+ 12000p -0.3
+ 12010p 0.9
+ 14000p 0.9
+ 14010p -0.3
+ 16000p -0.3
+ 16010p 0.9
+ 18000p 0.9
+ 18010p -0.3
+ 20000p -0.3
+ 20010p 0.9
+ 22000p 0.9
+ 22010p -0.3
+ 24000p -0.3
+ 24010p 0.9
+ 26000p 0.9
+ 26010p -0.3
+ 28000p -0.3
+ 28010p 0.9
+ 30000p 0.9
+ 30010p -0.3
+ 32000p -0.3
+ 32010p 0.9
+ 34000p 0.9
+ 34010p -0.3
+ 36000p -0.3
+ 36010p 0.9
+ 38000p 0.9
+ 38010p -0.3
+ 40000p -0.3
+ 40010p 0.9
+ 42000p 0.9
+ 42010p -0.3
+ 44000p -0.3
+ 44010p 0.9
+ 46000p 0.9
+ 46010p -0.3
+ 48000p -0.3
+ 48010p 0.9
+ 50000p 0.9
+ 50010p -0.3
+ 52000p -0.3
+ 52010p 0.9
+ 54000p 0.9
+ 54010p -0.3
+ 56000p -0.3
+ 56010p 0.9
+ 58000p 0.9
+ 58010p -0.3
+ 60000p -0.3
+ 60010p 0.9
+ 62000p 0.9
+ 62010p -0.3
+ 64000p -0.3
+ 64010p 0.9
+ 66000p 0.9
+ 66010p -0.3
+ 68000p -0.3
+ 68010p 0.9
+ 70000p 0.9
+ 70010p -0.3
+ 72000p -0.3
+ 72010p 0.9
+ 74000p 0.9
+ 74010p -0.3
+ 76000p -0.3
+ 76010p 0.9
+ 78000p 0.9
+ 78010p -0.3
+ 80000p -0.3
+ 80010p 0.9
+ 82000p 0.9
+ 82010p -0.3
+ 84000p -0.3
+ 84010p 0.9
+ 86000p 0.9
+ 86010p -0.3
+ 88000p -0.3
+ 88010p 0.9
+ 90000p 0.9
+ 90010p -0.3
+ 92000p -0.3
+ 92010p 0.9
+ 94000p 0.9
+ 94010p -0.3
+ 96000p -0.3
+ 96010p 0.9
+ 98000p 0.9
+ 98010p -0.3
+ 100000p -0.3
+ 100010p 0.9
+ 102000p 0.9
+ 102010p -0.3
+ 104000p -0.3
+ 104010p 0.9
+ 106000p 0.9
+ 106010p -0.3
+ 108000p -0.3
+ 108010p 0.9
+ 110000p 0.9
+ 110010p -0.3
+ 112000p -0.3
+ 112010p 0.9
+ 114000p 0.9
+ 114010p -0.3
+ 116000p -0.3
+ 116010p 0.9
+ 118000p 0.9
+ 118010p -0.3
+ 120000p -0.3
+ 120010p 0.9
+ 122000p 0.9
+ 122010p -0.3
+ 124000p -0.3
+ 124010p 0.9
+ 126000p 0.9
+ 126010p -0.3
+ 128000p -0.3
+ 128010p 0.9
+ 130000p 0.9
+ 130010p -0.3
+ 132000p -0.3
+ 132010p 0.9
+ 134000p 0.9
+ 134010p -0.3
+ 136000p -0.3
+ 136010p 0.9
+ 138000p 0.9
+ 138010p -0.3
+ 140000p -0.3
+ 140010p 0.9
+ 142000p 0.9
+ 142010p -0.3
+ 144000p -0.3
+ 144010p 0.9
+ 146000p 0.9
+ 146010p -0.3
+ 148000p -0.3
+ 148010p 0.9
+ 150000p 0.9
+ 150010p -0.3
+ 152000p -0.3
+ 152010p 0.9
+ 154000p 0.9
+ 154010p -0.3
+ 156000p -0.3
+ 156010p 0.9
+ 158000p 0.9
+ 158010p -0.3
+ 160000p -0.3
+ 160010p 0.9
+ 162000p 0.9
+ 162010p -0.3
+ 164000p -0.3
+ 164010p 0.9
+ 166000p 0.9
+ 166010p -0.3
+ 168000p -0.3
+ 168010p 0.9
+ 170000p 0.9
+ 170010p -0.3
+ 172000p -0.3
+ 172010p 0.9
+ 174000p 0.9
+ 174010p -0.3
+ 176000p -0.3
+ 176010p 0.9
+ 178000p 0.9
+ 178010p -0.3
+ 180000p -0.3
+ 180010p 0.9
+ 182000p 0.9
+ 182010p -0.3
+ 184000p -0.3
+ 184010p 0.9
+ 186000p 0.9
+ 186010p -0.3
+ 188000p -0.3
+ 188010p 0.9
+ 190000p 0.9
+ 190010p -0.3
+ 192000p -0.3
+ 192010p 0.9
+ 194000p 0.9
+ 194010p -0.3
+ 196000p -0.3
+ 196010p 0.9
+ 198000p 0.9
+ 198010p -0.3
+ 200000p -0.3
+ 200010p 0.9
+ 202000p 0.9
+ 202010p -0.3
+ 204000p -0.3
+ 204010p 0.9
+ 206000p 0.9
+ 206010p -0.3
+ 208000p -0.3
+ 208010p 0.9
+ 210000p 0.9
+ 210010p -0.3
+ 212000p -0.3
+ 212010p 0.9
+ 214000p 0.9
+ 214010p -0.3
+ 216000p -0.3
+ 216010p 0.9
+ 218000p 0.9
+ 218010p -0.3
+ 220000p -0.3
+ 220010p 0.9
+ 222000p 0.9
+ 222010p -0.3
+ 224000p -0.3
+ 224010p 0.9
+ 226000p 0.9
+ 226010p -0.3
+ 228000p -0.3
+ 228010p 0.9
+ 230000p 0.9
+ 230010p -0.3
+ 232000p -0.3
+ 232010p 0.9
+ 234000p 0.9
+ 234010p -0.3
+ 236000p -0.3
+ 236010p 0.9
+ 238000p 0.9
+ 238010p -0.3
+ 240000p -0.3
+ 240010p 0.9
+ 242000p 0.9
+ 242010p -0.3
+ 244000p -0.3
+ 244010p 0.9
+ 246000p 0.9
+ 246010p -0.3
+ 248000p -0.3
+ 248010p 0.9
+ 250000p 0.9
+ 250010p -0.3
+ 252000p -0.3
+ 252010p 0.9
+ 254000p 0.9
+ 254010p -0.3
+ 256000p -0.3
+ 256010p 0.9
+ 258000p 0.9
+ 258010p -0.3
+ 260000p -0.3
+ 260010p 0.9
+ 262000p 0.9
+ 262010p -0.3
+ 264000p -0.3
+ 264010p 0.9
+ 266000p 0.9
+ 266010p -0.3
+ 268000p -0.3
+ 268010p 0.9
+ 270000p 0.9
+ 270010p -0.3
+ 272000p -0.3
+ 272010p 0.9
+ 274000p 0.9
+ 274010p -0.3
+ 276000p -0.3
+ 276010p 0.9
+ 278000p 0.9
+ 278010p -0.3
+ 280000p -0.3
+ 280010p 0.9
+ 282000p 0.9
+ 282010p -0.3
+ 284000p -0.3
+ 284010p 0.9
+ 286000p 0.9
+ 286010p -0.3
+ 288000p -0.3
+ 288010p 0.9
+ 290000p 0.9
+ 290010p -0.3
+ 292000p -0.3
+ 292010p 0.9
+ 294000p 0.9
+ 294010p -0.3
+ 296000p -0.3
+ 296010p 0.9
+ 298000p 0.9
+ 298010p -0.3
+ 300000p -0.3
+ 300010p 0.9
+ 302000p 0.9
+ 302010p -0.3
+ 304000p -0.3
+ 304010p 0.9
+ 306000p 0.9
+ 306010p -0.3
+ 308000p -0.3
+ 308010p 0.9
+ 310000p 0.9
+ 310010p -0.3
+ 312000p -0.3
+ 312010p 0.9
+ 314000p 0.9
+ 314010p -0.3
+ 316000p -0.3
+ 316010p 0.9
+ 318000p 0.9
+ 318010p -0.3
+ 320000p -0.3
+ 320010p 0.9
+ 322000p 0.9
+ 322010p -0.3
+ 324000p -0.3
+ 324010p 0.9
+ 326000p 0.9
+ 326010p -0.3
+ 328000p -0.3
+ 328010p 0.9
+ 330000p 0.9
+ 330010p -0.3
+ 332000p -0.3
+ 332010p 0.9
+ 334000p 0.9
+ 334010p -0.3
+ 336000p -0.3
+ 336010p 0.9
+ 338000p 0.9
+ 338010p -0.3
+ 340000p -0.3
+ 340010p 0.9
+ 342000p 0.9
+ 342010p -0.3
+ 344000p -0.3
+ 344010p 0.9
+ 346000p 0.9
+ 346010p -0.3
+ 348000p -0.3
+ 348010p 0.9
+ 350000p 0.9
+ 350010p -0.3
+ 352000p -0.3
+ 352010p 0.9
+ 354000p 0.9
+ 354010p -0.3
+ 356000p -0.3
+ 356010p 0.9
+ 358000p 0.9
+ 358010p -0.3
+ 360000p -0.3
+ 360010p 0.9
+ 362000p 0.9
+ 362010p -0.3
+ 364000p -0.3
+ 364010p 0.9
+ 366000p 0.9
+ 366010p -0.3
+ 368000p -0.3
+ 368010p 0.9
+ 370000p 0.9
+ 370010p -0.3
+ 372000p -0.3
+ 372010p 0.9
+ 374000p 0.9
+ 374010p -0.3
+ 376000p -0.3
+ 376010p 0.9
+ 378000p 0.9
+ 378010p -0.3
+ 380000p -0.3
+ 380010p 0.9
+ 382000p 0.9
+ 382010p -0.3
+ 384000p -0.3
+ 384010p 0.9
+ 386000p 0.9
+ 386010p -0.3
+ 388000p -0.3
+ 388010p 0.9
+ 390000p 0.9
+ 390010p -0.3
+ 392000p -0.3
+ 392010p 0.9
+ 394000p 0.9
+ 394010p -0.3
+ 396000p -0.3
+ 396010p 0.9
+ 398000p 0.9
+ 398010p -0.3
+ 400000p -0.3
+ 400010p 0.9
+ 402000p 0.9
+ 402010p -0.3
+ 404000p -0.3
+ 404010p 0.9
+ 406000p 0.9
+ 406010p -0.3
+ 408000p -0.3
+ 408010p 0.9
+ 410000p 0.9
+ 410010p -0.3
+ 412000p -0.3
+ 412010p 0.9
+ 414000p 0.9
+ 414010p -0.3
+ 416000p -0.3
+ 416010p 0.9
+ 418000p 0.9
+ 418010p -0.3
+ 420000p -0.3
+ 420010p 0.9
+ 422000p 0.9
+ 422010p -0.3
+ 424000p -0.3
+ 424010p 0.9
+ 426000p 0.9
+ 426010p -0.3
+ 428000p -0.3
+ 428010p 0.9
+ 430000p 0.9
+ 430010p -0.3
+ 432000p -0.3
+ 432010p 0.9
+ 434000p 0.9
+ 434010p -0.3
+ 436000p -0.3
+ 436010p 0.9
+ 438000p 0.9
+ 438010p -0.3
+ 440000p -0.3
+ 440010p 0.9
+ 442000p 0.9
+ 442010p -0.3
+ 444000p -0.3
+ 444010p 0.9
+ 446000p 0.9
+ 446010p -0.3
+ 448000p -0.3
+ 448010p 0.9
+ 450000p 0.9
+ 450010p -0.3
+ 452000p -0.3
+ 452010p 0.9
+ 454000p 0.9
+ 454010p -0.3
+ 456000p -0.3
+ 456010p 0.9
+ 458000p 0.9
+ 458010p -0.3
+ 460000p -0.3
+ 460010p 0.9
+ 462000p 0.9
+ 462010p -0.3
+ 464000p -0.3
+ 464010p 0.9
+ 466000p 0.9
+ 466010p -0.3
+ 468000p -0.3
+ 468010p 0.9
+ 470000p 0.9
+ 470010p -0.3
+ 472000p -0.3
+ 472010p 0.9
+ 474000p 0.9
+ 474010p -0.3
+ 476000p -0.3
+ 476010p 0.9
+ 478000p 0.9
+ 478010p -0.3
+ 480000p -0.3
+ 480010p 0.9
+ 482000p 0.9
+ 482010p -0.3
+ 484000p -0.3
+ 484010p 0.9
+ 486000p 0.9
+ 486010p -0.3
+ 488000p -0.3
+ 488010p 0.9
+ 490000p 0.9
+ 490010p -0.3
+ 492000p -0.3
+ 492010p 0.9
+ 494000p 0.9
+ 494010p -0.3
+ 496000p -0.3
+ 496010p 0.9
+ 498000p 0.9
+ 498010p -0.3
+ 500000p -0.3
+ 500010p 0.9
+ 502000p 0.9
+ 502010p -0.3
+ 504000p -0.3
+ 504010p 0.9
+ 506000p 0.9
+ 506010p -0.3
+ 508000p -0.3
+ 508010p 0.9
+ 510000p 0.9
+ 510010p -0.3
+ 512000p -0.3
+ 512010p 0.9
+ 514000p 0.9
+ 514010p -0.3
+ 516000p -0.3
+ 516010p 0.9
+ 518000p 0.9
+ 518010p -0.3
+ 520000p -0.3
+ 520010p 0.9
+ 522000p 0.9
+ 522010p -0.3
+ 524000p -0.3
+ 524010p 0.9
+ 526000p 0.9
+ 526010p -0.3
+ 528000p -0.3
+ 528010p 0.9
+ 530000p 0.9
+ 530010p -0.3
+ 532000p -0.3
+ 532010p 0.9
+ 534000p 0.9
+ 534010p -0.3
+ 536000p -0.3
+ 536010p 0.9
+ 538000p 0.9
+ 538010p -0.3
+ 540000p -0.3
+ 540010p 0.9
+ 542000p 0.9
+ 542010p -0.3
+ 544000p -0.3
+ 544010p 0.9
+ 546000p 0.9
+ 546010p -0.3
+ 548000p -0.3
+ 548010p 0.9
+ 550000p 0.9
+ 550010p -0.3
+ 552000p -0.3
+ 552010p 0.9
+ 554000p 0.9
+ 554010p -0.3
+ 556000p -0.3
+ 556010p 0.9
+ 558000p 0.9
+ 558010p -0.3
+ 560000p -0.3
+ 560010p 0.9
+ 562000p 0.9
+ 562010p -0.3
+ 564000p -0.3
+ 564010p 0.9
+ 566000p 0.9
+ 566010p -0.3
+ 568000p -0.3
+ 568010p 0.9
+ 570000p 0.9
+ 570010p -0.3
+ 572000p -0.3
+ 572010p 0.9
+ 574000p 0.9
+ 574010p -0.3
+ 576000p -0.3
+ 576010p 0.9
+ 578000p 0.9
+ 578010p -0.3
+ 580000p -0.3
+ 580010p 0.9
+ 582000p 0.9
+ 582010p -0.3
+ 584000p -0.3
+ 584010p 0.9
+ 586000p 0.9
+ 586010p -0.3
+ 588000p -0.3
+ 588010p 0.9
+ 590000p 0.9
+ 590010p -0.3
+ 592000p -0.3
+ 592010p 0.9
+ 594000p 0.9
+ 594010p -0.3
+ 596000p -0.3
+ 596010p 0.9
+ 598000p 0.9
+ 598010p -0.3
+ 600000p -0.3
+ 600010p 0.9
+ 602000p 0.9
+ 602010p -0.3
+ 604000p -0.3
+ 604010p 0.9
+ 606000p 0.9
+ 606010p -0.3
+ 608000p -0.3
+ 608010p 0.9
+ 610000p 0.9
+ 610010p -0.3
+ 612000p -0.3
+ 612010p 0.9
+ 614000p 0.9
+ 614010p -0.3
+ 616000p -0.3
+ 616010p 0.9
+ 618000p 0.9
+ 618010p -0.3
+ 620000p -0.3
+ 620010p 0.9
+ 622000p 0.9
+ 622010p -0.3
+ 624000p -0.3
+ 624010p 0.9
+ 626000p 0.9
+ 626010p -0.3
+ 628000p -0.3
+ 628010p 0.9
+ 630000p 0.9
+ 630010p -0.3
+ 632000p -0.3
+ 632010p 0.9
+ 634000p 0.9
+ 634010p -0.3
+ 636000p -0.3
+ 636010p 0.9
+ 638000p 0.9
+ 638010p -0.3
+ 640000p -0.3
+ 640010p 0.9
+ 642000p 0.9
+ 642010p -0.3
+ 644000p -0.3
+ 644010p 0.9
+ 646000p 0.9
+ 646010p -0.3
+ 648000p -0.3
+ 648010p 0.9
+ 650000p 0.9
+ 650010p -0.3
+ 652000p -0.3
+ 652010p 0.9
+ 654000p 0.9
+ 654010p -0.3
+ 656000p -0.3
+ 656010p 0.9
+ 658000p 0.9
+ 658010p -0.3
+ 660000p -0.3
+ 660010p 0.9
+ 662000p 0.9
+ 662010p -0.3
+ 664000p -0.3
+ 664010p 0.9
+ 666000p 0.9
+ 666010p -0.3
+ 668000p -0.3
+ 668010p 0.9
+ 670000p 0.9
+ 670010p -0.3
+ 672000p -0.3
+ 672010p 0.9
+ 674000p 0.9
+ 674010p -0.3
+ 676000p -0.3
+ 676010p 0.9
+ 678000p 0.9
+ 678010p -0.3
+ 680000p -0.3
+ 680010p 0.9
+ 682000p 0.9
+ 682010p -0.3
+ 684000p -0.3
+ 684010p 0.9
+ 686000p 0.9
+ 686010p -0.3
+ 688000p -0.3
+ 688010p 0.9
+ 690000p 0.9
+ 690010p -0.3
+ 692000p -0.3
+ 692010p 0.9
+ 694000p 0.9
+ 694010p -0.3
+ 696000p -0.3
+ 696010p 0.9
+ 698000p 0.9
+ 698010p -0.3
+ 700000p -0.3
+ 700010p 0.9
+ 702000p 0.9
+ 702010p -0.3
+ 704000p -0.3
+ 704010p 0.9
+ 706000p 0.9
+ 706010p -0.3
+ 708000p -0.3
+ 708010p 0.9
+ 710000p 0.9
+ 710010p -0.3
+ 712000p -0.3
+ 712010p 0.9
+ 714000p 0.9
+ 714010p -0.3
+ 716000p -0.3
+ 716010p 0.9
+ 718000p 0.9
+ 718010p -0.3
+ 720000p -0.3
+ 720010p 0.9
+ 722000p 0.9
+ 722010p -0.3
+ 724000p -0.3
+ 724010p 0.9
+ 726000p 0.9
+ 726010p -0.3
+ 728000p -0.3
+ 728010p 0.9
+ 730000p 0.9
+ 730010p -0.3
+ 732000p -0.3
+ 732010p 0.9
+ 734000p 0.9
+ 734010p -0.3
+ 736000p -0.3
+ 736010p 0.9
+ 738000p 0.9
+ 738010p -0.3
+ 740000p -0.3
+ 740010p 0.9
+ 742000p 0.9
+ 742010p -0.3
+ 744000p -0.3
+ 744010p 0.9
+ 746000p 0.9
+ 746010p -0.3
+ 748000p -0.3
+ 748010p 0.9
+ 750000p 0.9
+ 750010p -0.3
+ 752000p -0.3
+ 752010p 0.9
+ 754000p 0.9
+ 754010p -0.3
+ 756000p -0.3
+ 756010p 0.9
+ 758000p 0.9
+ 758010p -0.3
+ 760000p -0.3
+ 760010p 0.9
+ 762000p 0.9
+ 762010p -0.3
+ 764000p -0.3
+ 764010p 0.9
+ 766000p 0.9
+ 766010p -0.3
+ 768000p -0.3
+ 768010p 0.9
+ 770000p 0.9
+ 770010p -0.3
+ 772000p -0.3
+ 772010p 0.9
+ 774000p 0.9
+ 774010p -0.3
+ 776000p -0.3
+ 776010p 0.9
+ 778000p 0.9
+ 778010p -0.3
+ 780000p -0.3
+ 780010p 0.9
+ 782000p 0.9
+ 782010p -0.3
+ 784000p -0.3
+ 784010p 0.9
+ 786000p 0.9
+ 786010p -0.3
+ 788000p -0.3
+ 788010p 0.9
+ 790000p 0.9
+ 790010p -0.3
+ 792000p -0.3
+ 792010p 0.9
+ 794000p 0.9
+ 794010p -0.3
+ 796000p -0.3
+ 796010p 0.9
+ 798000p 0.9
+ 798010p -0.3
+ 800000p -0.3
+ 800010p 0.9
+ 802000p 0.9
+ 802010p -0.3
+ 804000p -0.3
+ 804010p 0.9
+ 806000p 0.9
+ 806010p -0.3
+ 808000p -0.3
+ 808010p 0.9
+ 810000p 0.9
+ 810010p -0.3
+ 812000p -0.3
+ 812010p 0.9
+ 814000p 0.9
+ 814010p -0.3
+ 816000p -0.3
+ 816010p 0.9
+ 818000p 0.9
+ 818010p -0.3
+ 820000p -0.3
+ 820010p 0.9
+ 822000p 0.9
+ 822010p -0.3
+ 824000p -0.3
+ 824010p 0.9
+ 826000p 0.9
+ 826010p -0.3
+ 828000p -0.3
+ 828010p 0.9
+ 830000p 0.9
+ 830010p -0.3
+ 832000p -0.3
+ 832010p 0.9
+ 834000p 0.9
+ 834010p -0.3
+ 836000p -0.3
+ 836010p 0.9
+ 838000p 0.9
+ 838010p -0.3
+ 840000p -0.3
+ 840010p 0.9
+ 842000p 0.9
+ 842010p -0.3
+ 844000p -0.3
+ 844010p 0.9
+ 846000p 0.9
+ 846010p -0.3
+ 848000p -0.3
+ 848010p 0.9
+ 850000p 0.9
+ 850010p -0.3
+ 852000p -0.3
+ 852010p 0.9
+ 854000p 0.9
+ 854010p -0.3
+ 856000p -0.3
+ 856010p 0.9
+ 858000p 0.9
+ 858010p -0.3
+ 860000p -0.3
+ 860010p 0.9
+ 862000p 0.9
+ 862010p -0.3
+ 864000p -0.3
+ 864010p 0.9
+ 866000p 0.9
+ 866010p -0.3
+ 868000p -0.3
+ 868010p 0.9
+ 870000p 0.9
+ 870010p -0.3
+ 872000p -0.3
+ 872010p 0.9
+ 874000p 0.9
+ 874010p -0.3
+ 876000p -0.3
+ 876010p 0.9
+ 878000p 0.9
+ 878010p -0.3
+ 880000p -0.3
+ 880010p 0.9
+ 882000p 0.9
+ 882010p -0.3
+ 884000p -0.3
+ 884010p 0.9
+ 886000p 0.9
+ 886010p -0.3
+ 888000p -0.3
+ 888010p 0.9
+ 890000p 0.9
+ 890010p -0.3
+ 892000p -0.3
+ 892010p 0.9
+ 894000p 0.9
+ 894010p -0.3
+ 896000p -0.3
+ 896010p 0.9
+ 898000p 0.9
+ 898010p -0.3
+ 900000p -0.3
+ 900010p 0.9
+ 902000p 0.9
+ 902010p -0.3
+ 904000p -0.3
+ 904010p 0.9
+ 906000p 0.9
+ 906010p -0.3
+ 908000p -0.3
+ 908010p 0.9
+ 910000p 0.9
+ 910010p -0.3
+ 912000p -0.3
+ 912010p 0.9
+ 914000p 0.9
+ 914010p -0.3
+ 916000p -0.3
+ 916010p 0.9
+ 918000p 0.9
+ 918010p -0.3
+ 920000p -0.3
+ 920010p 0.9
+ 922000p 0.9
+ 922010p -0.3
+ 924000p -0.3
+ 924010p 0.9
+ 926000p 0.9
+ 926010p -0.3
+ 928000p -0.3
+ 928010p 0.9
+ 930000p 0.9
+ 930010p -0.3
+ 932000p -0.3
+ 932010p 0.9
+ 934000p 0.9
+ 934010p -0.3
+ 936000p -0.3
+ 936010p 0.9
+ 938000p 0.9
+ 938010p -0.3
+ 940000p -0.3
+ 940010p 0.9
+ 942000p 0.9
+ 942010p -0.3
+ 944000p -0.3
+ 944010p 0.9
+ 946000p 0.9
+ 946010p -0.3
+ 948000p -0.3
+ 948010p 0.9
+ 950000p 0.9
+ 950010p -0.3
+ 952000p -0.3
+ 952010p 0.9
+ 954000p 0.9
+ 954010p -0.3
+ 956000p -0.3
+ 956010p 0.9
+ 958000p 0.9
+ 958010p -0.3
+ 960000p -0.3
+ 960010p 0.9
+ 962000p 0.9
+ 962010p -0.3
+ 964000p -0.3
+ 964010p 0.9
+ 966000p 0.9
+ 966010p -0.3
+ 968000p -0.3
+ 968010p 0.9
+ 970000p 0.9
+ 970010p -0.3
+ 972000p -0.3
+ 972010p 0.9
+ 974000p 0.9
+ 974010p -0.3
+ 976000p -0.3
+ 976010p 0.9
+ 978000p 0.9
+ 978010p -0.3
+ 980000p -0.3
+ 980010p 0.9
+ 982000p 0.9
+ 982010p -0.3
+ 984000p -0.3
+ 984010p 0.9
+ 986000p 0.9
+ 986010p -0.3
+ 988000p -0.3
+ 988010p 0.9
+ 990000p 0.9
+ 990010p -0.3
+ 992000p -0.3
+ 992010p 0.9
+ 994000p 0.9
+ 994010p -0.3
+ 996000p -0.3
+ 996010p 0.9
+ 998000p 0.9
+ 998010p -0.3
+ 1000000p -0.3
+ 1000010p 0.9
+ 1002000p 0.9
+ 1002010p -0.3
+ 1004000p -0.3
+ 1004010p 0.9
+ 1006000p 0.9
+ 1006010p -0.3
+ 1008000p -0.3
+ 1008010p 0.9
+ 1010000p 0.9
+ 1010010p -0.3
+ 1012000p -0.3
+ 1012010p 0.9
+ 1014000p 0.9
+ 1014010p -0.3
+ 1016000p -0.3
+ 1016010p 0.9
+ 1018000p 0.9
+ 1018010p -0.3
+ 1020000p -0.3
+ 1020010p 0.9
+ 1022000p 0.9
+ 1022010p -0.3
+ 1024000p -0.3
+ 1024010p 0.9
+ 1026000p 0.9
+ 1026010p -0.3
+ 1028000p -0.3
+ 1028010p 0.9
+ 1030000p 0.9
+ 1030010p -0.3
+ 1032000p -0.3
+ 1032010p 0.9
+ 1034000p 0.9
+ 1034010p -0.3
+ 1036000p -0.3
+ 1036010p 0.9
+ 1038000p 0.9
+ 1038010p -0.3
+ 1040000p -0.3
+ 1040010p 0.9
+ 1042000p 0.9
+ 1042010p -0.3
+ 1044000p -0.3
+ 1044010p 0.9
+ 1046000p 0.9
+ 1046010p -0.3
+ 1048000p -0.3
+ 1048010p 0.9
+ 1050000p 0.9
+ 1050010p -0.3
+ 1052000p -0.3
+ 1052010p 0.9
+ 1054000p 0.9
+ 1054010p -0.3
+ 1056000p -0.3
+ 1056010p 0.9
+ 1058000p 0.9
+ 1058010p -0.3
+ 1060000p -0.3
+ 1060010p 0.9
+ 1062000p 0.9
+ 1062010p -0.3
+ 1064000p -0.3
+ 1064010p 0.9
+ 1066000p 0.9
+ 1066010p -0.3
+ 1068000p -0.3
+ 1068010p 0.9
+ 1070000p 0.9
+ 1070010p -0.3
+ 1072000p -0.3
+ 1072010p 0.9
+ 1074000p 0.9
+ 1074010p -0.3
+ 1076000p -0.3
+ 1076010p 0.9
+ 1078000p 0.9
+ 1078010p -0.3
+ 1080000p -0.3
+ 1080010p 0.9
+ 1082000p 0.9
+ 1082010p -0.3
+ 1084000p -0.3
+ 1084010p 0.9
+ 1086000p 0.9
+ 1086010p -0.3
+ 1088000p -0.3
+ 1088010p 0.9
+ 1090000p 0.9
+ 1090010p -0.3
+ 1092000p -0.3
+ 1092010p 0.9
+ 1094000p 0.9
+ 1094010p -0.3
+ 1096000p -0.3
+ 1096010p 0.9
+ 1098000p 0.9
+ 1098010p -0.3
+ 1100000p -0.3
+ 1100010p 0.9
+ 1102000p 0.9
+ 1102010p -0.3
+ 1104000p -0.3
+ 1104010p 0.9
+ 1106000p 0.9
+ 1106010p -0.3
+ 1108000p -0.3
+ 1108010p 0.9
+ 1110000p 0.9
+ 1110010p -0.3
+ 1112000p -0.3
+ 1112010p 0.9
+ 1114000p 0.9
+ 1114010p -0.3
+ 1116000p -0.3
+ 1116010p 0.9
+ 1118000p 0.9
+ 1118010p -0.3
+ 1120000p -0.3
+ 1120010p 0.9
+ 1122000p 0.9
+ 1122010p -0.3
+ 1124000p -0.3
+ 1124010p 0.9
+ 1126000p 0.9
+ 1126010p -0.3
+ 1128000p -0.3
+ 1128010p 0.9
+ 1130000p 0.9
+ 1130010p -0.3
+ 1132000p -0.3
+ 1132010p 0.9
+ 1134000p 0.9
+ 1134010p -0.3
+ 1136000p -0.3
+ 1136010p 0.9
+ 1138000p 0.9
+ 1138010p -0.3
+ 1140000p -0.3
+ 1140010p 0.9
+ 1142000p 0.9
+ 1142010p -0.3
+ 1144000p -0.3
+ 1144010p 0.9
+ 1146000p 0.9
+ 1146010p -0.3
+ 1148000p -0.3
+ 1148010p 0.9
+ 1150000p 0.9
+ 1150010p -0.3
+ 1152000p -0.3
+ 1152010p 0.9
+ 1154000p 0.9
+ 1154010p -0.3
+ 1156000p -0.3
+ 1156010p 0.9
+ 1158000p 0.9
+ 1158010p -0.3
+ 1160000p -0.3
+ 1160010p 0.9
+ 1162000p 0.9
+ 1162010p -0.3
+ 1164000p -0.3
+ 1164010p 0.9
+ 1166000p 0.9
+ 1166010p -0.3
+ 1168000p -0.3
+ 1168010p 0.9
+ 1170000p 0.9
+ 1170010p -0.3
+ 1172000p -0.3
+ 1172010p 0.9
+ 1174000p 0.9
+ 1174010p -0.3
+ 1176000p -0.3
+ 1176010p 0.9
+ 1178000p 0.9
+ 1178010p -0.3
+ 1180000p -0.3
+ 1180010p 0.9
+ 1182000p 0.9
+ 1182010p -0.3
+ 1184000p -0.3
+ 1184010p 0.9
+ 1186000p 0.9
+ 1186010p -0.3
+ 1188000p -0.3
+ 1188010p 0.9
+ 1190000p 0.9
+ 1190010p -0.3
+ 1192000p -0.3
+ 1192010p 0.9
+ 1194000p 0.9
+ 1194010p -0.3
+ 1196000p -0.3
+ 1196010p 0.9
+ 1198000p 0.9
+ 1198010p -0.3
+ 1200000p -0.3
+ 1200010p 0.9
+ 1202000p 0.9
+ 1202010p -0.3
+ 1204000p -0.3
+ 1204010p 0.9
+ 1206000p 0.9
+ 1206010p -0.3
+ 1208000p -0.3
+ 1208010p 0.9
+ 1210000p 0.9
+ 1210010p -0.3
+ 1212000p -0.3
+ 1212010p 0.9
+ 1214000p 0.9
+ 1214010p -0.3
+ 1216000p -0.3
+ 1216010p 0.9
+ 1218000p 0.9
+ 1218010p -0.3
+ 1220000p -0.3
+ 1220010p 0.9
+ 1222000p 0.9
+ 1222010p -0.3
+ 1224000p -0.3
+ 1224010p 0.9
+ 1226000p 0.9
+ 1226010p -0.3
+ 1228000p -0.3
+ 1228010p 0.9
+ 1230000p 0.9
+ 1230010p -0.3
+ 1232000p -0.3
+ 1232010p 0.9
+ 1234000p 0.9
+ 1234010p -0.3
+ 1236000p -0.3
+ 1236010p 0.9
+ 1238000p 0.9
+ 1238010p -0.3
+ 1240000p -0.3
+ 1240010p 0.9
+ 1242000p 0.9
+ 1242010p -0.3
+ 1244000p -0.3
+ 1244010p 0.9
+ 1246000p 0.9
+ 1246010p -0.3
+ 1248000p -0.3
+ 1248010p 0.9
+ 1250000p 0.9
+ 1250010p -0.3
+ 1252000p -0.3
+ 1252010p 0.9
+ 1254000p 0.9
+ 1254010p -0.3
+ 1256000p -0.3
+ 1256010p 0.9
+ 1258000p 0.9
+ 1258010p -0.3
+ 1260000p -0.3
+ 1260010p 0.9
+ 1262000p 0.9
+ 1262010p -0.3
+ 1264000p -0.3
+ 1264010p 0.9
+ 1266000p 0.9
+ 1266010p -0.3
+ 1268000p -0.3
+ 1268010p 0.9
+ 1270000p 0.9
+ 1270010p -0.3
+ 1272000p -0.3
+ 1272010p 0.9
+ 1274000p 0.9
+ 1274010p -0.3
+ 1276000p -0.3
+ 1276010p 0.9
+ 1278000p 0.9
+ 1278010p -0.3
+ 1280000p -0.3
+ 1280010p 0.9
+ 1282000p 0.9
+ 1282010p -0.3
+ 1284000p -0.3
+ 1284010p 0.9
+ 1286000p 0.9
+ 1286010p -0.3
+ 1288000p -0.3
+ 1288010p 0.9
+ 1290000p 0.9
+ 1290010p -0.3
+ 1292000p -0.3
+ 1292010p 0.9
+ 1294000p 0.9
+ 1294010p -0.3
+ 1296000p -0.3
+ 1296010p 0.9
+ 1298000p 0.9
+ 1298010p -0.3
+ 1300000p -0.3
+ 1300010p 0.9
+ 1302000p 0.9
+ 1302010p -0.3
+ 1304000p -0.3
+ 1304010p 0.9
+ 1306000p 0.9
+ 1306010p -0.3
+ 1308000p -0.3
+ 1308010p 0.9
+ 1310000p 0.9
+ 1310010p -0.3
+ 1312000p -0.3
+ 1312010p 0.9
+ 1314000p 0.9
+ 1314010p -0.3
+ 1316000p -0.3
+ 1316010p 0.9
+ 1318000p 0.9
+ 1318010p -0.3
+ 1320000p -0.3
+ 1320010p 0.9
+ 1322000p 0.9
+ 1322010p -0.3
+ 1324000p -0.3
+ 1324010p 0.9
+ 1326000p 0.9
+ 1326010p -0.3
+ 1328000p -0.3
+ 1328010p 0.9
+ 1330000p 0.9
+ 1330010p -0.3
+ 1332000p -0.3
+ 1332010p 0.9
+ 1334000p 0.9
+ 1334010p -0.3
+ 1336000p -0.3
+ 1336010p 0.9
+ 1338000p 0.9
+ 1338010p -0.3
+ 1340000p -0.3
+ 1340010p 0.9
+ 1342000p 0.9
+ 1342010p -0.3
+ 1344000p -0.3
+ 1344010p 0.9
+ 1346000p 0.9
+ 1346010p -0.3
+ 1348000p -0.3
+ 1348010p 0.9
+ 1350000p 0.9
+ 1350010p -0.3
+ 1352000p -0.3
+ 1352010p 0.9
+ 1354000p 0.9
+ 1354010p -0.3
+ 1356000p -0.3
+ 1356010p 0.9
+ 1358000p 0.9
+ 1358010p -0.3
+ 1360000p -0.3
+ 1360010p 0.9
+ 1362000p 0.9
+ 1362010p -0.3
+ 1364000p -0.3
+ 1364010p 0.9
+ 1366000p 0.9
+ 1366010p -0.3
+ 1368000p -0.3
+ 1368010p 0.9
+ 1370000p 0.9
+ 1370010p -0.3
+ 1372000p -0.3
+ 1372010p 0.9
+ 1374000p 0.9
+ 1374010p -0.3
+ 1376000p -0.3
+ 1376010p 0.9
+ 1378000p 0.9
+ 1378010p -0.3
+ 1380000p -0.3
+ 1380010p 0.9
+ 1382000p 0.9
+ 1382010p -0.3
+ 1384000p -0.3
+ 1384010p 0.9
+ 1386000p 0.9
+ 1386010p -0.3
+ 1388000p -0.3
+ 1388010p 0.9
+ 1390000p 0.9
+ 1390010p -0.3
+ 1392000p -0.3
+ 1392010p 0.9
+ 1394000p 0.9
+ 1394010p -0.3
+ 1396000p -0.3
+ 1396010p 0.9
+ 1398000p 0.9
+ 1398010p -0.3
+ 1400000p -0.3
+ 1400010p 0.9
+ 1402000p 0.9
+ 1402010p -0.3
+ 1404000p -0.3
+ 1404010p 0.9
+ 1406000p 0.9
+ 1406010p -0.3
+ 1408000p -0.3
+ 1408010p 0.9
+ 1410000p 0.9
+ 1410010p -0.3
+ 1412000p -0.3
+ 1412010p 0.9
+ 1414000p 0.9
+ 1414010p -0.3
+ 1416000p -0.3
+ 1416010p 0.9
+ 1418000p 0.9
+ 1418010p -0.3
+ 1420000p -0.3
+ 1420010p 0.9
+ 1422000p 0.9
+ 1422010p -0.3
+ 1424000p -0.3
+ 1424010p 0.9
+ 1426000p 0.9
+ 1426010p -0.3
+ 1428000p -0.3
+ 1428010p 0.9
+ 1430000p 0.9
+ 1430010p -0.3
+ 1432000p -0.3
+ 1432010p 0.9
+ 1434000p 0.9
+ 1434010p -0.3
+ 1436000p -0.3
+ 1436010p 0.9
+ 1438000p 0.9
+ 1438010p -0.3
+ 1440000p -0.3
+ 1440010p 0.9
+ 1442000p 0.9
+ 1442010p -0.3
+ 1444000p -0.3
+ 1444010p 0.9
+ 1446000p 0.9
+ 1446010p -0.3
+ 1448000p -0.3
+ 1448010p 0.9
+ 1450000p 0.9
+ 1450010p -0.3
+ 1452000p -0.3
+ 1452010p 0.9
+ 1454000p 0.9
+ 1454010p -0.3
+ 1456000p -0.3
+ 1456010p 0.9
+ 1458000p 0.9
+ 1458010p -0.3
+ 1460000p -0.3
+ 1460010p 0.9
+ 1462000p 0.9
+ 1462010p -0.3
+ 1464000p -0.3
+ 1464010p 0.9
+ 1466000p 0.9
+ 1466010p -0.3
+ 1468000p -0.3
+ 1468010p 0.9
+ 1470000p 0.9
+ 1470010p -0.3
+ 1472000p -0.3
+ 1472010p 0.9
+ 1474000p 0.9
+ 1474010p -0.3
+ 1476000p -0.3
+ 1476010p 0.9
+ 1478000p 0.9
+ 1478010p -0.3
+ 1480000p -0.3
+ 1480010p 0.9
+ 1482000p 0.9
+ 1482010p -0.3
+ 1484000p -0.3
+ 1484010p 0.9
+ 1486000p 0.9
+ 1486010p -0.3
+ 1488000p -0.3
+ 1488010p 0.9
+ 1490000p 0.9
+ 1490010p -0.3
+ 1492000p -0.3
+ 1492010p 0.9
+ 1494000p 0.9
+ 1494010p -0.3
+ 1496000p -0.3
+ 1496010p 0.9
+ 1498000p 0.9
+ 1498010p -0.3
+ 1500000p -0.3
+ 1500010p 0.9
+ 1502000p 0.9
+ 1502010p -0.3
+ 1504000p -0.3
+ 1504010p 0.9
+ 1506000p 0.9
+ 1506010p -0.3
+ 1508000p -0.3
+ 1508010p 0.9
+ 1510000p 0.9
+ 1510010p -0.3
+ 1512000p -0.3
+ 1512010p 0.9
+ 1514000p 0.9
+ 1514010p -0.3
+ 1516000p -0.3
+ 1516010p 0.9
+ 1518000p 0.9
+ 1518010p -0.3
+ 1520000p -0.3
+ 1520010p 0.9
+ 1522000p 0.9
+ 1522010p -0.3
+ 1524000p -0.3
+ 1524010p 0.9
+ 1526000p 0.9
+ 1526010p -0.3
+ 1528000p -0.3
+ 1528010p 0.9
+ 1530000p 0.9
+ 1530010p -0.3
+ 1532000p -0.3
+ 1532010p 0.9
+ 1534000p 0.9
+ 1534010p -0.3
+ 1536000p -0.3
+ 1536010p 0.9
+ 1538000p 0.9
+ 1538010p -0.3
+ 1540000p -0.3
+ 1540010p 0.9
+ 1542000p 0.9
+ 1542010p -0.3
+ 1544000p -0.3
+ 1544010p 0.9
+ 1546000p 0.9
+ 1546010p -0.3
+ 1548000p -0.3
+ 1548010p 0.9
+ 1550000p 0.9
+ 1550010p -0.3
+ 1552000p -0.3
+ 1552010p 0.9
+ 1554000p 0.9
+ 1554010p -0.3
+ 1556000p -0.3
+ 1556010p 0.9
+ 1558000p 0.9
+ 1558010p -0.3
+ 1560000p -0.3
+ 1560010p 0.9
+ 1562000p 0.9
+ 1562010p -0.3
+ 1564000p -0.3
+ 1564010p 0.9
+ 1566000p 0.9
+ 1566010p -0.3
+ 1568000p -0.3
+ 1568010p 0.9
+ 1570000p 0.9
+ 1570010p -0.3
+ 1572000p -0.3
+ 1572010p 0.9
+ 1574000p 0.9
+ 1574010p -0.3
+ 1576000p -0.3
+ 1576010p 0.9
+ 1578000p 0.9
+ 1578010p -0.3
+ 1580000p -0.3
+ 1580010p 0.9
+ 1582000p 0.9
+ 1582010p -0.3
+ 1584000p -0.3
+ 1584010p 0.9
+ 1586000p 0.9
+ 1586010p -0.3
+ 1588000p -0.3
+ 1588010p 0.9
+ 1590000p 0.9
+ 1590010p -0.3
+ 1592000p -0.3
+ 1592010p 0.9
+ 1594000p 0.9
+ 1594010p -0.3
+ 1596000p -0.3
+ 1596010p 0.9
+ 1598000p 0.9
+ 1598010p -0.3
+ 1600000p -0.3
+ 1600010p 0.9
+ 1602000p 0.9
+ 1602010p -0.3
+ 1604000p -0.3
+ 1604010p 0.9
+ 1606000p 0.9
+ 1606010p -0.3
+ 1608000p -0.3
+ 1608010p 0.9
+ 1610000p 0.9
+ 1610010p -0.3
+ 1612000p -0.3
+ 1612010p 0.9
+ 1614000p 0.9
+ 1614010p -0.3
+ 1616000p -0.3
+ 1616010p 0.9
+ 1618000p 0.9
+ 1618010p -0.3
+ 1620000p -0.3
+ 1620010p 0.9
+ 1622000p 0.9
+ 1622010p -0.3
+ 1624000p -0.3
+ 1624010p 0.9
+ 1626000p 0.9
+ 1626010p -0.3
+ 1628000p -0.3
+ 1628010p 0.9
+ 1630000p 0.9
+ 1630010p -0.3
+ 1632000p -0.3
+ 1632010p 0.9
+ 1634000p 0.9
+ 1634010p -0.3
+ 1636000p -0.3
+ 1636010p 0.9
+ 1638000p 0.9
+ 1638010p -0.3
+ 1640000p -0.3
+ 1640010p 0.9
+ 1642000p 0.9
+ 1642010p -0.3
+ 1644000p -0.3
+ 1644010p 0.9
+ 1646000p 0.9
+ 1646010p -0.3
+ 1648000p -0.3
+ 1648010p 0.9
+ 1650000p 0.9
+ 1650010p -0.3
+ 1652000p -0.3
+ 1652010p 0.9
+ 1654000p 0.9
+ 1654010p -0.3
+ 1656000p -0.3
+ 1656010p 0.9
+ 1658000p 0.9
+ 1658010p -0.3
+ 1660000p -0.3
+ 1660010p 0.9
+ 1662000p 0.9
+ 1662010p -0.3
+ 1664000p -0.3
+ 1664010p 0.9
+ 1666000p 0.9
+ 1666010p -0.3
+ 1668000p -0.3
+ 1668010p 0.9
+ 1670000p 0.9
+ 1670010p -0.3
+ 1672000p -0.3
+ 1672010p 0.9
+ 1674000p 0.9
+ 1674010p -0.3
+ 1676000p -0.3
+ 1676010p 0.9
+ 1678000p 0.9
+ 1678010p -0.3
+ 1680000p -0.3
+ 1680010p 0.9
+ 1682000p 0.9
+ 1682010p -0.3
+ 1684000p -0.3
+ 1684010p 0.9
+ 1686000p 0.9
+ 1686010p -0.3
+ 1688000p -0.3
+ 1688010p 0.9
+ 1690000p 0.9
+ 1690010p -0.3
+ 1692000p -0.3
+ 1692010p 0.9
+ 1694000p 0.9
+ 1694010p -0.3
+ 1696000p -0.3
+ 1696010p 0.9
+ 1698000p 0.9
+ 1698010p -0.3
+ 1700000p -0.3
+ 1700010p 0.9
+ 1702000p 0.9
+ 1702010p -0.3
+ 1704000p -0.3
+ 1704010p 0.9
+ 1706000p 0.9
+ 1706010p -0.3
+ 1708000p -0.3
+ 1708010p 0.9
+ 1710000p 0.9
+ 1710010p -0.3
+ 1712000p -0.3
+ 1712010p 0.9
+ 1714000p 0.9
+ 1714010p -0.3
+ 1716000p -0.3
+ 1716010p 0.9
+ 1718000p 0.9
+ 1718010p -0.3
+ 1720000p -0.3
+ 1720010p 0.9
+ 1722000p 0.9
+ 1722010p -0.3
+ 1724000p -0.3
+ 1724010p 0.9
+ 1726000p 0.9
+ 1726010p -0.3
+ 1728000p -0.3
+ 1728010p 0.9
+ 1730000p 0.9
+ 1730010p -0.3
+ 1732000p -0.3
+ 1732010p 0.9
+ 1734000p 0.9
+ 1734010p -0.3
+ 1736000p -0.3
+ 1736010p 0.9
+ 1738000p 0.9
+ 1738010p -0.3
+ 1740000p -0.3
+ 1740010p 0.9
+ 1742000p 0.9
+ 1742010p -0.3
+ 1744000p -0.3
+ 1744010p 0.9
+ 1746000p 0.9
+ 1746010p -0.3
+ 1748000p -0.3
+ 1748010p 0.9
+ 1750000p 0.9
+ 1750010p -0.3
+ 1752000p -0.3
+ 1752010p 0.9
+ 1754000p 0.9
+ 1754010p -0.3
+ 1756000p -0.3
+ 1756010p 0.9
+ 1758000p 0.9
+ 1758010p -0.3
+ 1760000p -0.3
+ 1760010p 0.9
+ 1762000p 0.9
+ 1762010p -0.3
+ 1764000p -0.3
+ 1764010p 0.9
+ 1766000p 0.9
+ 1766010p -0.3
+ 1768000p -0.3
+ 1768010p 0.9
+ 1770000p 0.9
+ 1770010p -0.3
+ 1772000p -0.3
+ 1772010p 0.9
+ 1774000p 0.9
+ 1774010p -0.3
+ 1776000p -0.3
+ 1776010p 0.9
+ 1778000p 0.9
+ 1778010p -0.3
+ 1780000p -0.3
+ 1780010p 0.9
+ 1782000p 0.9
+ 1782010p -0.3
+ 1784000p -0.3
+ 1784010p 0.9
+ 1786000p 0.9
+ 1786010p -0.3
+ 1788000p -0.3
+ 1788010p 0.9
+ 1790000p 0.9
+ 1790010p -0.3
+ 1792000p -0.3
+ 1792010p 0.9
+ 1794000p 0.9
+ 1794010p -0.3
+ 1796000p -0.3
+ 1796010p 0.9
+ 1798000p 0.9
+ 1798010p -0.3
+ 1800000p -0.3
+ 1800010p 0.9
+ 1802000p 0.9
+ 1802010p -0.3
+ 1804000p -0.3
+ 1804010p 0.9
+ 1806000p 0.9
+ 1806010p -0.3
+ 1808000p -0.3
+ 1808010p 0.9
+ 1810000p 0.9
+ 1810010p -0.3
+ 1812000p -0.3
+ 1812010p 0.9
+ 1814000p 0.9
+ 1814010p -0.3
+ 1816000p -0.3
+ 1816010p 0.9
+ 1818000p 0.9
+ 1818010p -0.3
+ 1820000p -0.3
+ 1820010p 0.9
+ 1822000p 0.9
+ 1822010p -0.3
+ 1824000p -0.3
+ 1824010p 0.9
+ 1826000p 0.9
+ 1826010p -0.3
+ 1828000p -0.3
+ 1828010p 0.9
+ 1830000p 0.9
+ 1830010p -0.3
+ 1832000p -0.3
+ 1832010p 0.9
+ 1834000p 0.9
+ 1834010p -0.3
+ 1836000p -0.3
+ 1836010p 0.9
+ 1838000p 0.9
+ 1838010p -0.3
+ 1840000p -0.3
+ 1840010p 0.9
+ 1842000p 0.9
+ 1842010p -0.3
+ 1844000p -0.3
+ 1844010p 0.9
+ 1846000p 0.9
+ 1846010p -0.3
+ 1848000p -0.3
+ 1848010p 0.9
+ 1850000p 0.9
+ 1850010p -0.3
+ 1852000p -0.3
+ 1852010p 0.9
+ 1854000p 0.9
+ 1854010p -0.3
+ 1856000p -0.3
+ 1856010p 0.9
+ 1858000p 0.9
+ 1858010p -0.3
+ 1860000p -0.3
+ 1860010p 0.9
+ 1862000p 0.9
+ 1862010p -0.3
+ 1864000p -0.3
+ 1864010p 0.9
+ 1866000p 0.9
+ 1866010p -0.3
+ 1868000p -0.3
+ 1868010p 0.9
+ 1870000p 0.9
+ 1870010p -0.3
+ 1872000p -0.3
+ 1872010p 0.9
+ 1874000p 0.9
+ 1874010p -0.3
+ 1876000p -0.3
+ 1876010p 0.9
+ 1878000p 0.9
+ 1878010p -0.3
+ 1880000p -0.3
+ 1880010p 0.9
+ 1882000p 0.9
+ 1882010p -0.3
+ 1884000p -0.3
+ 1884010p 0.9
+ 1886000p 0.9
+ 1886010p -0.3
+ 1888000p -0.3
+ 1888010p 0.9
+ 1890000p 0.9
+ 1890010p -0.3
+ 1892000p -0.3
+ 1892010p 0.9
+ 1894000p 0.9
+ 1894010p -0.3
+ 1896000p -0.3
+ 1896010p 0.9
+ 1898000p 0.9
+ 1898010p -0.3
+ 1900000p -0.3
+ 1900010p 0.9
+ 1902000p 0.9
+ 1902010p -0.3
+ 1904000p -0.3
+ 1904010p 0.9
+ 1906000p 0.9
+ 1906010p -0.3
+ 1908000p -0.3
+ 1908010p 0.9
+ 1910000p 0.9
+ 1910010p -0.3
+ 1912000p -0.3
+ 1912010p 0.9
+ 1914000p 0.9
+ 1914010p -0.3
+ 1916000p -0.3
+ 1916010p 0.9
+ 1918000p 0.9
+ 1918010p -0.3
+ 1920000p -0.3
+ 1920010p 0.9
+ 1922000p 0.9
+ 1922010p -0.3
+ 1924000p -0.3
+ 1924010p 0.9
+ 1926000p 0.9
+ 1926010p -0.3
+ 1928000p -0.3
+ 1928010p 0.9
+ 1930000p 0.9
+ 1930010p -0.3
+ 1932000p -0.3
+ 1932010p 0.9
+ 1934000p 0.9
+ 1934010p -0.3
+ 1936000p -0.3
+ 1936010p 0.9
+ 1938000p 0.9
+ 1938010p -0.3
+ 1940000p -0.3
+ 1940010p 0.9
+ 1942000p 0.9
+ 1942010p -0.3
+ 1944000p -0.3
+ 1944010p 0.9
+ 1946000p 0.9
+ 1946010p -0.3
+ 1948000p -0.3
+ 1948010p 0.9
+ 1950000p 0.9
+ 1950010p -0.3
+ 1952000p -0.3
+ 1952010p 0.9
+ 1954000p 0.9
+ 1954010p -0.3
+ 1956000p -0.3
+ 1956010p 0.9
+ 1958000p 0.9
+ 1958010p -0.3
+ 1960000p -0.3
+ 1960010p 0.9
+ 1962000p 0.9
+ 1962010p -0.3
+ 1964000p -0.3
+ 1964010p 0.9
+ 1966000p 0.9
+ 1966010p -0.3
+ 1968000p -0.3
+ 1968010p 0.9
+ 1970000p 0.9
+ 1970010p -0.3
+ 1972000p -0.3
+ 1972010p 0.9
+ 1974000p 0.9
+ 1974010p -0.3
+ 1976000p -0.3
+ 1976010p 0.9
+ 1978000p 0.9
+ 1978010p -0.3
+ 1980000p -0.3
+ 1980010p 0.9
+ 1982000p 0.9
+ 1982010p -0.3
+ 1984000p -0.3
+ 1984010p 0.9
+ 1986000p 0.9
+ 1986010p -0.3
+ 1988000p -0.3
+ 1988010p 0.9
+ 1990000p 0.9
+ 1990010p -0.3
+ 1992000p -0.3
+ 1992010p 0.9
+ 1994000p 0.9
+ 1994010p -0.3
+ 1996000p -0.3
+ 1996010p 0.9
+ 1998000p 0.9
+ 1998010p -0.3
+ 2000000p -0.3
+ 2000010p 0.9
+ 2002000p 0.9
+ 2002010p -0.3
+ 2004000p -0.3
+ 2004010p 0.9
+ 2006000p 0.9
+ 2006010p -0.3
+ 2008000p -0.3
+ 2008010p 0.9
+ 2010000p 0.9
+ 2010010p -0.3
+ 2012000p -0.3
+ 2012010p 0.9
+ 2014000p 0.9
+ 2014010p -0.3
+ 2016000p -0.3
+ 2016010p 0.9
+ 2018000p 0.9
+ 2018010p -0.3
+ 2020000p -0.3
+ 2020010p 0.9
+ 2022000p 0.9
+ 2022010p -0.3
+ 2024000p -0.3
+ 2024010p 0.9
+ 2026000p 0.9
+ 2026010p -0.3
+ 2028000p -0.3
+ 2028010p 0.9
+ 2030000p 0.9
+ 2030010p -0.3
+ 2032000p -0.3
+ 2032010p 0.9
+ 2034000p 0.9
+ 2034010p -0.3
+ 2036000p -0.3
+ 2036010p 0.9
+ 2038000p 0.9
+ 2038010p -0.3
+ 2040000p -0.3
+ 2040010p 0.9
+ 2042000p 0.9
+ 2042010p -0.3
+ 2044000p -0.3
+ 2044010p 0.9
+ 2046000p 0.9
+ 2046010p -0.3
+ 2048000p -0.3
+ 2048010p 0.9
+ \]
V_data_bar_20 (Data_bar\\<20\\> gnd!) vsource type=pwl wave=\[
+ 0    -0.3
+ 2000p -0.3
+ 2010p 0.9
+ 4000p 0.9
+ 4010p -0.3
+ 6000p -0.3
+ 6010p 0.9
+ 8000p 0.9
+ 8010p -0.3
+ 10000p -0.3
+ 10010p 0.9
+ 12000p 0.9
+ 12010p -0.3
+ 14000p -0.3
+ 14010p 0.9
+ 16000p 0.9
+ 16010p -0.3
+ 18000p -0.3
+ 18010p 0.9
+ 20000p 0.9
+ 20010p -0.3
+ 22000p -0.3
+ 22010p 0.9
+ 24000p 0.9
+ 24010p -0.3
+ 26000p -0.3
+ 26010p 0.9
+ 28000p 0.9
+ 28010p -0.3
+ 30000p -0.3
+ 30010p 0.9
+ 32000p 0.9
+ 32010p -0.3
+ 34000p -0.3
+ 34010p 0.9
+ 36000p 0.9
+ 36010p -0.3
+ 38000p -0.3
+ 38010p 0.9
+ 40000p 0.9
+ 40010p -0.3
+ 42000p -0.3
+ 42010p 0.9
+ 44000p 0.9
+ 44010p -0.3
+ 46000p -0.3
+ 46010p 0.9
+ 48000p 0.9
+ 48010p -0.3
+ 50000p -0.3
+ 50010p 0.9
+ 52000p 0.9
+ 52010p -0.3
+ 54000p -0.3
+ 54010p 0.9
+ 56000p 0.9
+ 56010p -0.3
+ 58000p -0.3
+ 58010p 0.9
+ 60000p 0.9
+ 60010p -0.3
+ 62000p -0.3
+ 62010p 0.9
+ 64000p 0.9
+ 64010p -0.3
+ 66000p -0.3
+ 66010p 0.9
+ 68000p 0.9
+ 68010p -0.3
+ 70000p -0.3
+ 70010p 0.9
+ 72000p 0.9
+ 72010p -0.3
+ 74000p -0.3
+ 74010p 0.9
+ 76000p 0.9
+ 76010p -0.3
+ 78000p -0.3
+ 78010p 0.9
+ 80000p 0.9
+ 80010p -0.3
+ 82000p -0.3
+ 82010p 0.9
+ 84000p 0.9
+ 84010p -0.3
+ 86000p -0.3
+ 86010p 0.9
+ 88000p 0.9
+ 88010p -0.3
+ 90000p -0.3
+ 90010p 0.9
+ 92000p 0.9
+ 92010p -0.3
+ 94000p -0.3
+ 94010p 0.9
+ 96000p 0.9
+ 96010p -0.3
+ 98000p -0.3
+ 98010p 0.9
+ 100000p 0.9
+ 100010p -0.3
+ 102000p -0.3
+ 102010p 0.9
+ 104000p 0.9
+ 104010p -0.3
+ 106000p -0.3
+ 106010p 0.9
+ 108000p 0.9
+ 108010p -0.3
+ 110000p -0.3
+ 110010p 0.9
+ 112000p 0.9
+ 112010p -0.3
+ 114000p -0.3
+ 114010p 0.9
+ 116000p 0.9
+ 116010p -0.3
+ 118000p -0.3
+ 118010p 0.9
+ 120000p 0.9
+ 120010p -0.3
+ 122000p -0.3
+ 122010p 0.9
+ 124000p 0.9
+ 124010p -0.3
+ 126000p -0.3
+ 126010p 0.9
+ 128000p 0.9
+ 128010p -0.3
+ 130000p -0.3
+ 130010p 0.9
+ 132000p 0.9
+ 132010p -0.3
+ 134000p -0.3
+ 134010p 0.9
+ 136000p 0.9
+ 136010p -0.3
+ 138000p -0.3
+ 138010p 0.9
+ 140000p 0.9
+ 140010p -0.3
+ 142000p -0.3
+ 142010p 0.9
+ 144000p 0.9
+ 144010p -0.3
+ 146000p -0.3
+ 146010p 0.9
+ 148000p 0.9
+ 148010p -0.3
+ 150000p -0.3
+ 150010p 0.9
+ 152000p 0.9
+ 152010p -0.3
+ 154000p -0.3
+ 154010p 0.9
+ 156000p 0.9
+ 156010p -0.3
+ 158000p -0.3
+ 158010p 0.9
+ 160000p 0.9
+ 160010p -0.3
+ 162000p -0.3
+ 162010p 0.9
+ 164000p 0.9
+ 164010p -0.3
+ 166000p -0.3
+ 166010p 0.9
+ 168000p 0.9
+ 168010p -0.3
+ 170000p -0.3
+ 170010p 0.9
+ 172000p 0.9
+ 172010p -0.3
+ 174000p -0.3
+ 174010p 0.9
+ 176000p 0.9
+ 176010p -0.3
+ 178000p -0.3
+ 178010p 0.9
+ 180000p 0.9
+ 180010p -0.3
+ 182000p -0.3
+ 182010p 0.9
+ 184000p 0.9
+ 184010p -0.3
+ 186000p -0.3
+ 186010p 0.9
+ 188000p 0.9
+ 188010p -0.3
+ 190000p -0.3
+ 190010p 0.9
+ 192000p 0.9
+ 192010p -0.3
+ 194000p -0.3
+ 194010p 0.9
+ 196000p 0.9
+ 196010p -0.3
+ 198000p -0.3
+ 198010p 0.9
+ 200000p 0.9
+ 200010p -0.3
+ 202000p -0.3
+ 202010p 0.9
+ 204000p 0.9
+ 204010p -0.3
+ 206000p -0.3
+ 206010p 0.9
+ 208000p 0.9
+ 208010p -0.3
+ 210000p -0.3
+ 210010p 0.9
+ 212000p 0.9
+ 212010p -0.3
+ 214000p -0.3
+ 214010p 0.9
+ 216000p 0.9
+ 216010p -0.3
+ 218000p -0.3
+ 218010p 0.9
+ 220000p 0.9
+ 220010p -0.3
+ 222000p -0.3
+ 222010p 0.9
+ 224000p 0.9
+ 224010p -0.3
+ 226000p -0.3
+ 226010p 0.9
+ 228000p 0.9
+ 228010p -0.3
+ 230000p -0.3
+ 230010p 0.9
+ 232000p 0.9
+ 232010p -0.3
+ 234000p -0.3
+ 234010p 0.9
+ 236000p 0.9
+ 236010p -0.3
+ 238000p -0.3
+ 238010p 0.9
+ 240000p 0.9
+ 240010p -0.3
+ 242000p -0.3
+ 242010p 0.9
+ 244000p 0.9
+ 244010p -0.3
+ 246000p -0.3
+ 246010p 0.9
+ 248000p 0.9
+ 248010p -0.3
+ 250000p -0.3
+ 250010p 0.9
+ 252000p 0.9
+ 252010p -0.3
+ 254000p -0.3
+ 254010p 0.9
+ 256000p 0.9
+ 256010p -0.3
+ 258000p -0.3
+ 258010p 0.9
+ 260000p 0.9
+ 260010p -0.3
+ 262000p -0.3
+ 262010p 0.9
+ 264000p 0.9
+ 264010p -0.3
+ 266000p -0.3
+ 266010p 0.9
+ 268000p 0.9
+ 268010p -0.3
+ 270000p -0.3
+ 270010p 0.9
+ 272000p 0.9
+ 272010p -0.3
+ 274000p -0.3
+ 274010p 0.9
+ 276000p 0.9
+ 276010p -0.3
+ 278000p -0.3
+ 278010p 0.9
+ 280000p 0.9
+ 280010p -0.3
+ 282000p -0.3
+ 282010p 0.9
+ 284000p 0.9
+ 284010p -0.3
+ 286000p -0.3
+ 286010p 0.9
+ 288000p 0.9
+ 288010p -0.3
+ 290000p -0.3
+ 290010p 0.9
+ 292000p 0.9
+ 292010p -0.3
+ 294000p -0.3
+ 294010p 0.9
+ 296000p 0.9
+ 296010p -0.3
+ 298000p -0.3
+ 298010p 0.9
+ 300000p 0.9
+ 300010p -0.3
+ 302000p -0.3
+ 302010p 0.9
+ 304000p 0.9
+ 304010p -0.3
+ 306000p -0.3
+ 306010p 0.9
+ 308000p 0.9
+ 308010p -0.3
+ 310000p -0.3
+ 310010p 0.9
+ 312000p 0.9
+ 312010p -0.3
+ 314000p -0.3
+ 314010p 0.9
+ 316000p 0.9
+ 316010p -0.3
+ 318000p -0.3
+ 318010p 0.9
+ 320000p 0.9
+ 320010p -0.3
+ 322000p -0.3
+ 322010p 0.9
+ 324000p 0.9
+ 324010p -0.3
+ 326000p -0.3
+ 326010p 0.9
+ 328000p 0.9
+ 328010p -0.3
+ 330000p -0.3
+ 330010p 0.9
+ 332000p 0.9
+ 332010p -0.3
+ 334000p -0.3
+ 334010p 0.9
+ 336000p 0.9
+ 336010p -0.3
+ 338000p -0.3
+ 338010p 0.9
+ 340000p 0.9
+ 340010p -0.3
+ 342000p -0.3
+ 342010p 0.9
+ 344000p 0.9
+ 344010p -0.3
+ 346000p -0.3
+ 346010p 0.9
+ 348000p 0.9
+ 348010p -0.3
+ 350000p -0.3
+ 350010p 0.9
+ 352000p 0.9
+ 352010p -0.3
+ 354000p -0.3
+ 354010p 0.9
+ 356000p 0.9
+ 356010p -0.3
+ 358000p -0.3
+ 358010p 0.9
+ 360000p 0.9
+ 360010p -0.3
+ 362000p -0.3
+ 362010p 0.9
+ 364000p 0.9
+ 364010p -0.3
+ 366000p -0.3
+ 366010p 0.9
+ 368000p 0.9
+ 368010p -0.3
+ 370000p -0.3
+ 370010p 0.9
+ 372000p 0.9
+ 372010p -0.3
+ 374000p -0.3
+ 374010p 0.9
+ 376000p 0.9
+ 376010p -0.3
+ 378000p -0.3
+ 378010p 0.9
+ 380000p 0.9
+ 380010p -0.3
+ 382000p -0.3
+ 382010p 0.9
+ 384000p 0.9
+ 384010p -0.3
+ 386000p -0.3
+ 386010p 0.9
+ 388000p 0.9
+ 388010p -0.3
+ 390000p -0.3
+ 390010p 0.9
+ 392000p 0.9
+ 392010p -0.3
+ 394000p -0.3
+ 394010p 0.9
+ 396000p 0.9
+ 396010p -0.3
+ 398000p -0.3
+ 398010p 0.9
+ 400000p 0.9
+ 400010p -0.3
+ 402000p -0.3
+ 402010p 0.9
+ 404000p 0.9
+ 404010p -0.3
+ 406000p -0.3
+ 406010p 0.9
+ 408000p 0.9
+ 408010p -0.3
+ 410000p -0.3
+ 410010p 0.9
+ 412000p 0.9
+ 412010p -0.3
+ 414000p -0.3
+ 414010p 0.9
+ 416000p 0.9
+ 416010p -0.3
+ 418000p -0.3
+ 418010p 0.9
+ 420000p 0.9
+ 420010p -0.3
+ 422000p -0.3
+ 422010p 0.9
+ 424000p 0.9
+ 424010p -0.3
+ 426000p -0.3
+ 426010p 0.9
+ 428000p 0.9
+ 428010p -0.3
+ 430000p -0.3
+ 430010p 0.9
+ 432000p 0.9
+ 432010p -0.3
+ 434000p -0.3
+ 434010p 0.9
+ 436000p 0.9
+ 436010p -0.3
+ 438000p -0.3
+ 438010p 0.9
+ 440000p 0.9
+ 440010p -0.3
+ 442000p -0.3
+ 442010p 0.9
+ 444000p 0.9
+ 444010p -0.3
+ 446000p -0.3
+ 446010p 0.9
+ 448000p 0.9
+ 448010p -0.3
+ 450000p -0.3
+ 450010p 0.9
+ 452000p 0.9
+ 452010p -0.3
+ 454000p -0.3
+ 454010p 0.9
+ 456000p 0.9
+ 456010p -0.3
+ 458000p -0.3
+ 458010p 0.9
+ 460000p 0.9
+ 460010p -0.3
+ 462000p -0.3
+ 462010p 0.9
+ 464000p 0.9
+ 464010p -0.3
+ 466000p -0.3
+ 466010p 0.9
+ 468000p 0.9
+ 468010p -0.3
+ 470000p -0.3
+ 470010p 0.9
+ 472000p 0.9
+ 472010p -0.3
+ 474000p -0.3
+ 474010p 0.9
+ 476000p 0.9
+ 476010p -0.3
+ 478000p -0.3
+ 478010p 0.9
+ 480000p 0.9
+ 480010p -0.3
+ 482000p -0.3
+ 482010p 0.9
+ 484000p 0.9
+ 484010p -0.3
+ 486000p -0.3
+ 486010p 0.9
+ 488000p 0.9
+ 488010p -0.3
+ 490000p -0.3
+ 490010p 0.9
+ 492000p 0.9
+ 492010p -0.3
+ 494000p -0.3
+ 494010p 0.9
+ 496000p 0.9
+ 496010p -0.3
+ 498000p -0.3
+ 498010p 0.9
+ 500000p 0.9
+ 500010p -0.3
+ 502000p -0.3
+ 502010p 0.9
+ 504000p 0.9
+ 504010p -0.3
+ 506000p -0.3
+ 506010p 0.9
+ 508000p 0.9
+ 508010p -0.3
+ 510000p -0.3
+ 510010p 0.9
+ 512000p 0.9
+ 512010p -0.3
+ 514000p -0.3
+ 514010p 0.9
+ 516000p 0.9
+ 516010p -0.3
+ 518000p -0.3
+ 518010p 0.9
+ 520000p 0.9
+ 520010p -0.3
+ 522000p -0.3
+ 522010p 0.9
+ 524000p 0.9
+ 524010p -0.3
+ 526000p -0.3
+ 526010p 0.9
+ 528000p 0.9
+ 528010p -0.3
+ 530000p -0.3
+ 530010p 0.9
+ 532000p 0.9
+ 532010p -0.3
+ 534000p -0.3
+ 534010p 0.9
+ 536000p 0.9
+ 536010p -0.3
+ 538000p -0.3
+ 538010p 0.9
+ 540000p 0.9
+ 540010p -0.3
+ 542000p -0.3
+ 542010p 0.9
+ 544000p 0.9
+ 544010p -0.3
+ 546000p -0.3
+ 546010p 0.9
+ 548000p 0.9
+ 548010p -0.3
+ 550000p -0.3
+ 550010p 0.9
+ 552000p 0.9
+ 552010p -0.3
+ 554000p -0.3
+ 554010p 0.9
+ 556000p 0.9
+ 556010p -0.3
+ 558000p -0.3
+ 558010p 0.9
+ 560000p 0.9
+ 560010p -0.3
+ 562000p -0.3
+ 562010p 0.9
+ 564000p 0.9
+ 564010p -0.3
+ 566000p -0.3
+ 566010p 0.9
+ 568000p 0.9
+ 568010p -0.3
+ 570000p -0.3
+ 570010p 0.9
+ 572000p 0.9
+ 572010p -0.3
+ 574000p -0.3
+ 574010p 0.9
+ 576000p 0.9
+ 576010p -0.3
+ 578000p -0.3
+ 578010p 0.9
+ 580000p 0.9
+ 580010p -0.3
+ 582000p -0.3
+ 582010p 0.9
+ 584000p 0.9
+ 584010p -0.3
+ 586000p -0.3
+ 586010p 0.9
+ 588000p 0.9
+ 588010p -0.3
+ 590000p -0.3
+ 590010p 0.9
+ 592000p 0.9
+ 592010p -0.3
+ 594000p -0.3
+ 594010p 0.9
+ 596000p 0.9
+ 596010p -0.3
+ 598000p -0.3
+ 598010p 0.9
+ 600000p 0.9
+ 600010p -0.3
+ 602000p -0.3
+ 602010p 0.9
+ 604000p 0.9
+ 604010p -0.3
+ 606000p -0.3
+ 606010p 0.9
+ 608000p 0.9
+ 608010p -0.3
+ 610000p -0.3
+ 610010p 0.9
+ 612000p 0.9
+ 612010p -0.3
+ 614000p -0.3
+ 614010p 0.9
+ 616000p 0.9
+ 616010p -0.3
+ 618000p -0.3
+ 618010p 0.9
+ 620000p 0.9
+ 620010p -0.3
+ 622000p -0.3
+ 622010p 0.9
+ 624000p 0.9
+ 624010p -0.3
+ 626000p -0.3
+ 626010p 0.9
+ 628000p 0.9
+ 628010p -0.3
+ 630000p -0.3
+ 630010p 0.9
+ 632000p 0.9
+ 632010p -0.3
+ 634000p -0.3
+ 634010p 0.9
+ 636000p 0.9
+ 636010p -0.3
+ 638000p -0.3
+ 638010p 0.9
+ 640000p 0.9
+ 640010p -0.3
+ 642000p -0.3
+ 642010p 0.9
+ 644000p 0.9
+ 644010p -0.3
+ 646000p -0.3
+ 646010p 0.9
+ 648000p 0.9
+ 648010p -0.3
+ 650000p -0.3
+ 650010p 0.9
+ 652000p 0.9
+ 652010p -0.3
+ 654000p -0.3
+ 654010p 0.9
+ 656000p 0.9
+ 656010p -0.3
+ 658000p -0.3
+ 658010p 0.9
+ 660000p 0.9
+ 660010p -0.3
+ 662000p -0.3
+ 662010p 0.9
+ 664000p 0.9
+ 664010p -0.3
+ 666000p -0.3
+ 666010p 0.9
+ 668000p 0.9
+ 668010p -0.3
+ 670000p -0.3
+ 670010p 0.9
+ 672000p 0.9
+ 672010p -0.3
+ 674000p -0.3
+ 674010p 0.9
+ 676000p 0.9
+ 676010p -0.3
+ 678000p -0.3
+ 678010p 0.9
+ 680000p 0.9
+ 680010p -0.3
+ 682000p -0.3
+ 682010p 0.9
+ 684000p 0.9
+ 684010p -0.3
+ 686000p -0.3
+ 686010p 0.9
+ 688000p 0.9
+ 688010p -0.3
+ 690000p -0.3
+ 690010p 0.9
+ 692000p 0.9
+ 692010p -0.3
+ 694000p -0.3
+ 694010p 0.9
+ 696000p 0.9
+ 696010p -0.3
+ 698000p -0.3
+ 698010p 0.9
+ 700000p 0.9
+ 700010p -0.3
+ 702000p -0.3
+ 702010p 0.9
+ 704000p 0.9
+ 704010p -0.3
+ 706000p -0.3
+ 706010p 0.9
+ 708000p 0.9
+ 708010p -0.3
+ 710000p -0.3
+ 710010p 0.9
+ 712000p 0.9
+ 712010p -0.3
+ 714000p -0.3
+ 714010p 0.9
+ 716000p 0.9
+ 716010p -0.3
+ 718000p -0.3
+ 718010p 0.9
+ 720000p 0.9
+ 720010p -0.3
+ 722000p -0.3
+ 722010p 0.9
+ 724000p 0.9
+ 724010p -0.3
+ 726000p -0.3
+ 726010p 0.9
+ 728000p 0.9
+ 728010p -0.3
+ 730000p -0.3
+ 730010p 0.9
+ 732000p 0.9
+ 732010p -0.3
+ 734000p -0.3
+ 734010p 0.9
+ 736000p 0.9
+ 736010p -0.3
+ 738000p -0.3
+ 738010p 0.9
+ 740000p 0.9
+ 740010p -0.3
+ 742000p -0.3
+ 742010p 0.9
+ 744000p 0.9
+ 744010p -0.3
+ 746000p -0.3
+ 746010p 0.9
+ 748000p 0.9
+ 748010p -0.3
+ 750000p -0.3
+ 750010p 0.9
+ 752000p 0.9
+ 752010p -0.3
+ 754000p -0.3
+ 754010p 0.9
+ 756000p 0.9
+ 756010p -0.3
+ 758000p -0.3
+ 758010p 0.9
+ 760000p 0.9
+ 760010p -0.3
+ 762000p -0.3
+ 762010p 0.9
+ 764000p 0.9
+ 764010p -0.3
+ 766000p -0.3
+ 766010p 0.9
+ 768000p 0.9
+ 768010p -0.3
+ 770000p -0.3
+ 770010p 0.9
+ 772000p 0.9
+ 772010p -0.3
+ 774000p -0.3
+ 774010p 0.9
+ 776000p 0.9
+ 776010p -0.3
+ 778000p -0.3
+ 778010p 0.9
+ 780000p 0.9
+ 780010p -0.3
+ 782000p -0.3
+ 782010p 0.9
+ 784000p 0.9
+ 784010p -0.3
+ 786000p -0.3
+ 786010p 0.9
+ 788000p 0.9
+ 788010p -0.3
+ 790000p -0.3
+ 790010p 0.9
+ 792000p 0.9
+ 792010p -0.3
+ 794000p -0.3
+ 794010p 0.9
+ 796000p 0.9
+ 796010p -0.3
+ 798000p -0.3
+ 798010p 0.9
+ 800000p 0.9
+ 800010p -0.3
+ 802000p -0.3
+ 802010p 0.9
+ 804000p 0.9
+ 804010p -0.3
+ 806000p -0.3
+ 806010p 0.9
+ 808000p 0.9
+ 808010p -0.3
+ 810000p -0.3
+ 810010p 0.9
+ 812000p 0.9
+ 812010p -0.3
+ 814000p -0.3
+ 814010p 0.9
+ 816000p 0.9
+ 816010p -0.3
+ 818000p -0.3
+ 818010p 0.9
+ 820000p 0.9
+ 820010p -0.3
+ 822000p -0.3
+ 822010p 0.9
+ 824000p 0.9
+ 824010p -0.3
+ 826000p -0.3
+ 826010p 0.9
+ 828000p 0.9
+ 828010p -0.3
+ 830000p -0.3
+ 830010p 0.9
+ 832000p 0.9
+ 832010p -0.3
+ 834000p -0.3
+ 834010p 0.9
+ 836000p 0.9
+ 836010p -0.3
+ 838000p -0.3
+ 838010p 0.9
+ 840000p 0.9
+ 840010p -0.3
+ 842000p -0.3
+ 842010p 0.9
+ 844000p 0.9
+ 844010p -0.3
+ 846000p -0.3
+ 846010p 0.9
+ 848000p 0.9
+ 848010p -0.3
+ 850000p -0.3
+ 850010p 0.9
+ 852000p 0.9
+ 852010p -0.3
+ 854000p -0.3
+ 854010p 0.9
+ 856000p 0.9
+ 856010p -0.3
+ 858000p -0.3
+ 858010p 0.9
+ 860000p 0.9
+ 860010p -0.3
+ 862000p -0.3
+ 862010p 0.9
+ 864000p 0.9
+ 864010p -0.3
+ 866000p -0.3
+ 866010p 0.9
+ 868000p 0.9
+ 868010p -0.3
+ 870000p -0.3
+ 870010p 0.9
+ 872000p 0.9
+ 872010p -0.3
+ 874000p -0.3
+ 874010p 0.9
+ 876000p 0.9
+ 876010p -0.3
+ 878000p -0.3
+ 878010p 0.9
+ 880000p 0.9
+ 880010p -0.3
+ 882000p -0.3
+ 882010p 0.9
+ 884000p 0.9
+ 884010p -0.3
+ 886000p -0.3
+ 886010p 0.9
+ 888000p 0.9
+ 888010p -0.3
+ 890000p -0.3
+ 890010p 0.9
+ 892000p 0.9
+ 892010p -0.3
+ 894000p -0.3
+ 894010p 0.9
+ 896000p 0.9
+ 896010p -0.3
+ 898000p -0.3
+ 898010p 0.9
+ 900000p 0.9
+ 900010p -0.3
+ 902000p -0.3
+ 902010p 0.9
+ 904000p 0.9
+ 904010p -0.3
+ 906000p -0.3
+ 906010p 0.9
+ 908000p 0.9
+ 908010p -0.3
+ 910000p -0.3
+ 910010p 0.9
+ 912000p 0.9
+ 912010p -0.3
+ 914000p -0.3
+ 914010p 0.9
+ 916000p 0.9
+ 916010p -0.3
+ 918000p -0.3
+ 918010p 0.9
+ 920000p 0.9
+ 920010p -0.3
+ 922000p -0.3
+ 922010p 0.9
+ 924000p 0.9
+ 924010p -0.3
+ 926000p -0.3
+ 926010p 0.9
+ 928000p 0.9
+ 928010p -0.3
+ 930000p -0.3
+ 930010p 0.9
+ 932000p 0.9
+ 932010p -0.3
+ 934000p -0.3
+ 934010p 0.9
+ 936000p 0.9
+ 936010p -0.3
+ 938000p -0.3
+ 938010p 0.9
+ 940000p 0.9
+ 940010p -0.3
+ 942000p -0.3
+ 942010p 0.9
+ 944000p 0.9
+ 944010p -0.3
+ 946000p -0.3
+ 946010p 0.9
+ 948000p 0.9
+ 948010p -0.3
+ 950000p -0.3
+ 950010p 0.9
+ 952000p 0.9
+ 952010p -0.3
+ 954000p -0.3
+ 954010p 0.9
+ 956000p 0.9
+ 956010p -0.3
+ 958000p -0.3
+ 958010p 0.9
+ 960000p 0.9
+ 960010p -0.3
+ 962000p -0.3
+ 962010p 0.9
+ 964000p 0.9
+ 964010p -0.3
+ 966000p -0.3
+ 966010p 0.9
+ 968000p 0.9
+ 968010p -0.3
+ 970000p -0.3
+ 970010p 0.9
+ 972000p 0.9
+ 972010p -0.3
+ 974000p -0.3
+ 974010p 0.9
+ 976000p 0.9
+ 976010p -0.3
+ 978000p -0.3
+ 978010p 0.9
+ 980000p 0.9
+ 980010p -0.3
+ 982000p -0.3
+ 982010p 0.9
+ 984000p 0.9
+ 984010p -0.3
+ 986000p -0.3
+ 986010p 0.9
+ 988000p 0.9
+ 988010p -0.3
+ 990000p -0.3
+ 990010p 0.9
+ 992000p 0.9
+ 992010p -0.3
+ 994000p -0.3
+ 994010p 0.9
+ 996000p 0.9
+ 996010p -0.3
+ 998000p -0.3
+ 998010p 0.9
+ 1000000p 0.9
+ 1000010p -0.3
+ 1002000p -0.3
+ 1002010p 0.9
+ 1004000p 0.9
+ 1004010p -0.3
+ 1006000p -0.3
+ 1006010p 0.9
+ 1008000p 0.9
+ 1008010p -0.3
+ 1010000p -0.3
+ 1010010p 0.9
+ 1012000p 0.9
+ 1012010p -0.3
+ 1014000p -0.3
+ 1014010p 0.9
+ 1016000p 0.9
+ 1016010p -0.3
+ 1018000p -0.3
+ 1018010p 0.9
+ 1020000p 0.9
+ 1020010p -0.3
+ 1022000p -0.3
+ 1022010p 0.9
+ 1024000p 0.9
+ 1024010p -0.3
+ 1026000p -0.3
+ 1026010p 0.9
+ 1028000p 0.9
+ 1028010p -0.3
+ 1030000p -0.3
+ 1030010p 0.9
+ 1032000p 0.9
+ 1032010p -0.3
+ 1034000p -0.3
+ 1034010p 0.9
+ 1036000p 0.9
+ 1036010p -0.3
+ 1038000p -0.3
+ 1038010p 0.9
+ 1040000p 0.9
+ 1040010p -0.3
+ 1042000p -0.3
+ 1042010p 0.9
+ 1044000p 0.9
+ 1044010p -0.3
+ 1046000p -0.3
+ 1046010p 0.9
+ 1048000p 0.9
+ 1048010p -0.3
+ 1050000p -0.3
+ 1050010p 0.9
+ 1052000p 0.9
+ 1052010p -0.3
+ 1054000p -0.3
+ 1054010p 0.9
+ 1056000p 0.9
+ 1056010p -0.3
+ 1058000p -0.3
+ 1058010p 0.9
+ 1060000p 0.9
+ 1060010p -0.3
+ 1062000p -0.3
+ 1062010p 0.9
+ 1064000p 0.9
+ 1064010p -0.3
+ 1066000p -0.3
+ 1066010p 0.9
+ 1068000p 0.9
+ 1068010p -0.3
+ 1070000p -0.3
+ 1070010p 0.9
+ 1072000p 0.9
+ 1072010p -0.3
+ 1074000p -0.3
+ 1074010p 0.9
+ 1076000p 0.9
+ 1076010p -0.3
+ 1078000p -0.3
+ 1078010p 0.9
+ 1080000p 0.9
+ 1080010p -0.3
+ 1082000p -0.3
+ 1082010p 0.9
+ 1084000p 0.9
+ 1084010p -0.3
+ 1086000p -0.3
+ 1086010p 0.9
+ 1088000p 0.9
+ 1088010p -0.3
+ 1090000p -0.3
+ 1090010p 0.9
+ 1092000p 0.9
+ 1092010p -0.3
+ 1094000p -0.3
+ 1094010p 0.9
+ 1096000p 0.9
+ 1096010p -0.3
+ 1098000p -0.3
+ 1098010p 0.9
+ 1100000p 0.9
+ 1100010p -0.3
+ 1102000p -0.3
+ 1102010p 0.9
+ 1104000p 0.9
+ 1104010p -0.3
+ 1106000p -0.3
+ 1106010p 0.9
+ 1108000p 0.9
+ 1108010p -0.3
+ 1110000p -0.3
+ 1110010p 0.9
+ 1112000p 0.9
+ 1112010p -0.3
+ 1114000p -0.3
+ 1114010p 0.9
+ 1116000p 0.9
+ 1116010p -0.3
+ 1118000p -0.3
+ 1118010p 0.9
+ 1120000p 0.9
+ 1120010p -0.3
+ 1122000p -0.3
+ 1122010p 0.9
+ 1124000p 0.9
+ 1124010p -0.3
+ 1126000p -0.3
+ 1126010p 0.9
+ 1128000p 0.9
+ 1128010p -0.3
+ 1130000p -0.3
+ 1130010p 0.9
+ 1132000p 0.9
+ 1132010p -0.3
+ 1134000p -0.3
+ 1134010p 0.9
+ 1136000p 0.9
+ 1136010p -0.3
+ 1138000p -0.3
+ 1138010p 0.9
+ 1140000p 0.9
+ 1140010p -0.3
+ 1142000p -0.3
+ 1142010p 0.9
+ 1144000p 0.9
+ 1144010p -0.3
+ 1146000p -0.3
+ 1146010p 0.9
+ 1148000p 0.9
+ 1148010p -0.3
+ 1150000p -0.3
+ 1150010p 0.9
+ 1152000p 0.9
+ 1152010p -0.3
+ 1154000p -0.3
+ 1154010p 0.9
+ 1156000p 0.9
+ 1156010p -0.3
+ 1158000p -0.3
+ 1158010p 0.9
+ 1160000p 0.9
+ 1160010p -0.3
+ 1162000p -0.3
+ 1162010p 0.9
+ 1164000p 0.9
+ 1164010p -0.3
+ 1166000p -0.3
+ 1166010p 0.9
+ 1168000p 0.9
+ 1168010p -0.3
+ 1170000p -0.3
+ 1170010p 0.9
+ 1172000p 0.9
+ 1172010p -0.3
+ 1174000p -0.3
+ 1174010p 0.9
+ 1176000p 0.9
+ 1176010p -0.3
+ 1178000p -0.3
+ 1178010p 0.9
+ 1180000p 0.9
+ 1180010p -0.3
+ 1182000p -0.3
+ 1182010p 0.9
+ 1184000p 0.9
+ 1184010p -0.3
+ 1186000p -0.3
+ 1186010p 0.9
+ 1188000p 0.9
+ 1188010p -0.3
+ 1190000p -0.3
+ 1190010p 0.9
+ 1192000p 0.9
+ 1192010p -0.3
+ 1194000p -0.3
+ 1194010p 0.9
+ 1196000p 0.9
+ 1196010p -0.3
+ 1198000p -0.3
+ 1198010p 0.9
+ 1200000p 0.9
+ 1200010p -0.3
+ 1202000p -0.3
+ 1202010p 0.9
+ 1204000p 0.9
+ 1204010p -0.3
+ 1206000p -0.3
+ 1206010p 0.9
+ 1208000p 0.9
+ 1208010p -0.3
+ 1210000p -0.3
+ 1210010p 0.9
+ 1212000p 0.9
+ 1212010p -0.3
+ 1214000p -0.3
+ 1214010p 0.9
+ 1216000p 0.9
+ 1216010p -0.3
+ 1218000p -0.3
+ 1218010p 0.9
+ 1220000p 0.9
+ 1220010p -0.3
+ 1222000p -0.3
+ 1222010p 0.9
+ 1224000p 0.9
+ 1224010p -0.3
+ 1226000p -0.3
+ 1226010p 0.9
+ 1228000p 0.9
+ 1228010p -0.3
+ 1230000p -0.3
+ 1230010p 0.9
+ 1232000p 0.9
+ 1232010p -0.3
+ 1234000p -0.3
+ 1234010p 0.9
+ 1236000p 0.9
+ 1236010p -0.3
+ 1238000p -0.3
+ 1238010p 0.9
+ 1240000p 0.9
+ 1240010p -0.3
+ 1242000p -0.3
+ 1242010p 0.9
+ 1244000p 0.9
+ 1244010p -0.3
+ 1246000p -0.3
+ 1246010p 0.9
+ 1248000p 0.9
+ 1248010p -0.3
+ 1250000p -0.3
+ 1250010p 0.9
+ 1252000p 0.9
+ 1252010p -0.3
+ 1254000p -0.3
+ 1254010p 0.9
+ 1256000p 0.9
+ 1256010p -0.3
+ 1258000p -0.3
+ 1258010p 0.9
+ 1260000p 0.9
+ 1260010p -0.3
+ 1262000p -0.3
+ 1262010p 0.9
+ 1264000p 0.9
+ 1264010p -0.3
+ 1266000p -0.3
+ 1266010p 0.9
+ 1268000p 0.9
+ 1268010p -0.3
+ 1270000p -0.3
+ 1270010p 0.9
+ 1272000p 0.9
+ 1272010p -0.3
+ 1274000p -0.3
+ 1274010p 0.9
+ 1276000p 0.9
+ 1276010p -0.3
+ 1278000p -0.3
+ 1278010p 0.9
+ 1280000p 0.9
+ 1280010p -0.3
+ 1282000p -0.3
+ 1282010p 0.9
+ 1284000p 0.9
+ 1284010p -0.3
+ 1286000p -0.3
+ 1286010p 0.9
+ 1288000p 0.9
+ 1288010p -0.3
+ 1290000p -0.3
+ 1290010p 0.9
+ 1292000p 0.9
+ 1292010p -0.3
+ 1294000p -0.3
+ 1294010p 0.9
+ 1296000p 0.9
+ 1296010p -0.3
+ 1298000p -0.3
+ 1298010p 0.9
+ 1300000p 0.9
+ 1300010p -0.3
+ 1302000p -0.3
+ 1302010p 0.9
+ 1304000p 0.9
+ 1304010p -0.3
+ 1306000p -0.3
+ 1306010p 0.9
+ 1308000p 0.9
+ 1308010p -0.3
+ 1310000p -0.3
+ 1310010p 0.9
+ 1312000p 0.9
+ 1312010p -0.3
+ 1314000p -0.3
+ 1314010p 0.9
+ 1316000p 0.9
+ 1316010p -0.3
+ 1318000p -0.3
+ 1318010p 0.9
+ 1320000p 0.9
+ 1320010p -0.3
+ 1322000p -0.3
+ 1322010p 0.9
+ 1324000p 0.9
+ 1324010p -0.3
+ 1326000p -0.3
+ 1326010p 0.9
+ 1328000p 0.9
+ 1328010p -0.3
+ 1330000p -0.3
+ 1330010p 0.9
+ 1332000p 0.9
+ 1332010p -0.3
+ 1334000p -0.3
+ 1334010p 0.9
+ 1336000p 0.9
+ 1336010p -0.3
+ 1338000p -0.3
+ 1338010p 0.9
+ 1340000p 0.9
+ 1340010p -0.3
+ 1342000p -0.3
+ 1342010p 0.9
+ 1344000p 0.9
+ 1344010p -0.3
+ 1346000p -0.3
+ 1346010p 0.9
+ 1348000p 0.9
+ 1348010p -0.3
+ 1350000p -0.3
+ 1350010p 0.9
+ 1352000p 0.9
+ 1352010p -0.3
+ 1354000p -0.3
+ 1354010p 0.9
+ 1356000p 0.9
+ 1356010p -0.3
+ 1358000p -0.3
+ 1358010p 0.9
+ 1360000p 0.9
+ 1360010p -0.3
+ 1362000p -0.3
+ 1362010p 0.9
+ 1364000p 0.9
+ 1364010p -0.3
+ 1366000p -0.3
+ 1366010p 0.9
+ 1368000p 0.9
+ 1368010p -0.3
+ 1370000p -0.3
+ 1370010p 0.9
+ 1372000p 0.9
+ 1372010p -0.3
+ 1374000p -0.3
+ 1374010p 0.9
+ 1376000p 0.9
+ 1376010p -0.3
+ 1378000p -0.3
+ 1378010p 0.9
+ 1380000p 0.9
+ 1380010p -0.3
+ 1382000p -0.3
+ 1382010p 0.9
+ 1384000p 0.9
+ 1384010p -0.3
+ 1386000p -0.3
+ 1386010p 0.9
+ 1388000p 0.9
+ 1388010p -0.3
+ 1390000p -0.3
+ 1390010p 0.9
+ 1392000p 0.9
+ 1392010p -0.3
+ 1394000p -0.3
+ 1394010p 0.9
+ 1396000p 0.9
+ 1396010p -0.3
+ 1398000p -0.3
+ 1398010p 0.9
+ 1400000p 0.9
+ 1400010p -0.3
+ 1402000p -0.3
+ 1402010p 0.9
+ 1404000p 0.9
+ 1404010p -0.3
+ 1406000p -0.3
+ 1406010p 0.9
+ 1408000p 0.9
+ 1408010p -0.3
+ 1410000p -0.3
+ 1410010p 0.9
+ 1412000p 0.9
+ 1412010p -0.3
+ 1414000p -0.3
+ 1414010p 0.9
+ 1416000p 0.9
+ 1416010p -0.3
+ 1418000p -0.3
+ 1418010p 0.9
+ 1420000p 0.9
+ 1420010p -0.3
+ 1422000p -0.3
+ 1422010p 0.9
+ 1424000p 0.9
+ 1424010p -0.3
+ 1426000p -0.3
+ 1426010p 0.9
+ 1428000p 0.9
+ 1428010p -0.3
+ 1430000p -0.3
+ 1430010p 0.9
+ 1432000p 0.9
+ 1432010p -0.3
+ 1434000p -0.3
+ 1434010p 0.9
+ 1436000p 0.9
+ 1436010p -0.3
+ 1438000p -0.3
+ 1438010p 0.9
+ 1440000p 0.9
+ 1440010p -0.3
+ 1442000p -0.3
+ 1442010p 0.9
+ 1444000p 0.9
+ 1444010p -0.3
+ 1446000p -0.3
+ 1446010p 0.9
+ 1448000p 0.9
+ 1448010p -0.3
+ 1450000p -0.3
+ 1450010p 0.9
+ 1452000p 0.9
+ 1452010p -0.3
+ 1454000p -0.3
+ 1454010p 0.9
+ 1456000p 0.9
+ 1456010p -0.3
+ 1458000p -0.3
+ 1458010p 0.9
+ 1460000p 0.9
+ 1460010p -0.3
+ 1462000p -0.3
+ 1462010p 0.9
+ 1464000p 0.9
+ 1464010p -0.3
+ 1466000p -0.3
+ 1466010p 0.9
+ 1468000p 0.9
+ 1468010p -0.3
+ 1470000p -0.3
+ 1470010p 0.9
+ 1472000p 0.9
+ 1472010p -0.3
+ 1474000p -0.3
+ 1474010p 0.9
+ 1476000p 0.9
+ 1476010p -0.3
+ 1478000p -0.3
+ 1478010p 0.9
+ 1480000p 0.9
+ 1480010p -0.3
+ 1482000p -0.3
+ 1482010p 0.9
+ 1484000p 0.9
+ 1484010p -0.3
+ 1486000p -0.3
+ 1486010p 0.9
+ 1488000p 0.9
+ 1488010p -0.3
+ 1490000p -0.3
+ 1490010p 0.9
+ 1492000p 0.9
+ 1492010p -0.3
+ 1494000p -0.3
+ 1494010p 0.9
+ 1496000p 0.9
+ 1496010p -0.3
+ 1498000p -0.3
+ 1498010p 0.9
+ 1500000p 0.9
+ 1500010p -0.3
+ 1502000p -0.3
+ 1502010p 0.9
+ 1504000p 0.9
+ 1504010p -0.3
+ 1506000p -0.3
+ 1506010p 0.9
+ 1508000p 0.9
+ 1508010p -0.3
+ 1510000p -0.3
+ 1510010p 0.9
+ 1512000p 0.9
+ 1512010p -0.3
+ 1514000p -0.3
+ 1514010p 0.9
+ 1516000p 0.9
+ 1516010p -0.3
+ 1518000p -0.3
+ 1518010p 0.9
+ 1520000p 0.9
+ 1520010p -0.3
+ 1522000p -0.3
+ 1522010p 0.9
+ 1524000p 0.9
+ 1524010p -0.3
+ 1526000p -0.3
+ 1526010p 0.9
+ 1528000p 0.9
+ 1528010p -0.3
+ 1530000p -0.3
+ 1530010p 0.9
+ 1532000p 0.9
+ 1532010p -0.3
+ 1534000p -0.3
+ 1534010p 0.9
+ 1536000p 0.9
+ 1536010p -0.3
+ 1538000p -0.3
+ 1538010p 0.9
+ 1540000p 0.9
+ 1540010p -0.3
+ 1542000p -0.3
+ 1542010p 0.9
+ 1544000p 0.9
+ 1544010p -0.3
+ 1546000p -0.3
+ 1546010p 0.9
+ 1548000p 0.9
+ 1548010p -0.3
+ 1550000p -0.3
+ 1550010p 0.9
+ 1552000p 0.9
+ 1552010p -0.3
+ 1554000p -0.3
+ 1554010p 0.9
+ 1556000p 0.9
+ 1556010p -0.3
+ 1558000p -0.3
+ 1558010p 0.9
+ 1560000p 0.9
+ 1560010p -0.3
+ 1562000p -0.3
+ 1562010p 0.9
+ 1564000p 0.9
+ 1564010p -0.3
+ 1566000p -0.3
+ 1566010p 0.9
+ 1568000p 0.9
+ 1568010p -0.3
+ 1570000p -0.3
+ 1570010p 0.9
+ 1572000p 0.9
+ 1572010p -0.3
+ 1574000p -0.3
+ 1574010p 0.9
+ 1576000p 0.9
+ 1576010p -0.3
+ 1578000p -0.3
+ 1578010p 0.9
+ 1580000p 0.9
+ 1580010p -0.3
+ 1582000p -0.3
+ 1582010p 0.9
+ 1584000p 0.9
+ 1584010p -0.3
+ 1586000p -0.3
+ 1586010p 0.9
+ 1588000p 0.9
+ 1588010p -0.3
+ 1590000p -0.3
+ 1590010p 0.9
+ 1592000p 0.9
+ 1592010p -0.3
+ 1594000p -0.3
+ 1594010p 0.9
+ 1596000p 0.9
+ 1596010p -0.3
+ 1598000p -0.3
+ 1598010p 0.9
+ 1600000p 0.9
+ 1600010p -0.3
+ 1602000p -0.3
+ 1602010p 0.9
+ 1604000p 0.9
+ 1604010p -0.3
+ 1606000p -0.3
+ 1606010p 0.9
+ 1608000p 0.9
+ 1608010p -0.3
+ 1610000p -0.3
+ 1610010p 0.9
+ 1612000p 0.9
+ 1612010p -0.3
+ 1614000p -0.3
+ 1614010p 0.9
+ 1616000p 0.9
+ 1616010p -0.3
+ 1618000p -0.3
+ 1618010p 0.9
+ 1620000p 0.9
+ 1620010p -0.3
+ 1622000p -0.3
+ 1622010p 0.9
+ 1624000p 0.9
+ 1624010p -0.3
+ 1626000p -0.3
+ 1626010p 0.9
+ 1628000p 0.9
+ 1628010p -0.3
+ 1630000p -0.3
+ 1630010p 0.9
+ 1632000p 0.9
+ 1632010p -0.3
+ 1634000p -0.3
+ 1634010p 0.9
+ 1636000p 0.9
+ 1636010p -0.3
+ 1638000p -0.3
+ 1638010p 0.9
+ 1640000p 0.9
+ 1640010p -0.3
+ 1642000p -0.3
+ 1642010p 0.9
+ 1644000p 0.9
+ 1644010p -0.3
+ 1646000p -0.3
+ 1646010p 0.9
+ 1648000p 0.9
+ 1648010p -0.3
+ 1650000p -0.3
+ 1650010p 0.9
+ 1652000p 0.9
+ 1652010p -0.3
+ 1654000p -0.3
+ 1654010p 0.9
+ 1656000p 0.9
+ 1656010p -0.3
+ 1658000p -0.3
+ 1658010p 0.9
+ 1660000p 0.9
+ 1660010p -0.3
+ 1662000p -0.3
+ 1662010p 0.9
+ 1664000p 0.9
+ 1664010p -0.3
+ 1666000p -0.3
+ 1666010p 0.9
+ 1668000p 0.9
+ 1668010p -0.3
+ 1670000p -0.3
+ 1670010p 0.9
+ 1672000p 0.9
+ 1672010p -0.3
+ 1674000p -0.3
+ 1674010p 0.9
+ 1676000p 0.9
+ 1676010p -0.3
+ 1678000p -0.3
+ 1678010p 0.9
+ 1680000p 0.9
+ 1680010p -0.3
+ 1682000p -0.3
+ 1682010p 0.9
+ 1684000p 0.9
+ 1684010p -0.3
+ 1686000p -0.3
+ 1686010p 0.9
+ 1688000p 0.9
+ 1688010p -0.3
+ 1690000p -0.3
+ 1690010p 0.9
+ 1692000p 0.9
+ 1692010p -0.3
+ 1694000p -0.3
+ 1694010p 0.9
+ 1696000p 0.9
+ 1696010p -0.3
+ 1698000p -0.3
+ 1698010p 0.9
+ 1700000p 0.9
+ 1700010p -0.3
+ 1702000p -0.3
+ 1702010p 0.9
+ 1704000p 0.9
+ 1704010p -0.3
+ 1706000p -0.3
+ 1706010p 0.9
+ 1708000p 0.9
+ 1708010p -0.3
+ 1710000p -0.3
+ 1710010p 0.9
+ 1712000p 0.9
+ 1712010p -0.3
+ 1714000p -0.3
+ 1714010p 0.9
+ 1716000p 0.9
+ 1716010p -0.3
+ 1718000p -0.3
+ 1718010p 0.9
+ 1720000p 0.9
+ 1720010p -0.3
+ 1722000p -0.3
+ 1722010p 0.9
+ 1724000p 0.9
+ 1724010p -0.3
+ 1726000p -0.3
+ 1726010p 0.9
+ 1728000p 0.9
+ 1728010p -0.3
+ 1730000p -0.3
+ 1730010p 0.9
+ 1732000p 0.9
+ 1732010p -0.3
+ 1734000p -0.3
+ 1734010p 0.9
+ 1736000p 0.9
+ 1736010p -0.3
+ 1738000p -0.3
+ 1738010p 0.9
+ 1740000p 0.9
+ 1740010p -0.3
+ 1742000p -0.3
+ 1742010p 0.9
+ 1744000p 0.9
+ 1744010p -0.3
+ 1746000p -0.3
+ 1746010p 0.9
+ 1748000p 0.9
+ 1748010p -0.3
+ 1750000p -0.3
+ 1750010p 0.9
+ 1752000p 0.9
+ 1752010p -0.3
+ 1754000p -0.3
+ 1754010p 0.9
+ 1756000p 0.9
+ 1756010p -0.3
+ 1758000p -0.3
+ 1758010p 0.9
+ 1760000p 0.9
+ 1760010p -0.3
+ 1762000p -0.3
+ 1762010p 0.9
+ 1764000p 0.9
+ 1764010p -0.3
+ 1766000p -0.3
+ 1766010p 0.9
+ 1768000p 0.9
+ 1768010p -0.3
+ 1770000p -0.3
+ 1770010p 0.9
+ 1772000p 0.9
+ 1772010p -0.3
+ 1774000p -0.3
+ 1774010p 0.9
+ 1776000p 0.9
+ 1776010p -0.3
+ 1778000p -0.3
+ 1778010p 0.9
+ 1780000p 0.9
+ 1780010p -0.3
+ 1782000p -0.3
+ 1782010p 0.9
+ 1784000p 0.9
+ 1784010p -0.3
+ 1786000p -0.3
+ 1786010p 0.9
+ 1788000p 0.9
+ 1788010p -0.3
+ 1790000p -0.3
+ 1790010p 0.9
+ 1792000p 0.9
+ 1792010p -0.3
+ 1794000p -0.3
+ 1794010p 0.9
+ 1796000p 0.9
+ 1796010p -0.3
+ 1798000p -0.3
+ 1798010p 0.9
+ 1800000p 0.9
+ 1800010p -0.3
+ 1802000p -0.3
+ 1802010p 0.9
+ 1804000p 0.9
+ 1804010p -0.3
+ 1806000p -0.3
+ 1806010p 0.9
+ 1808000p 0.9
+ 1808010p -0.3
+ 1810000p -0.3
+ 1810010p 0.9
+ 1812000p 0.9
+ 1812010p -0.3
+ 1814000p -0.3
+ 1814010p 0.9
+ 1816000p 0.9
+ 1816010p -0.3
+ 1818000p -0.3
+ 1818010p 0.9
+ 1820000p 0.9
+ 1820010p -0.3
+ 1822000p -0.3
+ 1822010p 0.9
+ 1824000p 0.9
+ 1824010p -0.3
+ 1826000p -0.3
+ 1826010p 0.9
+ 1828000p 0.9
+ 1828010p -0.3
+ 1830000p -0.3
+ 1830010p 0.9
+ 1832000p 0.9
+ 1832010p -0.3
+ 1834000p -0.3
+ 1834010p 0.9
+ 1836000p 0.9
+ 1836010p -0.3
+ 1838000p -0.3
+ 1838010p 0.9
+ 1840000p 0.9
+ 1840010p -0.3
+ 1842000p -0.3
+ 1842010p 0.9
+ 1844000p 0.9
+ 1844010p -0.3
+ 1846000p -0.3
+ 1846010p 0.9
+ 1848000p 0.9
+ 1848010p -0.3
+ 1850000p -0.3
+ 1850010p 0.9
+ 1852000p 0.9
+ 1852010p -0.3
+ 1854000p -0.3
+ 1854010p 0.9
+ 1856000p 0.9
+ 1856010p -0.3
+ 1858000p -0.3
+ 1858010p 0.9
+ 1860000p 0.9
+ 1860010p -0.3
+ 1862000p -0.3
+ 1862010p 0.9
+ 1864000p 0.9
+ 1864010p -0.3
+ 1866000p -0.3
+ 1866010p 0.9
+ 1868000p 0.9
+ 1868010p -0.3
+ 1870000p -0.3
+ 1870010p 0.9
+ 1872000p 0.9
+ 1872010p -0.3
+ 1874000p -0.3
+ 1874010p 0.9
+ 1876000p 0.9
+ 1876010p -0.3
+ 1878000p -0.3
+ 1878010p 0.9
+ 1880000p 0.9
+ 1880010p -0.3
+ 1882000p -0.3
+ 1882010p 0.9
+ 1884000p 0.9
+ 1884010p -0.3
+ 1886000p -0.3
+ 1886010p 0.9
+ 1888000p 0.9
+ 1888010p -0.3
+ 1890000p -0.3
+ 1890010p 0.9
+ 1892000p 0.9
+ 1892010p -0.3
+ 1894000p -0.3
+ 1894010p 0.9
+ 1896000p 0.9
+ 1896010p -0.3
+ 1898000p -0.3
+ 1898010p 0.9
+ 1900000p 0.9
+ 1900010p -0.3
+ 1902000p -0.3
+ 1902010p 0.9
+ 1904000p 0.9
+ 1904010p -0.3
+ 1906000p -0.3
+ 1906010p 0.9
+ 1908000p 0.9
+ 1908010p -0.3
+ 1910000p -0.3
+ 1910010p 0.9
+ 1912000p 0.9
+ 1912010p -0.3
+ 1914000p -0.3
+ 1914010p 0.9
+ 1916000p 0.9
+ 1916010p -0.3
+ 1918000p -0.3
+ 1918010p 0.9
+ 1920000p 0.9
+ 1920010p -0.3
+ 1922000p -0.3
+ 1922010p 0.9
+ 1924000p 0.9
+ 1924010p -0.3
+ 1926000p -0.3
+ 1926010p 0.9
+ 1928000p 0.9
+ 1928010p -0.3
+ 1930000p -0.3
+ 1930010p 0.9
+ 1932000p 0.9
+ 1932010p -0.3
+ 1934000p -0.3
+ 1934010p 0.9
+ 1936000p 0.9
+ 1936010p -0.3
+ 1938000p -0.3
+ 1938010p 0.9
+ 1940000p 0.9
+ 1940010p -0.3
+ 1942000p -0.3
+ 1942010p 0.9
+ 1944000p 0.9
+ 1944010p -0.3
+ 1946000p -0.3
+ 1946010p 0.9
+ 1948000p 0.9
+ 1948010p -0.3
+ 1950000p -0.3
+ 1950010p 0.9
+ 1952000p 0.9
+ 1952010p -0.3
+ 1954000p -0.3
+ 1954010p 0.9
+ 1956000p 0.9
+ 1956010p -0.3
+ 1958000p -0.3
+ 1958010p 0.9
+ 1960000p 0.9
+ 1960010p -0.3
+ 1962000p -0.3
+ 1962010p 0.9
+ 1964000p 0.9
+ 1964010p -0.3
+ 1966000p -0.3
+ 1966010p 0.9
+ 1968000p 0.9
+ 1968010p -0.3
+ 1970000p -0.3
+ 1970010p 0.9
+ 1972000p 0.9
+ 1972010p -0.3
+ 1974000p -0.3
+ 1974010p 0.9
+ 1976000p 0.9
+ 1976010p -0.3
+ 1978000p -0.3
+ 1978010p 0.9
+ 1980000p 0.9
+ 1980010p -0.3
+ 1982000p -0.3
+ 1982010p 0.9
+ 1984000p 0.9
+ 1984010p -0.3
+ 1986000p -0.3
+ 1986010p 0.9
+ 1988000p 0.9
+ 1988010p -0.3
+ 1990000p -0.3
+ 1990010p 0.9
+ 1992000p 0.9
+ 1992010p -0.3
+ 1994000p -0.3
+ 1994010p 0.9
+ 1996000p 0.9
+ 1996010p -0.3
+ 1998000p -0.3
+ 1998010p 0.9
+ 2000000p 0.9
+ 2000010p -0.3
+ 2002000p -0.3
+ 2002010p 0.9
+ 2004000p 0.9
+ 2004010p -0.3
+ 2006000p -0.3
+ 2006010p 0.9
+ 2008000p 0.9
+ 2008010p -0.3
+ 2010000p -0.3
+ 2010010p 0.9
+ 2012000p 0.9
+ 2012010p -0.3
+ 2014000p -0.3
+ 2014010p 0.9
+ 2016000p 0.9
+ 2016010p -0.3
+ 2018000p -0.3
+ 2018010p 0.9
+ 2020000p 0.9
+ 2020010p -0.3
+ 2022000p -0.3
+ 2022010p 0.9
+ 2024000p 0.9
+ 2024010p -0.3
+ 2026000p -0.3
+ 2026010p 0.9
+ 2028000p 0.9
+ 2028010p -0.3
+ 2030000p -0.3
+ 2030010p 0.9
+ 2032000p 0.9
+ 2032010p -0.3
+ 2034000p -0.3
+ 2034010p 0.9
+ 2036000p 0.9
+ 2036010p -0.3
+ 2038000p -0.3
+ 2038010p 0.9
+ 2040000p 0.9
+ 2040010p -0.3
+ 2042000p -0.3
+ 2042010p 0.9
+ 2044000p 0.9
+ 2044010p -0.3
+ 2046000p -0.3
+ 2046010p 0.9
+ 2048000p 0.9
+ 2048010p -0.3
+ \]
V_data_21 (Data\\<21\\> gnd!) vsource type=pwl wave=\[
+ 0    0.9
+ 2000p 0.9
+ 2010p -0.3
+ 4000p -0.3
+ 4010p 0.9
+ 6000p 0.9
+ 6010p -0.3
+ 8000p -0.3
+ 8010p 0.9
+ 10000p 0.9
+ 10010p -0.3
+ 12000p -0.3
+ 12010p 0.9
+ 14000p 0.9
+ 14010p -0.3
+ 16000p -0.3
+ 16010p 0.9
+ 18000p 0.9
+ 18010p -0.3
+ 20000p -0.3
+ 20010p 0.9
+ 22000p 0.9
+ 22010p -0.3
+ 24000p -0.3
+ 24010p 0.9
+ 26000p 0.9
+ 26010p -0.3
+ 28000p -0.3
+ 28010p 0.9
+ 30000p 0.9
+ 30010p -0.3
+ 32000p -0.3
+ 32010p 0.9
+ 34000p 0.9
+ 34010p -0.3
+ 36000p -0.3
+ 36010p 0.9
+ 38000p 0.9
+ 38010p -0.3
+ 40000p -0.3
+ 40010p 0.9
+ 42000p 0.9
+ 42010p -0.3
+ 44000p -0.3
+ 44010p 0.9
+ 46000p 0.9
+ 46010p -0.3
+ 48000p -0.3
+ 48010p 0.9
+ 50000p 0.9
+ 50010p -0.3
+ 52000p -0.3
+ 52010p 0.9
+ 54000p 0.9
+ 54010p -0.3
+ 56000p -0.3
+ 56010p 0.9
+ 58000p 0.9
+ 58010p -0.3
+ 60000p -0.3
+ 60010p 0.9
+ 62000p 0.9
+ 62010p -0.3
+ 64000p -0.3
+ 64010p 0.9
+ 66000p 0.9
+ 66010p -0.3
+ 68000p -0.3
+ 68010p 0.9
+ 70000p 0.9
+ 70010p -0.3
+ 72000p -0.3
+ 72010p 0.9
+ 74000p 0.9
+ 74010p -0.3
+ 76000p -0.3
+ 76010p 0.9
+ 78000p 0.9
+ 78010p -0.3
+ 80000p -0.3
+ 80010p 0.9
+ 82000p 0.9
+ 82010p -0.3
+ 84000p -0.3
+ 84010p 0.9
+ 86000p 0.9
+ 86010p -0.3
+ 88000p -0.3
+ 88010p 0.9
+ 90000p 0.9
+ 90010p -0.3
+ 92000p -0.3
+ 92010p 0.9
+ 94000p 0.9
+ 94010p -0.3
+ 96000p -0.3
+ 96010p 0.9
+ 98000p 0.9
+ 98010p -0.3
+ 100000p -0.3
+ 100010p 0.9
+ 102000p 0.9
+ 102010p -0.3
+ 104000p -0.3
+ 104010p 0.9
+ 106000p 0.9
+ 106010p -0.3
+ 108000p -0.3
+ 108010p 0.9
+ 110000p 0.9
+ 110010p -0.3
+ 112000p -0.3
+ 112010p 0.9
+ 114000p 0.9
+ 114010p -0.3
+ 116000p -0.3
+ 116010p 0.9
+ 118000p 0.9
+ 118010p -0.3
+ 120000p -0.3
+ 120010p 0.9
+ 122000p 0.9
+ 122010p -0.3
+ 124000p -0.3
+ 124010p 0.9
+ 126000p 0.9
+ 126010p -0.3
+ 128000p -0.3
+ 128010p 0.9
+ 130000p 0.9
+ 130010p -0.3
+ 132000p -0.3
+ 132010p 0.9
+ 134000p 0.9
+ 134010p -0.3
+ 136000p -0.3
+ 136010p 0.9
+ 138000p 0.9
+ 138010p -0.3
+ 140000p -0.3
+ 140010p 0.9
+ 142000p 0.9
+ 142010p -0.3
+ 144000p -0.3
+ 144010p 0.9
+ 146000p 0.9
+ 146010p -0.3
+ 148000p -0.3
+ 148010p 0.9
+ 150000p 0.9
+ 150010p -0.3
+ 152000p -0.3
+ 152010p 0.9
+ 154000p 0.9
+ 154010p -0.3
+ 156000p -0.3
+ 156010p 0.9
+ 158000p 0.9
+ 158010p -0.3
+ 160000p -0.3
+ 160010p 0.9
+ 162000p 0.9
+ 162010p -0.3
+ 164000p -0.3
+ 164010p 0.9
+ 166000p 0.9
+ 166010p -0.3
+ 168000p -0.3
+ 168010p 0.9
+ 170000p 0.9
+ 170010p -0.3
+ 172000p -0.3
+ 172010p 0.9
+ 174000p 0.9
+ 174010p -0.3
+ 176000p -0.3
+ 176010p 0.9
+ 178000p 0.9
+ 178010p -0.3
+ 180000p -0.3
+ 180010p 0.9
+ 182000p 0.9
+ 182010p -0.3
+ 184000p -0.3
+ 184010p 0.9
+ 186000p 0.9
+ 186010p -0.3
+ 188000p -0.3
+ 188010p 0.9
+ 190000p 0.9
+ 190010p -0.3
+ 192000p -0.3
+ 192010p 0.9
+ 194000p 0.9
+ 194010p -0.3
+ 196000p -0.3
+ 196010p 0.9
+ 198000p 0.9
+ 198010p -0.3
+ 200000p -0.3
+ 200010p 0.9
+ 202000p 0.9
+ 202010p -0.3
+ 204000p -0.3
+ 204010p 0.9
+ 206000p 0.9
+ 206010p -0.3
+ 208000p -0.3
+ 208010p 0.9
+ 210000p 0.9
+ 210010p -0.3
+ 212000p -0.3
+ 212010p 0.9
+ 214000p 0.9
+ 214010p -0.3
+ 216000p -0.3
+ 216010p 0.9
+ 218000p 0.9
+ 218010p -0.3
+ 220000p -0.3
+ 220010p 0.9
+ 222000p 0.9
+ 222010p -0.3
+ 224000p -0.3
+ 224010p 0.9
+ 226000p 0.9
+ 226010p -0.3
+ 228000p -0.3
+ 228010p 0.9
+ 230000p 0.9
+ 230010p -0.3
+ 232000p -0.3
+ 232010p 0.9
+ 234000p 0.9
+ 234010p -0.3
+ 236000p -0.3
+ 236010p 0.9
+ 238000p 0.9
+ 238010p -0.3
+ 240000p -0.3
+ 240010p 0.9
+ 242000p 0.9
+ 242010p -0.3
+ 244000p -0.3
+ 244010p 0.9
+ 246000p 0.9
+ 246010p -0.3
+ 248000p -0.3
+ 248010p 0.9
+ 250000p 0.9
+ 250010p -0.3
+ 252000p -0.3
+ 252010p 0.9
+ 254000p 0.9
+ 254010p -0.3
+ 256000p -0.3
+ 256010p 0.9
+ 258000p 0.9
+ 258010p -0.3
+ 260000p -0.3
+ 260010p 0.9
+ 262000p 0.9
+ 262010p -0.3
+ 264000p -0.3
+ 264010p 0.9
+ 266000p 0.9
+ 266010p -0.3
+ 268000p -0.3
+ 268010p 0.9
+ 270000p 0.9
+ 270010p -0.3
+ 272000p -0.3
+ 272010p 0.9
+ 274000p 0.9
+ 274010p -0.3
+ 276000p -0.3
+ 276010p 0.9
+ 278000p 0.9
+ 278010p -0.3
+ 280000p -0.3
+ 280010p 0.9
+ 282000p 0.9
+ 282010p -0.3
+ 284000p -0.3
+ 284010p 0.9
+ 286000p 0.9
+ 286010p -0.3
+ 288000p -0.3
+ 288010p 0.9
+ 290000p 0.9
+ 290010p -0.3
+ 292000p -0.3
+ 292010p 0.9
+ 294000p 0.9
+ 294010p -0.3
+ 296000p -0.3
+ 296010p 0.9
+ 298000p 0.9
+ 298010p -0.3
+ 300000p -0.3
+ 300010p 0.9
+ 302000p 0.9
+ 302010p -0.3
+ 304000p -0.3
+ 304010p 0.9
+ 306000p 0.9
+ 306010p -0.3
+ 308000p -0.3
+ 308010p 0.9
+ 310000p 0.9
+ 310010p -0.3
+ 312000p -0.3
+ 312010p 0.9
+ 314000p 0.9
+ 314010p -0.3
+ 316000p -0.3
+ 316010p 0.9
+ 318000p 0.9
+ 318010p -0.3
+ 320000p -0.3
+ 320010p 0.9
+ 322000p 0.9
+ 322010p -0.3
+ 324000p -0.3
+ 324010p 0.9
+ 326000p 0.9
+ 326010p -0.3
+ 328000p -0.3
+ 328010p 0.9
+ 330000p 0.9
+ 330010p -0.3
+ 332000p -0.3
+ 332010p 0.9
+ 334000p 0.9
+ 334010p -0.3
+ 336000p -0.3
+ 336010p 0.9
+ 338000p 0.9
+ 338010p -0.3
+ 340000p -0.3
+ 340010p 0.9
+ 342000p 0.9
+ 342010p -0.3
+ 344000p -0.3
+ 344010p 0.9
+ 346000p 0.9
+ 346010p -0.3
+ 348000p -0.3
+ 348010p 0.9
+ 350000p 0.9
+ 350010p -0.3
+ 352000p -0.3
+ 352010p 0.9
+ 354000p 0.9
+ 354010p -0.3
+ 356000p -0.3
+ 356010p 0.9
+ 358000p 0.9
+ 358010p -0.3
+ 360000p -0.3
+ 360010p 0.9
+ 362000p 0.9
+ 362010p -0.3
+ 364000p -0.3
+ 364010p 0.9
+ 366000p 0.9
+ 366010p -0.3
+ 368000p -0.3
+ 368010p 0.9
+ 370000p 0.9
+ 370010p -0.3
+ 372000p -0.3
+ 372010p 0.9
+ 374000p 0.9
+ 374010p -0.3
+ 376000p -0.3
+ 376010p 0.9
+ 378000p 0.9
+ 378010p -0.3
+ 380000p -0.3
+ 380010p 0.9
+ 382000p 0.9
+ 382010p -0.3
+ 384000p -0.3
+ 384010p 0.9
+ 386000p 0.9
+ 386010p -0.3
+ 388000p -0.3
+ 388010p 0.9
+ 390000p 0.9
+ 390010p -0.3
+ 392000p -0.3
+ 392010p 0.9
+ 394000p 0.9
+ 394010p -0.3
+ 396000p -0.3
+ 396010p 0.9
+ 398000p 0.9
+ 398010p -0.3
+ 400000p -0.3
+ 400010p 0.9
+ 402000p 0.9
+ 402010p -0.3
+ 404000p -0.3
+ 404010p 0.9
+ 406000p 0.9
+ 406010p -0.3
+ 408000p -0.3
+ 408010p 0.9
+ 410000p 0.9
+ 410010p -0.3
+ 412000p -0.3
+ 412010p 0.9
+ 414000p 0.9
+ 414010p -0.3
+ 416000p -0.3
+ 416010p 0.9
+ 418000p 0.9
+ 418010p -0.3
+ 420000p -0.3
+ 420010p 0.9
+ 422000p 0.9
+ 422010p -0.3
+ 424000p -0.3
+ 424010p 0.9
+ 426000p 0.9
+ 426010p -0.3
+ 428000p -0.3
+ 428010p 0.9
+ 430000p 0.9
+ 430010p -0.3
+ 432000p -0.3
+ 432010p 0.9
+ 434000p 0.9
+ 434010p -0.3
+ 436000p -0.3
+ 436010p 0.9
+ 438000p 0.9
+ 438010p -0.3
+ 440000p -0.3
+ 440010p 0.9
+ 442000p 0.9
+ 442010p -0.3
+ 444000p -0.3
+ 444010p 0.9
+ 446000p 0.9
+ 446010p -0.3
+ 448000p -0.3
+ 448010p 0.9
+ 450000p 0.9
+ 450010p -0.3
+ 452000p -0.3
+ 452010p 0.9
+ 454000p 0.9
+ 454010p -0.3
+ 456000p -0.3
+ 456010p 0.9
+ 458000p 0.9
+ 458010p -0.3
+ 460000p -0.3
+ 460010p 0.9
+ 462000p 0.9
+ 462010p -0.3
+ 464000p -0.3
+ 464010p 0.9
+ 466000p 0.9
+ 466010p -0.3
+ 468000p -0.3
+ 468010p 0.9
+ 470000p 0.9
+ 470010p -0.3
+ 472000p -0.3
+ 472010p 0.9
+ 474000p 0.9
+ 474010p -0.3
+ 476000p -0.3
+ 476010p 0.9
+ 478000p 0.9
+ 478010p -0.3
+ 480000p -0.3
+ 480010p 0.9
+ 482000p 0.9
+ 482010p -0.3
+ 484000p -0.3
+ 484010p 0.9
+ 486000p 0.9
+ 486010p -0.3
+ 488000p -0.3
+ 488010p 0.9
+ 490000p 0.9
+ 490010p -0.3
+ 492000p -0.3
+ 492010p 0.9
+ 494000p 0.9
+ 494010p -0.3
+ 496000p -0.3
+ 496010p 0.9
+ 498000p 0.9
+ 498010p -0.3
+ 500000p -0.3
+ 500010p 0.9
+ 502000p 0.9
+ 502010p -0.3
+ 504000p -0.3
+ 504010p 0.9
+ 506000p 0.9
+ 506010p -0.3
+ 508000p -0.3
+ 508010p 0.9
+ 510000p 0.9
+ 510010p -0.3
+ 512000p -0.3
+ 512010p 0.9
+ 514000p 0.9
+ 514010p -0.3
+ 516000p -0.3
+ 516010p 0.9
+ 518000p 0.9
+ 518010p -0.3
+ 520000p -0.3
+ 520010p 0.9
+ 522000p 0.9
+ 522010p -0.3
+ 524000p -0.3
+ 524010p 0.9
+ 526000p 0.9
+ 526010p -0.3
+ 528000p -0.3
+ 528010p 0.9
+ 530000p 0.9
+ 530010p -0.3
+ 532000p -0.3
+ 532010p 0.9
+ 534000p 0.9
+ 534010p -0.3
+ 536000p -0.3
+ 536010p 0.9
+ 538000p 0.9
+ 538010p -0.3
+ 540000p -0.3
+ 540010p 0.9
+ 542000p 0.9
+ 542010p -0.3
+ 544000p -0.3
+ 544010p 0.9
+ 546000p 0.9
+ 546010p -0.3
+ 548000p -0.3
+ 548010p 0.9
+ 550000p 0.9
+ 550010p -0.3
+ 552000p -0.3
+ 552010p 0.9
+ 554000p 0.9
+ 554010p -0.3
+ 556000p -0.3
+ 556010p 0.9
+ 558000p 0.9
+ 558010p -0.3
+ 560000p -0.3
+ 560010p 0.9
+ 562000p 0.9
+ 562010p -0.3
+ 564000p -0.3
+ 564010p 0.9
+ 566000p 0.9
+ 566010p -0.3
+ 568000p -0.3
+ 568010p 0.9
+ 570000p 0.9
+ 570010p -0.3
+ 572000p -0.3
+ 572010p 0.9
+ 574000p 0.9
+ 574010p -0.3
+ 576000p -0.3
+ 576010p 0.9
+ 578000p 0.9
+ 578010p -0.3
+ 580000p -0.3
+ 580010p 0.9
+ 582000p 0.9
+ 582010p -0.3
+ 584000p -0.3
+ 584010p 0.9
+ 586000p 0.9
+ 586010p -0.3
+ 588000p -0.3
+ 588010p 0.9
+ 590000p 0.9
+ 590010p -0.3
+ 592000p -0.3
+ 592010p 0.9
+ 594000p 0.9
+ 594010p -0.3
+ 596000p -0.3
+ 596010p 0.9
+ 598000p 0.9
+ 598010p -0.3
+ 600000p -0.3
+ 600010p 0.9
+ 602000p 0.9
+ 602010p -0.3
+ 604000p -0.3
+ 604010p 0.9
+ 606000p 0.9
+ 606010p -0.3
+ 608000p -0.3
+ 608010p 0.9
+ 610000p 0.9
+ 610010p -0.3
+ 612000p -0.3
+ 612010p 0.9
+ 614000p 0.9
+ 614010p -0.3
+ 616000p -0.3
+ 616010p 0.9
+ 618000p 0.9
+ 618010p -0.3
+ 620000p -0.3
+ 620010p 0.9
+ 622000p 0.9
+ 622010p -0.3
+ 624000p -0.3
+ 624010p 0.9
+ 626000p 0.9
+ 626010p -0.3
+ 628000p -0.3
+ 628010p 0.9
+ 630000p 0.9
+ 630010p -0.3
+ 632000p -0.3
+ 632010p 0.9
+ 634000p 0.9
+ 634010p -0.3
+ 636000p -0.3
+ 636010p 0.9
+ 638000p 0.9
+ 638010p -0.3
+ 640000p -0.3
+ 640010p 0.9
+ 642000p 0.9
+ 642010p -0.3
+ 644000p -0.3
+ 644010p 0.9
+ 646000p 0.9
+ 646010p -0.3
+ 648000p -0.3
+ 648010p 0.9
+ 650000p 0.9
+ 650010p -0.3
+ 652000p -0.3
+ 652010p 0.9
+ 654000p 0.9
+ 654010p -0.3
+ 656000p -0.3
+ 656010p 0.9
+ 658000p 0.9
+ 658010p -0.3
+ 660000p -0.3
+ 660010p 0.9
+ 662000p 0.9
+ 662010p -0.3
+ 664000p -0.3
+ 664010p 0.9
+ 666000p 0.9
+ 666010p -0.3
+ 668000p -0.3
+ 668010p 0.9
+ 670000p 0.9
+ 670010p -0.3
+ 672000p -0.3
+ 672010p 0.9
+ 674000p 0.9
+ 674010p -0.3
+ 676000p -0.3
+ 676010p 0.9
+ 678000p 0.9
+ 678010p -0.3
+ 680000p -0.3
+ 680010p 0.9
+ 682000p 0.9
+ 682010p -0.3
+ 684000p -0.3
+ 684010p 0.9
+ 686000p 0.9
+ 686010p -0.3
+ 688000p -0.3
+ 688010p 0.9
+ 690000p 0.9
+ 690010p -0.3
+ 692000p -0.3
+ 692010p 0.9
+ 694000p 0.9
+ 694010p -0.3
+ 696000p -0.3
+ 696010p 0.9
+ 698000p 0.9
+ 698010p -0.3
+ 700000p -0.3
+ 700010p 0.9
+ 702000p 0.9
+ 702010p -0.3
+ 704000p -0.3
+ 704010p 0.9
+ 706000p 0.9
+ 706010p -0.3
+ 708000p -0.3
+ 708010p 0.9
+ 710000p 0.9
+ 710010p -0.3
+ 712000p -0.3
+ 712010p 0.9
+ 714000p 0.9
+ 714010p -0.3
+ 716000p -0.3
+ 716010p 0.9
+ 718000p 0.9
+ 718010p -0.3
+ 720000p -0.3
+ 720010p 0.9
+ 722000p 0.9
+ 722010p -0.3
+ 724000p -0.3
+ 724010p 0.9
+ 726000p 0.9
+ 726010p -0.3
+ 728000p -0.3
+ 728010p 0.9
+ 730000p 0.9
+ 730010p -0.3
+ 732000p -0.3
+ 732010p 0.9
+ 734000p 0.9
+ 734010p -0.3
+ 736000p -0.3
+ 736010p 0.9
+ 738000p 0.9
+ 738010p -0.3
+ 740000p -0.3
+ 740010p 0.9
+ 742000p 0.9
+ 742010p -0.3
+ 744000p -0.3
+ 744010p 0.9
+ 746000p 0.9
+ 746010p -0.3
+ 748000p -0.3
+ 748010p 0.9
+ 750000p 0.9
+ 750010p -0.3
+ 752000p -0.3
+ 752010p 0.9
+ 754000p 0.9
+ 754010p -0.3
+ 756000p -0.3
+ 756010p 0.9
+ 758000p 0.9
+ 758010p -0.3
+ 760000p -0.3
+ 760010p 0.9
+ 762000p 0.9
+ 762010p -0.3
+ 764000p -0.3
+ 764010p 0.9
+ 766000p 0.9
+ 766010p -0.3
+ 768000p -0.3
+ 768010p 0.9
+ 770000p 0.9
+ 770010p -0.3
+ 772000p -0.3
+ 772010p 0.9
+ 774000p 0.9
+ 774010p -0.3
+ 776000p -0.3
+ 776010p 0.9
+ 778000p 0.9
+ 778010p -0.3
+ 780000p -0.3
+ 780010p 0.9
+ 782000p 0.9
+ 782010p -0.3
+ 784000p -0.3
+ 784010p 0.9
+ 786000p 0.9
+ 786010p -0.3
+ 788000p -0.3
+ 788010p 0.9
+ 790000p 0.9
+ 790010p -0.3
+ 792000p -0.3
+ 792010p 0.9
+ 794000p 0.9
+ 794010p -0.3
+ 796000p -0.3
+ 796010p 0.9
+ 798000p 0.9
+ 798010p -0.3
+ 800000p -0.3
+ 800010p 0.9
+ 802000p 0.9
+ 802010p -0.3
+ 804000p -0.3
+ 804010p 0.9
+ 806000p 0.9
+ 806010p -0.3
+ 808000p -0.3
+ 808010p 0.9
+ 810000p 0.9
+ 810010p -0.3
+ 812000p -0.3
+ 812010p 0.9
+ 814000p 0.9
+ 814010p -0.3
+ 816000p -0.3
+ 816010p 0.9
+ 818000p 0.9
+ 818010p -0.3
+ 820000p -0.3
+ 820010p 0.9
+ 822000p 0.9
+ 822010p -0.3
+ 824000p -0.3
+ 824010p 0.9
+ 826000p 0.9
+ 826010p -0.3
+ 828000p -0.3
+ 828010p 0.9
+ 830000p 0.9
+ 830010p -0.3
+ 832000p -0.3
+ 832010p 0.9
+ 834000p 0.9
+ 834010p -0.3
+ 836000p -0.3
+ 836010p 0.9
+ 838000p 0.9
+ 838010p -0.3
+ 840000p -0.3
+ 840010p 0.9
+ 842000p 0.9
+ 842010p -0.3
+ 844000p -0.3
+ 844010p 0.9
+ 846000p 0.9
+ 846010p -0.3
+ 848000p -0.3
+ 848010p 0.9
+ 850000p 0.9
+ 850010p -0.3
+ 852000p -0.3
+ 852010p 0.9
+ 854000p 0.9
+ 854010p -0.3
+ 856000p -0.3
+ 856010p 0.9
+ 858000p 0.9
+ 858010p -0.3
+ 860000p -0.3
+ 860010p 0.9
+ 862000p 0.9
+ 862010p -0.3
+ 864000p -0.3
+ 864010p 0.9
+ 866000p 0.9
+ 866010p -0.3
+ 868000p -0.3
+ 868010p 0.9
+ 870000p 0.9
+ 870010p -0.3
+ 872000p -0.3
+ 872010p 0.9
+ 874000p 0.9
+ 874010p -0.3
+ 876000p -0.3
+ 876010p 0.9
+ 878000p 0.9
+ 878010p -0.3
+ 880000p -0.3
+ 880010p 0.9
+ 882000p 0.9
+ 882010p -0.3
+ 884000p -0.3
+ 884010p 0.9
+ 886000p 0.9
+ 886010p -0.3
+ 888000p -0.3
+ 888010p 0.9
+ 890000p 0.9
+ 890010p -0.3
+ 892000p -0.3
+ 892010p 0.9
+ 894000p 0.9
+ 894010p -0.3
+ 896000p -0.3
+ 896010p 0.9
+ 898000p 0.9
+ 898010p -0.3
+ 900000p -0.3
+ 900010p 0.9
+ 902000p 0.9
+ 902010p -0.3
+ 904000p -0.3
+ 904010p 0.9
+ 906000p 0.9
+ 906010p -0.3
+ 908000p -0.3
+ 908010p 0.9
+ 910000p 0.9
+ 910010p -0.3
+ 912000p -0.3
+ 912010p 0.9
+ 914000p 0.9
+ 914010p -0.3
+ 916000p -0.3
+ 916010p 0.9
+ 918000p 0.9
+ 918010p -0.3
+ 920000p -0.3
+ 920010p 0.9
+ 922000p 0.9
+ 922010p -0.3
+ 924000p -0.3
+ 924010p 0.9
+ 926000p 0.9
+ 926010p -0.3
+ 928000p -0.3
+ 928010p 0.9
+ 930000p 0.9
+ 930010p -0.3
+ 932000p -0.3
+ 932010p 0.9
+ 934000p 0.9
+ 934010p -0.3
+ 936000p -0.3
+ 936010p 0.9
+ 938000p 0.9
+ 938010p -0.3
+ 940000p -0.3
+ 940010p 0.9
+ 942000p 0.9
+ 942010p -0.3
+ 944000p -0.3
+ 944010p 0.9
+ 946000p 0.9
+ 946010p -0.3
+ 948000p -0.3
+ 948010p 0.9
+ 950000p 0.9
+ 950010p -0.3
+ 952000p -0.3
+ 952010p 0.9
+ 954000p 0.9
+ 954010p -0.3
+ 956000p -0.3
+ 956010p 0.9
+ 958000p 0.9
+ 958010p -0.3
+ 960000p -0.3
+ 960010p 0.9
+ 962000p 0.9
+ 962010p -0.3
+ 964000p -0.3
+ 964010p 0.9
+ 966000p 0.9
+ 966010p -0.3
+ 968000p -0.3
+ 968010p 0.9
+ 970000p 0.9
+ 970010p -0.3
+ 972000p -0.3
+ 972010p 0.9
+ 974000p 0.9
+ 974010p -0.3
+ 976000p -0.3
+ 976010p 0.9
+ 978000p 0.9
+ 978010p -0.3
+ 980000p -0.3
+ 980010p 0.9
+ 982000p 0.9
+ 982010p -0.3
+ 984000p -0.3
+ 984010p 0.9
+ 986000p 0.9
+ 986010p -0.3
+ 988000p -0.3
+ 988010p 0.9
+ 990000p 0.9
+ 990010p -0.3
+ 992000p -0.3
+ 992010p 0.9
+ 994000p 0.9
+ 994010p -0.3
+ 996000p -0.3
+ 996010p 0.9
+ 998000p 0.9
+ 998010p -0.3
+ 1000000p -0.3
+ 1000010p 0.9
+ 1002000p 0.9
+ 1002010p -0.3
+ 1004000p -0.3
+ 1004010p 0.9
+ 1006000p 0.9
+ 1006010p -0.3
+ 1008000p -0.3
+ 1008010p 0.9
+ 1010000p 0.9
+ 1010010p -0.3
+ 1012000p -0.3
+ 1012010p 0.9
+ 1014000p 0.9
+ 1014010p -0.3
+ 1016000p -0.3
+ 1016010p 0.9
+ 1018000p 0.9
+ 1018010p -0.3
+ 1020000p -0.3
+ 1020010p 0.9
+ 1022000p 0.9
+ 1022010p -0.3
+ 1024000p -0.3
+ 1024010p 0.9
+ 1026000p 0.9
+ 1026010p -0.3
+ 1028000p -0.3
+ 1028010p 0.9
+ 1030000p 0.9
+ 1030010p -0.3
+ 1032000p -0.3
+ 1032010p 0.9
+ 1034000p 0.9
+ 1034010p -0.3
+ 1036000p -0.3
+ 1036010p 0.9
+ 1038000p 0.9
+ 1038010p -0.3
+ 1040000p -0.3
+ 1040010p 0.9
+ 1042000p 0.9
+ 1042010p -0.3
+ 1044000p -0.3
+ 1044010p 0.9
+ 1046000p 0.9
+ 1046010p -0.3
+ 1048000p -0.3
+ 1048010p 0.9
+ 1050000p 0.9
+ 1050010p -0.3
+ 1052000p -0.3
+ 1052010p 0.9
+ 1054000p 0.9
+ 1054010p -0.3
+ 1056000p -0.3
+ 1056010p 0.9
+ 1058000p 0.9
+ 1058010p -0.3
+ 1060000p -0.3
+ 1060010p 0.9
+ 1062000p 0.9
+ 1062010p -0.3
+ 1064000p -0.3
+ 1064010p 0.9
+ 1066000p 0.9
+ 1066010p -0.3
+ 1068000p -0.3
+ 1068010p 0.9
+ 1070000p 0.9
+ 1070010p -0.3
+ 1072000p -0.3
+ 1072010p 0.9
+ 1074000p 0.9
+ 1074010p -0.3
+ 1076000p -0.3
+ 1076010p 0.9
+ 1078000p 0.9
+ 1078010p -0.3
+ 1080000p -0.3
+ 1080010p 0.9
+ 1082000p 0.9
+ 1082010p -0.3
+ 1084000p -0.3
+ 1084010p 0.9
+ 1086000p 0.9
+ 1086010p -0.3
+ 1088000p -0.3
+ 1088010p 0.9
+ 1090000p 0.9
+ 1090010p -0.3
+ 1092000p -0.3
+ 1092010p 0.9
+ 1094000p 0.9
+ 1094010p -0.3
+ 1096000p -0.3
+ 1096010p 0.9
+ 1098000p 0.9
+ 1098010p -0.3
+ 1100000p -0.3
+ 1100010p 0.9
+ 1102000p 0.9
+ 1102010p -0.3
+ 1104000p -0.3
+ 1104010p 0.9
+ 1106000p 0.9
+ 1106010p -0.3
+ 1108000p -0.3
+ 1108010p 0.9
+ 1110000p 0.9
+ 1110010p -0.3
+ 1112000p -0.3
+ 1112010p 0.9
+ 1114000p 0.9
+ 1114010p -0.3
+ 1116000p -0.3
+ 1116010p 0.9
+ 1118000p 0.9
+ 1118010p -0.3
+ 1120000p -0.3
+ 1120010p 0.9
+ 1122000p 0.9
+ 1122010p -0.3
+ 1124000p -0.3
+ 1124010p 0.9
+ 1126000p 0.9
+ 1126010p -0.3
+ 1128000p -0.3
+ 1128010p 0.9
+ 1130000p 0.9
+ 1130010p -0.3
+ 1132000p -0.3
+ 1132010p 0.9
+ 1134000p 0.9
+ 1134010p -0.3
+ 1136000p -0.3
+ 1136010p 0.9
+ 1138000p 0.9
+ 1138010p -0.3
+ 1140000p -0.3
+ 1140010p 0.9
+ 1142000p 0.9
+ 1142010p -0.3
+ 1144000p -0.3
+ 1144010p 0.9
+ 1146000p 0.9
+ 1146010p -0.3
+ 1148000p -0.3
+ 1148010p 0.9
+ 1150000p 0.9
+ 1150010p -0.3
+ 1152000p -0.3
+ 1152010p 0.9
+ 1154000p 0.9
+ 1154010p -0.3
+ 1156000p -0.3
+ 1156010p 0.9
+ 1158000p 0.9
+ 1158010p -0.3
+ 1160000p -0.3
+ 1160010p 0.9
+ 1162000p 0.9
+ 1162010p -0.3
+ 1164000p -0.3
+ 1164010p 0.9
+ 1166000p 0.9
+ 1166010p -0.3
+ 1168000p -0.3
+ 1168010p 0.9
+ 1170000p 0.9
+ 1170010p -0.3
+ 1172000p -0.3
+ 1172010p 0.9
+ 1174000p 0.9
+ 1174010p -0.3
+ 1176000p -0.3
+ 1176010p 0.9
+ 1178000p 0.9
+ 1178010p -0.3
+ 1180000p -0.3
+ 1180010p 0.9
+ 1182000p 0.9
+ 1182010p -0.3
+ 1184000p -0.3
+ 1184010p 0.9
+ 1186000p 0.9
+ 1186010p -0.3
+ 1188000p -0.3
+ 1188010p 0.9
+ 1190000p 0.9
+ 1190010p -0.3
+ 1192000p -0.3
+ 1192010p 0.9
+ 1194000p 0.9
+ 1194010p -0.3
+ 1196000p -0.3
+ 1196010p 0.9
+ 1198000p 0.9
+ 1198010p -0.3
+ 1200000p -0.3
+ 1200010p 0.9
+ 1202000p 0.9
+ 1202010p -0.3
+ 1204000p -0.3
+ 1204010p 0.9
+ 1206000p 0.9
+ 1206010p -0.3
+ 1208000p -0.3
+ 1208010p 0.9
+ 1210000p 0.9
+ 1210010p -0.3
+ 1212000p -0.3
+ 1212010p 0.9
+ 1214000p 0.9
+ 1214010p -0.3
+ 1216000p -0.3
+ 1216010p 0.9
+ 1218000p 0.9
+ 1218010p -0.3
+ 1220000p -0.3
+ 1220010p 0.9
+ 1222000p 0.9
+ 1222010p -0.3
+ 1224000p -0.3
+ 1224010p 0.9
+ 1226000p 0.9
+ 1226010p -0.3
+ 1228000p -0.3
+ 1228010p 0.9
+ 1230000p 0.9
+ 1230010p -0.3
+ 1232000p -0.3
+ 1232010p 0.9
+ 1234000p 0.9
+ 1234010p -0.3
+ 1236000p -0.3
+ 1236010p 0.9
+ 1238000p 0.9
+ 1238010p -0.3
+ 1240000p -0.3
+ 1240010p 0.9
+ 1242000p 0.9
+ 1242010p -0.3
+ 1244000p -0.3
+ 1244010p 0.9
+ 1246000p 0.9
+ 1246010p -0.3
+ 1248000p -0.3
+ 1248010p 0.9
+ 1250000p 0.9
+ 1250010p -0.3
+ 1252000p -0.3
+ 1252010p 0.9
+ 1254000p 0.9
+ 1254010p -0.3
+ 1256000p -0.3
+ 1256010p 0.9
+ 1258000p 0.9
+ 1258010p -0.3
+ 1260000p -0.3
+ 1260010p 0.9
+ 1262000p 0.9
+ 1262010p -0.3
+ 1264000p -0.3
+ 1264010p 0.9
+ 1266000p 0.9
+ 1266010p -0.3
+ 1268000p -0.3
+ 1268010p 0.9
+ 1270000p 0.9
+ 1270010p -0.3
+ 1272000p -0.3
+ 1272010p 0.9
+ 1274000p 0.9
+ 1274010p -0.3
+ 1276000p -0.3
+ 1276010p 0.9
+ 1278000p 0.9
+ 1278010p -0.3
+ 1280000p -0.3
+ 1280010p 0.9
+ 1282000p 0.9
+ 1282010p -0.3
+ 1284000p -0.3
+ 1284010p 0.9
+ 1286000p 0.9
+ 1286010p -0.3
+ 1288000p -0.3
+ 1288010p 0.9
+ 1290000p 0.9
+ 1290010p -0.3
+ 1292000p -0.3
+ 1292010p 0.9
+ 1294000p 0.9
+ 1294010p -0.3
+ 1296000p -0.3
+ 1296010p 0.9
+ 1298000p 0.9
+ 1298010p -0.3
+ 1300000p -0.3
+ 1300010p 0.9
+ 1302000p 0.9
+ 1302010p -0.3
+ 1304000p -0.3
+ 1304010p 0.9
+ 1306000p 0.9
+ 1306010p -0.3
+ 1308000p -0.3
+ 1308010p 0.9
+ 1310000p 0.9
+ 1310010p -0.3
+ 1312000p -0.3
+ 1312010p 0.9
+ 1314000p 0.9
+ 1314010p -0.3
+ 1316000p -0.3
+ 1316010p 0.9
+ 1318000p 0.9
+ 1318010p -0.3
+ 1320000p -0.3
+ 1320010p 0.9
+ 1322000p 0.9
+ 1322010p -0.3
+ 1324000p -0.3
+ 1324010p 0.9
+ 1326000p 0.9
+ 1326010p -0.3
+ 1328000p -0.3
+ 1328010p 0.9
+ 1330000p 0.9
+ 1330010p -0.3
+ 1332000p -0.3
+ 1332010p 0.9
+ 1334000p 0.9
+ 1334010p -0.3
+ 1336000p -0.3
+ 1336010p 0.9
+ 1338000p 0.9
+ 1338010p -0.3
+ 1340000p -0.3
+ 1340010p 0.9
+ 1342000p 0.9
+ 1342010p -0.3
+ 1344000p -0.3
+ 1344010p 0.9
+ 1346000p 0.9
+ 1346010p -0.3
+ 1348000p -0.3
+ 1348010p 0.9
+ 1350000p 0.9
+ 1350010p -0.3
+ 1352000p -0.3
+ 1352010p 0.9
+ 1354000p 0.9
+ 1354010p -0.3
+ 1356000p -0.3
+ 1356010p 0.9
+ 1358000p 0.9
+ 1358010p -0.3
+ 1360000p -0.3
+ 1360010p 0.9
+ 1362000p 0.9
+ 1362010p -0.3
+ 1364000p -0.3
+ 1364010p 0.9
+ 1366000p 0.9
+ 1366010p -0.3
+ 1368000p -0.3
+ 1368010p 0.9
+ 1370000p 0.9
+ 1370010p -0.3
+ 1372000p -0.3
+ 1372010p 0.9
+ 1374000p 0.9
+ 1374010p -0.3
+ 1376000p -0.3
+ 1376010p 0.9
+ 1378000p 0.9
+ 1378010p -0.3
+ 1380000p -0.3
+ 1380010p 0.9
+ 1382000p 0.9
+ 1382010p -0.3
+ 1384000p -0.3
+ 1384010p 0.9
+ 1386000p 0.9
+ 1386010p -0.3
+ 1388000p -0.3
+ 1388010p 0.9
+ 1390000p 0.9
+ 1390010p -0.3
+ 1392000p -0.3
+ 1392010p 0.9
+ 1394000p 0.9
+ 1394010p -0.3
+ 1396000p -0.3
+ 1396010p 0.9
+ 1398000p 0.9
+ 1398010p -0.3
+ 1400000p -0.3
+ 1400010p 0.9
+ 1402000p 0.9
+ 1402010p -0.3
+ 1404000p -0.3
+ 1404010p 0.9
+ 1406000p 0.9
+ 1406010p -0.3
+ 1408000p -0.3
+ 1408010p 0.9
+ 1410000p 0.9
+ 1410010p -0.3
+ 1412000p -0.3
+ 1412010p 0.9
+ 1414000p 0.9
+ 1414010p -0.3
+ 1416000p -0.3
+ 1416010p 0.9
+ 1418000p 0.9
+ 1418010p -0.3
+ 1420000p -0.3
+ 1420010p 0.9
+ 1422000p 0.9
+ 1422010p -0.3
+ 1424000p -0.3
+ 1424010p 0.9
+ 1426000p 0.9
+ 1426010p -0.3
+ 1428000p -0.3
+ 1428010p 0.9
+ 1430000p 0.9
+ 1430010p -0.3
+ 1432000p -0.3
+ 1432010p 0.9
+ 1434000p 0.9
+ 1434010p -0.3
+ 1436000p -0.3
+ 1436010p 0.9
+ 1438000p 0.9
+ 1438010p -0.3
+ 1440000p -0.3
+ 1440010p 0.9
+ 1442000p 0.9
+ 1442010p -0.3
+ 1444000p -0.3
+ 1444010p 0.9
+ 1446000p 0.9
+ 1446010p -0.3
+ 1448000p -0.3
+ 1448010p 0.9
+ 1450000p 0.9
+ 1450010p -0.3
+ 1452000p -0.3
+ 1452010p 0.9
+ 1454000p 0.9
+ 1454010p -0.3
+ 1456000p -0.3
+ 1456010p 0.9
+ 1458000p 0.9
+ 1458010p -0.3
+ 1460000p -0.3
+ 1460010p 0.9
+ 1462000p 0.9
+ 1462010p -0.3
+ 1464000p -0.3
+ 1464010p 0.9
+ 1466000p 0.9
+ 1466010p -0.3
+ 1468000p -0.3
+ 1468010p 0.9
+ 1470000p 0.9
+ 1470010p -0.3
+ 1472000p -0.3
+ 1472010p 0.9
+ 1474000p 0.9
+ 1474010p -0.3
+ 1476000p -0.3
+ 1476010p 0.9
+ 1478000p 0.9
+ 1478010p -0.3
+ 1480000p -0.3
+ 1480010p 0.9
+ 1482000p 0.9
+ 1482010p -0.3
+ 1484000p -0.3
+ 1484010p 0.9
+ 1486000p 0.9
+ 1486010p -0.3
+ 1488000p -0.3
+ 1488010p 0.9
+ 1490000p 0.9
+ 1490010p -0.3
+ 1492000p -0.3
+ 1492010p 0.9
+ 1494000p 0.9
+ 1494010p -0.3
+ 1496000p -0.3
+ 1496010p 0.9
+ 1498000p 0.9
+ 1498010p -0.3
+ 1500000p -0.3
+ 1500010p 0.9
+ 1502000p 0.9
+ 1502010p -0.3
+ 1504000p -0.3
+ 1504010p 0.9
+ 1506000p 0.9
+ 1506010p -0.3
+ 1508000p -0.3
+ 1508010p 0.9
+ 1510000p 0.9
+ 1510010p -0.3
+ 1512000p -0.3
+ 1512010p 0.9
+ 1514000p 0.9
+ 1514010p -0.3
+ 1516000p -0.3
+ 1516010p 0.9
+ 1518000p 0.9
+ 1518010p -0.3
+ 1520000p -0.3
+ 1520010p 0.9
+ 1522000p 0.9
+ 1522010p -0.3
+ 1524000p -0.3
+ 1524010p 0.9
+ 1526000p 0.9
+ 1526010p -0.3
+ 1528000p -0.3
+ 1528010p 0.9
+ 1530000p 0.9
+ 1530010p -0.3
+ 1532000p -0.3
+ 1532010p 0.9
+ 1534000p 0.9
+ 1534010p -0.3
+ 1536000p -0.3
+ 1536010p 0.9
+ 1538000p 0.9
+ 1538010p -0.3
+ 1540000p -0.3
+ 1540010p 0.9
+ 1542000p 0.9
+ 1542010p -0.3
+ 1544000p -0.3
+ 1544010p 0.9
+ 1546000p 0.9
+ 1546010p -0.3
+ 1548000p -0.3
+ 1548010p 0.9
+ 1550000p 0.9
+ 1550010p -0.3
+ 1552000p -0.3
+ 1552010p 0.9
+ 1554000p 0.9
+ 1554010p -0.3
+ 1556000p -0.3
+ 1556010p 0.9
+ 1558000p 0.9
+ 1558010p -0.3
+ 1560000p -0.3
+ 1560010p 0.9
+ 1562000p 0.9
+ 1562010p -0.3
+ 1564000p -0.3
+ 1564010p 0.9
+ 1566000p 0.9
+ 1566010p -0.3
+ 1568000p -0.3
+ 1568010p 0.9
+ 1570000p 0.9
+ 1570010p -0.3
+ 1572000p -0.3
+ 1572010p 0.9
+ 1574000p 0.9
+ 1574010p -0.3
+ 1576000p -0.3
+ 1576010p 0.9
+ 1578000p 0.9
+ 1578010p -0.3
+ 1580000p -0.3
+ 1580010p 0.9
+ 1582000p 0.9
+ 1582010p -0.3
+ 1584000p -0.3
+ 1584010p 0.9
+ 1586000p 0.9
+ 1586010p -0.3
+ 1588000p -0.3
+ 1588010p 0.9
+ 1590000p 0.9
+ 1590010p -0.3
+ 1592000p -0.3
+ 1592010p 0.9
+ 1594000p 0.9
+ 1594010p -0.3
+ 1596000p -0.3
+ 1596010p 0.9
+ 1598000p 0.9
+ 1598010p -0.3
+ 1600000p -0.3
+ 1600010p 0.9
+ 1602000p 0.9
+ 1602010p -0.3
+ 1604000p -0.3
+ 1604010p 0.9
+ 1606000p 0.9
+ 1606010p -0.3
+ 1608000p -0.3
+ 1608010p 0.9
+ 1610000p 0.9
+ 1610010p -0.3
+ 1612000p -0.3
+ 1612010p 0.9
+ 1614000p 0.9
+ 1614010p -0.3
+ 1616000p -0.3
+ 1616010p 0.9
+ 1618000p 0.9
+ 1618010p -0.3
+ 1620000p -0.3
+ 1620010p 0.9
+ 1622000p 0.9
+ 1622010p -0.3
+ 1624000p -0.3
+ 1624010p 0.9
+ 1626000p 0.9
+ 1626010p -0.3
+ 1628000p -0.3
+ 1628010p 0.9
+ 1630000p 0.9
+ 1630010p -0.3
+ 1632000p -0.3
+ 1632010p 0.9
+ 1634000p 0.9
+ 1634010p -0.3
+ 1636000p -0.3
+ 1636010p 0.9
+ 1638000p 0.9
+ 1638010p -0.3
+ 1640000p -0.3
+ 1640010p 0.9
+ 1642000p 0.9
+ 1642010p -0.3
+ 1644000p -0.3
+ 1644010p 0.9
+ 1646000p 0.9
+ 1646010p -0.3
+ 1648000p -0.3
+ 1648010p 0.9
+ 1650000p 0.9
+ 1650010p -0.3
+ 1652000p -0.3
+ 1652010p 0.9
+ 1654000p 0.9
+ 1654010p -0.3
+ 1656000p -0.3
+ 1656010p 0.9
+ 1658000p 0.9
+ 1658010p -0.3
+ 1660000p -0.3
+ 1660010p 0.9
+ 1662000p 0.9
+ 1662010p -0.3
+ 1664000p -0.3
+ 1664010p 0.9
+ 1666000p 0.9
+ 1666010p -0.3
+ 1668000p -0.3
+ 1668010p 0.9
+ 1670000p 0.9
+ 1670010p -0.3
+ 1672000p -0.3
+ 1672010p 0.9
+ 1674000p 0.9
+ 1674010p -0.3
+ 1676000p -0.3
+ 1676010p 0.9
+ 1678000p 0.9
+ 1678010p -0.3
+ 1680000p -0.3
+ 1680010p 0.9
+ 1682000p 0.9
+ 1682010p -0.3
+ 1684000p -0.3
+ 1684010p 0.9
+ 1686000p 0.9
+ 1686010p -0.3
+ 1688000p -0.3
+ 1688010p 0.9
+ 1690000p 0.9
+ 1690010p -0.3
+ 1692000p -0.3
+ 1692010p 0.9
+ 1694000p 0.9
+ 1694010p -0.3
+ 1696000p -0.3
+ 1696010p 0.9
+ 1698000p 0.9
+ 1698010p -0.3
+ 1700000p -0.3
+ 1700010p 0.9
+ 1702000p 0.9
+ 1702010p -0.3
+ 1704000p -0.3
+ 1704010p 0.9
+ 1706000p 0.9
+ 1706010p -0.3
+ 1708000p -0.3
+ 1708010p 0.9
+ 1710000p 0.9
+ 1710010p -0.3
+ 1712000p -0.3
+ 1712010p 0.9
+ 1714000p 0.9
+ 1714010p -0.3
+ 1716000p -0.3
+ 1716010p 0.9
+ 1718000p 0.9
+ 1718010p -0.3
+ 1720000p -0.3
+ 1720010p 0.9
+ 1722000p 0.9
+ 1722010p -0.3
+ 1724000p -0.3
+ 1724010p 0.9
+ 1726000p 0.9
+ 1726010p -0.3
+ 1728000p -0.3
+ 1728010p 0.9
+ 1730000p 0.9
+ 1730010p -0.3
+ 1732000p -0.3
+ 1732010p 0.9
+ 1734000p 0.9
+ 1734010p -0.3
+ 1736000p -0.3
+ 1736010p 0.9
+ 1738000p 0.9
+ 1738010p -0.3
+ 1740000p -0.3
+ 1740010p 0.9
+ 1742000p 0.9
+ 1742010p -0.3
+ 1744000p -0.3
+ 1744010p 0.9
+ 1746000p 0.9
+ 1746010p -0.3
+ 1748000p -0.3
+ 1748010p 0.9
+ 1750000p 0.9
+ 1750010p -0.3
+ 1752000p -0.3
+ 1752010p 0.9
+ 1754000p 0.9
+ 1754010p -0.3
+ 1756000p -0.3
+ 1756010p 0.9
+ 1758000p 0.9
+ 1758010p -0.3
+ 1760000p -0.3
+ 1760010p 0.9
+ 1762000p 0.9
+ 1762010p -0.3
+ 1764000p -0.3
+ 1764010p 0.9
+ 1766000p 0.9
+ 1766010p -0.3
+ 1768000p -0.3
+ 1768010p 0.9
+ 1770000p 0.9
+ 1770010p -0.3
+ 1772000p -0.3
+ 1772010p 0.9
+ 1774000p 0.9
+ 1774010p -0.3
+ 1776000p -0.3
+ 1776010p 0.9
+ 1778000p 0.9
+ 1778010p -0.3
+ 1780000p -0.3
+ 1780010p 0.9
+ 1782000p 0.9
+ 1782010p -0.3
+ 1784000p -0.3
+ 1784010p 0.9
+ 1786000p 0.9
+ 1786010p -0.3
+ 1788000p -0.3
+ 1788010p 0.9
+ 1790000p 0.9
+ 1790010p -0.3
+ 1792000p -0.3
+ 1792010p 0.9
+ 1794000p 0.9
+ 1794010p -0.3
+ 1796000p -0.3
+ 1796010p 0.9
+ 1798000p 0.9
+ 1798010p -0.3
+ 1800000p -0.3
+ 1800010p 0.9
+ 1802000p 0.9
+ 1802010p -0.3
+ 1804000p -0.3
+ 1804010p 0.9
+ 1806000p 0.9
+ 1806010p -0.3
+ 1808000p -0.3
+ 1808010p 0.9
+ 1810000p 0.9
+ 1810010p -0.3
+ 1812000p -0.3
+ 1812010p 0.9
+ 1814000p 0.9
+ 1814010p -0.3
+ 1816000p -0.3
+ 1816010p 0.9
+ 1818000p 0.9
+ 1818010p -0.3
+ 1820000p -0.3
+ 1820010p 0.9
+ 1822000p 0.9
+ 1822010p -0.3
+ 1824000p -0.3
+ 1824010p 0.9
+ 1826000p 0.9
+ 1826010p -0.3
+ 1828000p -0.3
+ 1828010p 0.9
+ 1830000p 0.9
+ 1830010p -0.3
+ 1832000p -0.3
+ 1832010p 0.9
+ 1834000p 0.9
+ 1834010p -0.3
+ 1836000p -0.3
+ 1836010p 0.9
+ 1838000p 0.9
+ 1838010p -0.3
+ 1840000p -0.3
+ 1840010p 0.9
+ 1842000p 0.9
+ 1842010p -0.3
+ 1844000p -0.3
+ 1844010p 0.9
+ 1846000p 0.9
+ 1846010p -0.3
+ 1848000p -0.3
+ 1848010p 0.9
+ 1850000p 0.9
+ 1850010p -0.3
+ 1852000p -0.3
+ 1852010p 0.9
+ 1854000p 0.9
+ 1854010p -0.3
+ 1856000p -0.3
+ 1856010p 0.9
+ 1858000p 0.9
+ 1858010p -0.3
+ 1860000p -0.3
+ 1860010p 0.9
+ 1862000p 0.9
+ 1862010p -0.3
+ 1864000p -0.3
+ 1864010p 0.9
+ 1866000p 0.9
+ 1866010p -0.3
+ 1868000p -0.3
+ 1868010p 0.9
+ 1870000p 0.9
+ 1870010p -0.3
+ 1872000p -0.3
+ 1872010p 0.9
+ 1874000p 0.9
+ 1874010p -0.3
+ 1876000p -0.3
+ 1876010p 0.9
+ 1878000p 0.9
+ 1878010p -0.3
+ 1880000p -0.3
+ 1880010p 0.9
+ 1882000p 0.9
+ 1882010p -0.3
+ 1884000p -0.3
+ 1884010p 0.9
+ 1886000p 0.9
+ 1886010p -0.3
+ 1888000p -0.3
+ 1888010p 0.9
+ 1890000p 0.9
+ 1890010p -0.3
+ 1892000p -0.3
+ 1892010p 0.9
+ 1894000p 0.9
+ 1894010p -0.3
+ 1896000p -0.3
+ 1896010p 0.9
+ 1898000p 0.9
+ 1898010p -0.3
+ 1900000p -0.3
+ 1900010p 0.9
+ 1902000p 0.9
+ 1902010p -0.3
+ 1904000p -0.3
+ 1904010p 0.9
+ 1906000p 0.9
+ 1906010p -0.3
+ 1908000p -0.3
+ 1908010p 0.9
+ 1910000p 0.9
+ 1910010p -0.3
+ 1912000p -0.3
+ 1912010p 0.9
+ 1914000p 0.9
+ 1914010p -0.3
+ 1916000p -0.3
+ 1916010p 0.9
+ 1918000p 0.9
+ 1918010p -0.3
+ 1920000p -0.3
+ 1920010p 0.9
+ 1922000p 0.9
+ 1922010p -0.3
+ 1924000p -0.3
+ 1924010p 0.9
+ 1926000p 0.9
+ 1926010p -0.3
+ 1928000p -0.3
+ 1928010p 0.9
+ 1930000p 0.9
+ 1930010p -0.3
+ 1932000p -0.3
+ 1932010p 0.9
+ 1934000p 0.9
+ 1934010p -0.3
+ 1936000p -0.3
+ 1936010p 0.9
+ 1938000p 0.9
+ 1938010p -0.3
+ 1940000p -0.3
+ 1940010p 0.9
+ 1942000p 0.9
+ 1942010p -0.3
+ 1944000p -0.3
+ 1944010p 0.9
+ 1946000p 0.9
+ 1946010p -0.3
+ 1948000p -0.3
+ 1948010p 0.9
+ 1950000p 0.9
+ 1950010p -0.3
+ 1952000p -0.3
+ 1952010p 0.9
+ 1954000p 0.9
+ 1954010p -0.3
+ 1956000p -0.3
+ 1956010p 0.9
+ 1958000p 0.9
+ 1958010p -0.3
+ 1960000p -0.3
+ 1960010p 0.9
+ 1962000p 0.9
+ 1962010p -0.3
+ 1964000p -0.3
+ 1964010p 0.9
+ 1966000p 0.9
+ 1966010p -0.3
+ 1968000p -0.3
+ 1968010p 0.9
+ 1970000p 0.9
+ 1970010p -0.3
+ 1972000p -0.3
+ 1972010p 0.9
+ 1974000p 0.9
+ 1974010p -0.3
+ 1976000p -0.3
+ 1976010p 0.9
+ 1978000p 0.9
+ 1978010p -0.3
+ 1980000p -0.3
+ 1980010p 0.9
+ 1982000p 0.9
+ 1982010p -0.3
+ 1984000p -0.3
+ 1984010p 0.9
+ 1986000p 0.9
+ 1986010p -0.3
+ 1988000p -0.3
+ 1988010p 0.9
+ 1990000p 0.9
+ 1990010p -0.3
+ 1992000p -0.3
+ 1992010p 0.9
+ 1994000p 0.9
+ 1994010p -0.3
+ 1996000p -0.3
+ 1996010p 0.9
+ 1998000p 0.9
+ 1998010p -0.3
+ 2000000p -0.3
+ 2000010p 0.9
+ 2002000p 0.9
+ 2002010p -0.3
+ 2004000p -0.3
+ 2004010p 0.9
+ 2006000p 0.9
+ 2006010p -0.3
+ 2008000p -0.3
+ 2008010p 0.9
+ 2010000p 0.9
+ 2010010p -0.3
+ 2012000p -0.3
+ 2012010p 0.9
+ 2014000p 0.9
+ 2014010p -0.3
+ 2016000p -0.3
+ 2016010p 0.9
+ 2018000p 0.9
+ 2018010p -0.3
+ 2020000p -0.3
+ 2020010p 0.9
+ 2022000p 0.9
+ 2022010p -0.3
+ 2024000p -0.3
+ 2024010p 0.9
+ 2026000p 0.9
+ 2026010p -0.3
+ 2028000p -0.3
+ 2028010p 0.9
+ 2030000p 0.9
+ 2030010p -0.3
+ 2032000p -0.3
+ 2032010p 0.9
+ 2034000p 0.9
+ 2034010p -0.3
+ 2036000p -0.3
+ 2036010p 0.9
+ 2038000p 0.9
+ 2038010p -0.3
+ 2040000p -0.3
+ 2040010p 0.9
+ 2042000p 0.9
+ 2042010p -0.3
+ 2044000p -0.3
+ 2044010p 0.9
+ 2046000p 0.9
+ 2046010p -0.3
+ 2048000p -0.3
+ 2048010p 0.9
+ \]
V_data_bar_21 (Data_bar\\<21\\> gnd!) vsource type=pwl wave=\[
+ 0    -0.3
+ 2000p -0.3
+ 2010p 0.9
+ 4000p 0.9
+ 4010p -0.3
+ 6000p -0.3
+ 6010p 0.9
+ 8000p 0.9
+ 8010p -0.3
+ 10000p -0.3
+ 10010p 0.9
+ 12000p 0.9
+ 12010p -0.3
+ 14000p -0.3
+ 14010p 0.9
+ 16000p 0.9
+ 16010p -0.3
+ 18000p -0.3
+ 18010p 0.9
+ 20000p 0.9
+ 20010p -0.3
+ 22000p -0.3
+ 22010p 0.9
+ 24000p 0.9
+ 24010p -0.3
+ 26000p -0.3
+ 26010p 0.9
+ 28000p 0.9
+ 28010p -0.3
+ 30000p -0.3
+ 30010p 0.9
+ 32000p 0.9
+ 32010p -0.3
+ 34000p -0.3
+ 34010p 0.9
+ 36000p 0.9
+ 36010p -0.3
+ 38000p -0.3
+ 38010p 0.9
+ 40000p 0.9
+ 40010p -0.3
+ 42000p -0.3
+ 42010p 0.9
+ 44000p 0.9
+ 44010p -0.3
+ 46000p -0.3
+ 46010p 0.9
+ 48000p 0.9
+ 48010p -0.3
+ 50000p -0.3
+ 50010p 0.9
+ 52000p 0.9
+ 52010p -0.3
+ 54000p -0.3
+ 54010p 0.9
+ 56000p 0.9
+ 56010p -0.3
+ 58000p -0.3
+ 58010p 0.9
+ 60000p 0.9
+ 60010p -0.3
+ 62000p -0.3
+ 62010p 0.9
+ 64000p 0.9
+ 64010p -0.3
+ 66000p -0.3
+ 66010p 0.9
+ 68000p 0.9
+ 68010p -0.3
+ 70000p -0.3
+ 70010p 0.9
+ 72000p 0.9
+ 72010p -0.3
+ 74000p -0.3
+ 74010p 0.9
+ 76000p 0.9
+ 76010p -0.3
+ 78000p -0.3
+ 78010p 0.9
+ 80000p 0.9
+ 80010p -0.3
+ 82000p -0.3
+ 82010p 0.9
+ 84000p 0.9
+ 84010p -0.3
+ 86000p -0.3
+ 86010p 0.9
+ 88000p 0.9
+ 88010p -0.3
+ 90000p -0.3
+ 90010p 0.9
+ 92000p 0.9
+ 92010p -0.3
+ 94000p -0.3
+ 94010p 0.9
+ 96000p 0.9
+ 96010p -0.3
+ 98000p -0.3
+ 98010p 0.9
+ 100000p 0.9
+ 100010p -0.3
+ 102000p -0.3
+ 102010p 0.9
+ 104000p 0.9
+ 104010p -0.3
+ 106000p -0.3
+ 106010p 0.9
+ 108000p 0.9
+ 108010p -0.3
+ 110000p -0.3
+ 110010p 0.9
+ 112000p 0.9
+ 112010p -0.3
+ 114000p -0.3
+ 114010p 0.9
+ 116000p 0.9
+ 116010p -0.3
+ 118000p -0.3
+ 118010p 0.9
+ 120000p 0.9
+ 120010p -0.3
+ 122000p -0.3
+ 122010p 0.9
+ 124000p 0.9
+ 124010p -0.3
+ 126000p -0.3
+ 126010p 0.9
+ 128000p 0.9
+ 128010p -0.3
+ 130000p -0.3
+ 130010p 0.9
+ 132000p 0.9
+ 132010p -0.3
+ 134000p -0.3
+ 134010p 0.9
+ 136000p 0.9
+ 136010p -0.3
+ 138000p -0.3
+ 138010p 0.9
+ 140000p 0.9
+ 140010p -0.3
+ 142000p -0.3
+ 142010p 0.9
+ 144000p 0.9
+ 144010p -0.3
+ 146000p -0.3
+ 146010p 0.9
+ 148000p 0.9
+ 148010p -0.3
+ 150000p -0.3
+ 150010p 0.9
+ 152000p 0.9
+ 152010p -0.3
+ 154000p -0.3
+ 154010p 0.9
+ 156000p 0.9
+ 156010p -0.3
+ 158000p -0.3
+ 158010p 0.9
+ 160000p 0.9
+ 160010p -0.3
+ 162000p -0.3
+ 162010p 0.9
+ 164000p 0.9
+ 164010p -0.3
+ 166000p -0.3
+ 166010p 0.9
+ 168000p 0.9
+ 168010p -0.3
+ 170000p -0.3
+ 170010p 0.9
+ 172000p 0.9
+ 172010p -0.3
+ 174000p -0.3
+ 174010p 0.9
+ 176000p 0.9
+ 176010p -0.3
+ 178000p -0.3
+ 178010p 0.9
+ 180000p 0.9
+ 180010p -0.3
+ 182000p -0.3
+ 182010p 0.9
+ 184000p 0.9
+ 184010p -0.3
+ 186000p -0.3
+ 186010p 0.9
+ 188000p 0.9
+ 188010p -0.3
+ 190000p -0.3
+ 190010p 0.9
+ 192000p 0.9
+ 192010p -0.3
+ 194000p -0.3
+ 194010p 0.9
+ 196000p 0.9
+ 196010p -0.3
+ 198000p -0.3
+ 198010p 0.9
+ 200000p 0.9
+ 200010p -0.3
+ 202000p -0.3
+ 202010p 0.9
+ 204000p 0.9
+ 204010p -0.3
+ 206000p -0.3
+ 206010p 0.9
+ 208000p 0.9
+ 208010p -0.3
+ 210000p -0.3
+ 210010p 0.9
+ 212000p 0.9
+ 212010p -0.3
+ 214000p -0.3
+ 214010p 0.9
+ 216000p 0.9
+ 216010p -0.3
+ 218000p -0.3
+ 218010p 0.9
+ 220000p 0.9
+ 220010p -0.3
+ 222000p -0.3
+ 222010p 0.9
+ 224000p 0.9
+ 224010p -0.3
+ 226000p -0.3
+ 226010p 0.9
+ 228000p 0.9
+ 228010p -0.3
+ 230000p -0.3
+ 230010p 0.9
+ 232000p 0.9
+ 232010p -0.3
+ 234000p -0.3
+ 234010p 0.9
+ 236000p 0.9
+ 236010p -0.3
+ 238000p -0.3
+ 238010p 0.9
+ 240000p 0.9
+ 240010p -0.3
+ 242000p -0.3
+ 242010p 0.9
+ 244000p 0.9
+ 244010p -0.3
+ 246000p -0.3
+ 246010p 0.9
+ 248000p 0.9
+ 248010p -0.3
+ 250000p -0.3
+ 250010p 0.9
+ 252000p 0.9
+ 252010p -0.3
+ 254000p -0.3
+ 254010p 0.9
+ 256000p 0.9
+ 256010p -0.3
+ 258000p -0.3
+ 258010p 0.9
+ 260000p 0.9
+ 260010p -0.3
+ 262000p -0.3
+ 262010p 0.9
+ 264000p 0.9
+ 264010p -0.3
+ 266000p -0.3
+ 266010p 0.9
+ 268000p 0.9
+ 268010p -0.3
+ 270000p -0.3
+ 270010p 0.9
+ 272000p 0.9
+ 272010p -0.3
+ 274000p -0.3
+ 274010p 0.9
+ 276000p 0.9
+ 276010p -0.3
+ 278000p -0.3
+ 278010p 0.9
+ 280000p 0.9
+ 280010p -0.3
+ 282000p -0.3
+ 282010p 0.9
+ 284000p 0.9
+ 284010p -0.3
+ 286000p -0.3
+ 286010p 0.9
+ 288000p 0.9
+ 288010p -0.3
+ 290000p -0.3
+ 290010p 0.9
+ 292000p 0.9
+ 292010p -0.3
+ 294000p -0.3
+ 294010p 0.9
+ 296000p 0.9
+ 296010p -0.3
+ 298000p -0.3
+ 298010p 0.9
+ 300000p 0.9
+ 300010p -0.3
+ 302000p -0.3
+ 302010p 0.9
+ 304000p 0.9
+ 304010p -0.3
+ 306000p -0.3
+ 306010p 0.9
+ 308000p 0.9
+ 308010p -0.3
+ 310000p -0.3
+ 310010p 0.9
+ 312000p 0.9
+ 312010p -0.3
+ 314000p -0.3
+ 314010p 0.9
+ 316000p 0.9
+ 316010p -0.3
+ 318000p -0.3
+ 318010p 0.9
+ 320000p 0.9
+ 320010p -0.3
+ 322000p -0.3
+ 322010p 0.9
+ 324000p 0.9
+ 324010p -0.3
+ 326000p -0.3
+ 326010p 0.9
+ 328000p 0.9
+ 328010p -0.3
+ 330000p -0.3
+ 330010p 0.9
+ 332000p 0.9
+ 332010p -0.3
+ 334000p -0.3
+ 334010p 0.9
+ 336000p 0.9
+ 336010p -0.3
+ 338000p -0.3
+ 338010p 0.9
+ 340000p 0.9
+ 340010p -0.3
+ 342000p -0.3
+ 342010p 0.9
+ 344000p 0.9
+ 344010p -0.3
+ 346000p -0.3
+ 346010p 0.9
+ 348000p 0.9
+ 348010p -0.3
+ 350000p -0.3
+ 350010p 0.9
+ 352000p 0.9
+ 352010p -0.3
+ 354000p -0.3
+ 354010p 0.9
+ 356000p 0.9
+ 356010p -0.3
+ 358000p -0.3
+ 358010p 0.9
+ 360000p 0.9
+ 360010p -0.3
+ 362000p -0.3
+ 362010p 0.9
+ 364000p 0.9
+ 364010p -0.3
+ 366000p -0.3
+ 366010p 0.9
+ 368000p 0.9
+ 368010p -0.3
+ 370000p -0.3
+ 370010p 0.9
+ 372000p 0.9
+ 372010p -0.3
+ 374000p -0.3
+ 374010p 0.9
+ 376000p 0.9
+ 376010p -0.3
+ 378000p -0.3
+ 378010p 0.9
+ 380000p 0.9
+ 380010p -0.3
+ 382000p -0.3
+ 382010p 0.9
+ 384000p 0.9
+ 384010p -0.3
+ 386000p -0.3
+ 386010p 0.9
+ 388000p 0.9
+ 388010p -0.3
+ 390000p -0.3
+ 390010p 0.9
+ 392000p 0.9
+ 392010p -0.3
+ 394000p -0.3
+ 394010p 0.9
+ 396000p 0.9
+ 396010p -0.3
+ 398000p -0.3
+ 398010p 0.9
+ 400000p 0.9
+ 400010p -0.3
+ 402000p -0.3
+ 402010p 0.9
+ 404000p 0.9
+ 404010p -0.3
+ 406000p -0.3
+ 406010p 0.9
+ 408000p 0.9
+ 408010p -0.3
+ 410000p -0.3
+ 410010p 0.9
+ 412000p 0.9
+ 412010p -0.3
+ 414000p -0.3
+ 414010p 0.9
+ 416000p 0.9
+ 416010p -0.3
+ 418000p -0.3
+ 418010p 0.9
+ 420000p 0.9
+ 420010p -0.3
+ 422000p -0.3
+ 422010p 0.9
+ 424000p 0.9
+ 424010p -0.3
+ 426000p -0.3
+ 426010p 0.9
+ 428000p 0.9
+ 428010p -0.3
+ 430000p -0.3
+ 430010p 0.9
+ 432000p 0.9
+ 432010p -0.3
+ 434000p -0.3
+ 434010p 0.9
+ 436000p 0.9
+ 436010p -0.3
+ 438000p -0.3
+ 438010p 0.9
+ 440000p 0.9
+ 440010p -0.3
+ 442000p -0.3
+ 442010p 0.9
+ 444000p 0.9
+ 444010p -0.3
+ 446000p -0.3
+ 446010p 0.9
+ 448000p 0.9
+ 448010p -0.3
+ 450000p -0.3
+ 450010p 0.9
+ 452000p 0.9
+ 452010p -0.3
+ 454000p -0.3
+ 454010p 0.9
+ 456000p 0.9
+ 456010p -0.3
+ 458000p -0.3
+ 458010p 0.9
+ 460000p 0.9
+ 460010p -0.3
+ 462000p -0.3
+ 462010p 0.9
+ 464000p 0.9
+ 464010p -0.3
+ 466000p -0.3
+ 466010p 0.9
+ 468000p 0.9
+ 468010p -0.3
+ 470000p -0.3
+ 470010p 0.9
+ 472000p 0.9
+ 472010p -0.3
+ 474000p -0.3
+ 474010p 0.9
+ 476000p 0.9
+ 476010p -0.3
+ 478000p -0.3
+ 478010p 0.9
+ 480000p 0.9
+ 480010p -0.3
+ 482000p -0.3
+ 482010p 0.9
+ 484000p 0.9
+ 484010p -0.3
+ 486000p -0.3
+ 486010p 0.9
+ 488000p 0.9
+ 488010p -0.3
+ 490000p -0.3
+ 490010p 0.9
+ 492000p 0.9
+ 492010p -0.3
+ 494000p -0.3
+ 494010p 0.9
+ 496000p 0.9
+ 496010p -0.3
+ 498000p -0.3
+ 498010p 0.9
+ 500000p 0.9
+ 500010p -0.3
+ 502000p -0.3
+ 502010p 0.9
+ 504000p 0.9
+ 504010p -0.3
+ 506000p -0.3
+ 506010p 0.9
+ 508000p 0.9
+ 508010p -0.3
+ 510000p -0.3
+ 510010p 0.9
+ 512000p 0.9
+ 512010p -0.3
+ 514000p -0.3
+ 514010p 0.9
+ 516000p 0.9
+ 516010p -0.3
+ 518000p -0.3
+ 518010p 0.9
+ 520000p 0.9
+ 520010p -0.3
+ 522000p -0.3
+ 522010p 0.9
+ 524000p 0.9
+ 524010p -0.3
+ 526000p -0.3
+ 526010p 0.9
+ 528000p 0.9
+ 528010p -0.3
+ 530000p -0.3
+ 530010p 0.9
+ 532000p 0.9
+ 532010p -0.3
+ 534000p -0.3
+ 534010p 0.9
+ 536000p 0.9
+ 536010p -0.3
+ 538000p -0.3
+ 538010p 0.9
+ 540000p 0.9
+ 540010p -0.3
+ 542000p -0.3
+ 542010p 0.9
+ 544000p 0.9
+ 544010p -0.3
+ 546000p -0.3
+ 546010p 0.9
+ 548000p 0.9
+ 548010p -0.3
+ 550000p -0.3
+ 550010p 0.9
+ 552000p 0.9
+ 552010p -0.3
+ 554000p -0.3
+ 554010p 0.9
+ 556000p 0.9
+ 556010p -0.3
+ 558000p -0.3
+ 558010p 0.9
+ 560000p 0.9
+ 560010p -0.3
+ 562000p -0.3
+ 562010p 0.9
+ 564000p 0.9
+ 564010p -0.3
+ 566000p -0.3
+ 566010p 0.9
+ 568000p 0.9
+ 568010p -0.3
+ 570000p -0.3
+ 570010p 0.9
+ 572000p 0.9
+ 572010p -0.3
+ 574000p -0.3
+ 574010p 0.9
+ 576000p 0.9
+ 576010p -0.3
+ 578000p -0.3
+ 578010p 0.9
+ 580000p 0.9
+ 580010p -0.3
+ 582000p -0.3
+ 582010p 0.9
+ 584000p 0.9
+ 584010p -0.3
+ 586000p -0.3
+ 586010p 0.9
+ 588000p 0.9
+ 588010p -0.3
+ 590000p -0.3
+ 590010p 0.9
+ 592000p 0.9
+ 592010p -0.3
+ 594000p -0.3
+ 594010p 0.9
+ 596000p 0.9
+ 596010p -0.3
+ 598000p -0.3
+ 598010p 0.9
+ 600000p 0.9
+ 600010p -0.3
+ 602000p -0.3
+ 602010p 0.9
+ 604000p 0.9
+ 604010p -0.3
+ 606000p -0.3
+ 606010p 0.9
+ 608000p 0.9
+ 608010p -0.3
+ 610000p -0.3
+ 610010p 0.9
+ 612000p 0.9
+ 612010p -0.3
+ 614000p -0.3
+ 614010p 0.9
+ 616000p 0.9
+ 616010p -0.3
+ 618000p -0.3
+ 618010p 0.9
+ 620000p 0.9
+ 620010p -0.3
+ 622000p -0.3
+ 622010p 0.9
+ 624000p 0.9
+ 624010p -0.3
+ 626000p -0.3
+ 626010p 0.9
+ 628000p 0.9
+ 628010p -0.3
+ 630000p -0.3
+ 630010p 0.9
+ 632000p 0.9
+ 632010p -0.3
+ 634000p -0.3
+ 634010p 0.9
+ 636000p 0.9
+ 636010p -0.3
+ 638000p -0.3
+ 638010p 0.9
+ 640000p 0.9
+ 640010p -0.3
+ 642000p -0.3
+ 642010p 0.9
+ 644000p 0.9
+ 644010p -0.3
+ 646000p -0.3
+ 646010p 0.9
+ 648000p 0.9
+ 648010p -0.3
+ 650000p -0.3
+ 650010p 0.9
+ 652000p 0.9
+ 652010p -0.3
+ 654000p -0.3
+ 654010p 0.9
+ 656000p 0.9
+ 656010p -0.3
+ 658000p -0.3
+ 658010p 0.9
+ 660000p 0.9
+ 660010p -0.3
+ 662000p -0.3
+ 662010p 0.9
+ 664000p 0.9
+ 664010p -0.3
+ 666000p -0.3
+ 666010p 0.9
+ 668000p 0.9
+ 668010p -0.3
+ 670000p -0.3
+ 670010p 0.9
+ 672000p 0.9
+ 672010p -0.3
+ 674000p -0.3
+ 674010p 0.9
+ 676000p 0.9
+ 676010p -0.3
+ 678000p -0.3
+ 678010p 0.9
+ 680000p 0.9
+ 680010p -0.3
+ 682000p -0.3
+ 682010p 0.9
+ 684000p 0.9
+ 684010p -0.3
+ 686000p -0.3
+ 686010p 0.9
+ 688000p 0.9
+ 688010p -0.3
+ 690000p -0.3
+ 690010p 0.9
+ 692000p 0.9
+ 692010p -0.3
+ 694000p -0.3
+ 694010p 0.9
+ 696000p 0.9
+ 696010p -0.3
+ 698000p -0.3
+ 698010p 0.9
+ 700000p 0.9
+ 700010p -0.3
+ 702000p -0.3
+ 702010p 0.9
+ 704000p 0.9
+ 704010p -0.3
+ 706000p -0.3
+ 706010p 0.9
+ 708000p 0.9
+ 708010p -0.3
+ 710000p -0.3
+ 710010p 0.9
+ 712000p 0.9
+ 712010p -0.3
+ 714000p -0.3
+ 714010p 0.9
+ 716000p 0.9
+ 716010p -0.3
+ 718000p -0.3
+ 718010p 0.9
+ 720000p 0.9
+ 720010p -0.3
+ 722000p -0.3
+ 722010p 0.9
+ 724000p 0.9
+ 724010p -0.3
+ 726000p -0.3
+ 726010p 0.9
+ 728000p 0.9
+ 728010p -0.3
+ 730000p -0.3
+ 730010p 0.9
+ 732000p 0.9
+ 732010p -0.3
+ 734000p -0.3
+ 734010p 0.9
+ 736000p 0.9
+ 736010p -0.3
+ 738000p -0.3
+ 738010p 0.9
+ 740000p 0.9
+ 740010p -0.3
+ 742000p -0.3
+ 742010p 0.9
+ 744000p 0.9
+ 744010p -0.3
+ 746000p -0.3
+ 746010p 0.9
+ 748000p 0.9
+ 748010p -0.3
+ 750000p -0.3
+ 750010p 0.9
+ 752000p 0.9
+ 752010p -0.3
+ 754000p -0.3
+ 754010p 0.9
+ 756000p 0.9
+ 756010p -0.3
+ 758000p -0.3
+ 758010p 0.9
+ 760000p 0.9
+ 760010p -0.3
+ 762000p -0.3
+ 762010p 0.9
+ 764000p 0.9
+ 764010p -0.3
+ 766000p -0.3
+ 766010p 0.9
+ 768000p 0.9
+ 768010p -0.3
+ 770000p -0.3
+ 770010p 0.9
+ 772000p 0.9
+ 772010p -0.3
+ 774000p -0.3
+ 774010p 0.9
+ 776000p 0.9
+ 776010p -0.3
+ 778000p -0.3
+ 778010p 0.9
+ 780000p 0.9
+ 780010p -0.3
+ 782000p -0.3
+ 782010p 0.9
+ 784000p 0.9
+ 784010p -0.3
+ 786000p -0.3
+ 786010p 0.9
+ 788000p 0.9
+ 788010p -0.3
+ 790000p -0.3
+ 790010p 0.9
+ 792000p 0.9
+ 792010p -0.3
+ 794000p -0.3
+ 794010p 0.9
+ 796000p 0.9
+ 796010p -0.3
+ 798000p -0.3
+ 798010p 0.9
+ 800000p 0.9
+ 800010p -0.3
+ 802000p -0.3
+ 802010p 0.9
+ 804000p 0.9
+ 804010p -0.3
+ 806000p -0.3
+ 806010p 0.9
+ 808000p 0.9
+ 808010p -0.3
+ 810000p -0.3
+ 810010p 0.9
+ 812000p 0.9
+ 812010p -0.3
+ 814000p -0.3
+ 814010p 0.9
+ 816000p 0.9
+ 816010p -0.3
+ 818000p -0.3
+ 818010p 0.9
+ 820000p 0.9
+ 820010p -0.3
+ 822000p -0.3
+ 822010p 0.9
+ 824000p 0.9
+ 824010p -0.3
+ 826000p -0.3
+ 826010p 0.9
+ 828000p 0.9
+ 828010p -0.3
+ 830000p -0.3
+ 830010p 0.9
+ 832000p 0.9
+ 832010p -0.3
+ 834000p -0.3
+ 834010p 0.9
+ 836000p 0.9
+ 836010p -0.3
+ 838000p -0.3
+ 838010p 0.9
+ 840000p 0.9
+ 840010p -0.3
+ 842000p -0.3
+ 842010p 0.9
+ 844000p 0.9
+ 844010p -0.3
+ 846000p -0.3
+ 846010p 0.9
+ 848000p 0.9
+ 848010p -0.3
+ 850000p -0.3
+ 850010p 0.9
+ 852000p 0.9
+ 852010p -0.3
+ 854000p -0.3
+ 854010p 0.9
+ 856000p 0.9
+ 856010p -0.3
+ 858000p -0.3
+ 858010p 0.9
+ 860000p 0.9
+ 860010p -0.3
+ 862000p -0.3
+ 862010p 0.9
+ 864000p 0.9
+ 864010p -0.3
+ 866000p -0.3
+ 866010p 0.9
+ 868000p 0.9
+ 868010p -0.3
+ 870000p -0.3
+ 870010p 0.9
+ 872000p 0.9
+ 872010p -0.3
+ 874000p -0.3
+ 874010p 0.9
+ 876000p 0.9
+ 876010p -0.3
+ 878000p -0.3
+ 878010p 0.9
+ 880000p 0.9
+ 880010p -0.3
+ 882000p -0.3
+ 882010p 0.9
+ 884000p 0.9
+ 884010p -0.3
+ 886000p -0.3
+ 886010p 0.9
+ 888000p 0.9
+ 888010p -0.3
+ 890000p -0.3
+ 890010p 0.9
+ 892000p 0.9
+ 892010p -0.3
+ 894000p -0.3
+ 894010p 0.9
+ 896000p 0.9
+ 896010p -0.3
+ 898000p -0.3
+ 898010p 0.9
+ 900000p 0.9
+ 900010p -0.3
+ 902000p -0.3
+ 902010p 0.9
+ 904000p 0.9
+ 904010p -0.3
+ 906000p -0.3
+ 906010p 0.9
+ 908000p 0.9
+ 908010p -0.3
+ 910000p -0.3
+ 910010p 0.9
+ 912000p 0.9
+ 912010p -0.3
+ 914000p -0.3
+ 914010p 0.9
+ 916000p 0.9
+ 916010p -0.3
+ 918000p -0.3
+ 918010p 0.9
+ 920000p 0.9
+ 920010p -0.3
+ 922000p -0.3
+ 922010p 0.9
+ 924000p 0.9
+ 924010p -0.3
+ 926000p -0.3
+ 926010p 0.9
+ 928000p 0.9
+ 928010p -0.3
+ 930000p -0.3
+ 930010p 0.9
+ 932000p 0.9
+ 932010p -0.3
+ 934000p -0.3
+ 934010p 0.9
+ 936000p 0.9
+ 936010p -0.3
+ 938000p -0.3
+ 938010p 0.9
+ 940000p 0.9
+ 940010p -0.3
+ 942000p -0.3
+ 942010p 0.9
+ 944000p 0.9
+ 944010p -0.3
+ 946000p -0.3
+ 946010p 0.9
+ 948000p 0.9
+ 948010p -0.3
+ 950000p -0.3
+ 950010p 0.9
+ 952000p 0.9
+ 952010p -0.3
+ 954000p -0.3
+ 954010p 0.9
+ 956000p 0.9
+ 956010p -0.3
+ 958000p -0.3
+ 958010p 0.9
+ 960000p 0.9
+ 960010p -0.3
+ 962000p -0.3
+ 962010p 0.9
+ 964000p 0.9
+ 964010p -0.3
+ 966000p -0.3
+ 966010p 0.9
+ 968000p 0.9
+ 968010p -0.3
+ 970000p -0.3
+ 970010p 0.9
+ 972000p 0.9
+ 972010p -0.3
+ 974000p -0.3
+ 974010p 0.9
+ 976000p 0.9
+ 976010p -0.3
+ 978000p -0.3
+ 978010p 0.9
+ 980000p 0.9
+ 980010p -0.3
+ 982000p -0.3
+ 982010p 0.9
+ 984000p 0.9
+ 984010p -0.3
+ 986000p -0.3
+ 986010p 0.9
+ 988000p 0.9
+ 988010p -0.3
+ 990000p -0.3
+ 990010p 0.9
+ 992000p 0.9
+ 992010p -0.3
+ 994000p -0.3
+ 994010p 0.9
+ 996000p 0.9
+ 996010p -0.3
+ 998000p -0.3
+ 998010p 0.9
+ 1000000p 0.9
+ 1000010p -0.3
+ 1002000p -0.3
+ 1002010p 0.9
+ 1004000p 0.9
+ 1004010p -0.3
+ 1006000p -0.3
+ 1006010p 0.9
+ 1008000p 0.9
+ 1008010p -0.3
+ 1010000p -0.3
+ 1010010p 0.9
+ 1012000p 0.9
+ 1012010p -0.3
+ 1014000p -0.3
+ 1014010p 0.9
+ 1016000p 0.9
+ 1016010p -0.3
+ 1018000p -0.3
+ 1018010p 0.9
+ 1020000p 0.9
+ 1020010p -0.3
+ 1022000p -0.3
+ 1022010p 0.9
+ 1024000p 0.9
+ 1024010p -0.3
+ 1026000p -0.3
+ 1026010p 0.9
+ 1028000p 0.9
+ 1028010p -0.3
+ 1030000p -0.3
+ 1030010p 0.9
+ 1032000p 0.9
+ 1032010p -0.3
+ 1034000p -0.3
+ 1034010p 0.9
+ 1036000p 0.9
+ 1036010p -0.3
+ 1038000p -0.3
+ 1038010p 0.9
+ 1040000p 0.9
+ 1040010p -0.3
+ 1042000p -0.3
+ 1042010p 0.9
+ 1044000p 0.9
+ 1044010p -0.3
+ 1046000p -0.3
+ 1046010p 0.9
+ 1048000p 0.9
+ 1048010p -0.3
+ 1050000p -0.3
+ 1050010p 0.9
+ 1052000p 0.9
+ 1052010p -0.3
+ 1054000p -0.3
+ 1054010p 0.9
+ 1056000p 0.9
+ 1056010p -0.3
+ 1058000p -0.3
+ 1058010p 0.9
+ 1060000p 0.9
+ 1060010p -0.3
+ 1062000p -0.3
+ 1062010p 0.9
+ 1064000p 0.9
+ 1064010p -0.3
+ 1066000p -0.3
+ 1066010p 0.9
+ 1068000p 0.9
+ 1068010p -0.3
+ 1070000p -0.3
+ 1070010p 0.9
+ 1072000p 0.9
+ 1072010p -0.3
+ 1074000p -0.3
+ 1074010p 0.9
+ 1076000p 0.9
+ 1076010p -0.3
+ 1078000p -0.3
+ 1078010p 0.9
+ 1080000p 0.9
+ 1080010p -0.3
+ 1082000p -0.3
+ 1082010p 0.9
+ 1084000p 0.9
+ 1084010p -0.3
+ 1086000p -0.3
+ 1086010p 0.9
+ 1088000p 0.9
+ 1088010p -0.3
+ 1090000p -0.3
+ 1090010p 0.9
+ 1092000p 0.9
+ 1092010p -0.3
+ 1094000p -0.3
+ 1094010p 0.9
+ 1096000p 0.9
+ 1096010p -0.3
+ 1098000p -0.3
+ 1098010p 0.9
+ 1100000p 0.9
+ 1100010p -0.3
+ 1102000p -0.3
+ 1102010p 0.9
+ 1104000p 0.9
+ 1104010p -0.3
+ 1106000p -0.3
+ 1106010p 0.9
+ 1108000p 0.9
+ 1108010p -0.3
+ 1110000p -0.3
+ 1110010p 0.9
+ 1112000p 0.9
+ 1112010p -0.3
+ 1114000p -0.3
+ 1114010p 0.9
+ 1116000p 0.9
+ 1116010p -0.3
+ 1118000p -0.3
+ 1118010p 0.9
+ 1120000p 0.9
+ 1120010p -0.3
+ 1122000p -0.3
+ 1122010p 0.9
+ 1124000p 0.9
+ 1124010p -0.3
+ 1126000p -0.3
+ 1126010p 0.9
+ 1128000p 0.9
+ 1128010p -0.3
+ 1130000p -0.3
+ 1130010p 0.9
+ 1132000p 0.9
+ 1132010p -0.3
+ 1134000p -0.3
+ 1134010p 0.9
+ 1136000p 0.9
+ 1136010p -0.3
+ 1138000p -0.3
+ 1138010p 0.9
+ 1140000p 0.9
+ 1140010p -0.3
+ 1142000p -0.3
+ 1142010p 0.9
+ 1144000p 0.9
+ 1144010p -0.3
+ 1146000p -0.3
+ 1146010p 0.9
+ 1148000p 0.9
+ 1148010p -0.3
+ 1150000p -0.3
+ 1150010p 0.9
+ 1152000p 0.9
+ 1152010p -0.3
+ 1154000p -0.3
+ 1154010p 0.9
+ 1156000p 0.9
+ 1156010p -0.3
+ 1158000p -0.3
+ 1158010p 0.9
+ 1160000p 0.9
+ 1160010p -0.3
+ 1162000p -0.3
+ 1162010p 0.9
+ 1164000p 0.9
+ 1164010p -0.3
+ 1166000p -0.3
+ 1166010p 0.9
+ 1168000p 0.9
+ 1168010p -0.3
+ 1170000p -0.3
+ 1170010p 0.9
+ 1172000p 0.9
+ 1172010p -0.3
+ 1174000p -0.3
+ 1174010p 0.9
+ 1176000p 0.9
+ 1176010p -0.3
+ 1178000p -0.3
+ 1178010p 0.9
+ 1180000p 0.9
+ 1180010p -0.3
+ 1182000p -0.3
+ 1182010p 0.9
+ 1184000p 0.9
+ 1184010p -0.3
+ 1186000p -0.3
+ 1186010p 0.9
+ 1188000p 0.9
+ 1188010p -0.3
+ 1190000p -0.3
+ 1190010p 0.9
+ 1192000p 0.9
+ 1192010p -0.3
+ 1194000p -0.3
+ 1194010p 0.9
+ 1196000p 0.9
+ 1196010p -0.3
+ 1198000p -0.3
+ 1198010p 0.9
+ 1200000p 0.9
+ 1200010p -0.3
+ 1202000p -0.3
+ 1202010p 0.9
+ 1204000p 0.9
+ 1204010p -0.3
+ 1206000p -0.3
+ 1206010p 0.9
+ 1208000p 0.9
+ 1208010p -0.3
+ 1210000p -0.3
+ 1210010p 0.9
+ 1212000p 0.9
+ 1212010p -0.3
+ 1214000p -0.3
+ 1214010p 0.9
+ 1216000p 0.9
+ 1216010p -0.3
+ 1218000p -0.3
+ 1218010p 0.9
+ 1220000p 0.9
+ 1220010p -0.3
+ 1222000p -0.3
+ 1222010p 0.9
+ 1224000p 0.9
+ 1224010p -0.3
+ 1226000p -0.3
+ 1226010p 0.9
+ 1228000p 0.9
+ 1228010p -0.3
+ 1230000p -0.3
+ 1230010p 0.9
+ 1232000p 0.9
+ 1232010p -0.3
+ 1234000p -0.3
+ 1234010p 0.9
+ 1236000p 0.9
+ 1236010p -0.3
+ 1238000p -0.3
+ 1238010p 0.9
+ 1240000p 0.9
+ 1240010p -0.3
+ 1242000p -0.3
+ 1242010p 0.9
+ 1244000p 0.9
+ 1244010p -0.3
+ 1246000p -0.3
+ 1246010p 0.9
+ 1248000p 0.9
+ 1248010p -0.3
+ 1250000p -0.3
+ 1250010p 0.9
+ 1252000p 0.9
+ 1252010p -0.3
+ 1254000p -0.3
+ 1254010p 0.9
+ 1256000p 0.9
+ 1256010p -0.3
+ 1258000p -0.3
+ 1258010p 0.9
+ 1260000p 0.9
+ 1260010p -0.3
+ 1262000p -0.3
+ 1262010p 0.9
+ 1264000p 0.9
+ 1264010p -0.3
+ 1266000p -0.3
+ 1266010p 0.9
+ 1268000p 0.9
+ 1268010p -0.3
+ 1270000p -0.3
+ 1270010p 0.9
+ 1272000p 0.9
+ 1272010p -0.3
+ 1274000p -0.3
+ 1274010p 0.9
+ 1276000p 0.9
+ 1276010p -0.3
+ 1278000p -0.3
+ 1278010p 0.9
+ 1280000p 0.9
+ 1280010p -0.3
+ 1282000p -0.3
+ 1282010p 0.9
+ 1284000p 0.9
+ 1284010p -0.3
+ 1286000p -0.3
+ 1286010p 0.9
+ 1288000p 0.9
+ 1288010p -0.3
+ 1290000p -0.3
+ 1290010p 0.9
+ 1292000p 0.9
+ 1292010p -0.3
+ 1294000p -0.3
+ 1294010p 0.9
+ 1296000p 0.9
+ 1296010p -0.3
+ 1298000p -0.3
+ 1298010p 0.9
+ 1300000p 0.9
+ 1300010p -0.3
+ 1302000p -0.3
+ 1302010p 0.9
+ 1304000p 0.9
+ 1304010p -0.3
+ 1306000p -0.3
+ 1306010p 0.9
+ 1308000p 0.9
+ 1308010p -0.3
+ 1310000p -0.3
+ 1310010p 0.9
+ 1312000p 0.9
+ 1312010p -0.3
+ 1314000p -0.3
+ 1314010p 0.9
+ 1316000p 0.9
+ 1316010p -0.3
+ 1318000p -0.3
+ 1318010p 0.9
+ 1320000p 0.9
+ 1320010p -0.3
+ 1322000p -0.3
+ 1322010p 0.9
+ 1324000p 0.9
+ 1324010p -0.3
+ 1326000p -0.3
+ 1326010p 0.9
+ 1328000p 0.9
+ 1328010p -0.3
+ 1330000p -0.3
+ 1330010p 0.9
+ 1332000p 0.9
+ 1332010p -0.3
+ 1334000p -0.3
+ 1334010p 0.9
+ 1336000p 0.9
+ 1336010p -0.3
+ 1338000p -0.3
+ 1338010p 0.9
+ 1340000p 0.9
+ 1340010p -0.3
+ 1342000p -0.3
+ 1342010p 0.9
+ 1344000p 0.9
+ 1344010p -0.3
+ 1346000p -0.3
+ 1346010p 0.9
+ 1348000p 0.9
+ 1348010p -0.3
+ 1350000p -0.3
+ 1350010p 0.9
+ 1352000p 0.9
+ 1352010p -0.3
+ 1354000p -0.3
+ 1354010p 0.9
+ 1356000p 0.9
+ 1356010p -0.3
+ 1358000p -0.3
+ 1358010p 0.9
+ 1360000p 0.9
+ 1360010p -0.3
+ 1362000p -0.3
+ 1362010p 0.9
+ 1364000p 0.9
+ 1364010p -0.3
+ 1366000p -0.3
+ 1366010p 0.9
+ 1368000p 0.9
+ 1368010p -0.3
+ 1370000p -0.3
+ 1370010p 0.9
+ 1372000p 0.9
+ 1372010p -0.3
+ 1374000p -0.3
+ 1374010p 0.9
+ 1376000p 0.9
+ 1376010p -0.3
+ 1378000p -0.3
+ 1378010p 0.9
+ 1380000p 0.9
+ 1380010p -0.3
+ 1382000p -0.3
+ 1382010p 0.9
+ 1384000p 0.9
+ 1384010p -0.3
+ 1386000p -0.3
+ 1386010p 0.9
+ 1388000p 0.9
+ 1388010p -0.3
+ 1390000p -0.3
+ 1390010p 0.9
+ 1392000p 0.9
+ 1392010p -0.3
+ 1394000p -0.3
+ 1394010p 0.9
+ 1396000p 0.9
+ 1396010p -0.3
+ 1398000p -0.3
+ 1398010p 0.9
+ 1400000p 0.9
+ 1400010p -0.3
+ 1402000p -0.3
+ 1402010p 0.9
+ 1404000p 0.9
+ 1404010p -0.3
+ 1406000p -0.3
+ 1406010p 0.9
+ 1408000p 0.9
+ 1408010p -0.3
+ 1410000p -0.3
+ 1410010p 0.9
+ 1412000p 0.9
+ 1412010p -0.3
+ 1414000p -0.3
+ 1414010p 0.9
+ 1416000p 0.9
+ 1416010p -0.3
+ 1418000p -0.3
+ 1418010p 0.9
+ 1420000p 0.9
+ 1420010p -0.3
+ 1422000p -0.3
+ 1422010p 0.9
+ 1424000p 0.9
+ 1424010p -0.3
+ 1426000p -0.3
+ 1426010p 0.9
+ 1428000p 0.9
+ 1428010p -0.3
+ 1430000p -0.3
+ 1430010p 0.9
+ 1432000p 0.9
+ 1432010p -0.3
+ 1434000p -0.3
+ 1434010p 0.9
+ 1436000p 0.9
+ 1436010p -0.3
+ 1438000p -0.3
+ 1438010p 0.9
+ 1440000p 0.9
+ 1440010p -0.3
+ 1442000p -0.3
+ 1442010p 0.9
+ 1444000p 0.9
+ 1444010p -0.3
+ 1446000p -0.3
+ 1446010p 0.9
+ 1448000p 0.9
+ 1448010p -0.3
+ 1450000p -0.3
+ 1450010p 0.9
+ 1452000p 0.9
+ 1452010p -0.3
+ 1454000p -0.3
+ 1454010p 0.9
+ 1456000p 0.9
+ 1456010p -0.3
+ 1458000p -0.3
+ 1458010p 0.9
+ 1460000p 0.9
+ 1460010p -0.3
+ 1462000p -0.3
+ 1462010p 0.9
+ 1464000p 0.9
+ 1464010p -0.3
+ 1466000p -0.3
+ 1466010p 0.9
+ 1468000p 0.9
+ 1468010p -0.3
+ 1470000p -0.3
+ 1470010p 0.9
+ 1472000p 0.9
+ 1472010p -0.3
+ 1474000p -0.3
+ 1474010p 0.9
+ 1476000p 0.9
+ 1476010p -0.3
+ 1478000p -0.3
+ 1478010p 0.9
+ 1480000p 0.9
+ 1480010p -0.3
+ 1482000p -0.3
+ 1482010p 0.9
+ 1484000p 0.9
+ 1484010p -0.3
+ 1486000p -0.3
+ 1486010p 0.9
+ 1488000p 0.9
+ 1488010p -0.3
+ 1490000p -0.3
+ 1490010p 0.9
+ 1492000p 0.9
+ 1492010p -0.3
+ 1494000p -0.3
+ 1494010p 0.9
+ 1496000p 0.9
+ 1496010p -0.3
+ 1498000p -0.3
+ 1498010p 0.9
+ 1500000p 0.9
+ 1500010p -0.3
+ 1502000p -0.3
+ 1502010p 0.9
+ 1504000p 0.9
+ 1504010p -0.3
+ 1506000p -0.3
+ 1506010p 0.9
+ 1508000p 0.9
+ 1508010p -0.3
+ 1510000p -0.3
+ 1510010p 0.9
+ 1512000p 0.9
+ 1512010p -0.3
+ 1514000p -0.3
+ 1514010p 0.9
+ 1516000p 0.9
+ 1516010p -0.3
+ 1518000p -0.3
+ 1518010p 0.9
+ 1520000p 0.9
+ 1520010p -0.3
+ 1522000p -0.3
+ 1522010p 0.9
+ 1524000p 0.9
+ 1524010p -0.3
+ 1526000p -0.3
+ 1526010p 0.9
+ 1528000p 0.9
+ 1528010p -0.3
+ 1530000p -0.3
+ 1530010p 0.9
+ 1532000p 0.9
+ 1532010p -0.3
+ 1534000p -0.3
+ 1534010p 0.9
+ 1536000p 0.9
+ 1536010p -0.3
+ 1538000p -0.3
+ 1538010p 0.9
+ 1540000p 0.9
+ 1540010p -0.3
+ 1542000p -0.3
+ 1542010p 0.9
+ 1544000p 0.9
+ 1544010p -0.3
+ 1546000p -0.3
+ 1546010p 0.9
+ 1548000p 0.9
+ 1548010p -0.3
+ 1550000p -0.3
+ 1550010p 0.9
+ 1552000p 0.9
+ 1552010p -0.3
+ 1554000p -0.3
+ 1554010p 0.9
+ 1556000p 0.9
+ 1556010p -0.3
+ 1558000p -0.3
+ 1558010p 0.9
+ 1560000p 0.9
+ 1560010p -0.3
+ 1562000p -0.3
+ 1562010p 0.9
+ 1564000p 0.9
+ 1564010p -0.3
+ 1566000p -0.3
+ 1566010p 0.9
+ 1568000p 0.9
+ 1568010p -0.3
+ 1570000p -0.3
+ 1570010p 0.9
+ 1572000p 0.9
+ 1572010p -0.3
+ 1574000p -0.3
+ 1574010p 0.9
+ 1576000p 0.9
+ 1576010p -0.3
+ 1578000p -0.3
+ 1578010p 0.9
+ 1580000p 0.9
+ 1580010p -0.3
+ 1582000p -0.3
+ 1582010p 0.9
+ 1584000p 0.9
+ 1584010p -0.3
+ 1586000p -0.3
+ 1586010p 0.9
+ 1588000p 0.9
+ 1588010p -0.3
+ 1590000p -0.3
+ 1590010p 0.9
+ 1592000p 0.9
+ 1592010p -0.3
+ 1594000p -0.3
+ 1594010p 0.9
+ 1596000p 0.9
+ 1596010p -0.3
+ 1598000p -0.3
+ 1598010p 0.9
+ 1600000p 0.9
+ 1600010p -0.3
+ 1602000p -0.3
+ 1602010p 0.9
+ 1604000p 0.9
+ 1604010p -0.3
+ 1606000p -0.3
+ 1606010p 0.9
+ 1608000p 0.9
+ 1608010p -0.3
+ 1610000p -0.3
+ 1610010p 0.9
+ 1612000p 0.9
+ 1612010p -0.3
+ 1614000p -0.3
+ 1614010p 0.9
+ 1616000p 0.9
+ 1616010p -0.3
+ 1618000p -0.3
+ 1618010p 0.9
+ 1620000p 0.9
+ 1620010p -0.3
+ 1622000p -0.3
+ 1622010p 0.9
+ 1624000p 0.9
+ 1624010p -0.3
+ 1626000p -0.3
+ 1626010p 0.9
+ 1628000p 0.9
+ 1628010p -0.3
+ 1630000p -0.3
+ 1630010p 0.9
+ 1632000p 0.9
+ 1632010p -0.3
+ 1634000p -0.3
+ 1634010p 0.9
+ 1636000p 0.9
+ 1636010p -0.3
+ 1638000p -0.3
+ 1638010p 0.9
+ 1640000p 0.9
+ 1640010p -0.3
+ 1642000p -0.3
+ 1642010p 0.9
+ 1644000p 0.9
+ 1644010p -0.3
+ 1646000p -0.3
+ 1646010p 0.9
+ 1648000p 0.9
+ 1648010p -0.3
+ 1650000p -0.3
+ 1650010p 0.9
+ 1652000p 0.9
+ 1652010p -0.3
+ 1654000p -0.3
+ 1654010p 0.9
+ 1656000p 0.9
+ 1656010p -0.3
+ 1658000p -0.3
+ 1658010p 0.9
+ 1660000p 0.9
+ 1660010p -0.3
+ 1662000p -0.3
+ 1662010p 0.9
+ 1664000p 0.9
+ 1664010p -0.3
+ 1666000p -0.3
+ 1666010p 0.9
+ 1668000p 0.9
+ 1668010p -0.3
+ 1670000p -0.3
+ 1670010p 0.9
+ 1672000p 0.9
+ 1672010p -0.3
+ 1674000p -0.3
+ 1674010p 0.9
+ 1676000p 0.9
+ 1676010p -0.3
+ 1678000p -0.3
+ 1678010p 0.9
+ 1680000p 0.9
+ 1680010p -0.3
+ 1682000p -0.3
+ 1682010p 0.9
+ 1684000p 0.9
+ 1684010p -0.3
+ 1686000p -0.3
+ 1686010p 0.9
+ 1688000p 0.9
+ 1688010p -0.3
+ 1690000p -0.3
+ 1690010p 0.9
+ 1692000p 0.9
+ 1692010p -0.3
+ 1694000p -0.3
+ 1694010p 0.9
+ 1696000p 0.9
+ 1696010p -0.3
+ 1698000p -0.3
+ 1698010p 0.9
+ 1700000p 0.9
+ 1700010p -0.3
+ 1702000p -0.3
+ 1702010p 0.9
+ 1704000p 0.9
+ 1704010p -0.3
+ 1706000p -0.3
+ 1706010p 0.9
+ 1708000p 0.9
+ 1708010p -0.3
+ 1710000p -0.3
+ 1710010p 0.9
+ 1712000p 0.9
+ 1712010p -0.3
+ 1714000p -0.3
+ 1714010p 0.9
+ 1716000p 0.9
+ 1716010p -0.3
+ 1718000p -0.3
+ 1718010p 0.9
+ 1720000p 0.9
+ 1720010p -0.3
+ 1722000p -0.3
+ 1722010p 0.9
+ 1724000p 0.9
+ 1724010p -0.3
+ 1726000p -0.3
+ 1726010p 0.9
+ 1728000p 0.9
+ 1728010p -0.3
+ 1730000p -0.3
+ 1730010p 0.9
+ 1732000p 0.9
+ 1732010p -0.3
+ 1734000p -0.3
+ 1734010p 0.9
+ 1736000p 0.9
+ 1736010p -0.3
+ 1738000p -0.3
+ 1738010p 0.9
+ 1740000p 0.9
+ 1740010p -0.3
+ 1742000p -0.3
+ 1742010p 0.9
+ 1744000p 0.9
+ 1744010p -0.3
+ 1746000p -0.3
+ 1746010p 0.9
+ 1748000p 0.9
+ 1748010p -0.3
+ 1750000p -0.3
+ 1750010p 0.9
+ 1752000p 0.9
+ 1752010p -0.3
+ 1754000p -0.3
+ 1754010p 0.9
+ 1756000p 0.9
+ 1756010p -0.3
+ 1758000p -0.3
+ 1758010p 0.9
+ 1760000p 0.9
+ 1760010p -0.3
+ 1762000p -0.3
+ 1762010p 0.9
+ 1764000p 0.9
+ 1764010p -0.3
+ 1766000p -0.3
+ 1766010p 0.9
+ 1768000p 0.9
+ 1768010p -0.3
+ 1770000p -0.3
+ 1770010p 0.9
+ 1772000p 0.9
+ 1772010p -0.3
+ 1774000p -0.3
+ 1774010p 0.9
+ 1776000p 0.9
+ 1776010p -0.3
+ 1778000p -0.3
+ 1778010p 0.9
+ 1780000p 0.9
+ 1780010p -0.3
+ 1782000p -0.3
+ 1782010p 0.9
+ 1784000p 0.9
+ 1784010p -0.3
+ 1786000p -0.3
+ 1786010p 0.9
+ 1788000p 0.9
+ 1788010p -0.3
+ 1790000p -0.3
+ 1790010p 0.9
+ 1792000p 0.9
+ 1792010p -0.3
+ 1794000p -0.3
+ 1794010p 0.9
+ 1796000p 0.9
+ 1796010p -0.3
+ 1798000p -0.3
+ 1798010p 0.9
+ 1800000p 0.9
+ 1800010p -0.3
+ 1802000p -0.3
+ 1802010p 0.9
+ 1804000p 0.9
+ 1804010p -0.3
+ 1806000p -0.3
+ 1806010p 0.9
+ 1808000p 0.9
+ 1808010p -0.3
+ 1810000p -0.3
+ 1810010p 0.9
+ 1812000p 0.9
+ 1812010p -0.3
+ 1814000p -0.3
+ 1814010p 0.9
+ 1816000p 0.9
+ 1816010p -0.3
+ 1818000p -0.3
+ 1818010p 0.9
+ 1820000p 0.9
+ 1820010p -0.3
+ 1822000p -0.3
+ 1822010p 0.9
+ 1824000p 0.9
+ 1824010p -0.3
+ 1826000p -0.3
+ 1826010p 0.9
+ 1828000p 0.9
+ 1828010p -0.3
+ 1830000p -0.3
+ 1830010p 0.9
+ 1832000p 0.9
+ 1832010p -0.3
+ 1834000p -0.3
+ 1834010p 0.9
+ 1836000p 0.9
+ 1836010p -0.3
+ 1838000p -0.3
+ 1838010p 0.9
+ 1840000p 0.9
+ 1840010p -0.3
+ 1842000p -0.3
+ 1842010p 0.9
+ 1844000p 0.9
+ 1844010p -0.3
+ 1846000p -0.3
+ 1846010p 0.9
+ 1848000p 0.9
+ 1848010p -0.3
+ 1850000p -0.3
+ 1850010p 0.9
+ 1852000p 0.9
+ 1852010p -0.3
+ 1854000p -0.3
+ 1854010p 0.9
+ 1856000p 0.9
+ 1856010p -0.3
+ 1858000p -0.3
+ 1858010p 0.9
+ 1860000p 0.9
+ 1860010p -0.3
+ 1862000p -0.3
+ 1862010p 0.9
+ 1864000p 0.9
+ 1864010p -0.3
+ 1866000p -0.3
+ 1866010p 0.9
+ 1868000p 0.9
+ 1868010p -0.3
+ 1870000p -0.3
+ 1870010p 0.9
+ 1872000p 0.9
+ 1872010p -0.3
+ 1874000p -0.3
+ 1874010p 0.9
+ 1876000p 0.9
+ 1876010p -0.3
+ 1878000p -0.3
+ 1878010p 0.9
+ 1880000p 0.9
+ 1880010p -0.3
+ 1882000p -0.3
+ 1882010p 0.9
+ 1884000p 0.9
+ 1884010p -0.3
+ 1886000p -0.3
+ 1886010p 0.9
+ 1888000p 0.9
+ 1888010p -0.3
+ 1890000p -0.3
+ 1890010p 0.9
+ 1892000p 0.9
+ 1892010p -0.3
+ 1894000p -0.3
+ 1894010p 0.9
+ 1896000p 0.9
+ 1896010p -0.3
+ 1898000p -0.3
+ 1898010p 0.9
+ 1900000p 0.9
+ 1900010p -0.3
+ 1902000p -0.3
+ 1902010p 0.9
+ 1904000p 0.9
+ 1904010p -0.3
+ 1906000p -0.3
+ 1906010p 0.9
+ 1908000p 0.9
+ 1908010p -0.3
+ 1910000p -0.3
+ 1910010p 0.9
+ 1912000p 0.9
+ 1912010p -0.3
+ 1914000p -0.3
+ 1914010p 0.9
+ 1916000p 0.9
+ 1916010p -0.3
+ 1918000p -0.3
+ 1918010p 0.9
+ 1920000p 0.9
+ 1920010p -0.3
+ 1922000p -0.3
+ 1922010p 0.9
+ 1924000p 0.9
+ 1924010p -0.3
+ 1926000p -0.3
+ 1926010p 0.9
+ 1928000p 0.9
+ 1928010p -0.3
+ 1930000p -0.3
+ 1930010p 0.9
+ 1932000p 0.9
+ 1932010p -0.3
+ 1934000p -0.3
+ 1934010p 0.9
+ 1936000p 0.9
+ 1936010p -0.3
+ 1938000p -0.3
+ 1938010p 0.9
+ 1940000p 0.9
+ 1940010p -0.3
+ 1942000p -0.3
+ 1942010p 0.9
+ 1944000p 0.9
+ 1944010p -0.3
+ 1946000p -0.3
+ 1946010p 0.9
+ 1948000p 0.9
+ 1948010p -0.3
+ 1950000p -0.3
+ 1950010p 0.9
+ 1952000p 0.9
+ 1952010p -0.3
+ 1954000p -0.3
+ 1954010p 0.9
+ 1956000p 0.9
+ 1956010p -0.3
+ 1958000p -0.3
+ 1958010p 0.9
+ 1960000p 0.9
+ 1960010p -0.3
+ 1962000p -0.3
+ 1962010p 0.9
+ 1964000p 0.9
+ 1964010p -0.3
+ 1966000p -0.3
+ 1966010p 0.9
+ 1968000p 0.9
+ 1968010p -0.3
+ 1970000p -0.3
+ 1970010p 0.9
+ 1972000p 0.9
+ 1972010p -0.3
+ 1974000p -0.3
+ 1974010p 0.9
+ 1976000p 0.9
+ 1976010p -0.3
+ 1978000p -0.3
+ 1978010p 0.9
+ 1980000p 0.9
+ 1980010p -0.3
+ 1982000p -0.3
+ 1982010p 0.9
+ 1984000p 0.9
+ 1984010p -0.3
+ 1986000p -0.3
+ 1986010p 0.9
+ 1988000p 0.9
+ 1988010p -0.3
+ 1990000p -0.3
+ 1990010p 0.9
+ 1992000p 0.9
+ 1992010p -0.3
+ 1994000p -0.3
+ 1994010p 0.9
+ 1996000p 0.9
+ 1996010p -0.3
+ 1998000p -0.3
+ 1998010p 0.9
+ 2000000p 0.9
+ 2000010p -0.3
+ 2002000p -0.3
+ 2002010p 0.9
+ 2004000p 0.9
+ 2004010p -0.3
+ 2006000p -0.3
+ 2006010p 0.9
+ 2008000p 0.9
+ 2008010p -0.3
+ 2010000p -0.3
+ 2010010p 0.9
+ 2012000p 0.9
+ 2012010p -0.3
+ 2014000p -0.3
+ 2014010p 0.9
+ 2016000p 0.9
+ 2016010p -0.3
+ 2018000p -0.3
+ 2018010p 0.9
+ 2020000p 0.9
+ 2020010p -0.3
+ 2022000p -0.3
+ 2022010p 0.9
+ 2024000p 0.9
+ 2024010p -0.3
+ 2026000p -0.3
+ 2026010p 0.9
+ 2028000p 0.9
+ 2028010p -0.3
+ 2030000p -0.3
+ 2030010p 0.9
+ 2032000p 0.9
+ 2032010p -0.3
+ 2034000p -0.3
+ 2034010p 0.9
+ 2036000p 0.9
+ 2036010p -0.3
+ 2038000p -0.3
+ 2038010p 0.9
+ 2040000p 0.9
+ 2040010p -0.3
+ 2042000p -0.3
+ 2042010p 0.9
+ 2044000p 0.9
+ 2044010p -0.3
+ 2046000p -0.3
+ 2046010p 0.9
+ 2048000p 0.9
+ 2048010p -0.3
+ \]
V_data_22 (Data\\<22\\> gnd!) vsource type=pwl wave=\[
+ 0    0.9
+ 2000p 0.9
+ 2010p -0.3
+ 4000p -0.3
+ 4010p 0.9
+ 6000p 0.9
+ 6010p -0.3
+ 8000p -0.3
+ 8010p 0.9
+ 10000p 0.9
+ 10010p -0.3
+ 12000p -0.3
+ 12010p 0.9
+ 14000p 0.9
+ 14010p -0.3
+ 16000p -0.3
+ 16010p 0.9
+ 18000p 0.9
+ 18010p -0.3
+ 20000p -0.3
+ 20010p 0.9
+ 22000p 0.9
+ 22010p -0.3
+ 24000p -0.3
+ 24010p 0.9
+ 26000p 0.9
+ 26010p -0.3
+ 28000p -0.3
+ 28010p 0.9
+ 30000p 0.9
+ 30010p -0.3
+ 32000p -0.3
+ 32010p 0.9
+ 34000p 0.9
+ 34010p -0.3
+ 36000p -0.3
+ 36010p 0.9
+ 38000p 0.9
+ 38010p -0.3
+ 40000p -0.3
+ 40010p 0.9
+ 42000p 0.9
+ 42010p -0.3
+ 44000p -0.3
+ 44010p 0.9
+ 46000p 0.9
+ 46010p -0.3
+ 48000p -0.3
+ 48010p 0.9
+ 50000p 0.9
+ 50010p -0.3
+ 52000p -0.3
+ 52010p 0.9
+ 54000p 0.9
+ 54010p -0.3
+ 56000p -0.3
+ 56010p 0.9
+ 58000p 0.9
+ 58010p -0.3
+ 60000p -0.3
+ 60010p 0.9
+ 62000p 0.9
+ 62010p -0.3
+ 64000p -0.3
+ 64010p 0.9
+ 66000p 0.9
+ 66010p -0.3
+ 68000p -0.3
+ 68010p 0.9
+ 70000p 0.9
+ 70010p -0.3
+ 72000p -0.3
+ 72010p 0.9
+ 74000p 0.9
+ 74010p -0.3
+ 76000p -0.3
+ 76010p 0.9
+ 78000p 0.9
+ 78010p -0.3
+ 80000p -0.3
+ 80010p 0.9
+ 82000p 0.9
+ 82010p -0.3
+ 84000p -0.3
+ 84010p 0.9
+ 86000p 0.9
+ 86010p -0.3
+ 88000p -0.3
+ 88010p 0.9
+ 90000p 0.9
+ 90010p -0.3
+ 92000p -0.3
+ 92010p 0.9
+ 94000p 0.9
+ 94010p -0.3
+ 96000p -0.3
+ 96010p 0.9
+ 98000p 0.9
+ 98010p -0.3
+ 100000p -0.3
+ 100010p 0.9
+ 102000p 0.9
+ 102010p -0.3
+ 104000p -0.3
+ 104010p 0.9
+ 106000p 0.9
+ 106010p -0.3
+ 108000p -0.3
+ 108010p 0.9
+ 110000p 0.9
+ 110010p -0.3
+ 112000p -0.3
+ 112010p 0.9
+ 114000p 0.9
+ 114010p -0.3
+ 116000p -0.3
+ 116010p 0.9
+ 118000p 0.9
+ 118010p -0.3
+ 120000p -0.3
+ 120010p 0.9
+ 122000p 0.9
+ 122010p -0.3
+ 124000p -0.3
+ 124010p 0.9
+ 126000p 0.9
+ 126010p -0.3
+ 128000p -0.3
+ 128010p 0.9
+ 130000p 0.9
+ 130010p -0.3
+ 132000p -0.3
+ 132010p 0.9
+ 134000p 0.9
+ 134010p -0.3
+ 136000p -0.3
+ 136010p 0.9
+ 138000p 0.9
+ 138010p -0.3
+ 140000p -0.3
+ 140010p 0.9
+ 142000p 0.9
+ 142010p -0.3
+ 144000p -0.3
+ 144010p 0.9
+ 146000p 0.9
+ 146010p -0.3
+ 148000p -0.3
+ 148010p 0.9
+ 150000p 0.9
+ 150010p -0.3
+ 152000p -0.3
+ 152010p 0.9
+ 154000p 0.9
+ 154010p -0.3
+ 156000p -0.3
+ 156010p 0.9
+ 158000p 0.9
+ 158010p -0.3
+ 160000p -0.3
+ 160010p 0.9
+ 162000p 0.9
+ 162010p -0.3
+ 164000p -0.3
+ 164010p 0.9
+ 166000p 0.9
+ 166010p -0.3
+ 168000p -0.3
+ 168010p 0.9
+ 170000p 0.9
+ 170010p -0.3
+ 172000p -0.3
+ 172010p 0.9
+ 174000p 0.9
+ 174010p -0.3
+ 176000p -0.3
+ 176010p 0.9
+ 178000p 0.9
+ 178010p -0.3
+ 180000p -0.3
+ 180010p 0.9
+ 182000p 0.9
+ 182010p -0.3
+ 184000p -0.3
+ 184010p 0.9
+ 186000p 0.9
+ 186010p -0.3
+ 188000p -0.3
+ 188010p 0.9
+ 190000p 0.9
+ 190010p -0.3
+ 192000p -0.3
+ 192010p 0.9
+ 194000p 0.9
+ 194010p -0.3
+ 196000p -0.3
+ 196010p 0.9
+ 198000p 0.9
+ 198010p -0.3
+ 200000p -0.3
+ 200010p 0.9
+ 202000p 0.9
+ 202010p -0.3
+ 204000p -0.3
+ 204010p 0.9
+ 206000p 0.9
+ 206010p -0.3
+ 208000p -0.3
+ 208010p 0.9
+ 210000p 0.9
+ 210010p -0.3
+ 212000p -0.3
+ 212010p 0.9
+ 214000p 0.9
+ 214010p -0.3
+ 216000p -0.3
+ 216010p 0.9
+ 218000p 0.9
+ 218010p -0.3
+ 220000p -0.3
+ 220010p 0.9
+ 222000p 0.9
+ 222010p -0.3
+ 224000p -0.3
+ 224010p 0.9
+ 226000p 0.9
+ 226010p -0.3
+ 228000p -0.3
+ 228010p 0.9
+ 230000p 0.9
+ 230010p -0.3
+ 232000p -0.3
+ 232010p 0.9
+ 234000p 0.9
+ 234010p -0.3
+ 236000p -0.3
+ 236010p 0.9
+ 238000p 0.9
+ 238010p -0.3
+ 240000p -0.3
+ 240010p 0.9
+ 242000p 0.9
+ 242010p -0.3
+ 244000p -0.3
+ 244010p 0.9
+ 246000p 0.9
+ 246010p -0.3
+ 248000p -0.3
+ 248010p 0.9
+ 250000p 0.9
+ 250010p -0.3
+ 252000p -0.3
+ 252010p 0.9
+ 254000p 0.9
+ 254010p -0.3
+ 256000p -0.3
+ 256010p 0.9
+ 258000p 0.9
+ 258010p -0.3
+ 260000p -0.3
+ 260010p 0.9
+ 262000p 0.9
+ 262010p -0.3
+ 264000p -0.3
+ 264010p 0.9
+ 266000p 0.9
+ 266010p -0.3
+ 268000p -0.3
+ 268010p 0.9
+ 270000p 0.9
+ 270010p -0.3
+ 272000p -0.3
+ 272010p 0.9
+ 274000p 0.9
+ 274010p -0.3
+ 276000p -0.3
+ 276010p 0.9
+ 278000p 0.9
+ 278010p -0.3
+ 280000p -0.3
+ 280010p 0.9
+ 282000p 0.9
+ 282010p -0.3
+ 284000p -0.3
+ 284010p 0.9
+ 286000p 0.9
+ 286010p -0.3
+ 288000p -0.3
+ 288010p 0.9
+ 290000p 0.9
+ 290010p -0.3
+ 292000p -0.3
+ 292010p 0.9
+ 294000p 0.9
+ 294010p -0.3
+ 296000p -0.3
+ 296010p 0.9
+ 298000p 0.9
+ 298010p -0.3
+ 300000p -0.3
+ 300010p 0.9
+ 302000p 0.9
+ 302010p -0.3
+ 304000p -0.3
+ 304010p 0.9
+ 306000p 0.9
+ 306010p -0.3
+ 308000p -0.3
+ 308010p 0.9
+ 310000p 0.9
+ 310010p -0.3
+ 312000p -0.3
+ 312010p 0.9
+ 314000p 0.9
+ 314010p -0.3
+ 316000p -0.3
+ 316010p 0.9
+ 318000p 0.9
+ 318010p -0.3
+ 320000p -0.3
+ 320010p 0.9
+ 322000p 0.9
+ 322010p -0.3
+ 324000p -0.3
+ 324010p 0.9
+ 326000p 0.9
+ 326010p -0.3
+ 328000p -0.3
+ 328010p 0.9
+ 330000p 0.9
+ 330010p -0.3
+ 332000p -0.3
+ 332010p 0.9
+ 334000p 0.9
+ 334010p -0.3
+ 336000p -0.3
+ 336010p 0.9
+ 338000p 0.9
+ 338010p -0.3
+ 340000p -0.3
+ 340010p 0.9
+ 342000p 0.9
+ 342010p -0.3
+ 344000p -0.3
+ 344010p 0.9
+ 346000p 0.9
+ 346010p -0.3
+ 348000p -0.3
+ 348010p 0.9
+ 350000p 0.9
+ 350010p -0.3
+ 352000p -0.3
+ 352010p 0.9
+ 354000p 0.9
+ 354010p -0.3
+ 356000p -0.3
+ 356010p 0.9
+ 358000p 0.9
+ 358010p -0.3
+ 360000p -0.3
+ 360010p 0.9
+ 362000p 0.9
+ 362010p -0.3
+ 364000p -0.3
+ 364010p 0.9
+ 366000p 0.9
+ 366010p -0.3
+ 368000p -0.3
+ 368010p 0.9
+ 370000p 0.9
+ 370010p -0.3
+ 372000p -0.3
+ 372010p 0.9
+ 374000p 0.9
+ 374010p -0.3
+ 376000p -0.3
+ 376010p 0.9
+ 378000p 0.9
+ 378010p -0.3
+ 380000p -0.3
+ 380010p 0.9
+ 382000p 0.9
+ 382010p -0.3
+ 384000p -0.3
+ 384010p 0.9
+ 386000p 0.9
+ 386010p -0.3
+ 388000p -0.3
+ 388010p 0.9
+ 390000p 0.9
+ 390010p -0.3
+ 392000p -0.3
+ 392010p 0.9
+ 394000p 0.9
+ 394010p -0.3
+ 396000p -0.3
+ 396010p 0.9
+ 398000p 0.9
+ 398010p -0.3
+ 400000p -0.3
+ 400010p 0.9
+ 402000p 0.9
+ 402010p -0.3
+ 404000p -0.3
+ 404010p 0.9
+ 406000p 0.9
+ 406010p -0.3
+ 408000p -0.3
+ 408010p 0.9
+ 410000p 0.9
+ 410010p -0.3
+ 412000p -0.3
+ 412010p 0.9
+ 414000p 0.9
+ 414010p -0.3
+ 416000p -0.3
+ 416010p 0.9
+ 418000p 0.9
+ 418010p -0.3
+ 420000p -0.3
+ 420010p 0.9
+ 422000p 0.9
+ 422010p -0.3
+ 424000p -0.3
+ 424010p 0.9
+ 426000p 0.9
+ 426010p -0.3
+ 428000p -0.3
+ 428010p 0.9
+ 430000p 0.9
+ 430010p -0.3
+ 432000p -0.3
+ 432010p 0.9
+ 434000p 0.9
+ 434010p -0.3
+ 436000p -0.3
+ 436010p 0.9
+ 438000p 0.9
+ 438010p -0.3
+ 440000p -0.3
+ 440010p 0.9
+ 442000p 0.9
+ 442010p -0.3
+ 444000p -0.3
+ 444010p 0.9
+ 446000p 0.9
+ 446010p -0.3
+ 448000p -0.3
+ 448010p 0.9
+ 450000p 0.9
+ 450010p -0.3
+ 452000p -0.3
+ 452010p 0.9
+ 454000p 0.9
+ 454010p -0.3
+ 456000p -0.3
+ 456010p 0.9
+ 458000p 0.9
+ 458010p -0.3
+ 460000p -0.3
+ 460010p 0.9
+ 462000p 0.9
+ 462010p -0.3
+ 464000p -0.3
+ 464010p 0.9
+ 466000p 0.9
+ 466010p -0.3
+ 468000p -0.3
+ 468010p 0.9
+ 470000p 0.9
+ 470010p -0.3
+ 472000p -0.3
+ 472010p 0.9
+ 474000p 0.9
+ 474010p -0.3
+ 476000p -0.3
+ 476010p 0.9
+ 478000p 0.9
+ 478010p -0.3
+ 480000p -0.3
+ 480010p 0.9
+ 482000p 0.9
+ 482010p -0.3
+ 484000p -0.3
+ 484010p 0.9
+ 486000p 0.9
+ 486010p -0.3
+ 488000p -0.3
+ 488010p 0.9
+ 490000p 0.9
+ 490010p -0.3
+ 492000p -0.3
+ 492010p 0.9
+ 494000p 0.9
+ 494010p -0.3
+ 496000p -0.3
+ 496010p 0.9
+ 498000p 0.9
+ 498010p -0.3
+ 500000p -0.3
+ 500010p 0.9
+ 502000p 0.9
+ 502010p -0.3
+ 504000p -0.3
+ 504010p 0.9
+ 506000p 0.9
+ 506010p -0.3
+ 508000p -0.3
+ 508010p 0.9
+ 510000p 0.9
+ 510010p -0.3
+ 512000p -0.3
+ 512010p 0.9
+ 514000p 0.9
+ 514010p -0.3
+ 516000p -0.3
+ 516010p 0.9
+ 518000p 0.9
+ 518010p -0.3
+ 520000p -0.3
+ 520010p 0.9
+ 522000p 0.9
+ 522010p -0.3
+ 524000p -0.3
+ 524010p 0.9
+ 526000p 0.9
+ 526010p -0.3
+ 528000p -0.3
+ 528010p 0.9
+ 530000p 0.9
+ 530010p -0.3
+ 532000p -0.3
+ 532010p 0.9
+ 534000p 0.9
+ 534010p -0.3
+ 536000p -0.3
+ 536010p 0.9
+ 538000p 0.9
+ 538010p -0.3
+ 540000p -0.3
+ 540010p 0.9
+ 542000p 0.9
+ 542010p -0.3
+ 544000p -0.3
+ 544010p 0.9
+ 546000p 0.9
+ 546010p -0.3
+ 548000p -0.3
+ 548010p 0.9
+ 550000p 0.9
+ 550010p -0.3
+ 552000p -0.3
+ 552010p 0.9
+ 554000p 0.9
+ 554010p -0.3
+ 556000p -0.3
+ 556010p 0.9
+ 558000p 0.9
+ 558010p -0.3
+ 560000p -0.3
+ 560010p 0.9
+ 562000p 0.9
+ 562010p -0.3
+ 564000p -0.3
+ 564010p 0.9
+ 566000p 0.9
+ 566010p -0.3
+ 568000p -0.3
+ 568010p 0.9
+ 570000p 0.9
+ 570010p -0.3
+ 572000p -0.3
+ 572010p 0.9
+ 574000p 0.9
+ 574010p -0.3
+ 576000p -0.3
+ 576010p 0.9
+ 578000p 0.9
+ 578010p -0.3
+ 580000p -0.3
+ 580010p 0.9
+ 582000p 0.9
+ 582010p -0.3
+ 584000p -0.3
+ 584010p 0.9
+ 586000p 0.9
+ 586010p -0.3
+ 588000p -0.3
+ 588010p 0.9
+ 590000p 0.9
+ 590010p -0.3
+ 592000p -0.3
+ 592010p 0.9
+ 594000p 0.9
+ 594010p -0.3
+ 596000p -0.3
+ 596010p 0.9
+ 598000p 0.9
+ 598010p -0.3
+ 600000p -0.3
+ 600010p 0.9
+ 602000p 0.9
+ 602010p -0.3
+ 604000p -0.3
+ 604010p 0.9
+ 606000p 0.9
+ 606010p -0.3
+ 608000p -0.3
+ 608010p 0.9
+ 610000p 0.9
+ 610010p -0.3
+ 612000p -0.3
+ 612010p 0.9
+ 614000p 0.9
+ 614010p -0.3
+ 616000p -0.3
+ 616010p 0.9
+ 618000p 0.9
+ 618010p -0.3
+ 620000p -0.3
+ 620010p 0.9
+ 622000p 0.9
+ 622010p -0.3
+ 624000p -0.3
+ 624010p 0.9
+ 626000p 0.9
+ 626010p -0.3
+ 628000p -0.3
+ 628010p 0.9
+ 630000p 0.9
+ 630010p -0.3
+ 632000p -0.3
+ 632010p 0.9
+ 634000p 0.9
+ 634010p -0.3
+ 636000p -0.3
+ 636010p 0.9
+ 638000p 0.9
+ 638010p -0.3
+ 640000p -0.3
+ 640010p 0.9
+ 642000p 0.9
+ 642010p -0.3
+ 644000p -0.3
+ 644010p 0.9
+ 646000p 0.9
+ 646010p -0.3
+ 648000p -0.3
+ 648010p 0.9
+ 650000p 0.9
+ 650010p -0.3
+ 652000p -0.3
+ 652010p 0.9
+ 654000p 0.9
+ 654010p -0.3
+ 656000p -0.3
+ 656010p 0.9
+ 658000p 0.9
+ 658010p -0.3
+ 660000p -0.3
+ 660010p 0.9
+ 662000p 0.9
+ 662010p -0.3
+ 664000p -0.3
+ 664010p 0.9
+ 666000p 0.9
+ 666010p -0.3
+ 668000p -0.3
+ 668010p 0.9
+ 670000p 0.9
+ 670010p -0.3
+ 672000p -0.3
+ 672010p 0.9
+ 674000p 0.9
+ 674010p -0.3
+ 676000p -0.3
+ 676010p 0.9
+ 678000p 0.9
+ 678010p -0.3
+ 680000p -0.3
+ 680010p 0.9
+ 682000p 0.9
+ 682010p -0.3
+ 684000p -0.3
+ 684010p 0.9
+ 686000p 0.9
+ 686010p -0.3
+ 688000p -0.3
+ 688010p 0.9
+ 690000p 0.9
+ 690010p -0.3
+ 692000p -0.3
+ 692010p 0.9
+ 694000p 0.9
+ 694010p -0.3
+ 696000p -0.3
+ 696010p 0.9
+ 698000p 0.9
+ 698010p -0.3
+ 700000p -0.3
+ 700010p 0.9
+ 702000p 0.9
+ 702010p -0.3
+ 704000p -0.3
+ 704010p 0.9
+ 706000p 0.9
+ 706010p -0.3
+ 708000p -0.3
+ 708010p 0.9
+ 710000p 0.9
+ 710010p -0.3
+ 712000p -0.3
+ 712010p 0.9
+ 714000p 0.9
+ 714010p -0.3
+ 716000p -0.3
+ 716010p 0.9
+ 718000p 0.9
+ 718010p -0.3
+ 720000p -0.3
+ 720010p 0.9
+ 722000p 0.9
+ 722010p -0.3
+ 724000p -0.3
+ 724010p 0.9
+ 726000p 0.9
+ 726010p -0.3
+ 728000p -0.3
+ 728010p 0.9
+ 730000p 0.9
+ 730010p -0.3
+ 732000p -0.3
+ 732010p 0.9
+ 734000p 0.9
+ 734010p -0.3
+ 736000p -0.3
+ 736010p 0.9
+ 738000p 0.9
+ 738010p -0.3
+ 740000p -0.3
+ 740010p 0.9
+ 742000p 0.9
+ 742010p -0.3
+ 744000p -0.3
+ 744010p 0.9
+ 746000p 0.9
+ 746010p -0.3
+ 748000p -0.3
+ 748010p 0.9
+ 750000p 0.9
+ 750010p -0.3
+ 752000p -0.3
+ 752010p 0.9
+ 754000p 0.9
+ 754010p -0.3
+ 756000p -0.3
+ 756010p 0.9
+ 758000p 0.9
+ 758010p -0.3
+ 760000p -0.3
+ 760010p 0.9
+ 762000p 0.9
+ 762010p -0.3
+ 764000p -0.3
+ 764010p 0.9
+ 766000p 0.9
+ 766010p -0.3
+ 768000p -0.3
+ 768010p 0.9
+ 770000p 0.9
+ 770010p -0.3
+ 772000p -0.3
+ 772010p 0.9
+ 774000p 0.9
+ 774010p -0.3
+ 776000p -0.3
+ 776010p 0.9
+ 778000p 0.9
+ 778010p -0.3
+ 780000p -0.3
+ 780010p 0.9
+ 782000p 0.9
+ 782010p -0.3
+ 784000p -0.3
+ 784010p 0.9
+ 786000p 0.9
+ 786010p -0.3
+ 788000p -0.3
+ 788010p 0.9
+ 790000p 0.9
+ 790010p -0.3
+ 792000p -0.3
+ 792010p 0.9
+ 794000p 0.9
+ 794010p -0.3
+ 796000p -0.3
+ 796010p 0.9
+ 798000p 0.9
+ 798010p -0.3
+ 800000p -0.3
+ 800010p 0.9
+ 802000p 0.9
+ 802010p -0.3
+ 804000p -0.3
+ 804010p 0.9
+ 806000p 0.9
+ 806010p -0.3
+ 808000p -0.3
+ 808010p 0.9
+ 810000p 0.9
+ 810010p -0.3
+ 812000p -0.3
+ 812010p 0.9
+ 814000p 0.9
+ 814010p -0.3
+ 816000p -0.3
+ 816010p 0.9
+ 818000p 0.9
+ 818010p -0.3
+ 820000p -0.3
+ 820010p 0.9
+ 822000p 0.9
+ 822010p -0.3
+ 824000p -0.3
+ 824010p 0.9
+ 826000p 0.9
+ 826010p -0.3
+ 828000p -0.3
+ 828010p 0.9
+ 830000p 0.9
+ 830010p -0.3
+ 832000p -0.3
+ 832010p 0.9
+ 834000p 0.9
+ 834010p -0.3
+ 836000p -0.3
+ 836010p 0.9
+ 838000p 0.9
+ 838010p -0.3
+ 840000p -0.3
+ 840010p 0.9
+ 842000p 0.9
+ 842010p -0.3
+ 844000p -0.3
+ 844010p 0.9
+ 846000p 0.9
+ 846010p -0.3
+ 848000p -0.3
+ 848010p 0.9
+ 850000p 0.9
+ 850010p -0.3
+ 852000p -0.3
+ 852010p 0.9
+ 854000p 0.9
+ 854010p -0.3
+ 856000p -0.3
+ 856010p 0.9
+ 858000p 0.9
+ 858010p -0.3
+ 860000p -0.3
+ 860010p 0.9
+ 862000p 0.9
+ 862010p -0.3
+ 864000p -0.3
+ 864010p 0.9
+ 866000p 0.9
+ 866010p -0.3
+ 868000p -0.3
+ 868010p 0.9
+ 870000p 0.9
+ 870010p -0.3
+ 872000p -0.3
+ 872010p 0.9
+ 874000p 0.9
+ 874010p -0.3
+ 876000p -0.3
+ 876010p 0.9
+ 878000p 0.9
+ 878010p -0.3
+ 880000p -0.3
+ 880010p 0.9
+ 882000p 0.9
+ 882010p -0.3
+ 884000p -0.3
+ 884010p 0.9
+ 886000p 0.9
+ 886010p -0.3
+ 888000p -0.3
+ 888010p 0.9
+ 890000p 0.9
+ 890010p -0.3
+ 892000p -0.3
+ 892010p 0.9
+ 894000p 0.9
+ 894010p -0.3
+ 896000p -0.3
+ 896010p 0.9
+ 898000p 0.9
+ 898010p -0.3
+ 900000p -0.3
+ 900010p 0.9
+ 902000p 0.9
+ 902010p -0.3
+ 904000p -0.3
+ 904010p 0.9
+ 906000p 0.9
+ 906010p -0.3
+ 908000p -0.3
+ 908010p 0.9
+ 910000p 0.9
+ 910010p -0.3
+ 912000p -0.3
+ 912010p 0.9
+ 914000p 0.9
+ 914010p -0.3
+ 916000p -0.3
+ 916010p 0.9
+ 918000p 0.9
+ 918010p -0.3
+ 920000p -0.3
+ 920010p 0.9
+ 922000p 0.9
+ 922010p -0.3
+ 924000p -0.3
+ 924010p 0.9
+ 926000p 0.9
+ 926010p -0.3
+ 928000p -0.3
+ 928010p 0.9
+ 930000p 0.9
+ 930010p -0.3
+ 932000p -0.3
+ 932010p 0.9
+ 934000p 0.9
+ 934010p -0.3
+ 936000p -0.3
+ 936010p 0.9
+ 938000p 0.9
+ 938010p -0.3
+ 940000p -0.3
+ 940010p 0.9
+ 942000p 0.9
+ 942010p -0.3
+ 944000p -0.3
+ 944010p 0.9
+ 946000p 0.9
+ 946010p -0.3
+ 948000p -0.3
+ 948010p 0.9
+ 950000p 0.9
+ 950010p -0.3
+ 952000p -0.3
+ 952010p 0.9
+ 954000p 0.9
+ 954010p -0.3
+ 956000p -0.3
+ 956010p 0.9
+ 958000p 0.9
+ 958010p -0.3
+ 960000p -0.3
+ 960010p 0.9
+ 962000p 0.9
+ 962010p -0.3
+ 964000p -0.3
+ 964010p 0.9
+ 966000p 0.9
+ 966010p -0.3
+ 968000p -0.3
+ 968010p 0.9
+ 970000p 0.9
+ 970010p -0.3
+ 972000p -0.3
+ 972010p 0.9
+ 974000p 0.9
+ 974010p -0.3
+ 976000p -0.3
+ 976010p 0.9
+ 978000p 0.9
+ 978010p -0.3
+ 980000p -0.3
+ 980010p 0.9
+ 982000p 0.9
+ 982010p -0.3
+ 984000p -0.3
+ 984010p 0.9
+ 986000p 0.9
+ 986010p -0.3
+ 988000p -0.3
+ 988010p 0.9
+ 990000p 0.9
+ 990010p -0.3
+ 992000p -0.3
+ 992010p 0.9
+ 994000p 0.9
+ 994010p -0.3
+ 996000p -0.3
+ 996010p 0.9
+ 998000p 0.9
+ 998010p -0.3
+ 1000000p -0.3
+ 1000010p 0.9
+ 1002000p 0.9
+ 1002010p -0.3
+ 1004000p -0.3
+ 1004010p 0.9
+ 1006000p 0.9
+ 1006010p -0.3
+ 1008000p -0.3
+ 1008010p 0.9
+ 1010000p 0.9
+ 1010010p -0.3
+ 1012000p -0.3
+ 1012010p 0.9
+ 1014000p 0.9
+ 1014010p -0.3
+ 1016000p -0.3
+ 1016010p 0.9
+ 1018000p 0.9
+ 1018010p -0.3
+ 1020000p -0.3
+ 1020010p 0.9
+ 1022000p 0.9
+ 1022010p -0.3
+ 1024000p -0.3
+ 1024010p 0.9
+ 1026000p 0.9
+ 1026010p -0.3
+ 1028000p -0.3
+ 1028010p 0.9
+ 1030000p 0.9
+ 1030010p -0.3
+ 1032000p -0.3
+ 1032010p 0.9
+ 1034000p 0.9
+ 1034010p -0.3
+ 1036000p -0.3
+ 1036010p 0.9
+ 1038000p 0.9
+ 1038010p -0.3
+ 1040000p -0.3
+ 1040010p 0.9
+ 1042000p 0.9
+ 1042010p -0.3
+ 1044000p -0.3
+ 1044010p 0.9
+ 1046000p 0.9
+ 1046010p -0.3
+ 1048000p -0.3
+ 1048010p 0.9
+ 1050000p 0.9
+ 1050010p -0.3
+ 1052000p -0.3
+ 1052010p 0.9
+ 1054000p 0.9
+ 1054010p -0.3
+ 1056000p -0.3
+ 1056010p 0.9
+ 1058000p 0.9
+ 1058010p -0.3
+ 1060000p -0.3
+ 1060010p 0.9
+ 1062000p 0.9
+ 1062010p -0.3
+ 1064000p -0.3
+ 1064010p 0.9
+ 1066000p 0.9
+ 1066010p -0.3
+ 1068000p -0.3
+ 1068010p 0.9
+ 1070000p 0.9
+ 1070010p -0.3
+ 1072000p -0.3
+ 1072010p 0.9
+ 1074000p 0.9
+ 1074010p -0.3
+ 1076000p -0.3
+ 1076010p 0.9
+ 1078000p 0.9
+ 1078010p -0.3
+ 1080000p -0.3
+ 1080010p 0.9
+ 1082000p 0.9
+ 1082010p -0.3
+ 1084000p -0.3
+ 1084010p 0.9
+ 1086000p 0.9
+ 1086010p -0.3
+ 1088000p -0.3
+ 1088010p 0.9
+ 1090000p 0.9
+ 1090010p -0.3
+ 1092000p -0.3
+ 1092010p 0.9
+ 1094000p 0.9
+ 1094010p -0.3
+ 1096000p -0.3
+ 1096010p 0.9
+ 1098000p 0.9
+ 1098010p -0.3
+ 1100000p -0.3
+ 1100010p 0.9
+ 1102000p 0.9
+ 1102010p -0.3
+ 1104000p -0.3
+ 1104010p 0.9
+ 1106000p 0.9
+ 1106010p -0.3
+ 1108000p -0.3
+ 1108010p 0.9
+ 1110000p 0.9
+ 1110010p -0.3
+ 1112000p -0.3
+ 1112010p 0.9
+ 1114000p 0.9
+ 1114010p -0.3
+ 1116000p -0.3
+ 1116010p 0.9
+ 1118000p 0.9
+ 1118010p -0.3
+ 1120000p -0.3
+ 1120010p 0.9
+ 1122000p 0.9
+ 1122010p -0.3
+ 1124000p -0.3
+ 1124010p 0.9
+ 1126000p 0.9
+ 1126010p -0.3
+ 1128000p -0.3
+ 1128010p 0.9
+ 1130000p 0.9
+ 1130010p -0.3
+ 1132000p -0.3
+ 1132010p 0.9
+ 1134000p 0.9
+ 1134010p -0.3
+ 1136000p -0.3
+ 1136010p 0.9
+ 1138000p 0.9
+ 1138010p -0.3
+ 1140000p -0.3
+ 1140010p 0.9
+ 1142000p 0.9
+ 1142010p -0.3
+ 1144000p -0.3
+ 1144010p 0.9
+ 1146000p 0.9
+ 1146010p -0.3
+ 1148000p -0.3
+ 1148010p 0.9
+ 1150000p 0.9
+ 1150010p -0.3
+ 1152000p -0.3
+ 1152010p 0.9
+ 1154000p 0.9
+ 1154010p -0.3
+ 1156000p -0.3
+ 1156010p 0.9
+ 1158000p 0.9
+ 1158010p -0.3
+ 1160000p -0.3
+ 1160010p 0.9
+ 1162000p 0.9
+ 1162010p -0.3
+ 1164000p -0.3
+ 1164010p 0.9
+ 1166000p 0.9
+ 1166010p -0.3
+ 1168000p -0.3
+ 1168010p 0.9
+ 1170000p 0.9
+ 1170010p -0.3
+ 1172000p -0.3
+ 1172010p 0.9
+ 1174000p 0.9
+ 1174010p -0.3
+ 1176000p -0.3
+ 1176010p 0.9
+ 1178000p 0.9
+ 1178010p -0.3
+ 1180000p -0.3
+ 1180010p 0.9
+ 1182000p 0.9
+ 1182010p -0.3
+ 1184000p -0.3
+ 1184010p 0.9
+ 1186000p 0.9
+ 1186010p -0.3
+ 1188000p -0.3
+ 1188010p 0.9
+ 1190000p 0.9
+ 1190010p -0.3
+ 1192000p -0.3
+ 1192010p 0.9
+ 1194000p 0.9
+ 1194010p -0.3
+ 1196000p -0.3
+ 1196010p 0.9
+ 1198000p 0.9
+ 1198010p -0.3
+ 1200000p -0.3
+ 1200010p 0.9
+ 1202000p 0.9
+ 1202010p -0.3
+ 1204000p -0.3
+ 1204010p 0.9
+ 1206000p 0.9
+ 1206010p -0.3
+ 1208000p -0.3
+ 1208010p 0.9
+ 1210000p 0.9
+ 1210010p -0.3
+ 1212000p -0.3
+ 1212010p 0.9
+ 1214000p 0.9
+ 1214010p -0.3
+ 1216000p -0.3
+ 1216010p 0.9
+ 1218000p 0.9
+ 1218010p -0.3
+ 1220000p -0.3
+ 1220010p 0.9
+ 1222000p 0.9
+ 1222010p -0.3
+ 1224000p -0.3
+ 1224010p 0.9
+ 1226000p 0.9
+ 1226010p -0.3
+ 1228000p -0.3
+ 1228010p 0.9
+ 1230000p 0.9
+ 1230010p -0.3
+ 1232000p -0.3
+ 1232010p 0.9
+ 1234000p 0.9
+ 1234010p -0.3
+ 1236000p -0.3
+ 1236010p 0.9
+ 1238000p 0.9
+ 1238010p -0.3
+ 1240000p -0.3
+ 1240010p 0.9
+ 1242000p 0.9
+ 1242010p -0.3
+ 1244000p -0.3
+ 1244010p 0.9
+ 1246000p 0.9
+ 1246010p -0.3
+ 1248000p -0.3
+ 1248010p 0.9
+ 1250000p 0.9
+ 1250010p -0.3
+ 1252000p -0.3
+ 1252010p 0.9
+ 1254000p 0.9
+ 1254010p -0.3
+ 1256000p -0.3
+ 1256010p 0.9
+ 1258000p 0.9
+ 1258010p -0.3
+ 1260000p -0.3
+ 1260010p 0.9
+ 1262000p 0.9
+ 1262010p -0.3
+ 1264000p -0.3
+ 1264010p 0.9
+ 1266000p 0.9
+ 1266010p -0.3
+ 1268000p -0.3
+ 1268010p 0.9
+ 1270000p 0.9
+ 1270010p -0.3
+ 1272000p -0.3
+ 1272010p 0.9
+ 1274000p 0.9
+ 1274010p -0.3
+ 1276000p -0.3
+ 1276010p 0.9
+ 1278000p 0.9
+ 1278010p -0.3
+ 1280000p -0.3
+ 1280010p 0.9
+ 1282000p 0.9
+ 1282010p -0.3
+ 1284000p -0.3
+ 1284010p 0.9
+ 1286000p 0.9
+ 1286010p -0.3
+ 1288000p -0.3
+ 1288010p 0.9
+ 1290000p 0.9
+ 1290010p -0.3
+ 1292000p -0.3
+ 1292010p 0.9
+ 1294000p 0.9
+ 1294010p -0.3
+ 1296000p -0.3
+ 1296010p 0.9
+ 1298000p 0.9
+ 1298010p -0.3
+ 1300000p -0.3
+ 1300010p 0.9
+ 1302000p 0.9
+ 1302010p -0.3
+ 1304000p -0.3
+ 1304010p 0.9
+ 1306000p 0.9
+ 1306010p -0.3
+ 1308000p -0.3
+ 1308010p 0.9
+ 1310000p 0.9
+ 1310010p -0.3
+ 1312000p -0.3
+ 1312010p 0.9
+ 1314000p 0.9
+ 1314010p -0.3
+ 1316000p -0.3
+ 1316010p 0.9
+ 1318000p 0.9
+ 1318010p -0.3
+ 1320000p -0.3
+ 1320010p 0.9
+ 1322000p 0.9
+ 1322010p -0.3
+ 1324000p -0.3
+ 1324010p 0.9
+ 1326000p 0.9
+ 1326010p -0.3
+ 1328000p -0.3
+ 1328010p 0.9
+ 1330000p 0.9
+ 1330010p -0.3
+ 1332000p -0.3
+ 1332010p 0.9
+ 1334000p 0.9
+ 1334010p -0.3
+ 1336000p -0.3
+ 1336010p 0.9
+ 1338000p 0.9
+ 1338010p -0.3
+ 1340000p -0.3
+ 1340010p 0.9
+ 1342000p 0.9
+ 1342010p -0.3
+ 1344000p -0.3
+ 1344010p 0.9
+ 1346000p 0.9
+ 1346010p -0.3
+ 1348000p -0.3
+ 1348010p 0.9
+ 1350000p 0.9
+ 1350010p -0.3
+ 1352000p -0.3
+ 1352010p 0.9
+ 1354000p 0.9
+ 1354010p -0.3
+ 1356000p -0.3
+ 1356010p 0.9
+ 1358000p 0.9
+ 1358010p -0.3
+ 1360000p -0.3
+ 1360010p 0.9
+ 1362000p 0.9
+ 1362010p -0.3
+ 1364000p -0.3
+ 1364010p 0.9
+ 1366000p 0.9
+ 1366010p -0.3
+ 1368000p -0.3
+ 1368010p 0.9
+ 1370000p 0.9
+ 1370010p -0.3
+ 1372000p -0.3
+ 1372010p 0.9
+ 1374000p 0.9
+ 1374010p -0.3
+ 1376000p -0.3
+ 1376010p 0.9
+ 1378000p 0.9
+ 1378010p -0.3
+ 1380000p -0.3
+ 1380010p 0.9
+ 1382000p 0.9
+ 1382010p -0.3
+ 1384000p -0.3
+ 1384010p 0.9
+ 1386000p 0.9
+ 1386010p -0.3
+ 1388000p -0.3
+ 1388010p 0.9
+ 1390000p 0.9
+ 1390010p -0.3
+ 1392000p -0.3
+ 1392010p 0.9
+ 1394000p 0.9
+ 1394010p -0.3
+ 1396000p -0.3
+ 1396010p 0.9
+ 1398000p 0.9
+ 1398010p -0.3
+ 1400000p -0.3
+ 1400010p 0.9
+ 1402000p 0.9
+ 1402010p -0.3
+ 1404000p -0.3
+ 1404010p 0.9
+ 1406000p 0.9
+ 1406010p -0.3
+ 1408000p -0.3
+ 1408010p 0.9
+ 1410000p 0.9
+ 1410010p -0.3
+ 1412000p -0.3
+ 1412010p 0.9
+ 1414000p 0.9
+ 1414010p -0.3
+ 1416000p -0.3
+ 1416010p 0.9
+ 1418000p 0.9
+ 1418010p -0.3
+ 1420000p -0.3
+ 1420010p 0.9
+ 1422000p 0.9
+ 1422010p -0.3
+ 1424000p -0.3
+ 1424010p 0.9
+ 1426000p 0.9
+ 1426010p -0.3
+ 1428000p -0.3
+ 1428010p 0.9
+ 1430000p 0.9
+ 1430010p -0.3
+ 1432000p -0.3
+ 1432010p 0.9
+ 1434000p 0.9
+ 1434010p -0.3
+ 1436000p -0.3
+ 1436010p 0.9
+ 1438000p 0.9
+ 1438010p -0.3
+ 1440000p -0.3
+ 1440010p 0.9
+ 1442000p 0.9
+ 1442010p -0.3
+ 1444000p -0.3
+ 1444010p 0.9
+ 1446000p 0.9
+ 1446010p -0.3
+ 1448000p -0.3
+ 1448010p 0.9
+ 1450000p 0.9
+ 1450010p -0.3
+ 1452000p -0.3
+ 1452010p 0.9
+ 1454000p 0.9
+ 1454010p -0.3
+ 1456000p -0.3
+ 1456010p 0.9
+ 1458000p 0.9
+ 1458010p -0.3
+ 1460000p -0.3
+ 1460010p 0.9
+ 1462000p 0.9
+ 1462010p -0.3
+ 1464000p -0.3
+ 1464010p 0.9
+ 1466000p 0.9
+ 1466010p -0.3
+ 1468000p -0.3
+ 1468010p 0.9
+ 1470000p 0.9
+ 1470010p -0.3
+ 1472000p -0.3
+ 1472010p 0.9
+ 1474000p 0.9
+ 1474010p -0.3
+ 1476000p -0.3
+ 1476010p 0.9
+ 1478000p 0.9
+ 1478010p -0.3
+ 1480000p -0.3
+ 1480010p 0.9
+ 1482000p 0.9
+ 1482010p -0.3
+ 1484000p -0.3
+ 1484010p 0.9
+ 1486000p 0.9
+ 1486010p -0.3
+ 1488000p -0.3
+ 1488010p 0.9
+ 1490000p 0.9
+ 1490010p -0.3
+ 1492000p -0.3
+ 1492010p 0.9
+ 1494000p 0.9
+ 1494010p -0.3
+ 1496000p -0.3
+ 1496010p 0.9
+ 1498000p 0.9
+ 1498010p -0.3
+ 1500000p -0.3
+ 1500010p 0.9
+ 1502000p 0.9
+ 1502010p -0.3
+ 1504000p -0.3
+ 1504010p 0.9
+ 1506000p 0.9
+ 1506010p -0.3
+ 1508000p -0.3
+ 1508010p 0.9
+ 1510000p 0.9
+ 1510010p -0.3
+ 1512000p -0.3
+ 1512010p 0.9
+ 1514000p 0.9
+ 1514010p -0.3
+ 1516000p -0.3
+ 1516010p 0.9
+ 1518000p 0.9
+ 1518010p -0.3
+ 1520000p -0.3
+ 1520010p 0.9
+ 1522000p 0.9
+ 1522010p -0.3
+ 1524000p -0.3
+ 1524010p 0.9
+ 1526000p 0.9
+ 1526010p -0.3
+ 1528000p -0.3
+ 1528010p 0.9
+ 1530000p 0.9
+ 1530010p -0.3
+ 1532000p -0.3
+ 1532010p 0.9
+ 1534000p 0.9
+ 1534010p -0.3
+ 1536000p -0.3
+ 1536010p 0.9
+ 1538000p 0.9
+ 1538010p -0.3
+ 1540000p -0.3
+ 1540010p 0.9
+ 1542000p 0.9
+ 1542010p -0.3
+ 1544000p -0.3
+ 1544010p 0.9
+ 1546000p 0.9
+ 1546010p -0.3
+ 1548000p -0.3
+ 1548010p 0.9
+ 1550000p 0.9
+ 1550010p -0.3
+ 1552000p -0.3
+ 1552010p 0.9
+ 1554000p 0.9
+ 1554010p -0.3
+ 1556000p -0.3
+ 1556010p 0.9
+ 1558000p 0.9
+ 1558010p -0.3
+ 1560000p -0.3
+ 1560010p 0.9
+ 1562000p 0.9
+ 1562010p -0.3
+ 1564000p -0.3
+ 1564010p 0.9
+ 1566000p 0.9
+ 1566010p -0.3
+ 1568000p -0.3
+ 1568010p 0.9
+ 1570000p 0.9
+ 1570010p -0.3
+ 1572000p -0.3
+ 1572010p 0.9
+ 1574000p 0.9
+ 1574010p -0.3
+ 1576000p -0.3
+ 1576010p 0.9
+ 1578000p 0.9
+ 1578010p -0.3
+ 1580000p -0.3
+ 1580010p 0.9
+ 1582000p 0.9
+ 1582010p -0.3
+ 1584000p -0.3
+ 1584010p 0.9
+ 1586000p 0.9
+ 1586010p -0.3
+ 1588000p -0.3
+ 1588010p 0.9
+ 1590000p 0.9
+ 1590010p -0.3
+ 1592000p -0.3
+ 1592010p 0.9
+ 1594000p 0.9
+ 1594010p -0.3
+ 1596000p -0.3
+ 1596010p 0.9
+ 1598000p 0.9
+ 1598010p -0.3
+ 1600000p -0.3
+ 1600010p 0.9
+ 1602000p 0.9
+ 1602010p -0.3
+ 1604000p -0.3
+ 1604010p 0.9
+ 1606000p 0.9
+ 1606010p -0.3
+ 1608000p -0.3
+ 1608010p 0.9
+ 1610000p 0.9
+ 1610010p -0.3
+ 1612000p -0.3
+ 1612010p 0.9
+ 1614000p 0.9
+ 1614010p -0.3
+ 1616000p -0.3
+ 1616010p 0.9
+ 1618000p 0.9
+ 1618010p -0.3
+ 1620000p -0.3
+ 1620010p 0.9
+ 1622000p 0.9
+ 1622010p -0.3
+ 1624000p -0.3
+ 1624010p 0.9
+ 1626000p 0.9
+ 1626010p -0.3
+ 1628000p -0.3
+ 1628010p 0.9
+ 1630000p 0.9
+ 1630010p -0.3
+ 1632000p -0.3
+ 1632010p 0.9
+ 1634000p 0.9
+ 1634010p -0.3
+ 1636000p -0.3
+ 1636010p 0.9
+ 1638000p 0.9
+ 1638010p -0.3
+ 1640000p -0.3
+ 1640010p 0.9
+ 1642000p 0.9
+ 1642010p -0.3
+ 1644000p -0.3
+ 1644010p 0.9
+ 1646000p 0.9
+ 1646010p -0.3
+ 1648000p -0.3
+ 1648010p 0.9
+ 1650000p 0.9
+ 1650010p -0.3
+ 1652000p -0.3
+ 1652010p 0.9
+ 1654000p 0.9
+ 1654010p -0.3
+ 1656000p -0.3
+ 1656010p 0.9
+ 1658000p 0.9
+ 1658010p -0.3
+ 1660000p -0.3
+ 1660010p 0.9
+ 1662000p 0.9
+ 1662010p -0.3
+ 1664000p -0.3
+ 1664010p 0.9
+ 1666000p 0.9
+ 1666010p -0.3
+ 1668000p -0.3
+ 1668010p 0.9
+ 1670000p 0.9
+ 1670010p -0.3
+ 1672000p -0.3
+ 1672010p 0.9
+ 1674000p 0.9
+ 1674010p -0.3
+ 1676000p -0.3
+ 1676010p 0.9
+ 1678000p 0.9
+ 1678010p -0.3
+ 1680000p -0.3
+ 1680010p 0.9
+ 1682000p 0.9
+ 1682010p -0.3
+ 1684000p -0.3
+ 1684010p 0.9
+ 1686000p 0.9
+ 1686010p -0.3
+ 1688000p -0.3
+ 1688010p 0.9
+ 1690000p 0.9
+ 1690010p -0.3
+ 1692000p -0.3
+ 1692010p 0.9
+ 1694000p 0.9
+ 1694010p -0.3
+ 1696000p -0.3
+ 1696010p 0.9
+ 1698000p 0.9
+ 1698010p -0.3
+ 1700000p -0.3
+ 1700010p 0.9
+ 1702000p 0.9
+ 1702010p -0.3
+ 1704000p -0.3
+ 1704010p 0.9
+ 1706000p 0.9
+ 1706010p -0.3
+ 1708000p -0.3
+ 1708010p 0.9
+ 1710000p 0.9
+ 1710010p -0.3
+ 1712000p -0.3
+ 1712010p 0.9
+ 1714000p 0.9
+ 1714010p -0.3
+ 1716000p -0.3
+ 1716010p 0.9
+ 1718000p 0.9
+ 1718010p -0.3
+ 1720000p -0.3
+ 1720010p 0.9
+ 1722000p 0.9
+ 1722010p -0.3
+ 1724000p -0.3
+ 1724010p 0.9
+ 1726000p 0.9
+ 1726010p -0.3
+ 1728000p -0.3
+ 1728010p 0.9
+ 1730000p 0.9
+ 1730010p -0.3
+ 1732000p -0.3
+ 1732010p 0.9
+ 1734000p 0.9
+ 1734010p -0.3
+ 1736000p -0.3
+ 1736010p 0.9
+ 1738000p 0.9
+ 1738010p -0.3
+ 1740000p -0.3
+ 1740010p 0.9
+ 1742000p 0.9
+ 1742010p -0.3
+ 1744000p -0.3
+ 1744010p 0.9
+ 1746000p 0.9
+ 1746010p -0.3
+ 1748000p -0.3
+ 1748010p 0.9
+ 1750000p 0.9
+ 1750010p -0.3
+ 1752000p -0.3
+ 1752010p 0.9
+ 1754000p 0.9
+ 1754010p -0.3
+ 1756000p -0.3
+ 1756010p 0.9
+ 1758000p 0.9
+ 1758010p -0.3
+ 1760000p -0.3
+ 1760010p 0.9
+ 1762000p 0.9
+ 1762010p -0.3
+ 1764000p -0.3
+ 1764010p 0.9
+ 1766000p 0.9
+ 1766010p -0.3
+ 1768000p -0.3
+ 1768010p 0.9
+ 1770000p 0.9
+ 1770010p -0.3
+ 1772000p -0.3
+ 1772010p 0.9
+ 1774000p 0.9
+ 1774010p -0.3
+ 1776000p -0.3
+ 1776010p 0.9
+ 1778000p 0.9
+ 1778010p -0.3
+ 1780000p -0.3
+ 1780010p 0.9
+ 1782000p 0.9
+ 1782010p -0.3
+ 1784000p -0.3
+ 1784010p 0.9
+ 1786000p 0.9
+ 1786010p -0.3
+ 1788000p -0.3
+ 1788010p 0.9
+ 1790000p 0.9
+ 1790010p -0.3
+ 1792000p -0.3
+ 1792010p 0.9
+ 1794000p 0.9
+ 1794010p -0.3
+ 1796000p -0.3
+ 1796010p 0.9
+ 1798000p 0.9
+ 1798010p -0.3
+ 1800000p -0.3
+ 1800010p 0.9
+ 1802000p 0.9
+ 1802010p -0.3
+ 1804000p -0.3
+ 1804010p 0.9
+ 1806000p 0.9
+ 1806010p -0.3
+ 1808000p -0.3
+ 1808010p 0.9
+ 1810000p 0.9
+ 1810010p -0.3
+ 1812000p -0.3
+ 1812010p 0.9
+ 1814000p 0.9
+ 1814010p -0.3
+ 1816000p -0.3
+ 1816010p 0.9
+ 1818000p 0.9
+ 1818010p -0.3
+ 1820000p -0.3
+ 1820010p 0.9
+ 1822000p 0.9
+ 1822010p -0.3
+ 1824000p -0.3
+ 1824010p 0.9
+ 1826000p 0.9
+ 1826010p -0.3
+ 1828000p -0.3
+ 1828010p 0.9
+ 1830000p 0.9
+ 1830010p -0.3
+ 1832000p -0.3
+ 1832010p 0.9
+ 1834000p 0.9
+ 1834010p -0.3
+ 1836000p -0.3
+ 1836010p 0.9
+ 1838000p 0.9
+ 1838010p -0.3
+ 1840000p -0.3
+ 1840010p 0.9
+ 1842000p 0.9
+ 1842010p -0.3
+ 1844000p -0.3
+ 1844010p 0.9
+ 1846000p 0.9
+ 1846010p -0.3
+ 1848000p -0.3
+ 1848010p 0.9
+ 1850000p 0.9
+ 1850010p -0.3
+ 1852000p -0.3
+ 1852010p 0.9
+ 1854000p 0.9
+ 1854010p -0.3
+ 1856000p -0.3
+ 1856010p 0.9
+ 1858000p 0.9
+ 1858010p -0.3
+ 1860000p -0.3
+ 1860010p 0.9
+ 1862000p 0.9
+ 1862010p -0.3
+ 1864000p -0.3
+ 1864010p 0.9
+ 1866000p 0.9
+ 1866010p -0.3
+ 1868000p -0.3
+ 1868010p 0.9
+ 1870000p 0.9
+ 1870010p -0.3
+ 1872000p -0.3
+ 1872010p 0.9
+ 1874000p 0.9
+ 1874010p -0.3
+ 1876000p -0.3
+ 1876010p 0.9
+ 1878000p 0.9
+ 1878010p -0.3
+ 1880000p -0.3
+ 1880010p 0.9
+ 1882000p 0.9
+ 1882010p -0.3
+ 1884000p -0.3
+ 1884010p 0.9
+ 1886000p 0.9
+ 1886010p -0.3
+ 1888000p -0.3
+ 1888010p 0.9
+ 1890000p 0.9
+ 1890010p -0.3
+ 1892000p -0.3
+ 1892010p 0.9
+ 1894000p 0.9
+ 1894010p -0.3
+ 1896000p -0.3
+ 1896010p 0.9
+ 1898000p 0.9
+ 1898010p -0.3
+ 1900000p -0.3
+ 1900010p 0.9
+ 1902000p 0.9
+ 1902010p -0.3
+ 1904000p -0.3
+ 1904010p 0.9
+ 1906000p 0.9
+ 1906010p -0.3
+ 1908000p -0.3
+ 1908010p 0.9
+ 1910000p 0.9
+ 1910010p -0.3
+ 1912000p -0.3
+ 1912010p 0.9
+ 1914000p 0.9
+ 1914010p -0.3
+ 1916000p -0.3
+ 1916010p 0.9
+ 1918000p 0.9
+ 1918010p -0.3
+ 1920000p -0.3
+ 1920010p 0.9
+ 1922000p 0.9
+ 1922010p -0.3
+ 1924000p -0.3
+ 1924010p 0.9
+ 1926000p 0.9
+ 1926010p -0.3
+ 1928000p -0.3
+ 1928010p 0.9
+ 1930000p 0.9
+ 1930010p -0.3
+ 1932000p -0.3
+ 1932010p 0.9
+ 1934000p 0.9
+ 1934010p -0.3
+ 1936000p -0.3
+ 1936010p 0.9
+ 1938000p 0.9
+ 1938010p -0.3
+ 1940000p -0.3
+ 1940010p 0.9
+ 1942000p 0.9
+ 1942010p -0.3
+ 1944000p -0.3
+ 1944010p 0.9
+ 1946000p 0.9
+ 1946010p -0.3
+ 1948000p -0.3
+ 1948010p 0.9
+ 1950000p 0.9
+ 1950010p -0.3
+ 1952000p -0.3
+ 1952010p 0.9
+ 1954000p 0.9
+ 1954010p -0.3
+ 1956000p -0.3
+ 1956010p 0.9
+ 1958000p 0.9
+ 1958010p -0.3
+ 1960000p -0.3
+ 1960010p 0.9
+ 1962000p 0.9
+ 1962010p -0.3
+ 1964000p -0.3
+ 1964010p 0.9
+ 1966000p 0.9
+ 1966010p -0.3
+ 1968000p -0.3
+ 1968010p 0.9
+ 1970000p 0.9
+ 1970010p -0.3
+ 1972000p -0.3
+ 1972010p 0.9
+ 1974000p 0.9
+ 1974010p -0.3
+ 1976000p -0.3
+ 1976010p 0.9
+ 1978000p 0.9
+ 1978010p -0.3
+ 1980000p -0.3
+ 1980010p 0.9
+ 1982000p 0.9
+ 1982010p -0.3
+ 1984000p -0.3
+ 1984010p 0.9
+ 1986000p 0.9
+ 1986010p -0.3
+ 1988000p -0.3
+ 1988010p 0.9
+ 1990000p 0.9
+ 1990010p -0.3
+ 1992000p -0.3
+ 1992010p 0.9
+ 1994000p 0.9
+ 1994010p -0.3
+ 1996000p -0.3
+ 1996010p 0.9
+ 1998000p 0.9
+ 1998010p -0.3
+ 2000000p -0.3
+ 2000010p 0.9
+ 2002000p 0.9
+ 2002010p -0.3
+ 2004000p -0.3
+ 2004010p 0.9
+ 2006000p 0.9
+ 2006010p -0.3
+ 2008000p -0.3
+ 2008010p 0.9
+ 2010000p 0.9
+ 2010010p -0.3
+ 2012000p -0.3
+ 2012010p 0.9
+ 2014000p 0.9
+ 2014010p -0.3
+ 2016000p -0.3
+ 2016010p 0.9
+ 2018000p 0.9
+ 2018010p -0.3
+ 2020000p -0.3
+ 2020010p 0.9
+ 2022000p 0.9
+ 2022010p -0.3
+ 2024000p -0.3
+ 2024010p 0.9
+ 2026000p 0.9
+ 2026010p -0.3
+ 2028000p -0.3
+ 2028010p 0.9
+ 2030000p 0.9
+ 2030010p -0.3
+ 2032000p -0.3
+ 2032010p 0.9
+ 2034000p 0.9
+ 2034010p -0.3
+ 2036000p -0.3
+ 2036010p 0.9
+ 2038000p 0.9
+ 2038010p -0.3
+ 2040000p -0.3
+ 2040010p 0.9
+ 2042000p 0.9
+ 2042010p -0.3
+ 2044000p -0.3
+ 2044010p 0.9
+ 2046000p 0.9
+ 2046010p -0.3
+ 2048000p -0.3
+ 2048010p 0.9
+ \]
V_data_bar_22 (Data_bar\\<22\\> gnd!) vsource type=pwl wave=\[
+ 0    -0.3
+ 2000p -0.3
+ 2010p 0.9
+ 4000p 0.9
+ 4010p -0.3
+ 6000p -0.3
+ 6010p 0.9
+ 8000p 0.9
+ 8010p -0.3
+ 10000p -0.3
+ 10010p 0.9
+ 12000p 0.9
+ 12010p -0.3
+ 14000p -0.3
+ 14010p 0.9
+ 16000p 0.9
+ 16010p -0.3
+ 18000p -0.3
+ 18010p 0.9
+ 20000p 0.9
+ 20010p -0.3
+ 22000p -0.3
+ 22010p 0.9
+ 24000p 0.9
+ 24010p -0.3
+ 26000p -0.3
+ 26010p 0.9
+ 28000p 0.9
+ 28010p -0.3
+ 30000p -0.3
+ 30010p 0.9
+ 32000p 0.9
+ 32010p -0.3
+ 34000p -0.3
+ 34010p 0.9
+ 36000p 0.9
+ 36010p -0.3
+ 38000p -0.3
+ 38010p 0.9
+ 40000p 0.9
+ 40010p -0.3
+ 42000p -0.3
+ 42010p 0.9
+ 44000p 0.9
+ 44010p -0.3
+ 46000p -0.3
+ 46010p 0.9
+ 48000p 0.9
+ 48010p -0.3
+ 50000p -0.3
+ 50010p 0.9
+ 52000p 0.9
+ 52010p -0.3
+ 54000p -0.3
+ 54010p 0.9
+ 56000p 0.9
+ 56010p -0.3
+ 58000p -0.3
+ 58010p 0.9
+ 60000p 0.9
+ 60010p -0.3
+ 62000p -0.3
+ 62010p 0.9
+ 64000p 0.9
+ 64010p -0.3
+ 66000p -0.3
+ 66010p 0.9
+ 68000p 0.9
+ 68010p -0.3
+ 70000p -0.3
+ 70010p 0.9
+ 72000p 0.9
+ 72010p -0.3
+ 74000p -0.3
+ 74010p 0.9
+ 76000p 0.9
+ 76010p -0.3
+ 78000p -0.3
+ 78010p 0.9
+ 80000p 0.9
+ 80010p -0.3
+ 82000p -0.3
+ 82010p 0.9
+ 84000p 0.9
+ 84010p -0.3
+ 86000p -0.3
+ 86010p 0.9
+ 88000p 0.9
+ 88010p -0.3
+ 90000p -0.3
+ 90010p 0.9
+ 92000p 0.9
+ 92010p -0.3
+ 94000p -0.3
+ 94010p 0.9
+ 96000p 0.9
+ 96010p -0.3
+ 98000p -0.3
+ 98010p 0.9
+ 100000p 0.9
+ 100010p -0.3
+ 102000p -0.3
+ 102010p 0.9
+ 104000p 0.9
+ 104010p -0.3
+ 106000p -0.3
+ 106010p 0.9
+ 108000p 0.9
+ 108010p -0.3
+ 110000p -0.3
+ 110010p 0.9
+ 112000p 0.9
+ 112010p -0.3
+ 114000p -0.3
+ 114010p 0.9
+ 116000p 0.9
+ 116010p -0.3
+ 118000p -0.3
+ 118010p 0.9
+ 120000p 0.9
+ 120010p -0.3
+ 122000p -0.3
+ 122010p 0.9
+ 124000p 0.9
+ 124010p -0.3
+ 126000p -0.3
+ 126010p 0.9
+ 128000p 0.9
+ 128010p -0.3
+ 130000p -0.3
+ 130010p 0.9
+ 132000p 0.9
+ 132010p -0.3
+ 134000p -0.3
+ 134010p 0.9
+ 136000p 0.9
+ 136010p -0.3
+ 138000p -0.3
+ 138010p 0.9
+ 140000p 0.9
+ 140010p -0.3
+ 142000p -0.3
+ 142010p 0.9
+ 144000p 0.9
+ 144010p -0.3
+ 146000p -0.3
+ 146010p 0.9
+ 148000p 0.9
+ 148010p -0.3
+ 150000p -0.3
+ 150010p 0.9
+ 152000p 0.9
+ 152010p -0.3
+ 154000p -0.3
+ 154010p 0.9
+ 156000p 0.9
+ 156010p -0.3
+ 158000p -0.3
+ 158010p 0.9
+ 160000p 0.9
+ 160010p -0.3
+ 162000p -0.3
+ 162010p 0.9
+ 164000p 0.9
+ 164010p -0.3
+ 166000p -0.3
+ 166010p 0.9
+ 168000p 0.9
+ 168010p -0.3
+ 170000p -0.3
+ 170010p 0.9
+ 172000p 0.9
+ 172010p -0.3
+ 174000p -0.3
+ 174010p 0.9
+ 176000p 0.9
+ 176010p -0.3
+ 178000p -0.3
+ 178010p 0.9
+ 180000p 0.9
+ 180010p -0.3
+ 182000p -0.3
+ 182010p 0.9
+ 184000p 0.9
+ 184010p -0.3
+ 186000p -0.3
+ 186010p 0.9
+ 188000p 0.9
+ 188010p -0.3
+ 190000p -0.3
+ 190010p 0.9
+ 192000p 0.9
+ 192010p -0.3
+ 194000p -0.3
+ 194010p 0.9
+ 196000p 0.9
+ 196010p -0.3
+ 198000p -0.3
+ 198010p 0.9
+ 200000p 0.9
+ 200010p -0.3
+ 202000p -0.3
+ 202010p 0.9
+ 204000p 0.9
+ 204010p -0.3
+ 206000p -0.3
+ 206010p 0.9
+ 208000p 0.9
+ 208010p -0.3
+ 210000p -0.3
+ 210010p 0.9
+ 212000p 0.9
+ 212010p -0.3
+ 214000p -0.3
+ 214010p 0.9
+ 216000p 0.9
+ 216010p -0.3
+ 218000p -0.3
+ 218010p 0.9
+ 220000p 0.9
+ 220010p -0.3
+ 222000p -0.3
+ 222010p 0.9
+ 224000p 0.9
+ 224010p -0.3
+ 226000p -0.3
+ 226010p 0.9
+ 228000p 0.9
+ 228010p -0.3
+ 230000p -0.3
+ 230010p 0.9
+ 232000p 0.9
+ 232010p -0.3
+ 234000p -0.3
+ 234010p 0.9
+ 236000p 0.9
+ 236010p -0.3
+ 238000p -0.3
+ 238010p 0.9
+ 240000p 0.9
+ 240010p -0.3
+ 242000p -0.3
+ 242010p 0.9
+ 244000p 0.9
+ 244010p -0.3
+ 246000p -0.3
+ 246010p 0.9
+ 248000p 0.9
+ 248010p -0.3
+ 250000p -0.3
+ 250010p 0.9
+ 252000p 0.9
+ 252010p -0.3
+ 254000p -0.3
+ 254010p 0.9
+ 256000p 0.9
+ 256010p -0.3
+ 258000p -0.3
+ 258010p 0.9
+ 260000p 0.9
+ 260010p -0.3
+ 262000p -0.3
+ 262010p 0.9
+ 264000p 0.9
+ 264010p -0.3
+ 266000p -0.3
+ 266010p 0.9
+ 268000p 0.9
+ 268010p -0.3
+ 270000p -0.3
+ 270010p 0.9
+ 272000p 0.9
+ 272010p -0.3
+ 274000p -0.3
+ 274010p 0.9
+ 276000p 0.9
+ 276010p -0.3
+ 278000p -0.3
+ 278010p 0.9
+ 280000p 0.9
+ 280010p -0.3
+ 282000p -0.3
+ 282010p 0.9
+ 284000p 0.9
+ 284010p -0.3
+ 286000p -0.3
+ 286010p 0.9
+ 288000p 0.9
+ 288010p -0.3
+ 290000p -0.3
+ 290010p 0.9
+ 292000p 0.9
+ 292010p -0.3
+ 294000p -0.3
+ 294010p 0.9
+ 296000p 0.9
+ 296010p -0.3
+ 298000p -0.3
+ 298010p 0.9
+ 300000p 0.9
+ 300010p -0.3
+ 302000p -0.3
+ 302010p 0.9
+ 304000p 0.9
+ 304010p -0.3
+ 306000p -0.3
+ 306010p 0.9
+ 308000p 0.9
+ 308010p -0.3
+ 310000p -0.3
+ 310010p 0.9
+ 312000p 0.9
+ 312010p -0.3
+ 314000p -0.3
+ 314010p 0.9
+ 316000p 0.9
+ 316010p -0.3
+ 318000p -0.3
+ 318010p 0.9
+ 320000p 0.9
+ 320010p -0.3
+ 322000p -0.3
+ 322010p 0.9
+ 324000p 0.9
+ 324010p -0.3
+ 326000p -0.3
+ 326010p 0.9
+ 328000p 0.9
+ 328010p -0.3
+ 330000p -0.3
+ 330010p 0.9
+ 332000p 0.9
+ 332010p -0.3
+ 334000p -0.3
+ 334010p 0.9
+ 336000p 0.9
+ 336010p -0.3
+ 338000p -0.3
+ 338010p 0.9
+ 340000p 0.9
+ 340010p -0.3
+ 342000p -0.3
+ 342010p 0.9
+ 344000p 0.9
+ 344010p -0.3
+ 346000p -0.3
+ 346010p 0.9
+ 348000p 0.9
+ 348010p -0.3
+ 350000p -0.3
+ 350010p 0.9
+ 352000p 0.9
+ 352010p -0.3
+ 354000p -0.3
+ 354010p 0.9
+ 356000p 0.9
+ 356010p -0.3
+ 358000p -0.3
+ 358010p 0.9
+ 360000p 0.9
+ 360010p -0.3
+ 362000p -0.3
+ 362010p 0.9
+ 364000p 0.9
+ 364010p -0.3
+ 366000p -0.3
+ 366010p 0.9
+ 368000p 0.9
+ 368010p -0.3
+ 370000p -0.3
+ 370010p 0.9
+ 372000p 0.9
+ 372010p -0.3
+ 374000p -0.3
+ 374010p 0.9
+ 376000p 0.9
+ 376010p -0.3
+ 378000p -0.3
+ 378010p 0.9
+ 380000p 0.9
+ 380010p -0.3
+ 382000p -0.3
+ 382010p 0.9
+ 384000p 0.9
+ 384010p -0.3
+ 386000p -0.3
+ 386010p 0.9
+ 388000p 0.9
+ 388010p -0.3
+ 390000p -0.3
+ 390010p 0.9
+ 392000p 0.9
+ 392010p -0.3
+ 394000p -0.3
+ 394010p 0.9
+ 396000p 0.9
+ 396010p -0.3
+ 398000p -0.3
+ 398010p 0.9
+ 400000p 0.9
+ 400010p -0.3
+ 402000p -0.3
+ 402010p 0.9
+ 404000p 0.9
+ 404010p -0.3
+ 406000p -0.3
+ 406010p 0.9
+ 408000p 0.9
+ 408010p -0.3
+ 410000p -0.3
+ 410010p 0.9
+ 412000p 0.9
+ 412010p -0.3
+ 414000p -0.3
+ 414010p 0.9
+ 416000p 0.9
+ 416010p -0.3
+ 418000p -0.3
+ 418010p 0.9
+ 420000p 0.9
+ 420010p -0.3
+ 422000p -0.3
+ 422010p 0.9
+ 424000p 0.9
+ 424010p -0.3
+ 426000p -0.3
+ 426010p 0.9
+ 428000p 0.9
+ 428010p -0.3
+ 430000p -0.3
+ 430010p 0.9
+ 432000p 0.9
+ 432010p -0.3
+ 434000p -0.3
+ 434010p 0.9
+ 436000p 0.9
+ 436010p -0.3
+ 438000p -0.3
+ 438010p 0.9
+ 440000p 0.9
+ 440010p -0.3
+ 442000p -0.3
+ 442010p 0.9
+ 444000p 0.9
+ 444010p -0.3
+ 446000p -0.3
+ 446010p 0.9
+ 448000p 0.9
+ 448010p -0.3
+ 450000p -0.3
+ 450010p 0.9
+ 452000p 0.9
+ 452010p -0.3
+ 454000p -0.3
+ 454010p 0.9
+ 456000p 0.9
+ 456010p -0.3
+ 458000p -0.3
+ 458010p 0.9
+ 460000p 0.9
+ 460010p -0.3
+ 462000p -0.3
+ 462010p 0.9
+ 464000p 0.9
+ 464010p -0.3
+ 466000p -0.3
+ 466010p 0.9
+ 468000p 0.9
+ 468010p -0.3
+ 470000p -0.3
+ 470010p 0.9
+ 472000p 0.9
+ 472010p -0.3
+ 474000p -0.3
+ 474010p 0.9
+ 476000p 0.9
+ 476010p -0.3
+ 478000p -0.3
+ 478010p 0.9
+ 480000p 0.9
+ 480010p -0.3
+ 482000p -0.3
+ 482010p 0.9
+ 484000p 0.9
+ 484010p -0.3
+ 486000p -0.3
+ 486010p 0.9
+ 488000p 0.9
+ 488010p -0.3
+ 490000p -0.3
+ 490010p 0.9
+ 492000p 0.9
+ 492010p -0.3
+ 494000p -0.3
+ 494010p 0.9
+ 496000p 0.9
+ 496010p -0.3
+ 498000p -0.3
+ 498010p 0.9
+ 500000p 0.9
+ 500010p -0.3
+ 502000p -0.3
+ 502010p 0.9
+ 504000p 0.9
+ 504010p -0.3
+ 506000p -0.3
+ 506010p 0.9
+ 508000p 0.9
+ 508010p -0.3
+ 510000p -0.3
+ 510010p 0.9
+ 512000p 0.9
+ 512010p -0.3
+ 514000p -0.3
+ 514010p 0.9
+ 516000p 0.9
+ 516010p -0.3
+ 518000p -0.3
+ 518010p 0.9
+ 520000p 0.9
+ 520010p -0.3
+ 522000p -0.3
+ 522010p 0.9
+ 524000p 0.9
+ 524010p -0.3
+ 526000p -0.3
+ 526010p 0.9
+ 528000p 0.9
+ 528010p -0.3
+ 530000p -0.3
+ 530010p 0.9
+ 532000p 0.9
+ 532010p -0.3
+ 534000p -0.3
+ 534010p 0.9
+ 536000p 0.9
+ 536010p -0.3
+ 538000p -0.3
+ 538010p 0.9
+ 540000p 0.9
+ 540010p -0.3
+ 542000p -0.3
+ 542010p 0.9
+ 544000p 0.9
+ 544010p -0.3
+ 546000p -0.3
+ 546010p 0.9
+ 548000p 0.9
+ 548010p -0.3
+ 550000p -0.3
+ 550010p 0.9
+ 552000p 0.9
+ 552010p -0.3
+ 554000p -0.3
+ 554010p 0.9
+ 556000p 0.9
+ 556010p -0.3
+ 558000p -0.3
+ 558010p 0.9
+ 560000p 0.9
+ 560010p -0.3
+ 562000p -0.3
+ 562010p 0.9
+ 564000p 0.9
+ 564010p -0.3
+ 566000p -0.3
+ 566010p 0.9
+ 568000p 0.9
+ 568010p -0.3
+ 570000p -0.3
+ 570010p 0.9
+ 572000p 0.9
+ 572010p -0.3
+ 574000p -0.3
+ 574010p 0.9
+ 576000p 0.9
+ 576010p -0.3
+ 578000p -0.3
+ 578010p 0.9
+ 580000p 0.9
+ 580010p -0.3
+ 582000p -0.3
+ 582010p 0.9
+ 584000p 0.9
+ 584010p -0.3
+ 586000p -0.3
+ 586010p 0.9
+ 588000p 0.9
+ 588010p -0.3
+ 590000p -0.3
+ 590010p 0.9
+ 592000p 0.9
+ 592010p -0.3
+ 594000p -0.3
+ 594010p 0.9
+ 596000p 0.9
+ 596010p -0.3
+ 598000p -0.3
+ 598010p 0.9
+ 600000p 0.9
+ 600010p -0.3
+ 602000p -0.3
+ 602010p 0.9
+ 604000p 0.9
+ 604010p -0.3
+ 606000p -0.3
+ 606010p 0.9
+ 608000p 0.9
+ 608010p -0.3
+ 610000p -0.3
+ 610010p 0.9
+ 612000p 0.9
+ 612010p -0.3
+ 614000p -0.3
+ 614010p 0.9
+ 616000p 0.9
+ 616010p -0.3
+ 618000p -0.3
+ 618010p 0.9
+ 620000p 0.9
+ 620010p -0.3
+ 622000p -0.3
+ 622010p 0.9
+ 624000p 0.9
+ 624010p -0.3
+ 626000p -0.3
+ 626010p 0.9
+ 628000p 0.9
+ 628010p -0.3
+ 630000p -0.3
+ 630010p 0.9
+ 632000p 0.9
+ 632010p -0.3
+ 634000p -0.3
+ 634010p 0.9
+ 636000p 0.9
+ 636010p -0.3
+ 638000p -0.3
+ 638010p 0.9
+ 640000p 0.9
+ 640010p -0.3
+ 642000p -0.3
+ 642010p 0.9
+ 644000p 0.9
+ 644010p -0.3
+ 646000p -0.3
+ 646010p 0.9
+ 648000p 0.9
+ 648010p -0.3
+ 650000p -0.3
+ 650010p 0.9
+ 652000p 0.9
+ 652010p -0.3
+ 654000p -0.3
+ 654010p 0.9
+ 656000p 0.9
+ 656010p -0.3
+ 658000p -0.3
+ 658010p 0.9
+ 660000p 0.9
+ 660010p -0.3
+ 662000p -0.3
+ 662010p 0.9
+ 664000p 0.9
+ 664010p -0.3
+ 666000p -0.3
+ 666010p 0.9
+ 668000p 0.9
+ 668010p -0.3
+ 670000p -0.3
+ 670010p 0.9
+ 672000p 0.9
+ 672010p -0.3
+ 674000p -0.3
+ 674010p 0.9
+ 676000p 0.9
+ 676010p -0.3
+ 678000p -0.3
+ 678010p 0.9
+ 680000p 0.9
+ 680010p -0.3
+ 682000p -0.3
+ 682010p 0.9
+ 684000p 0.9
+ 684010p -0.3
+ 686000p -0.3
+ 686010p 0.9
+ 688000p 0.9
+ 688010p -0.3
+ 690000p -0.3
+ 690010p 0.9
+ 692000p 0.9
+ 692010p -0.3
+ 694000p -0.3
+ 694010p 0.9
+ 696000p 0.9
+ 696010p -0.3
+ 698000p -0.3
+ 698010p 0.9
+ 700000p 0.9
+ 700010p -0.3
+ 702000p -0.3
+ 702010p 0.9
+ 704000p 0.9
+ 704010p -0.3
+ 706000p -0.3
+ 706010p 0.9
+ 708000p 0.9
+ 708010p -0.3
+ 710000p -0.3
+ 710010p 0.9
+ 712000p 0.9
+ 712010p -0.3
+ 714000p -0.3
+ 714010p 0.9
+ 716000p 0.9
+ 716010p -0.3
+ 718000p -0.3
+ 718010p 0.9
+ 720000p 0.9
+ 720010p -0.3
+ 722000p -0.3
+ 722010p 0.9
+ 724000p 0.9
+ 724010p -0.3
+ 726000p -0.3
+ 726010p 0.9
+ 728000p 0.9
+ 728010p -0.3
+ 730000p -0.3
+ 730010p 0.9
+ 732000p 0.9
+ 732010p -0.3
+ 734000p -0.3
+ 734010p 0.9
+ 736000p 0.9
+ 736010p -0.3
+ 738000p -0.3
+ 738010p 0.9
+ 740000p 0.9
+ 740010p -0.3
+ 742000p -0.3
+ 742010p 0.9
+ 744000p 0.9
+ 744010p -0.3
+ 746000p -0.3
+ 746010p 0.9
+ 748000p 0.9
+ 748010p -0.3
+ 750000p -0.3
+ 750010p 0.9
+ 752000p 0.9
+ 752010p -0.3
+ 754000p -0.3
+ 754010p 0.9
+ 756000p 0.9
+ 756010p -0.3
+ 758000p -0.3
+ 758010p 0.9
+ 760000p 0.9
+ 760010p -0.3
+ 762000p -0.3
+ 762010p 0.9
+ 764000p 0.9
+ 764010p -0.3
+ 766000p -0.3
+ 766010p 0.9
+ 768000p 0.9
+ 768010p -0.3
+ 770000p -0.3
+ 770010p 0.9
+ 772000p 0.9
+ 772010p -0.3
+ 774000p -0.3
+ 774010p 0.9
+ 776000p 0.9
+ 776010p -0.3
+ 778000p -0.3
+ 778010p 0.9
+ 780000p 0.9
+ 780010p -0.3
+ 782000p -0.3
+ 782010p 0.9
+ 784000p 0.9
+ 784010p -0.3
+ 786000p -0.3
+ 786010p 0.9
+ 788000p 0.9
+ 788010p -0.3
+ 790000p -0.3
+ 790010p 0.9
+ 792000p 0.9
+ 792010p -0.3
+ 794000p -0.3
+ 794010p 0.9
+ 796000p 0.9
+ 796010p -0.3
+ 798000p -0.3
+ 798010p 0.9
+ 800000p 0.9
+ 800010p -0.3
+ 802000p -0.3
+ 802010p 0.9
+ 804000p 0.9
+ 804010p -0.3
+ 806000p -0.3
+ 806010p 0.9
+ 808000p 0.9
+ 808010p -0.3
+ 810000p -0.3
+ 810010p 0.9
+ 812000p 0.9
+ 812010p -0.3
+ 814000p -0.3
+ 814010p 0.9
+ 816000p 0.9
+ 816010p -0.3
+ 818000p -0.3
+ 818010p 0.9
+ 820000p 0.9
+ 820010p -0.3
+ 822000p -0.3
+ 822010p 0.9
+ 824000p 0.9
+ 824010p -0.3
+ 826000p -0.3
+ 826010p 0.9
+ 828000p 0.9
+ 828010p -0.3
+ 830000p -0.3
+ 830010p 0.9
+ 832000p 0.9
+ 832010p -0.3
+ 834000p -0.3
+ 834010p 0.9
+ 836000p 0.9
+ 836010p -0.3
+ 838000p -0.3
+ 838010p 0.9
+ 840000p 0.9
+ 840010p -0.3
+ 842000p -0.3
+ 842010p 0.9
+ 844000p 0.9
+ 844010p -0.3
+ 846000p -0.3
+ 846010p 0.9
+ 848000p 0.9
+ 848010p -0.3
+ 850000p -0.3
+ 850010p 0.9
+ 852000p 0.9
+ 852010p -0.3
+ 854000p -0.3
+ 854010p 0.9
+ 856000p 0.9
+ 856010p -0.3
+ 858000p -0.3
+ 858010p 0.9
+ 860000p 0.9
+ 860010p -0.3
+ 862000p -0.3
+ 862010p 0.9
+ 864000p 0.9
+ 864010p -0.3
+ 866000p -0.3
+ 866010p 0.9
+ 868000p 0.9
+ 868010p -0.3
+ 870000p -0.3
+ 870010p 0.9
+ 872000p 0.9
+ 872010p -0.3
+ 874000p -0.3
+ 874010p 0.9
+ 876000p 0.9
+ 876010p -0.3
+ 878000p -0.3
+ 878010p 0.9
+ 880000p 0.9
+ 880010p -0.3
+ 882000p -0.3
+ 882010p 0.9
+ 884000p 0.9
+ 884010p -0.3
+ 886000p -0.3
+ 886010p 0.9
+ 888000p 0.9
+ 888010p -0.3
+ 890000p -0.3
+ 890010p 0.9
+ 892000p 0.9
+ 892010p -0.3
+ 894000p -0.3
+ 894010p 0.9
+ 896000p 0.9
+ 896010p -0.3
+ 898000p -0.3
+ 898010p 0.9
+ 900000p 0.9
+ 900010p -0.3
+ 902000p -0.3
+ 902010p 0.9
+ 904000p 0.9
+ 904010p -0.3
+ 906000p -0.3
+ 906010p 0.9
+ 908000p 0.9
+ 908010p -0.3
+ 910000p -0.3
+ 910010p 0.9
+ 912000p 0.9
+ 912010p -0.3
+ 914000p -0.3
+ 914010p 0.9
+ 916000p 0.9
+ 916010p -0.3
+ 918000p -0.3
+ 918010p 0.9
+ 920000p 0.9
+ 920010p -0.3
+ 922000p -0.3
+ 922010p 0.9
+ 924000p 0.9
+ 924010p -0.3
+ 926000p -0.3
+ 926010p 0.9
+ 928000p 0.9
+ 928010p -0.3
+ 930000p -0.3
+ 930010p 0.9
+ 932000p 0.9
+ 932010p -0.3
+ 934000p -0.3
+ 934010p 0.9
+ 936000p 0.9
+ 936010p -0.3
+ 938000p -0.3
+ 938010p 0.9
+ 940000p 0.9
+ 940010p -0.3
+ 942000p -0.3
+ 942010p 0.9
+ 944000p 0.9
+ 944010p -0.3
+ 946000p -0.3
+ 946010p 0.9
+ 948000p 0.9
+ 948010p -0.3
+ 950000p -0.3
+ 950010p 0.9
+ 952000p 0.9
+ 952010p -0.3
+ 954000p -0.3
+ 954010p 0.9
+ 956000p 0.9
+ 956010p -0.3
+ 958000p -0.3
+ 958010p 0.9
+ 960000p 0.9
+ 960010p -0.3
+ 962000p -0.3
+ 962010p 0.9
+ 964000p 0.9
+ 964010p -0.3
+ 966000p -0.3
+ 966010p 0.9
+ 968000p 0.9
+ 968010p -0.3
+ 970000p -0.3
+ 970010p 0.9
+ 972000p 0.9
+ 972010p -0.3
+ 974000p -0.3
+ 974010p 0.9
+ 976000p 0.9
+ 976010p -0.3
+ 978000p -0.3
+ 978010p 0.9
+ 980000p 0.9
+ 980010p -0.3
+ 982000p -0.3
+ 982010p 0.9
+ 984000p 0.9
+ 984010p -0.3
+ 986000p -0.3
+ 986010p 0.9
+ 988000p 0.9
+ 988010p -0.3
+ 990000p -0.3
+ 990010p 0.9
+ 992000p 0.9
+ 992010p -0.3
+ 994000p -0.3
+ 994010p 0.9
+ 996000p 0.9
+ 996010p -0.3
+ 998000p -0.3
+ 998010p 0.9
+ 1000000p 0.9
+ 1000010p -0.3
+ 1002000p -0.3
+ 1002010p 0.9
+ 1004000p 0.9
+ 1004010p -0.3
+ 1006000p -0.3
+ 1006010p 0.9
+ 1008000p 0.9
+ 1008010p -0.3
+ 1010000p -0.3
+ 1010010p 0.9
+ 1012000p 0.9
+ 1012010p -0.3
+ 1014000p -0.3
+ 1014010p 0.9
+ 1016000p 0.9
+ 1016010p -0.3
+ 1018000p -0.3
+ 1018010p 0.9
+ 1020000p 0.9
+ 1020010p -0.3
+ 1022000p -0.3
+ 1022010p 0.9
+ 1024000p 0.9
+ 1024010p -0.3
+ 1026000p -0.3
+ 1026010p 0.9
+ 1028000p 0.9
+ 1028010p -0.3
+ 1030000p -0.3
+ 1030010p 0.9
+ 1032000p 0.9
+ 1032010p -0.3
+ 1034000p -0.3
+ 1034010p 0.9
+ 1036000p 0.9
+ 1036010p -0.3
+ 1038000p -0.3
+ 1038010p 0.9
+ 1040000p 0.9
+ 1040010p -0.3
+ 1042000p -0.3
+ 1042010p 0.9
+ 1044000p 0.9
+ 1044010p -0.3
+ 1046000p -0.3
+ 1046010p 0.9
+ 1048000p 0.9
+ 1048010p -0.3
+ 1050000p -0.3
+ 1050010p 0.9
+ 1052000p 0.9
+ 1052010p -0.3
+ 1054000p -0.3
+ 1054010p 0.9
+ 1056000p 0.9
+ 1056010p -0.3
+ 1058000p -0.3
+ 1058010p 0.9
+ 1060000p 0.9
+ 1060010p -0.3
+ 1062000p -0.3
+ 1062010p 0.9
+ 1064000p 0.9
+ 1064010p -0.3
+ 1066000p -0.3
+ 1066010p 0.9
+ 1068000p 0.9
+ 1068010p -0.3
+ 1070000p -0.3
+ 1070010p 0.9
+ 1072000p 0.9
+ 1072010p -0.3
+ 1074000p -0.3
+ 1074010p 0.9
+ 1076000p 0.9
+ 1076010p -0.3
+ 1078000p -0.3
+ 1078010p 0.9
+ 1080000p 0.9
+ 1080010p -0.3
+ 1082000p -0.3
+ 1082010p 0.9
+ 1084000p 0.9
+ 1084010p -0.3
+ 1086000p -0.3
+ 1086010p 0.9
+ 1088000p 0.9
+ 1088010p -0.3
+ 1090000p -0.3
+ 1090010p 0.9
+ 1092000p 0.9
+ 1092010p -0.3
+ 1094000p -0.3
+ 1094010p 0.9
+ 1096000p 0.9
+ 1096010p -0.3
+ 1098000p -0.3
+ 1098010p 0.9
+ 1100000p 0.9
+ 1100010p -0.3
+ 1102000p -0.3
+ 1102010p 0.9
+ 1104000p 0.9
+ 1104010p -0.3
+ 1106000p -0.3
+ 1106010p 0.9
+ 1108000p 0.9
+ 1108010p -0.3
+ 1110000p -0.3
+ 1110010p 0.9
+ 1112000p 0.9
+ 1112010p -0.3
+ 1114000p -0.3
+ 1114010p 0.9
+ 1116000p 0.9
+ 1116010p -0.3
+ 1118000p -0.3
+ 1118010p 0.9
+ 1120000p 0.9
+ 1120010p -0.3
+ 1122000p -0.3
+ 1122010p 0.9
+ 1124000p 0.9
+ 1124010p -0.3
+ 1126000p -0.3
+ 1126010p 0.9
+ 1128000p 0.9
+ 1128010p -0.3
+ 1130000p -0.3
+ 1130010p 0.9
+ 1132000p 0.9
+ 1132010p -0.3
+ 1134000p -0.3
+ 1134010p 0.9
+ 1136000p 0.9
+ 1136010p -0.3
+ 1138000p -0.3
+ 1138010p 0.9
+ 1140000p 0.9
+ 1140010p -0.3
+ 1142000p -0.3
+ 1142010p 0.9
+ 1144000p 0.9
+ 1144010p -0.3
+ 1146000p -0.3
+ 1146010p 0.9
+ 1148000p 0.9
+ 1148010p -0.3
+ 1150000p -0.3
+ 1150010p 0.9
+ 1152000p 0.9
+ 1152010p -0.3
+ 1154000p -0.3
+ 1154010p 0.9
+ 1156000p 0.9
+ 1156010p -0.3
+ 1158000p -0.3
+ 1158010p 0.9
+ 1160000p 0.9
+ 1160010p -0.3
+ 1162000p -0.3
+ 1162010p 0.9
+ 1164000p 0.9
+ 1164010p -0.3
+ 1166000p -0.3
+ 1166010p 0.9
+ 1168000p 0.9
+ 1168010p -0.3
+ 1170000p -0.3
+ 1170010p 0.9
+ 1172000p 0.9
+ 1172010p -0.3
+ 1174000p -0.3
+ 1174010p 0.9
+ 1176000p 0.9
+ 1176010p -0.3
+ 1178000p -0.3
+ 1178010p 0.9
+ 1180000p 0.9
+ 1180010p -0.3
+ 1182000p -0.3
+ 1182010p 0.9
+ 1184000p 0.9
+ 1184010p -0.3
+ 1186000p -0.3
+ 1186010p 0.9
+ 1188000p 0.9
+ 1188010p -0.3
+ 1190000p -0.3
+ 1190010p 0.9
+ 1192000p 0.9
+ 1192010p -0.3
+ 1194000p -0.3
+ 1194010p 0.9
+ 1196000p 0.9
+ 1196010p -0.3
+ 1198000p -0.3
+ 1198010p 0.9
+ 1200000p 0.9
+ 1200010p -0.3
+ 1202000p -0.3
+ 1202010p 0.9
+ 1204000p 0.9
+ 1204010p -0.3
+ 1206000p -0.3
+ 1206010p 0.9
+ 1208000p 0.9
+ 1208010p -0.3
+ 1210000p -0.3
+ 1210010p 0.9
+ 1212000p 0.9
+ 1212010p -0.3
+ 1214000p -0.3
+ 1214010p 0.9
+ 1216000p 0.9
+ 1216010p -0.3
+ 1218000p -0.3
+ 1218010p 0.9
+ 1220000p 0.9
+ 1220010p -0.3
+ 1222000p -0.3
+ 1222010p 0.9
+ 1224000p 0.9
+ 1224010p -0.3
+ 1226000p -0.3
+ 1226010p 0.9
+ 1228000p 0.9
+ 1228010p -0.3
+ 1230000p -0.3
+ 1230010p 0.9
+ 1232000p 0.9
+ 1232010p -0.3
+ 1234000p -0.3
+ 1234010p 0.9
+ 1236000p 0.9
+ 1236010p -0.3
+ 1238000p -0.3
+ 1238010p 0.9
+ 1240000p 0.9
+ 1240010p -0.3
+ 1242000p -0.3
+ 1242010p 0.9
+ 1244000p 0.9
+ 1244010p -0.3
+ 1246000p -0.3
+ 1246010p 0.9
+ 1248000p 0.9
+ 1248010p -0.3
+ 1250000p -0.3
+ 1250010p 0.9
+ 1252000p 0.9
+ 1252010p -0.3
+ 1254000p -0.3
+ 1254010p 0.9
+ 1256000p 0.9
+ 1256010p -0.3
+ 1258000p -0.3
+ 1258010p 0.9
+ 1260000p 0.9
+ 1260010p -0.3
+ 1262000p -0.3
+ 1262010p 0.9
+ 1264000p 0.9
+ 1264010p -0.3
+ 1266000p -0.3
+ 1266010p 0.9
+ 1268000p 0.9
+ 1268010p -0.3
+ 1270000p -0.3
+ 1270010p 0.9
+ 1272000p 0.9
+ 1272010p -0.3
+ 1274000p -0.3
+ 1274010p 0.9
+ 1276000p 0.9
+ 1276010p -0.3
+ 1278000p -0.3
+ 1278010p 0.9
+ 1280000p 0.9
+ 1280010p -0.3
+ 1282000p -0.3
+ 1282010p 0.9
+ 1284000p 0.9
+ 1284010p -0.3
+ 1286000p -0.3
+ 1286010p 0.9
+ 1288000p 0.9
+ 1288010p -0.3
+ 1290000p -0.3
+ 1290010p 0.9
+ 1292000p 0.9
+ 1292010p -0.3
+ 1294000p -0.3
+ 1294010p 0.9
+ 1296000p 0.9
+ 1296010p -0.3
+ 1298000p -0.3
+ 1298010p 0.9
+ 1300000p 0.9
+ 1300010p -0.3
+ 1302000p -0.3
+ 1302010p 0.9
+ 1304000p 0.9
+ 1304010p -0.3
+ 1306000p -0.3
+ 1306010p 0.9
+ 1308000p 0.9
+ 1308010p -0.3
+ 1310000p -0.3
+ 1310010p 0.9
+ 1312000p 0.9
+ 1312010p -0.3
+ 1314000p -0.3
+ 1314010p 0.9
+ 1316000p 0.9
+ 1316010p -0.3
+ 1318000p -0.3
+ 1318010p 0.9
+ 1320000p 0.9
+ 1320010p -0.3
+ 1322000p -0.3
+ 1322010p 0.9
+ 1324000p 0.9
+ 1324010p -0.3
+ 1326000p -0.3
+ 1326010p 0.9
+ 1328000p 0.9
+ 1328010p -0.3
+ 1330000p -0.3
+ 1330010p 0.9
+ 1332000p 0.9
+ 1332010p -0.3
+ 1334000p -0.3
+ 1334010p 0.9
+ 1336000p 0.9
+ 1336010p -0.3
+ 1338000p -0.3
+ 1338010p 0.9
+ 1340000p 0.9
+ 1340010p -0.3
+ 1342000p -0.3
+ 1342010p 0.9
+ 1344000p 0.9
+ 1344010p -0.3
+ 1346000p -0.3
+ 1346010p 0.9
+ 1348000p 0.9
+ 1348010p -0.3
+ 1350000p -0.3
+ 1350010p 0.9
+ 1352000p 0.9
+ 1352010p -0.3
+ 1354000p -0.3
+ 1354010p 0.9
+ 1356000p 0.9
+ 1356010p -0.3
+ 1358000p -0.3
+ 1358010p 0.9
+ 1360000p 0.9
+ 1360010p -0.3
+ 1362000p -0.3
+ 1362010p 0.9
+ 1364000p 0.9
+ 1364010p -0.3
+ 1366000p -0.3
+ 1366010p 0.9
+ 1368000p 0.9
+ 1368010p -0.3
+ 1370000p -0.3
+ 1370010p 0.9
+ 1372000p 0.9
+ 1372010p -0.3
+ 1374000p -0.3
+ 1374010p 0.9
+ 1376000p 0.9
+ 1376010p -0.3
+ 1378000p -0.3
+ 1378010p 0.9
+ 1380000p 0.9
+ 1380010p -0.3
+ 1382000p -0.3
+ 1382010p 0.9
+ 1384000p 0.9
+ 1384010p -0.3
+ 1386000p -0.3
+ 1386010p 0.9
+ 1388000p 0.9
+ 1388010p -0.3
+ 1390000p -0.3
+ 1390010p 0.9
+ 1392000p 0.9
+ 1392010p -0.3
+ 1394000p -0.3
+ 1394010p 0.9
+ 1396000p 0.9
+ 1396010p -0.3
+ 1398000p -0.3
+ 1398010p 0.9
+ 1400000p 0.9
+ 1400010p -0.3
+ 1402000p -0.3
+ 1402010p 0.9
+ 1404000p 0.9
+ 1404010p -0.3
+ 1406000p -0.3
+ 1406010p 0.9
+ 1408000p 0.9
+ 1408010p -0.3
+ 1410000p -0.3
+ 1410010p 0.9
+ 1412000p 0.9
+ 1412010p -0.3
+ 1414000p -0.3
+ 1414010p 0.9
+ 1416000p 0.9
+ 1416010p -0.3
+ 1418000p -0.3
+ 1418010p 0.9
+ 1420000p 0.9
+ 1420010p -0.3
+ 1422000p -0.3
+ 1422010p 0.9
+ 1424000p 0.9
+ 1424010p -0.3
+ 1426000p -0.3
+ 1426010p 0.9
+ 1428000p 0.9
+ 1428010p -0.3
+ 1430000p -0.3
+ 1430010p 0.9
+ 1432000p 0.9
+ 1432010p -0.3
+ 1434000p -0.3
+ 1434010p 0.9
+ 1436000p 0.9
+ 1436010p -0.3
+ 1438000p -0.3
+ 1438010p 0.9
+ 1440000p 0.9
+ 1440010p -0.3
+ 1442000p -0.3
+ 1442010p 0.9
+ 1444000p 0.9
+ 1444010p -0.3
+ 1446000p -0.3
+ 1446010p 0.9
+ 1448000p 0.9
+ 1448010p -0.3
+ 1450000p -0.3
+ 1450010p 0.9
+ 1452000p 0.9
+ 1452010p -0.3
+ 1454000p -0.3
+ 1454010p 0.9
+ 1456000p 0.9
+ 1456010p -0.3
+ 1458000p -0.3
+ 1458010p 0.9
+ 1460000p 0.9
+ 1460010p -0.3
+ 1462000p -0.3
+ 1462010p 0.9
+ 1464000p 0.9
+ 1464010p -0.3
+ 1466000p -0.3
+ 1466010p 0.9
+ 1468000p 0.9
+ 1468010p -0.3
+ 1470000p -0.3
+ 1470010p 0.9
+ 1472000p 0.9
+ 1472010p -0.3
+ 1474000p -0.3
+ 1474010p 0.9
+ 1476000p 0.9
+ 1476010p -0.3
+ 1478000p -0.3
+ 1478010p 0.9
+ 1480000p 0.9
+ 1480010p -0.3
+ 1482000p -0.3
+ 1482010p 0.9
+ 1484000p 0.9
+ 1484010p -0.3
+ 1486000p -0.3
+ 1486010p 0.9
+ 1488000p 0.9
+ 1488010p -0.3
+ 1490000p -0.3
+ 1490010p 0.9
+ 1492000p 0.9
+ 1492010p -0.3
+ 1494000p -0.3
+ 1494010p 0.9
+ 1496000p 0.9
+ 1496010p -0.3
+ 1498000p -0.3
+ 1498010p 0.9
+ 1500000p 0.9
+ 1500010p -0.3
+ 1502000p -0.3
+ 1502010p 0.9
+ 1504000p 0.9
+ 1504010p -0.3
+ 1506000p -0.3
+ 1506010p 0.9
+ 1508000p 0.9
+ 1508010p -0.3
+ 1510000p -0.3
+ 1510010p 0.9
+ 1512000p 0.9
+ 1512010p -0.3
+ 1514000p -0.3
+ 1514010p 0.9
+ 1516000p 0.9
+ 1516010p -0.3
+ 1518000p -0.3
+ 1518010p 0.9
+ 1520000p 0.9
+ 1520010p -0.3
+ 1522000p -0.3
+ 1522010p 0.9
+ 1524000p 0.9
+ 1524010p -0.3
+ 1526000p -0.3
+ 1526010p 0.9
+ 1528000p 0.9
+ 1528010p -0.3
+ 1530000p -0.3
+ 1530010p 0.9
+ 1532000p 0.9
+ 1532010p -0.3
+ 1534000p -0.3
+ 1534010p 0.9
+ 1536000p 0.9
+ 1536010p -0.3
+ 1538000p -0.3
+ 1538010p 0.9
+ 1540000p 0.9
+ 1540010p -0.3
+ 1542000p -0.3
+ 1542010p 0.9
+ 1544000p 0.9
+ 1544010p -0.3
+ 1546000p -0.3
+ 1546010p 0.9
+ 1548000p 0.9
+ 1548010p -0.3
+ 1550000p -0.3
+ 1550010p 0.9
+ 1552000p 0.9
+ 1552010p -0.3
+ 1554000p -0.3
+ 1554010p 0.9
+ 1556000p 0.9
+ 1556010p -0.3
+ 1558000p -0.3
+ 1558010p 0.9
+ 1560000p 0.9
+ 1560010p -0.3
+ 1562000p -0.3
+ 1562010p 0.9
+ 1564000p 0.9
+ 1564010p -0.3
+ 1566000p -0.3
+ 1566010p 0.9
+ 1568000p 0.9
+ 1568010p -0.3
+ 1570000p -0.3
+ 1570010p 0.9
+ 1572000p 0.9
+ 1572010p -0.3
+ 1574000p -0.3
+ 1574010p 0.9
+ 1576000p 0.9
+ 1576010p -0.3
+ 1578000p -0.3
+ 1578010p 0.9
+ 1580000p 0.9
+ 1580010p -0.3
+ 1582000p -0.3
+ 1582010p 0.9
+ 1584000p 0.9
+ 1584010p -0.3
+ 1586000p -0.3
+ 1586010p 0.9
+ 1588000p 0.9
+ 1588010p -0.3
+ 1590000p -0.3
+ 1590010p 0.9
+ 1592000p 0.9
+ 1592010p -0.3
+ 1594000p -0.3
+ 1594010p 0.9
+ 1596000p 0.9
+ 1596010p -0.3
+ 1598000p -0.3
+ 1598010p 0.9
+ 1600000p 0.9
+ 1600010p -0.3
+ 1602000p -0.3
+ 1602010p 0.9
+ 1604000p 0.9
+ 1604010p -0.3
+ 1606000p -0.3
+ 1606010p 0.9
+ 1608000p 0.9
+ 1608010p -0.3
+ 1610000p -0.3
+ 1610010p 0.9
+ 1612000p 0.9
+ 1612010p -0.3
+ 1614000p -0.3
+ 1614010p 0.9
+ 1616000p 0.9
+ 1616010p -0.3
+ 1618000p -0.3
+ 1618010p 0.9
+ 1620000p 0.9
+ 1620010p -0.3
+ 1622000p -0.3
+ 1622010p 0.9
+ 1624000p 0.9
+ 1624010p -0.3
+ 1626000p -0.3
+ 1626010p 0.9
+ 1628000p 0.9
+ 1628010p -0.3
+ 1630000p -0.3
+ 1630010p 0.9
+ 1632000p 0.9
+ 1632010p -0.3
+ 1634000p -0.3
+ 1634010p 0.9
+ 1636000p 0.9
+ 1636010p -0.3
+ 1638000p -0.3
+ 1638010p 0.9
+ 1640000p 0.9
+ 1640010p -0.3
+ 1642000p -0.3
+ 1642010p 0.9
+ 1644000p 0.9
+ 1644010p -0.3
+ 1646000p -0.3
+ 1646010p 0.9
+ 1648000p 0.9
+ 1648010p -0.3
+ 1650000p -0.3
+ 1650010p 0.9
+ 1652000p 0.9
+ 1652010p -0.3
+ 1654000p -0.3
+ 1654010p 0.9
+ 1656000p 0.9
+ 1656010p -0.3
+ 1658000p -0.3
+ 1658010p 0.9
+ 1660000p 0.9
+ 1660010p -0.3
+ 1662000p -0.3
+ 1662010p 0.9
+ 1664000p 0.9
+ 1664010p -0.3
+ 1666000p -0.3
+ 1666010p 0.9
+ 1668000p 0.9
+ 1668010p -0.3
+ 1670000p -0.3
+ 1670010p 0.9
+ 1672000p 0.9
+ 1672010p -0.3
+ 1674000p -0.3
+ 1674010p 0.9
+ 1676000p 0.9
+ 1676010p -0.3
+ 1678000p -0.3
+ 1678010p 0.9
+ 1680000p 0.9
+ 1680010p -0.3
+ 1682000p -0.3
+ 1682010p 0.9
+ 1684000p 0.9
+ 1684010p -0.3
+ 1686000p -0.3
+ 1686010p 0.9
+ 1688000p 0.9
+ 1688010p -0.3
+ 1690000p -0.3
+ 1690010p 0.9
+ 1692000p 0.9
+ 1692010p -0.3
+ 1694000p -0.3
+ 1694010p 0.9
+ 1696000p 0.9
+ 1696010p -0.3
+ 1698000p -0.3
+ 1698010p 0.9
+ 1700000p 0.9
+ 1700010p -0.3
+ 1702000p -0.3
+ 1702010p 0.9
+ 1704000p 0.9
+ 1704010p -0.3
+ 1706000p -0.3
+ 1706010p 0.9
+ 1708000p 0.9
+ 1708010p -0.3
+ 1710000p -0.3
+ 1710010p 0.9
+ 1712000p 0.9
+ 1712010p -0.3
+ 1714000p -0.3
+ 1714010p 0.9
+ 1716000p 0.9
+ 1716010p -0.3
+ 1718000p -0.3
+ 1718010p 0.9
+ 1720000p 0.9
+ 1720010p -0.3
+ 1722000p -0.3
+ 1722010p 0.9
+ 1724000p 0.9
+ 1724010p -0.3
+ 1726000p -0.3
+ 1726010p 0.9
+ 1728000p 0.9
+ 1728010p -0.3
+ 1730000p -0.3
+ 1730010p 0.9
+ 1732000p 0.9
+ 1732010p -0.3
+ 1734000p -0.3
+ 1734010p 0.9
+ 1736000p 0.9
+ 1736010p -0.3
+ 1738000p -0.3
+ 1738010p 0.9
+ 1740000p 0.9
+ 1740010p -0.3
+ 1742000p -0.3
+ 1742010p 0.9
+ 1744000p 0.9
+ 1744010p -0.3
+ 1746000p -0.3
+ 1746010p 0.9
+ 1748000p 0.9
+ 1748010p -0.3
+ 1750000p -0.3
+ 1750010p 0.9
+ 1752000p 0.9
+ 1752010p -0.3
+ 1754000p -0.3
+ 1754010p 0.9
+ 1756000p 0.9
+ 1756010p -0.3
+ 1758000p -0.3
+ 1758010p 0.9
+ 1760000p 0.9
+ 1760010p -0.3
+ 1762000p -0.3
+ 1762010p 0.9
+ 1764000p 0.9
+ 1764010p -0.3
+ 1766000p -0.3
+ 1766010p 0.9
+ 1768000p 0.9
+ 1768010p -0.3
+ 1770000p -0.3
+ 1770010p 0.9
+ 1772000p 0.9
+ 1772010p -0.3
+ 1774000p -0.3
+ 1774010p 0.9
+ 1776000p 0.9
+ 1776010p -0.3
+ 1778000p -0.3
+ 1778010p 0.9
+ 1780000p 0.9
+ 1780010p -0.3
+ 1782000p -0.3
+ 1782010p 0.9
+ 1784000p 0.9
+ 1784010p -0.3
+ 1786000p -0.3
+ 1786010p 0.9
+ 1788000p 0.9
+ 1788010p -0.3
+ 1790000p -0.3
+ 1790010p 0.9
+ 1792000p 0.9
+ 1792010p -0.3
+ 1794000p -0.3
+ 1794010p 0.9
+ 1796000p 0.9
+ 1796010p -0.3
+ 1798000p -0.3
+ 1798010p 0.9
+ 1800000p 0.9
+ 1800010p -0.3
+ 1802000p -0.3
+ 1802010p 0.9
+ 1804000p 0.9
+ 1804010p -0.3
+ 1806000p -0.3
+ 1806010p 0.9
+ 1808000p 0.9
+ 1808010p -0.3
+ 1810000p -0.3
+ 1810010p 0.9
+ 1812000p 0.9
+ 1812010p -0.3
+ 1814000p -0.3
+ 1814010p 0.9
+ 1816000p 0.9
+ 1816010p -0.3
+ 1818000p -0.3
+ 1818010p 0.9
+ 1820000p 0.9
+ 1820010p -0.3
+ 1822000p -0.3
+ 1822010p 0.9
+ 1824000p 0.9
+ 1824010p -0.3
+ 1826000p -0.3
+ 1826010p 0.9
+ 1828000p 0.9
+ 1828010p -0.3
+ 1830000p -0.3
+ 1830010p 0.9
+ 1832000p 0.9
+ 1832010p -0.3
+ 1834000p -0.3
+ 1834010p 0.9
+ 1836000p 0.9
+ 1836010p -0.3
+ 1838000p -0.3
+ 1838010p 0.9
+ 1840000p 0.9
+ 1840010p -0.3
+ 1842000p -0.3
+ 1842010p 0.9
+ 1844000p 0.9
+ 1844010p -0.3
+ 1846000p -0.3
+ 1846010p 0.9
+ 1848000p 0.9
+ 1848010p -0.3
+ 1850000p -0.3
+ 1850010p 0.9
+ 1852000p 0.9
+ 1852010p -0.3
+ 1854000p -0.3
+ 1854010p 0.9
+ 1856000p 0.9
+ 1856010p -0.3
+ 1858000p -0.3
+ 1858010p 0.9
+ 1860000p 0.9
+ 1860010p -0.3
+ 1862000p -0.3
+ 1862010p 0.9
+ 1864000p 0.9
+ 1864010p -0.3
+ 1866000p -0.3
+ 1866010p 0.9
+ 1868000p 0.9
+ 1868010p -0.3
+ 1870000p -0.3
+ 1870010p 0.9
+ 1872000p 0.9
+ 1872010p -0.3
+ 1874000p -0.3
+ 1874010p 0.9
+ 1876000p 0.9
+ 1876010p -0.3
+ 1878000p -0.3
+ 1878010p 0.9
+ 1880000p 0.9
+ 1880010p -0.3
+ 1882000p -0.3
+ 1882010p 0.9
+ 1884000p 0.9
+ 1884010p -0.3
+ 1886000p -0.3
+ 1886010p 0.9
+ 1888000p 0.9
+ 1888010p -0.3
+ 1890000p -0.3
+ 1890010p 0.9
+ 1892000p 0.9
+ 1892010p -0.3
+ 1894000p -0.3
+ 1894010p 0.9
+ 1896000p 0.9
+ 1896010p -0.3
+ 1898000p -0.3
+ 1898010p 0.9
+ 1900000p 0.9
+ 1900010p -0.3
+ 1902000p -0.3
+ 1902010p 0.9
+ 1904000p 0.9
+ 1904010p -0.3
+ 1906000p -0.3
+ 1906010p 0.9
+ 1908000p 0.9
+ 1908010p -0.3
+ 1910000p -0.3
+ 1910010p 0.9
+ 1912000p 0.9
+ 1912010p -0.3
+ 1914000p -0.3
+ 1914010p 0.9
+ 1916000p 0.9
+ 1916010p -0.3
+ 1918000p -0.3
+ 1918010p 0.9
+ 1920000p 0.9
+ 1920010p -0.3
+ 1922000p -0.3
+ 1922010p 0.9
+ 1924000p 0.9
+ 1924010p -0.3
+ 1926000p -0.3
+ 1926010p 0.9
+ 1928000p 0.9
+ 1928010p -0.3
+ 1930000p -0.3
+ 1930010p 0.9
+ 1932000p 0.9
+ 1932010p -0.3
+ 1934000p -0.3
+ 1934010p 0.9
+ 1936000p 0.9
+ 1936010p -0.3
+ 1938000p -0.3
+ 1938010p 0.9
+ 1940000p 0.9
+ 1940010p -0.3
+ 1942000p -0.3
+ 1942010p 0.9
+ 1944000p 0.9
+ 1944010p -0.3
+ 1946000p -0.3
+ 1946010p 0.9
+ 1948000p 0.9
+ 1948010p -0.3
+ 1950000p -0.3
+ 1950010p 0.9
+ 1952000p 0.9
+ 1952010p -0.3
+ 1954000p -0.3
+ 1954010p 0.9
+ 1956000p 0.9
+ 1956010p -0.3
+ 1958000p -0.3
+ 1958010p 0.9
+ 1960000p 0.9
+ 1960010p -0.3
+ 1962000p -0.3
+ 1962010p 0.9
+ 1964000p 0.9
+ 1964010p -0.3
+ 1966000p -0.3
+ 1966010p 0.9
+ 1968000p 0.9
+ 1968010p -0.3
+ 1970000p -0.3
+ 1970010p 0.9
+ 1972000p 0.9
+ 1972010p -0.3
+ 1974000p -0.3
+ 1974010p 0.9
+ 1976000p 0.9
+ 1976010p -0.3
+ 1978000p -0.3
+ 1978010p 0.9
+ 1980000p 0.9
+ 1980010p -0.3
+ 1982000p -0.3
+ 1982010p 0.9
+ 1984000p 0.9
+ 1984010p -0.3
+ 1986000p -0.3
+ 1986010p 0.9
+ 1988000p 0.9
+ 1988010p -0.3
+ 1990000p -0.3
+ 1990010p 0.9
+ 1992000p 0.9
+ 1992010p -0.3
+ 1994000p -0.3
+ 1994010p 0.9
+ 1996000p 0.9
+ 1996010p -0.3
+ 1998000p -0.3
+ 1998010p 0.9
+ 2000000p 0.9
+ 2000010p -0.3
+ 2002000p -0.3
+ 2002010p 0.9
+ 2004000p 0.9
+ 2004010p -0.3
+ 2006000p -0.3
+ 2006010p 0.9
+ 2008000p 0.9
+ 2008010p -0.3
+ 2010000p -0.3
+ 2010010p 0.9
+ 2012000p 0.9
+ 2012010p -0.3
+ 2014000p -0.3
+ 2014010p 0.9
+ 2016000p 0.9
+ 2016010p -0.3
+ 2018000p -0.3
+ 2018010p 0.9
+ 2020000p 0.9
+ 2020010p -0.3
+ 2022000p -0.3
+ 2022010p 0.9
+ 2024000p 0.9
+ 2024010p -0.3
+ 2026000p -0.3
+ 2026010p 0.9
+ 2028000p 0.9
+ 2028010p -0.3
+ 2030000p -0.3
+ 2030010p 0.9
+ 2032000p 0.9
+ 2032010p -0.3
+ 2034000p -0.3
+ 2034010p 0.9
+ 2036000p 0.9
+ 2036010p -0.3
+ 2038000p -0.3
+ 2038010p 0.9
+ 2040000p 0.9
+ 2040010p -0.3
+ 2042000p -0.3
+ 2042010p 0.9
+ 2044000p 0.9
+ 2044010p -0.3
+ 2046000p -0.3
+ 2046010p 0.9
+ 2048000p 0.9
+ 2048010p -0.3
+ \]
V_data_23 (Data\\<23\\> gnd!) vsource type=pwl wave=\[
+ 0    0.9
+ 2000p 0.9
+ 2010p -0.3
+ 4000p -0.3
+ 4010p 0.9
+ 6000p 0.9
+ 6010p -0.3
+ 8000p -0.3
+ 8010p 0.9
+ 10000p 0.9
+ 10010p -0.3
+ 12000p -0.3
+ 12010p 0.9
+ 14000p 0.9
+ 14010p -0.3
+ 16000p -0.3
+ 16010p 0.9
+ 18000p 0.9
+ 18010p -0.3
+ 20000p -0.3
+ 20010p 0.9
+ 22000p 0.9
+ 22010p -0.3
+ 24000p -0.3
+ 24010p 0.9
+ 26000p 0.9
+ 26010p -0.3
+ 28000p -0.3
+ 28010p 0.9
+ 30000p 0.9
+ 30010p -0.3
+ 32000p -0.3
+ 32010p 0.9
+ 34000p 0.9
+ 34010p -0.3
+ 36000p -0.3
+ 36010p 0.9
+ 38000p 0.9
+ 38010p -0.3
+ 40000p -0.3
+ 40010p 0.9
+ 42000p 0.9
+ 42010p -0.3
+ 44000p -0.3
+ 44010p 0.9
+ 46000p 0.9
+ 46010p -0.3
+ 48000p -0.3
+ 48010p 0.9
+ 50000p 0.9
+ 50010p -0.3
+ 52000p -0.3
+ 52010p 0.9
+ 54000p 0.9
+ 54010p -0.3
+ 56000p -0.3
+ 56010p 0.9
+ 58000p 0.9
+ 58010p -0.3
+ 60000p -0.3
+ 60010p 0.9
+ 62000p 0.9
+ 62010p -0.3
+ 64000p -0.3
+ 64010p 0.9
+ 66000p 0.9
+ 66010p -0.3
+ 68000p -0.3
+ 68010p 0.9
+ 70000p 0.9
+ 70010p -0.3
+ 72000p -0.3
+ 72010p 0.9
+ 74000p 0.9
+ 74010p -0.3
+ 76000p -0.3
+ 76010p 0.9
+ 78000p 0.9
+ 78010p -0.3
+ 80000p -0.3
+ 80010p 0.9
+ 82000p 0.9
+ 82010p -0.3
+ 84000p -0.3
+ 84010p 0.9
+ 86000p 0.9
+ 86010p -0.3
+ 88000p -0.3
+ 88010p 0.9
+ 90000p 0.9
+ 90010p -0.3
+ 92000p -0.3
+ 92010p 0.9
+ 94000p 0.9
+ 94010p -0.3
+ 96000p -0.3
+ 96010p 0.9
+ 98000p 0.9
+ 98010p -0.3
+ 100000p -0.3
+ 100010p 0.9
+ 102000p 0.9
+ 102010p -0.3
+ 104000p -0.3
+ 104010p 0.9
+ 106000p 0.9
+ 106010p -0.3
+ 108000p -0.3
+ 108010p 0.9
+ 110000p 0.9
+ 110010p -0.3
+ 112000p -0.3
+ 112010p 0.9
+ 114000p 0.9
+ 114010p -0.3
+ 116000p -0.3
+ 116010p 0.9
+ 118000p 0.9
+ 118010p -0.3
+ 120000p -0.3
+ 120010p 0.9
+ 122000p 0.9
+ 122010p -0.3
+ 124000p -0.3
+ 124010p 0.9
+ 126000p 0.9
+ 126010p -0.3
+ 128000p -0.3
+ 128010p 0.9
+ 130000p 0.9
+ 130010p -0.3
+ 132000p -0.3
+ 132010p 0.9
+ 134000p 0.9
+ 134010p -0.3
+ 136000p -0.3
+ 136010p 0.9
+ 138000p 0.9
+ 138010p -0.3
+ 140000p -0.3
+ 140010p 0.9
+ 142000p 0.9
+ 142010p -0.3
+ 144000p -0.3
+ 144010p 0.9
+ 146000p 0.9
+ 146010p -0.3
+ 148000p -0.3
+ 148010p 0.9
+ 150000p 0.9
+ 150010p -0.3
+ 152000p -0.3
+ 152010p 0.9
+ 154000p 0.9
+ 154010p -0.3
+ 156000p -0.3
+ 156010p 0.9
+ 158000p 0.9
+ 158010p -0.3
+ 160000p -0.3
+ 160010p 0.9
+ 162000p 0.9
+ 162010p -0.3
+ 164000p -0.3
+ 164010p 0.9
+ 166000p 0.9
+ 166010p -0.3
+ 168000p -0.3
+ 168010p 0.9
+ 170000p 0.9
+ 170010p -0.3
+ 172000p -0.3
+ 172010p 0.9
+ 174000p 0.9
+ 174010p -0.3
+ 176000p -0.3
+ 176010p 0.9
+ 178000p 0.9
+ 178010p -0.3
+ 180000p -0.3
+ 180010p 0.9
+ 182000p 0.9
+ 182010p -0.3
+ 184000p -0.3
+ 184010p 0.9
+ 186000p 0.9
+ 186010p -0.3
+ 188000p -0.3
+ 188010p 0.9
+ 190000p 0.9
+ 190010p -0.3
+ 192000p -0.3
+ 192010p 0.9
+ 194000p 0.9
+ 194010p -0.3
+ 196000p -0.3
+ 196010p 0.9
+ 198000p 0.9
+ 198010p -0.3
+ 200000p -0.3
+ 200010p 0.9
+ 202000p 0.9
+ 202010p -0.3
+ 204000p -0.3
+ 204010p 0.9
+ 206000p 0.9
+ 206010p -0.3
+ 208000p -0.3
+ 208010p 0.9
+ 210000p 0.9
+ 210010p -0.3
+ 212000p -0.3
+ 212010p 0.9
+ 214000p 0.9
+ 214010p -0.3
+ 216000p -0.3
+ 216010p 0.9
+ 218000p 0.9
+ 218010p -0.3
+ 220000p -0.3
+ 220010p 0.9
+ 222000p 0.9
+ 222010p -0.3
+ 224000p -0.3
+ 224010p 0.9
+ 226000p 0.9
+ 226010p -0.3
+ 228000p -0.3
+ 228010p 0.9
+ 230000p 0.9
+ 230010p -0.3
+ 232000p -0.3
+ 232010p 0.9
+ 234000p 0.9
+ 234010p -0.3
+ 236000p -0.3
+ 236010p 0.9
+ 238000p 0.9
+ 238010p -0.3
+ 240000p -0.3
+ 240010p 0.9
+ 242000p 0.9
+ 242010p -0.3
+ 244000p -0.3
+ 244010p 0.9
+ 246000p 0.9
+ 246010p -0.3
+ 248000p -0.3
+ 248010p 0.9
+ 250000p 0.9
+ 250010p -0.3
+ 252000p -0.3
+ 252010p 0.9
+ 254000p 0.9
+ 254010p -0.3
+ 256000p -0.3
+ 256010p 0.9
+ 258000p 0.9
+ 258010p -0.3
+ 260000p -0.3
+ 260010p 0.9
+ 262000p 0.9
+ 262010p -0.3
+ 264000p -0.3
+ 264010p 0.9
+ 266000p 0.9
+ 266010p -0.3
+ 268000p -0.3
+ 268010p 0.9
+ 270000p 0.9
+ 270010p -0.3
+ 272000p -0.3
+ 272010p 0.9
+ 274000p 0.9
+ 274010p -0.3
+ 276000p -0.3
+ 276010p 0.9
+ 278000p 0.9
+ 278010p -0.3
+ 280000p -0.3
+ 280010p 0.9
+ 282000p 0.9
+ 282010p -0.3
+ 284000p -0.3
+ 284010p 0.9
+ 286000p 0.9
+ 286010p -0.3
+ 288000p -0.3
+ 288010p 0.9
+ 290000p 0.9
+ 290010p -0.3
+ 292000p -0.3
+ 292010p 0.9
+ 294000p 0.9
+ 294010p -0.3
+ 296000p -0.3
+ 296010p 0.9
+ 298000p 0.9
+ 298010p -0.3
+ 300000p -0.3
+ 300010p 0.9
+ 302000p 0.9
+ 302010p -0.3
+ 304000p -0.3
+ 304010p 0.9
+ 306000p 0.9
+ 306010p -0.3
+ 308000p -0.3
+ 308010p 0.9
+ 310000p 0.9
+ 310010p -0.3
+ 312000p -0.3
+ 312010p 0.9
+ 314000p 0.9
+ 314010p -0.3
+ 316000p -0.3
+ 316010p 0.9
+ 318000p 0.9
+ 318010p -0.3
+ 320000p -0.3
+ 320010p 0.9
+ 322000p 0.9
+ 322010p -0.3
+ 324000p -0.3
+ 324010p 0.9
+ 326000p 0.9
+ 326010p -0.3
+ 328000p -0.3
+ 328010p 0.9
+ 330000p 0.9
+ 330010p -0.3
+ 332000p -0.3
+ 332010p 0.9
+ 334000p 0.9
+ 334010p -0.3
+ 336000p -0.3
+ 336010p 0.9
+ 338000p 0.9
+ 338010p -0.3
+ 340000p -0.3
+ 340010p 0.9
+ 342000p 0.9
+ 342010p -0.3
+ 344000p -0.3
+ 344010p 0.9
+ 346000p 0.9
+ 346010p -0.3
+ 348000p -0.3
+ 348010p 0.9
+ 350000p 0.9
+ 350010p -0.3
+ 352000p -0.3
+ 352010p 0.9
+ 354000p 0.9
+ 354010p -0.3
+ 356000p -0.3
+ 356010p 0.9
+ 358000p 0.9
+ 358010p -0.3
+ 360000p -0.3
+ 360010p 0.9
+ 362000p 0.9
+ 362010p -0.3
+ 364000p -0.3
+ 364010p 0.9
+ 366000p 0.9
+ 366010p -0.3
+ 368000p -0.3
+ 368010p 0.9
+ 370000p 0.9
+ 370010p -0.3
+ 372000p -0.3
+ 372010p 0.9
+ 374000p 0.9
+ 374010p -0.3
+ 376000p -0.3
+ 376010p 0.9
+ 378000p 0.9
+ 378010p -0.3
+ 380000p -0.3
+ 380010p 0.9
+ 382000p 0.9
+ 382010p -0.3
+ 384000p -0.3
+ 384010p 0.9
+ 386000p 0.9
+ 386010p -0.3
+ 388000p -0.3
+ 388010p 0.9
+ 390000p 0.9
+ 390010p -0.3
+ 392000p -0.3
+ 392010p 0.9
+ 394000p 0.9
+ 394010p -0.3
+ 396000p -0.3
+ 396010p 0.9
+ 398000p 0.9
+ 398010p -0.3
+ 400000p -0.3
+ 400010p 0.9
+ 402000p 0.9
+ 402010p -0.3
+ 404000p -0.3
+ 404010p 0.9
+ 406000p 0.9
+ 406010p -0.3
+ 408000p -0.3
+ 408010p 0.9
+ 410000p 0.9
+ 410010p -0.3
+ 412000p -0.3
+ 412010p 0.9
+ 414000p 0.9
+ 414010p -0.3
+ 416000p -0.3
+ 416010p 0.9
+ 418000p 0.9
+ 418010p -0.3
+ 420000p -0.3
+ 420010p 0.9
+ 422000p 0.9
+ 422010p -0.3
+ 424000p -0.3
+ 424010p 0.9
+ 426000p 0.9
+ 426010p -0.3
+ 428000p -0.3
+ 428010p 0.9
+ 430000p 0.9
+ 430010p -0.3
+ 432000p -0.3
+ 432010p 0.9
+ 434000p 0.9
+ 434010p -0.3
+ 436000p -0.3
+ 436010p 0.9
+ 438000p 0.9
+ 438010p -0.3
+ 440000p -0.3
+ 440010p 0.9
+ 442000p 0.9
+ 442010p -0.3
+ 444000p -0.3
+ 444010p 0.9
+ 446000p 0.9
+ 446010p -0.3
+ 448000p -0.3
+ 448010p 0.9
+ 450000p 0.9
+ 450010p -0.3
+ 452000p -0.3
+ 452010p 0.9
+ 454000p 0.9
+ 454010p -0.3
+ 456000p -0.3
+ 456010p 0.9
+ 458000p 0.9
+ 458010p -0.3
+ 460000p -0.3
+ 460010p 0.9
+ 462000p 0.9
+ 462010p -0.3
+ 464000p -0.3
+ 464010p 0.9
+ 466000p 0.9
+ 466010p -0.3
+ 468000p -0.3
+ 468010p 0.9
+ 470000p 0.9
+ 470010p -0.3
+ 472000p -0.3
+ 472010p 0.9
+ 474000p 0.9
+ 474010p -0.3
+ 476000p -0.3
+ 476010p 0.9
+ 478000p 0.9
+ 478010p -0.3
+ 480000p -0.3
+ 480010p 0.9
+ 482000p 0.9
+ 482010p -0.3
+ 484000p -0.3
+ 484010p 0.9
+ 486000p 0.9
+ 486010p -0.3
+ 488000p -0.3
+ 488010p 0.9
+ 490000p 0.9
+ 490010p -0.3
+ 492000p -0.3
+ 492010p 0.9
+ 494000p 0.9
+ 494010p -0.3
+ 496000p -0.3
+ 496010p 0.9
+ 498000p 0.9
+ 498010p -0.3
+ 500000p -0.3
+ 500010p 0.9
+ 502000p 0.9
+ 502010p -0.3
+ 504000p -0.3
+ 504010p 0.9
+ 506000p 0.9
+ 506010p -0.3
+ 508000p -0.3
+ 508010p 0.9
+ 510000p 0.9
+ 510010p -0.3
+ 512000p -0.3
+ 512010p 0.9
+ 514000p 0.9
+ 514010p -0.3
+ 516000p -0.3
+ 516010p 0.9
+ 518000p 0.9
+ 518010p -0.3
+ 520000p -0.3
+ 520010p 0.9
+ 522000p 0.9
+ 522010p -0.3
+ 524000p -0.3
+ 524010p 0.9
+ 526000p 0.9
+ 526010p -0.3
+ 528000p -0.3
+ 528010p 0.9
+ 530000p 0.9
+ 530010p -0.3
+ 532000p -0.3
+ 532010p 0.9
+ 534000p 0.9
+ 534010p -0.3
+ 536000p -0.3
+ 536010p 0.9
+ 538000p 0.9
+ 538010p -0.3
+ 540000p -0.3
+ 540010p 0.9
+ 542000p 0.9
+ 542010p -0.3
+ 544000p -0.3
+ 544010p 0.9
+ 546000p 0.9
+ 546010p -0.3
+ 548000p -0.3
+ 548010p 0.9
+ 550000p 0.9
+ 550010p -0.3
+ 552000p -0.3
+ 552010p 0.9
+ 554000p 0.9
+ 554010p -0.3
+ 556000p -0.3
+ 556010p 0.9
+ 558000p 0.9
+ 558010p -0.3
+ 560000p -0.3
+ 560010p 0.9
+ 562000p 0.9
+ 562010p -0.3
+ 564000p -0.3
+ 564010p 0.9
+ 566000p 0.9
+ 566010p -0.3
+ 568000p -0.3
+ 568010p 0.9
+ 570000p 0.9
+ 570010p -0.3
+ 572000p -0.3
+ 572010p 0.9
+ 574000p 0.9
+ 574010p -0.3
+ 576000p -0.3
+ 576010p 0.9
+ 578000p 0.9
+ 578010p -0.3
+ 580000p -0.3
+ 580010p 0.9
+ 582000p 0.9
+ 582010p -0.3
+ 584000p -0.3
+ 584010p 0.9
+ 586000p 0.9
+ 586010p -0.3
+ 588000p -0.3
+ 588010p 0.9
+ 590000p 0.9
+ 590010p -0.3
+ 592000p -0.3
+ 592010p 0.9
+ 594000p 0.9
+ 594010p -0.3
+ 596000p -0.3
+ 596010p 0.9
+ 598000p 0.9
+ 598010p -0.3
+ 600000p -0.3
+ 600010p 0.9
+ 602000p 0.9
+ 602010p -0.3
+ 604000p -0.3
+ 604010p 0.9
+ 606000p 0.9
+ 606010p -0.3
+ 608000p -0.3
+ 608010p 0.9
+ 610000p 0.9
+ 610010p -0.3
+ 612000p -0.3
+ 612010p 0.9
+ 614000p 0.9
+ 614010p -0.3
+ 616000p -0.3
+ 616010p 0.9
+ 618000p 0.9
+ 618010p -0.3
+ 620000p -0.3
+ 620010p 0.9
+ 622000p 0.9
+ 622010p -0.3
+ 624000p -0.3
+ 624010p 0.9
+ 626000p 0.9
+ 626010p -0.3
+ 628000p -0.3
+ 628010p 0.9
+ 630000p 0.9
+ 630010p -0.3
+ 632000p -0.3
+ 632010p 0.9
+ 634000p 0.9
+ 634010p -0.3
+ 636000p -0.3
+ 636010p 0.9
+ 638000p 0.9
+ 638010p -0.3
+ 640000p -0.3
+ 640010p 0.9
+ 642000p 0.9
+ 642010p -0.3
+ 644000p -0.3
+ 644010p 0.9
+ 646000p 0.9
+ 646010p -0.3
+ 648000p -0.3
+ 648010p 0.9
+ 650000p 0.9
+ 650010p -0.3
+ 652000p -0.3
+ 652010p 0.9
+ 654000p 0.9
+ 654010p -0.3
+ 656000p -0.3
+ 656010p 0.9
+ 658000p 0.9
+ 658010p -0.3
+ 660000p -0.3
+ 660010p 0.9
+ 662000p 0.9
+ 662010p -0.3
+ 664000p -0.3
+ 664010p 0.9
+ 666000p 0.9
+ 666010p -0.3
+ 668000p -0.3
+ 668010p 0.9
+ 670000p 0.9
+ 670010p -0.3
+ 672000p -0.3
+ 672010p 0.9
+ 674000p 0.9
+ 674010p -0.3
+ 676000p -0.3
+ 676010p 0.9
+ 678000p 0.9
+ 678010p -0.3
+ 680000p -0.3
+ 680010p 0.9
+ 682000p 0.9
+ 682010p -0.3
+ 684000p -0.3
+ 684010p 0.9
+ 686000p 0.9
+ 686010p -0.3
+ 688000p -0.3
+ 688010p 0.9
+ 690000p 0.9
+ 690010p -0.3
+ 692000p -0.3
+ 692010p 0.9
+ 694000p 0.9
+ 694010p -0.3
+ 696000p -0.3
+ 696010p 0.9
+ 698000p 0.9
+ 698010p -0.3
+ 700000p -0.3
+ 700010p 0.9
+ 702000p 0.9
+ 702010p -0.3
+ 704000p -0.3
+ 704010p 0.9
+ 706000p 0.9
+ 706010p -0.3
+ 708000p -0.3
+ 708010p 0.9
+ 710000p 0.9
+ 710010p -0.3
+ 712000p -0.3
+ 712010p 0.9
+ 714000p 0.9
+ 714010p -0.3
+ 716000p -0.3
+ 716010p 0.9
+ 718000p 0.9
+ 718010p -0.3
+ 720000p -0.3
+ 720010p 0.9
+ 722000p 0.9
+ 722010p -0.3
+ 724000p -0.3
+ 724010p 0.9
+ 726000p 0.9
+ 726010p -0.3
+ 728000p -0.3
+ 728010p 0.9
+ 730000p 0.9
+ 730010p -0.3
+ 732000p -0.3
+ 732010p 0.9
+ 734000p 0.9
+ 734010p -0.3
+ 736000p -0.3
+ 736010p 0.9
+ 738000p 0.9
+ 738010p -0.3
+ 740000p -0.3
+ 740010p 0.9
+ 742000p 0.9
+ 742010p -0.3
+ 744000p -0.3
+ 744010p 0.9
+ 746000p 0.9
+ 746010p -0.3
+ 748000p -0.3
+ 748010p 0.9
+ 750000p 0.9
+ 750010p -0.3
+ 752000p -0.3
+ 752010p 0.9
+ 754000p 0.9
+ 754010p -0.3
+ 756000p -0.3
+ 756010p 0.9
+ 758000p 0.9
+ 758010p -0.3
+ 760000p -0.3
+ 760010p 0.9
+ 762000p 0.9
+ 762010p -0.3
+ 764000p -0.3
+ 764010p 0.9
+ 766000p 0.9
+ 766010p -0.3
+ 768000p -0.3
+ 768010p 0.9
+ 770000p 0.9
+ 770010p -0.3
+ 772000p -0.3
+ 772010p 0.9
+ 774000p 0.9
+ 774010p -0.3
+ 776000p -0.3
+ 776010p 0.9
+ 778000p 0.9
+ 778010p -0.3
+ 780000p -0.3
+ 780010p 0.9
+ 782000p 0.9
+ 782010p -0.3
+ 784000p -0.3
+ 784010p 0.9
+ 786000p 0.9
+ 786010p -0.3
+ 788000p -0.3
+ 788010p 0.9
+ 790000p 0.9
+ 790010p -0.3
+ 792000p -0.3
+ 792010p 0.9
+ 794000p 0.9
+ 794010p -0.3
+ 796000p -0.3
+ 796010p 0.9
+ 798000p 0.9
+ 798010p -0.3
+ 800000p -0.3
+ 800010p 0.9
+ 802000p 0.9
+ 802010p -0.3
+ 804000p -0.3
+ 804010p 0.9
+ 806000p 0.9
+ 806010p -0.3
+ 808000p -0.3
+ 808010p 0.9
+ 810000p 0.9
+ 810010p -0.3
+ 812000p -0.3
+ 812010p 0.9
+ 814000p 0.9
+ 814010p -0.3
+ 816000p -0.3
+ 816010p 0.9
+ 818000p 0.9
+ 818010p -0.3
+ 820000p -0.3
+ 820010p 0.9
+ 822000p 0.9
+ 822010p -0.3
+ 824000p -0.3
+ 824010p 0.9
+ 826000p 0.9
+ 826010p -0.3
+ 828000p -0.3
+ 828010p 0.9
+ 830000p 0.9
+ 830010p -0.3
+ 832000p -0.3
+ 832010p 0.9
+ 834000p 0.9
+ 834010p -0.3
+ 836000p -0.3
+ 836010p 0.9
+ 838000p 0.9
+ 838010p -0.3
+ 840000p -0.3
+ 840010p 0.9
+ 842000p 0.9
+ 842010p -0.3
+ 844000p -0.3
+ 844010p 0.9
+ 846000p 0.9
+ 846010p -0.3
+ 848000p -0.3
+ 848010p 0.9
+ 850000p 0.9
+ 850010p -0.3
+ 852000p -0.3
+ 852010p 0.9
+ 854000p 0.9
+ 854010p -0.3
+ 856000p -0.3
+ 856010p 0.9
+ 858000p 0.9
+ 858010p -0.3
+ 860000p -0.3
+ 860010p 0.9
+ 862000p 0.9
+ 862010p -0.3
+ 864000p -0.3
+ 864010p 0.9
+ 866000p 0.9
+ 866010p -0.3
+ 868000p -0.3
+ 868010p 0.9
+ 870000p 0.9
+ 870010p -0.3
+ 872000p -0.3
+ 872010p 0.9
+ 874000p 0.9
+ 874010p -0.3
+ 876000p -0.3
+ 876010p 0.9
+ 878000p 0.9
+ 878010p -0.3
+ 880000p -0.3
+ 880010p 0.9
+ 882000p 0.9
+ 882010p -0.3
+ 884000p -0.3
+ 884010p 0.9
+ 886000p 0.9
+ 886010p -0.3
+ 888000p -0.3
+ 888010p 0.9
+ 890000p 0.9
+ 890010p -0.3
+ 892000p -0.3
+ 892010p 0.9
+ 894000p 0.9
+ 894010p -0.3
+ 896000p -0.3
+ 896010p 0.9
+ 898000p 0.9
+ 898010p -0.3
+ 900000p -0.3
+ 900010p 0.9
+ 902000p 0.9
+ 902010p -0.3
+ 904000p -0.3
+ 904010p 0.9
+ 906000p 0.9
+ 906010p -0.3
+ 908000p -0.3
+ 908010p 0.9
+ 910000p 0.9
+ 910010p -0.3
+ 912000p -0.3
+ 912010p 0.9
+ 914000p 0.9
+ 914010p -0.3
+ 916000p -0.3
+ 916010p 0.9
+ 918000p 0.9
+ 918010p -0.3
+ 920000p -0.3
+ 920010p 0.9
+ 922000p 0.9
+ 922010p -0.3
+ 924000p -0.3
+ 924010p 0.9
+ 926000p 0.9
+ 926010p -0.3
+ 928000p -0.3
+ 928010p 0.9
+ 930000p 0.9
+ 930010p -0.3
+ 932000p -0.3
+ 932010p 0.9
+ 934000p 0.9
+ 934010p -0.3
+ 936000p -0.3
+ 936010p 0.9
+ 938000p 0.9
+ 938010p -0.3
+ 940000p -0.3
+ 940010p 0.9
+ 942000p 0.9
+ 942010p -0.3
+ 944000p -0.3
+ 944010p 0.9
+ 946000p 0.9
+ 946010p -0.3
+ 948000p -0.3
+ 948010p 0.9
+ 950000p 0.9
+ 950010p -0.3
+ 952000p -0.3
+ 952010p 0.9
+ 954000p 0.9
+ 954010p -0.3
+ 956000p -0.3
+ 956010p 0.9
+ 958000p 0.9
+ 958010p -0.3
+ 960000p -0.3
+ 960010p 0.9
+ 962000p 0.9
+ 962010p -0.3
+ 964000p -0.3
+ 964010p 0.9
+ 966000p 0.9
+ 966010p -0.3
+ 968000p -0.3
+ 968010p 0.9
+ 970000p 0.9
+ 970010p -0.3
+ 972000p -0.3
+ 972010p 0.9
+ 974000p 0.9
+ 974010p -0.3
+ 976000p -0.3
+ 976010p 0.9
+ 978000p 0.9
+ 978010p -0.3
+ 980000p -0.3
+ 980010p 0.9
+ 982000p 0.9
+ 982010p -0.3
+ 984000p -0.3
+ 984010p 0.9
+ 986000p 0.9
+ 986010p -0.3
+ 988000p -0.3
+ 988010p 0.9
+ 990000p 0.9
+ 990010p -0.3
+ 992000p -0.3
+ 992010p 0.9
+ 994000p 0.9
+ 994010p -0.3
+ 996000p -0.3
+ 996010p 0.9
+ 998000p 0.9
+ 998010p -0.3
+ 1000000p -0.3
+ 1000010p 0.9
+ 1002000p 0.9
+ 1002010p -0.3
+ 1004000p -0.3
+ 1004010p 0.9
+ 1006000p 0.9
+ 1006010p -0.3
+ 1008000p -0.3
+ 1008010p 0.9
+ 1010000p 0.9
+ 1010010p -0.3
+ 1012000p -0.3
+ 1012010p 0.9
+ 1014000p 0.9
+ 1014010p -0.3
+ 1016000p -0.3
+ 1016010p 0.9
+ 1018000p 0.9
+ 1018010p -0.3
+ 1020000p -0.3
+ 1020010p 0.9
+ 1022000p 0.9
+ 1022010p -0.3
+ 1024000p -0.3
+ 1024010p 0.9
+ 1026000p 0.9
+ 1026010p -0.3
+ 1028000p -0.3
+ 1028010p 0.9
+ 1030000p 0.9
+ 1030010p -0.3
+ 1032000p -0.3
+ 1032010p 0.9
+ 1034000p 0.9
+ 1034010p -0.3
+ 1036000p -0.3
+ 1036010p 0.9
+ 1038000p 0.9
+ 1038010p -0.3
+ 1040000p -0.3
+ 1040010p 0.9
+ 1042000p 0.9
+ 1042010p -0.3
+ 1044000p -0.3
+ 1044010p 0.9
+ 1046000p 0.9
+ 1046010p -0.3
+ 1048000p -0.3
+ 1048010p 0.9
+ 1050000p 0.9
+ 1050010p -0.3
+ 1052000p -0.3
+ 1052010p 0.9
+ 1054000p 0.9
+ 1054010p -0.3
+ 1056000p -0.3
+ 1056010p 0.9
+ 1058000p 0.9
+ 1058010p -0.3
+ 1060000p -0.3
+ 1060010p 0.9
+ 1062000p 0.9
+ 1062010p -0.3
+ 1064000p -0.3
+ 1064010p 0.9
+ 1066000p 0.9
+ 1066010p -0.3
+ 1068000p -0.3
+ 1068010p 0.9
+ 1070000p 0.9
+ 1070010p -0.3
+ 1072000p -0.3
+ 1072010p 0.9
+ 1074000p 0.9
+ 1074010p -0.3
+ 1076000p -0.3
+ 1076010p 0.9
+ 1078000p 0.9
+ 1078010p -0.3
+ 1080000p -0.3
+ 1080010p 0.9
+ 1082000p 0.9
+ 1082010p -0.3
+ 1084000p -0.3
+ 1084010p 0.9
+ 1086000p 0.9
+ 1086010p -0.3
+ 1088000p -0.3
+ 1088010p 0.9
+ 1090000p 0.9
+ 1090010p -0.3
+ 1092000p -0.3
+ 1092010p 0.9
+ 1094000p 0.9
+ 1094010p -0.3
+ 1096000p -0.3
+ 1096010p 0.9
+ 1098000p 0.9
+ 1098010p -0.3
+ 1100000p -0.3
+ 1100010p 0.9
+ 1102000p 0.9
+ 1102010p -0.3
+ 1104000p -0.3
+ 1104010p 0.9
+ 1106000p 0.9
+ 1106010p -0.3
+ 1108000p -0.3
+ 1108010p 0.9
+ 1110000p 0.9
+ 1110010p -0.3
+ 1112000p -0.3
+ 1112010p 0.9
+ 1114000p 0.9
+ 1114010p -0.3
+ 1116000p -0.3
+ 1116010p 0.9
+ 1118000p 0.9
+ 1118010p -0.3
+ 1120000p -0.3
+ 1120010p 0.9
+ 1122000p 0.9
+ 1122010p -0.3
+ 1124000p -0.3
+ 1124010p 0.9
+ 1126000p 0.9
+ 1126010p -0.3
+ 1128000p -0.3
+ 1128010p 0.9
+ 1130000p 0.9
+ 1130010p -0.3
+ 1132000p -0.3
+ 1132010p 0.9
+ 1134000p 0.9
+ 1134010p -0.3
+ 1136000p -0.3
+ 1136010p 0.9
+ 1138000p 0.9
+ 1138010p -0.3
+ 1140000p -0.3
+ 1140010p 0.9
+ 1142000p 0.9
+ 1142010p -0.3
+ 1144000p -0.3
+ 1144010p 0.9
+ 1146000p 0.9
+ 1146010p -0.3
+ 1148000p -0.3
+ 1148010p 0.9
+ 1150000p 0.9
+ 1150010p -0.3
+ 1152000p -0.3
+ 1152010p 0.9
+ 1154000p 0.9
+ 1154010p -0.3
+ 1156000p -0.3
+ 1156010p 0.9
+ 1158000p 0.9
+ 1158010p -0.3
+ 1160000p -0.3
+ 1160010p 0.9
+ 1162000p 0.9
+ 1162010p -0.3
+ 1164000p -0.3
+ 1164010p 0.9
+ 1166000p 0.9
+ 1166010p -0.3
+ 1168000p -0.3
+ 1168010p 0.9
+ 1170000p 0.9
+ 1170010p -0.3
+ 1172000p -0.3
+ 1172010p 0.9
+ 1174000p 0.9
+ 1174010p -0.3
+ 1176000p -0.3
+ 1176010p 0.9
+ 1178000p 0.9
+ 1178010p -0.3
+ 1180000p -0.3
+ 1180010p 0.9
+ 1182000p 0.9
+ 1182010p -0.3
+ 1184000p -0.3
+ 1184010p 0.9
+ 1186000p 0.9
+ 1186010p -0.3
+ 1188000p -0.3
+ 1188010p 0.9
+ 1190000p 0.9
+ 1190010p -0.3
+ 1192000p -0.3
+ 1192010p 0.9
+ 1194000p 0.9
+ 1194010p -0.3
+ 1196000p -0.3
+ 1196010p 0.9
+ 1198000p 0.9
+ 1198010p -0.3
+ 1200000p -0.3
+ 1200010p 0.9
+ 1202000p 0.9
+ 1202010p -0.3
+ 1204000p -0.3
+ 1204010p 0.9
+ 1206000p 0.9
+ 1206010p -0.3
+ 1208000p -0.3
+ 1208010p 0.9
+ 1210000p 0.9
+ 1210010p -0.3
+ 1212000p -0.3
+ 1212010p 0.9
+ 1214000p 0.9
+ 1214010p -0.3
+ 1216000p -0.3
+ 1216010p 0.9
+ 1218000p 0.9
+ 1218010p -0.3
+ 1220000p -0.3
+ 1220010p 0.9
+ 1222000p 0.9
+ 1222010p -0.3
+ 1224000p -0.3
+ 1224010p 0.9
+ 1226000p 0.9
+ 1226010p -0.3
+ 1228000p -0.3
+ 1228010p 0.9
+ 1230000p 0.9
+ 1230010p -0.3
+ 1232000p -0.3
+ 1232010p 0.9
+ 1234000p 0.9
+ 1234010p -0.3
+ 1236000p -0.3
+ 1236010p 0.9
+ 1238000p 0.9
+ 1238010p -0.3
+ 1240000p -0.3
+ 1240010p 0.9
+ 1242000p 0.9
+ 1242010p -0.3
+ 1244000p -0.3
+ 1244010p 0.9
+ 1246000p 0.9
+ 1246010p -0.3
+ 1248000p -0.3
+ 1248010p 0.9
+ 1250000p 0.9
+ 1250010p -0.3
+ 1252000p -0.3
+ 1252010p 0.9
+ 1254000p 0.9
+ 1254010p -0.3
+ 1256000p -0.3
+ 1256010p 0.9
+ 1258000p 0.9
+ 1258010p -0.3
+ 1260000p -0.3
+ 1260010p 0.9
+ 1262000p 0.9
+ 1262010p -0.3
+ 1264000p -0.3
+ 1264010p 0.9
+ 1266000p 0.9
+ 1266010p -0.3
+ 1268000p -0.3
+ 1268010p 0.9
+ 1270000p 0.9
+ 1270010p -0.3
+ 1272000p -0.3
+ 1272010p 0.9
+ 1274000p 0.9
+ 1274010p -0.3
+ 1276000p -0.3
+ 1276010p 0.9
+ 1278000p 0.9
+ 1278010p -0.3
+ 1280000p -0.3
+ 1280010p 0.9
+ 1282000p 0.9
+ 1282010p -0.3
+ 1284000p -0.3
+ 1284010p 0.9
+ 1286000p 0.9
+ 1286010p -0.3
+ 1288000p -0.3
+ 1288010p 0.9
+ 1290000p 0.9
+ 1290010p -0.3
+ 1292000p -0.3
+ 1292010p 0.9
+ 1294000p 0.9
+ 1294010p -0.3
+ 1296000p -0.3
+ 1296010p 0.9
+ 1298000p 0.9
+ 1298010p -0.3
+ 1300000p -0.3
+ 1300010p 0.9
+ 1302000p 0.9
+ 1302010p -0.3
+ 1304000p -0.3
+ 1304010p 0.9
+ 1306000p 0.9
+ 1306010p -0.3
+ 1308000p -0.3
+ 1308010p 0.9
+ 1310000p 0.9
+ 1310010p -0.3
+ 1312000p -0.3
+ 1312010p 0.9
+ 1314000p 0.9
+ 1314010p -0.3
+ 1316000p -0.3
+ 1316010p 0.9
+ 1318000p 0.9
+ 1318010p -0.3
+ 1320000p -0.3
+ 1320010p 0.9
+ 1322000p 0.9
+ 1322010p -0.3
+ 1324000p -0.3
+ 1324010p 0.9
+ 1326000p 0.9
+ 1326010p -0.3
+ 1328000p -0.3
+ 1328010p 0.9
+ 1330000p 0.9
+ 1330010p -0.3
+ 1332000p -0.3
+ 1332010p 0.9
+ 1334000p 0.9
+ 1334010p -0.3
+ 1336000p -0.3
+ 1336010p 0.9
+ 1338000p 0.9
+ 1338010p -0.3
+ 1340000p -0.3
+ 1340010p 0.9
+ 1342000p 0.9
+ 1342010p -0.3
+ 1344000p -0.3
+ 1344010p 0.9
+ 1346000p 0.9
+ 1346010p -0.3
+ 1348000p -0.3
+ 1348010p 0.9
+ 1350000p 0.9
+ 1350010p -0.3
+ 1352000p -0.3
+ 1352010p 0.9
+ 1354000p 0.9
+ 1354010p -0.3
+ 1356000p -0.3
+ 1356010p 0.9
+ 1358000p 0.9
+ 1358010p -0.3
+ 1360000p -0.3
+ 1360010p 0.9
+ 1362000p 0.9
+ 1362010p -0.3
+ 1364000p -0.3
+ 1364010p 0.9
+ 1366000p 0.9
+ 1366010p -0.3
+ 1368000p -0.3
+ 1368010p 0.9
+ 1370000p 0.9
+ 1370010p -0.3
+ 1372000p -0.3
+ 1372010p 0.9
+ 1374000p 0.9
+ 1374010p -0.3
+ 1376000p -0.3
+ 1376010p 0.9
+ 1378000p 0.9
+ 1378010p -0.3
+ 1380000p -0.3
+ 1380010p 0.9
+ 1382000p 0.9
+ 1382010p -0.3
+ 1384000p -0.3
+ 1384010p 0.9
+ 1386000p 0.9
+ 1386010p -0.3
+ 1388000p -0.3
+ 1388010p 0.9
+ 1390000p 0.9
+ 1390010p -0.3
+ 1392000p -0.3
+ 1392010p 0.9
+ 1394000p 0.9
+ 1394010p -0.3
+ 1396000p -0.3
+ 1396010p 0.9
+ 1398000p 0.9
+ 1398010p -0.3
+ 1400000p -0.3
+ 1400010p 0.9
+ 1402000p 0.9
+ 1402010p -0.3
+ 1404000p -0.3
+ 1404010p 0.9
+ 1406000p 0.9
+ 1406010p -0.3
+ 1408000p -0.3
+ 1408010p 0.9
+ 1410000p 0.9
+ 1410010p -0.3
+ 1412000p -0.3
+ 1412010p 0.9
+ 1414000p 0.9
+ 1414010p -0.3
+ 1416000p -0.3
+ 1416010p 0.9
+ 1418000p 0.9
+ 1418010p -0.3
+ 1420000p -0.3
+ 1420010p 0.9
+ 1422000p 0.9
+ 1422010p -0.3
+ 1424000p -0.3
+ 1424010p 0.9
+ 1426000p 0.9
+ 1426010p -0.3
+ 1428000p -0.3
+ 1428010p 0.9
+ 1430000p 0.9
+ 1430010p -0.3
+ 1432000p -0.3
+ 1432010p 0.9
+ 1434000p 0.9
+ 1434010p -0.3
+ 1436000p -0.3
+ 1436010p 0.9
+ 1438000p 0.9
+ 1438010p -0.3
+ 1440000p -0.3
+ 1440010p 0.9
+ 1442000p 0.9
+ 1442010p -0.3
+ 1444000p -0.3
+ 1444010p 0.9
+ 1446000p 0.9
+ 1446010p -0.3
+ 1448000p -0.3
+ 1448010p 0.9
+ 1450000p 0.9
+ 1450010p -0.3
+ 1452000p -0.3
+ 1452010p 0.9
+ 1454000p 0.9
+ 1454010p -0.3
+ 1456000p -0.3
+ 1456010p 0.9
+ 1458000p 0.9
+ 1458010p -0.3
+ 1460000p -0.3
+ 1460010p 0.9
+ 1462000p 0.9
+ 1462010p -0.3
+ 1464000p -0.3
+ 1464010p 0.9
+ 1466000p 0.9
+ 1466010p -0.3
+ 1468000p -0.3
+ 1468010p 0.9
+ 1470000p 0.9
+ 1470010p -0.3
+ 1472000p -0.3
+ 1472010p 0.9
+ 1474000p 0.9
+ 1474010p -0.3
+ 1476000p -0.3
+ 1476010p 0.9
+ 1478000p 0.9
+ 1478010p -0.3
+ 1480000p -0.3
+ 1480010p 0.9
+ 1482000p 0.9
+ 1482010p -0.3
+ 1484000p -0.3
+ 1484010p 0.9
+ 1486000p 0.9
+ 1486010p -0.3
+ 1488000p -0.3
+ 1488010p 0.9
+ 1490000p 0.9
+ 1490010p -0.3
+ 1492000p -0.3
+ 1492010p 0.9
+ 1494000p 0.9
+ 1494010p -0.3
+ 1496000p -0.3
+ 1496010p 0.9
+ 1498000p 0.9
+ 1498010p -0.3
+ 1500000p -0.3
+ 1500010p 0.9
+ 1502000p 0.9
+ 1502010p -0.3
+ 1504000p -0.3
+ 1504010p 0.9
+ 1506000p 0.9
+ 1506010p -0.3
+ 1508000p -0.3
+ 1508010p 0.9
+ 1510000p 0.9
+ 1510010p -0.3
+ 1512000p -0.3
+ 1512010p 0.9
+ 1514000p 0.9
+ 1514010p -0.3
+ 1516000p -0.3
+ 1516010p 0.9
+ 1518000p 0.9
+ 1518010p -0.3
+ 1520000p -0.3
+ 1520010p 0.9
+ 1522000p 0.9
+ 1522010p -0.3
+ 1524000p -0.3
+ 1524010p 0.9
+ 1526000p 0.9
+ 1526010p -0.3
+ 1528000p -0.3
+ 1528010p 0.9
+ 1530000p 0.9
+ 1530010p -0.3
+ 1532000p -0.3
+ 1532010p 0.9
+ 1534000p 0.9
+ 1534010p -0.3
+ 1536000p -0.3
+ 1536010p 0.9
+ 1538000p 0.9
+ 1538010p -0.3
+ 1540000p -0.3
+ 1540010p 0.9
+ 1542000p 0.9
+ 1542010p -0.3
+ 1544000p -0.3
+ 1544010p 0.9
+ 1546000p 0.9
+ 1546010p -0.3
+ 1548000p -0.3
+ 1548010p 0.9
+ 1550000p 0.9
+ 1550010p -0.3
+ 1552000p -0.3
+ 1552010p 0.9
+ 1554000p 0.9
+ 1554010p -0.3
+ 1556000p -0.3
+ 1556010p 0.9
+ 1558000p 0.9
+ 1558010p -0.3
+ 1560000p -0.3
+ 1560010p 0.9
+ 1562000p 0.9
+ 1562010p -0.3
+ 1564000p -0.3
+ 1564010p 0.9
+ 1566000p 0.9
+ 1566010p -0.3
+ 1568000p -0.3
+ 1568010p 0.9
+ 1570000p 0.9
+ 1570010p -0.3
+ 1572000p -0.3
+ 1572010p 0.9
+ 1574000p 0.9
+ 1574010p -0.3
+ 1576000p -0.3
+ 1576010p 0.9
+ 1578000p 0.9
+ 1578010p -0.3
+ 1580000p -0.3
+ 1580010p 0.9
+ 1582000p 0.9
+ 1582010p -0.3
+ 1584000p -0.3
+ 1584010p 0.9
+ 1586000p 0.9
+ 1586010p -0.3
+ 1588000p -0.3
+ 1588010p 0.9
+ 1590000p 0.9
+ 1590010p -0.3
+ 1592000p -0.3
+ 1592010p 0.9
+ 1594000p 0.9
+ 1594010p -0.3
+ 1596000p -0.3
+ 1596010p 0.9
+ 1598000p 0.9
+ 1598010p -0.3
+ 1600000p -0.3
+ 1600010p 0.9
+ 1602000p 0.9
+ 1602010p -0.3
+ 1604000p -0.3
+ 1604010p 0.9
+ 1606000p 0.9
+ 1606010p -0.3
+ 1608000p -0.3
+ 1608010p 0.9
+ 1610000p 0.9
+ 1610010p -0.3
+ 1612000p -0.3
+ 1612010p 0.9
+ 1614000p 0.9
+ 1614010p -0.3
+ 1616000p -0.3
+ 1616010p 0.9
+ 1618000p 0.9
+ 1618010p -0.3
+ 1620000p -0.3
+ 1620010p 0.9
+ 1622000p 0.9
+ 1622010p -0.3
+ 1624000p -0.3
+ 1624010p 0.9
+ 1626000p 0.9
+ 1626010p -0.3
+ 1628000p -0.3
+ 1628010p 0.9
+ 1630000p 0.9
+ 1630010p -0.3
+ 1632000p -0.3
+ 1632010p 0.9
+ 1634000p 0.9
+ 1634010p -0.3
+ 1636000p -0.3
+ 1636010p 0.9
+ 1638000p 0.9
+ 1638010p -0.3
+ 1640000p -0.3
+ 1640010p 0.9
+ 1642000p 0.9
+ 1642010p -0.3
+ 1644000p -0.3
+ 1644010p 0.9
+ 1646000p 0.9
+ 1646010p -0.3
+ 1648000p -0.3
+ 1648010p 0.9
+ 1650000p 0.9
+ 1650010p -0.3
+ 1652000p -0.3
+ 1652010p 0.9
+ 1654000p 0.9
+ 1654010p -0.3
+ 1656000p -0.3
+ 1656010p 0.9
+ 1658000p 0.9
+ 1658010p -0.3
+ 1660000p -0.3
+ 1660010p 0.9
+ 1662000p 0.9
+ 1662010p -0.3
+ 1664000p -0.3
+ 1664010p 0.9
+ 1666000p 0.9
+ 1666010p -0.3
+ 1668000p -0.3
+ 1668010p 0.9
+ 1670000p 0.9
+ 1670010p -0.3
+ 1672000p -0.3
+ 1672010p 0.9
+ 1674000p 0.9
+ 1674010p -0.3
+ 1676000p -0.3
+ 1676010p 0.9
+ 1678000p 0.9
+ 1678010p -0.3
+ 1680000p -0.3
+ 1680010p 0.9
+ 1682000p 0.9
+ 1682010p -0.3
+ 1684000p -0.3
+ 1684010p 0.9
+ 1686000p 0.9
+ 1686010p -0.3
+ 1688000p -0.3
+ 1688010p 0.9
+ 1690000p 0.9
+ 1690010p -0.3
+ 1692000p -0.3
+ 1692010p 0.9
+ 1694000p 0.9
+ 1694010p -0.3
+ 1696000p -0.3
+ 1696010p 0.9
+ 1698000p 0.9
+ 1698010p -0.3
+ 1700000p -0.3
+ 1700010p 0.9
+ 1702000p 0.9
+ 1702010p -0.3
+ 1704000p -0.3
+ 1704010p 0.9
+ 1706000p 0.9
+ 1706010p -0.3
+ 1708000p -0.3
+ 1708010p 0.9
+ 1710000p 0.9
+ 1710010p -0.3
+ 1712000p -0.3
+ 1712010p 0.9
+ 1714000p 0.9
+ 1714010p -0.3
+ 1716000p -0.3
+ 1716010p 0.9
+ 1718000p 0.9
+ 1718010p -0.3
+ 1720000p -0.3
+ 1720010p 0.9
+ 1722000p 0.9
+ 1722010p -0.3
+ 1724000p -0.3
+ 1724010p 0.9
+ 1726000p 0.9
+ 1726010p -0.3
+ 1728000p -0.3
+ 1728010p 0.9
+ 1730000p 0.9
+ 1730010p -0.3
+ 1732000p -0.3
+ 1732010p 0.9
+ 1734000p 0.9
+ 1734010p -0.3
+ 1736000p -0.3
+ 1736010p 0.9
+ 1738000p 0.9
+ 1738010p -0.3
+ 1740000p -0.3
+ 1740010p 0.9
+ 1742000p 0.9
+ 1742010p -0.3
+ 1744000p -0.3
+ 1744010p 0.9
+ 1746000p 0.9
+ 1746010p -0.3
+ 1748000p -0.3
+ 1748010p 0.9
+ 1750000p 0.9
+ 1750010p -0.3
+ 1752000p -0.3
+ 1752010p 0.9
+ 1754000p 0.9
+ 1754010p -0.3
+ 1756000p -0.3
+ 1756010p 0.9
+ 1758000p 0.9
+ 1758010p -0.3
+ 1760000p -0.3
+ 1760010p 0.9
+ 1762000p 0.9
+ 1762010p -0.3
+ 1764000p -0.3
+ 1764010p 0.9
+ 1766000p 0.9
+ 1766010p -0.3
+ 1768000p -0.3
+ 1768010p 0.9
+ 1770000p 0.9
+ 1770010p -0.3
+ 1772000p -0.3
+ 1772010p 0.9
+ 1774000p 0.9
+ 1774010p -0.3
+ 1776000p -0.3
+ 1776010p 0.9
+ 1778000p 0.9
+ 1778010p -0.3
+ 1780000p -0.3
+ 1780010p 0.9
+ 1782000p 0.9
+ 1782010p -0.3
+ 1784000p -0.3
+ 1784010p 0.9
+ 1786000p 0.9
+ 1786010p -0.3
+ 1788000p -0.3
+ 1788010p 0.9
+ 1790000p 0.9
+ 1790010p -0.3
+ 1792000p -0.3
+ 1792010p 0.9
+ 1794000p 0.9
+ 1794010p -0.3
+ 1796000p -0.3
+ 1796010p 0.9
+ 1798000p 0.9
+ 1798010p -0.3
+ 1800000p -0.3
+ 1800010p 0.9
+ 1802000p 0.9
+ 1802010p -0.3
+ 1804000p -0.3
+ 1804010p 0.9
+ 1806000p 0.9
+ 1806010p -0.3
+ 1808000p -0.3
+ 1808010p 0.9
+ 1810000p 0.9
+ 1810010p -0.3
+ 1812000p -0.3
+ 1812010p 0.9
+ 1814000p 0.9
+ 1814010p -0.3
+ 1816000p -0.3
+ 1816010p 0.9
+ 1818000p 0.9
+ 1818010p -0.3
+ 1820000p -0.3
+ 1820010p 0.9
+ 1822000p 0.9
+ 1822010p -0.3
+ 1824000p -0.3
+ 1824010p 0.9
+ 1826000p 0.9
+ 1826010p -0.3
+ 1828000p -0.3
+ 1828010p 0.9
+ 1830000p 0.9
+ 1830010p -0.3
+ 1832000p -0.3
+ 1832010p 0.9
+ 1834000p 0.9
+ 1834010p -0.3
+ 1836000p -0.3
+ 1836010p 0.9
+ 1838000p 0.9
+ 1838010p -0.3
+ 1840000p -0.3
+ 1840010p 0.9
+ 1842000p 0.9
+ 1842010p -0.3
+ 1844000p -0.3
+ 1844010p 0.9
+ 1846000p 0.9
+ 1846010p -0.3
+ 1848000p -0.3
+ 1848010p 0.9
+ 1850000p 0.9
+ 1850010p -0.3
+ 1852000p -0.3
+ 1852010p 0.9
+ 1854000p 0.9
+ 1854010p -0.3
+ 1856000p -0.3
+ 1856010p 0.9
+ 1858000p 0.9
+ 1858010p -0.3
+ 1860000p -0.3
+ 1860010p 0.9
+ 1862000p 0.9
+ 1862010p -0.3
+ 1864000p -0.3
+ 1864010p 0.9
+ 1866000p 0.9
+ 1866010p -0.3
+ 1868000p -0.3
+ 1868010p 0.9
+ 1870000p 0.9
+ 1870010p -0.3
+ 1872000p -0.3
+ 1872010p 0.9
+ 1874000p 0.9
+ 1874010p -0.3
+ 1876000p -0.3
+ 1876010p 0.9
+ 1878000p 0.9
+ 1878010p -0.3
+ 1880000p -0.3
+ 1880010p 0.9
+ 1882000p 0.9
+ 1882010p -0.3
+ 1884000p -0.3
+ 1884010p 0.9
+ 1886000p 0.9
+ 1886010p -0.3
+ 1888000p -0.3
+ 1888010p 0.9
+ 1890000p 0.9
+ 1890010p -0.3
+ 1892000p -0.3
+ 1892010p 0.9
+ 1894000p 0.9
+ 1894010p -0.3
+ 1896000p -0.3
+ 1896010p 0.9
+ 1898000p 0.9
+ 1898010p -0.3
+ 1900000p -0.3
+ 1900010p 0.9
+ 1902000p 0.9
+ 1902010p -0.3
+ 1904000p -0.3
+ 1904010p 0.9
+ 1906000p 0.9
+ 1906010p -0.3
+ 1908000p -0.3
+ 1908010p 0.9
+ 1910000p 0.9
+ 1910010p -0.3
+ 1912000p -0.3
+ 1912010p 0.9
+ 1914000p 0.9
+ 1914010p -0.3
+ 1916000p -0.3
+ 1916010p 0.9
+ 1918000p 0.9
+ 1918010p -0.3
+ 1920000p -0.3
+ 1920010p 0.9
+ 1922000p 0.9
+ 1922010p -0.3
+ 1924000p -0.3
+ 1924010p 0.9
+ 1926000p 0.9
+ 1926010p -0.3
+ 1928000p -0.3
+ 1928010p 0.9
+ 1930000p 0.9
+ 1930010p -0.3
+ 1932000p -0.3
+ 1932010p 0.9
+ 1934000p 0.9
+ 1934010p -0.3
+ 1936000p -0.3
+ 1936010p 0.9
+ 1938000p 0.9
+ 1938010p -0.3
+ 1940000p -0.3
+ 1940010p 0.9
+ 1942000p 0.9
+ 1942010p -0.3
+ 1944000p -0.3
+ 1944010p 0.9
+ 1946000p 0.9
+ 1946010p -0.3
+ 1948000p -0.3
+ 1948010p 0.9
+ 1950000p 0.9
+ 1950010p -0.3
+ 1952000p -0.3
+ 1952010p 0.9
+ 1954000p 0.9
+ 1954010p -0.3
+ 1956000p -0.3
+ 1956010p 0.9
+ 1958000p 0.9
+ 1958010p -0.3
+ 1960000p -0.3
+ 1960010p 0.9
+ 1962000p 0.9
+ 1962010p -0.3
+ 1964000p -0.3
+ 1964010p 0.9
+ 1966000p 0.9
+ 1966010p -0.3
+ 1968000p -0.3
+ 1968010p 0.9
+ 1970000p 0.9
+ 1970010p -0.3
+ 1972000p -0.3
+ 1972010p 0.9
+ 1974000p 0.9
+ 1974010p -0.3
+ 1976000p -0.3
+ 1976010p 0.9
+ 1978000p 0.9
+ 1978010p -0.3
+ 1980000p -0.3
+ 1980010p 0.9
+ 1982000p 0.9
+ 1982010p -0.3
+ 1984000p -0.3
+ 1984010p 0.9
+ 1986000p 0.9
+ 1986010p -0.3
+ 1988000p -0.3
+ 1988010p 0.9
+ 1990000p 0.9
+ 1990010p -0.3
+ 1992000p -0.3
+ 1992010p 0.9
+ 1994000p 0.9
+ 1994010p -0.3
+ 1996000p -0.3
+ 1996010p 0.9
+ 1998000p 0.9
+ 1998010p -0.3
+ 2000000p -0.3
+ 2000010p 0.9
+ 2002000p 0.9
+ 2002010p -0.3
+ 2004000p -0.3
+ 2004010p 0.9
+ 2006000p 0.9
+ 2006010p -0.3
+ 2008000p -0.3
+ 2008010p 0.9
+ 2010000p 0.9
+ 2010010p -0.3
+ 2012000p -0.3
+ 2012010p 0.9
+ 2014000p 0.9
+ 2014010p -0.3
+ 2016000p -0.3
+ 2016010p 0.9
+ 2018000p 0.9
+ 2018010p -0.3
+ 2020000p -0.3
+ 2020010p 0.9
+ 2022000p 0.9
+ 2022010p -0.3
+ 2024000p -0.3
+ 2024010p 0.9
+ 2026000p 0.9
+ 2026010p -0.3
+ 2028000p -0.3
+ 2028010p 0.9
+ 2030000p 0.9
+ 2030010p -0.3
+ 2032000p -0.3
+ 2032010p 0.9
+ 2034000p 0.9
+ 2034010p -0.3
+ 2036000p -0.3
+ 2036010p 0.9
+ 2038000p 0.9
+ 2038010p -0.3
+ 2040000p -0.3
+ 2040010p 0.9
+ 2042000p 0.9
+ 2042010p -0.3
+ 2044000p -0.3
+ 2044010p 0.9
+ 2046000p 0.9
+ 2046010p -0.3
+ 2048000p -0.3
+ 2048010p 0.9
+ \]
V_data_bar_23 (Data_bar\\<23\\> gnd!) vsource type=pwl wave=\[
+ 0    -0.3
+ 2000p -0.3
+ 2010p 0.9
+ 4000p 0.9
+ 4010p -0.3
+ 6000p -0.3
+ 6010p 0.9
+ 8000p 0.9
+ 8010p -0.3
+ 10000p -0.3
+ 10010p 0.9
+ 12000p 0.9
+ 12010p -0.3
+ 14000p -0.3
+ 14010p 0.9
+ 16000p 0.9
+ 16010p -0.3
+ 18000p -0.3
+ 18010p 0.9
+ 20000p 0.9
+ 20010p -0.3
+ 22000p -0.3
+ 22010p 0.9
+ 24000p 0.9
+ 24010p -0.3
+ 26000p -0.3
+ 26010p 0.9
+ 28000p 0.9
+ 28010p -0.3
+ 30000p -0.3
+ 30010p 0.9
+ 32000p 0.9
+ 32010p -0.3
+ 34000p -0.3
+ 34010p 0.9
+ 36000p 0.9
+ 36010p -0.3
+ 38000p -0.3
+ 38010p 0.9
+ 40000p 0.9
+ 40010p -0.3
+ 42000p -0.3
+ 42010p 0.9
+ 44000p 0.9
+ 44010p -0.3
+ 46000p -0.3
+ 46010p 0.9
+ 48000p 0.9
+ 48010p -0.3
+ 50000p -0.3
+ 50010p 0.9
+ 52000p 0.9
+ 52010p -0.3
+ 54000p -0.3
+ 54010p 0.9
+ 56000p 0.9
+ 56010p -0.3
+ 58000p -0.3
+ 58010p 0.9
+ 60000p 0.9
+ 60010p -0.3
+ 62000p -0.3
+ 62010p 0.9
+ 64000p 0.9
+ 64010p -0.3
+ 66000p -0.3
+ 66010p 0.9
+ 68000p 0.9
+ 68010p -0.3
+ 70000p -0.3
+ 70010p 0.9
+ 72000p 0.9
+ 72010p -0.3
+ 74000p -0.3
+ 74010p 0.9
+ 76000p 0.9
+ 76010p -0.3
+ 78000p -0.3
+ 78010p 0.9
+ 80000p 0.9
+ 80010p -0.3
+ 82000p -0.3
+ 82010p 0.9
+ 84000p 0.9
+ 84010p -0.3
+ 86000p -0.3
+ 86010p 0.9
+ 88000p 0.9
+ 88010p -0.3
+ 90000p -0.3
+ 90010p 0.9
+ 92000p 0.9
+ 92010p -0.3
+ 94000p -0.3
+ 94010p 0.9
+ 96000p 0.9
+ 96010p -0.3
+ 98000p -0.3
+ 98010p 0.9
+ 100000p 0.9
+ 100010p -0.3
+ 102000p -0.3
+ 102010p 0.9
+ 104000p 0.9
+ 104010p -0.3
+ 106000p -0.3
+ 106010p 0.9
+ 108000p 0.9
+ 108010p -0.3
+ 110000p -0.3
+ 110010p 0.9
+ 112000p 0.9
+ 112010p -0.3
+ 114000p -0.3
+ 114010p 0.9
+ 116000p 0.9
+ 116010p -0.3
+ 118000p -0.3
+ 118010p 0.9
+ 120000p 0.9
+ 120010p -0.3
+ 122000p -0.3
+ 122010p 0.9
+ 124000p 0.9
+ 124010p -0.3
+ 126000p -0.3
+ 126010p 0.9
+ 128000p 0.9
+ 128010p -0.3
+ 130000p -0.3
+ 130010p 0.9
+ 132000p 0.9
+ 132010p -0.3
+ 134000p -0.3
+ 134010p 0.9
+ 136000p 0.9
+ 136010p -0.3
+ 138000p -0.3
+ 138010p 0.9
+ 140000p 0.9
+ 140010p -0.3
+ 142000p -0.3
+ 142010p 0.9
+ 144000p 0.9
+ 144010p -0.3
+ 146000p -0.3
+ 146010p 0.9
+ 148000p 0.9
+ 148010p -0.3
+ 150000p -0.3
+ 150010p 0.9
+ 152000p 0.9
+ 152010p -0.3
+ 154000p -0.3
+ 154010p 0.9
+ 156000p 0.9
+ 156010p -0.3
+ 158000p -0.3
+ 158010p 0.9
+ 160000p 0.9
+ 160010p -0.3
+ 162000p -0.3
+ 162010p 0.9
+ 164000p 0.9
+ 164010p -0.3
+ 166000p -0.3
+ 166010p 0.9
+ 168000p 0.9
+ 168010p -0.3
+ 170000p -0.3
+ 170010p 0.9
+ 172000p 0.9
+ 172010p -0.3
+ 174000p -0.3
+ 174010p 0.9
+ 176000p 0.9
+ 176010p -0.3
+ 178000p -0.3
+ 178010p 0.9
+ 180000p 0.9
+ 180010p -0.3
+ 182000p -0.3
+ 182010p 0.9
+ 184000p 0.9
+ 184010p -0.3
+ 186000p -0.3
+ 186010p 0.9
+ 188000p 0.9
+ 188010p -0.3
+ 190000p -0.3
+ 190010p 0.9
+ 192000p 0.9
+ 192010p -0.3
+ 194000p -0.3
+ 194010p 0.9
+ 196000p 0.9
+ 196010p -0.3
+ 198000p -0.3
+ 198010p 0.9
+ 200000p 0.9
+ 200010p -0.3
+ 202000p -0.3
+ 202010p 0.9
+ 204000p 0.9
+ 204010p -0.3
+ 206000p -0.3
+ 206010p 0.9
+ 208000p 0.9
+ 208010p -0.3
+ 210000p -0.3
+ 210010p 0.9
+ 212000p 0.9
+ 212010p -0.3
+ 214000p -0.3
+ 214010p 0.9
+ 216000p 0.9
+ 216010p -0.3
+ 218000p -0.3
+ 218010p 0.9
+ 220000p 0.9
+ 220010p -0.3
+ 222000p -0.3
+ 222010p 0.9
+ 224000p 0.9
+ 224010p -0.3
+ 226000p -0.3
+ 226010p 0.9
+ 228000p 0.9
+ 228010p -0.3
+ 230000p -0.3
+ 230010p 0.9
+ 232000p 0.9
+ 232010p -0.3
+ 234000p -0.3
+ 234010p 0.9
+ 236000p 0.9
+ 236010p -0.3
+ 238000p -0.3
+ 238010p 0.9
+ 240000p 0.9
+ 240010p -0.3
+ 242000p -0.3
+ 242010p 0.9
+ 244000p 0.9
+ 244010p -0.3
+ 246000p -0.3
+ 246010p 0.9
+ 248000p 0.9
+ 248010p -0.3
+ 250000p -0.3
+ 250010p 0.9
+ 252000p 0.9
+ 252010p -0.3
+ 254000p -0.3
+ 254010p 0.9
+ 256000p 0.9
+ 256010p -0.3
+ 258000p -0.3
+ 258010p 0.9
+ 260000p 0.9
+ 260010p -0.3
+ 262000p -0.3
+ 262010p 0.9
+ 264000p 0.9
+ 264010p -0.3
+ 266000p -0.3
+ 266010p 0.9
+ 268000p 0.9
+ 268010p -0.3
+ 270000p -0.3
+ 270010p 0.9
+ 272000p 0.9
+ 272010p -0.3
+ 274000p -0.3
+ 274010p 0.9
+ 276000p 0.9
+ 276010p -0.3
+ 278000p -0.3
+ 278010p 0.9
+ 280000p 0.9
+ 280010p -0.3
+ 282000p -0.3
+ 282010p 0.9
+ 284000p 0.9
+ 284010p -0.3
+ 286000p -0.3
+ 286010p 0.9
+ 288000p 0.9
+ 288010p -0.3
+ 290000p -0.3
+ 290010p 0.9
+ 292000p 0.9
+ 292010p -0.3
+ 294000p -0.3
+ 294010p 0.9
+ 296000p 0.9
+ 296010p -0.3
+ 298000p -0.3
+ 298010p 0.9
+ 300000p 0.9
+ 300010p -0.3
+ 302000p -0.3
+ 302010p 0.9
+ 304000p 0.9
+ 304010p -0.3
+ 306000p -0.3
+ 306010p 0.9
+ 308000p 0.9
+ 308010p -0.3
+ 310000p -0.3
+ 310010p 0.9
+ 312000p 0.9
+ 312010p -0.3
+ 314000p -0.3
+ 314010p 0.9
+ 316000p 0.9
+ 316010p -0.3
+ 318000p -0.3
+ 318010p 0.9
+ 320000p 0.9
+ 320010p -0.3
+ 322000p -0.3
+ 322010p 0.9
+ 324000p 0.9
+ 324010p -0.3
+ 326000p -0.3
+ 326010p 0.9
+ 328000p 0.9
+ 328010p -0.3
+ 330000p -0.3
+ 330010p 0.9
+ 332000p 0.9
+ 332010p -0.3
+ 334000p -0.3
+ 334010p 0.9
+ 336000p 0.9
+ 336010p -0.3
+ 338000p -0.3
+ 338010p 0.9
+ 340000p 0.9
+ 340010p -0.3
+ 342000p -0.3
+ 342010p 0.9
+ 344000p 0.9
+ 344010p -0.3
+ 346000p -0.3
+ 346010p 0.9
+ 348000p 0.9
+ 348010p -0.3
+ 350000p -0.3
+ 350010p 0.9
+ 352000p 0.9
+ 352010p -0.3
+ 354000p -0.3
+ 354010p 0.9
+ 356000p 0.9
+ 356010p -0.3
+ 358000p -0.3
+ 358010p 0.9
+ 360000p 0.9
+ 360010p -0.3
+ 362000p -0.3
+ 362010p 0.9
+ 364000p 0.9
+ 364010p -0.3
+ 366000p -0.3
+ 366010p 0.9
+ 368000p 0.9
+ 368010p -0.3
+ 370000p -0.3
+ 370010p 0.9
+ 372000p 0.9
+ 372010p -0.3
+ 374000p -0.3
+ 374010p 0.9
+ 376000p 0.9
+ 376010p -0.3
+ 378000p -0.3
+ 378010p 0.9
+ 380000p 0.9
+ 380010p -0.3
+ 382000p -0.3
+ 382010p 0.9
+ 384000p 0.9
+ 384010p -0.3
+ 386000p -0.3
+ 386010p 0.9
+ 388000p 0.9
+ 388010p -0.3
+ 390000p -0.3
+ 390010p 0.9
+ 392000p 0.9
+ 392010p -0.3
+ 394000p -0.3
+ 394010p 0.9
+ 396000p 0.9
+ 396010p -0.3
+ 398000p -0.3
+ 398010p 0.9
+ 400000p 0.9
+ 400010p -0.3
+ 402000p -0.3
+ 402010p 0.9
+ 404000p 0.9
+ 404010p -0.3
+ 406000p -0.3
+ 406010p 0.9
+ 408000p 0.9
+ 408010p -0.3
+ 410000p -0.3
+ 410010p 0.9
+ 412000p 0.9
+ 412010p -0.3
+ 414000p -0.3
+ 414010p 0.9
+ 416000p 0.9
+ 416010p -0.3
+ 418000p -0.3
+ 418010p 0.9
+ 420000p 0.9
+ 420010p -0.3
+ 422000p -0.3
+ 422010p 0.9
+ 424000p 0.9
+ 424010p -0.3
+ 426000p -0.3
+ 426010p 0.9
+ 428000p 0.9
+ 428010p -0.3
+ 430000p -0.3
+ 430010p 0.9
+ 432000p 0.9
+ 432010p -0.3
+ 434000p -0.3
+ 434010p 0.9
+ 436000p 0.9
+ 436010p -0.3
+ 438000p -0.3
+ 438010p 0.9
+ 440000p 0.9
+ 440010p -0.3
+ 442000p -0.3
+ 442010p 0.9
+ 444000p 0.9
+ 444010p -0.3
+ 446000p -0.3
+ 446010p 0.9
+ 448000p 0.9
+ 448010p -0.3
+ 450000p -0.3
+ 450010p 0.9
+ 452000p 0.9
+ 452010p -0.3
+ 454000p -0.3
+ 454010p 0.9
+ 456000p 0.9
+ 456010p -0.3
+ 458000p -0.3
+ 458010p 0.9
+ 460000p 0.9
+ 460010p -0.3
+ 462000p -0.3
+ 462010p 0.9
+ 464000p 0.9
+ 464010p -0.3
+ 466000p -0.3
+ 466010p 0.9
+ 468000p 0.9
+ 468010p -0.3
+ 470000p -0.3
+ 470010p 0.9
+ 472000p 0.9
+ 472010p -0.3
+ 474000p -0.3
+ 474010p 0.9
+ 476000p 0.9
+ 476010p -0.3
+ 478000p -0.3
+ 478010p 0.9
+ 480000p 0.9
+ 480010p -0.3
+ 482000p -0.3
+ 482010p 0.9
+ 484000p 0.9
+ 484010p -0.3
+ 486000p -0.3
+ 486010p 0.9
+ 488000p 0.9
+ 488010p -0.3
+ 490000p -0.3
+ 490010p 0.9
+ 492000p 0.9
+ 492010p -0.3
+ 494000p -0.3
+ 494010p 0.9
+ 496000p 0.9
+ 496010p -0.3
+ 498000p -0.3
+ 498010p 0.9
+ 500000p 0.9
+ 500010p -0.3
+ 502000p -0.3
+ 502010p 0.9
+ 504000p 0.9
+ 504010p -0.3
+ 506000p -0.3
+ 506010p 0.9
+ 508000p 0.9
+ 508010p -0.3
+ 510000p -0.3
+ 510010p 0.9
+ 512000p 0.9
+ 512010p -0.3
+ 514000p -0.3
+ 514010p 0.9
+ 516000p 0.9
+ 516010p -0.3
+ 518000p -0.3
+ 518010p 0.9
+ 520000p 0.9
+ 520010p -0.3
+ 522000p -0.3
+ 522010p 0.9
+ 524000p 0.9
+ 524010p -0.3
+ 526000p -0.3
+ 526010p 0.9
+ 528000p 0.9
+ 528010p -0.3
+ 530000p -0.3
+ 530010p 0.9
+ 532000p 0.9
+ 532010p -0.3
+ 534000p -0.3
+ 534010p 0.9
+ 536000p 0.9
+ 536010p -0.3
+ 538000p -0.3
+ 538010p 0.9
+ 540000p 0.9
+ 540010p -0.3
+ 542000p -0.3
+ 542010p 0.9
+ 544000p 0.9
+ 544010p -0.3
+ 546000p -0.3
+ 546010p 0.9
+ 548000p 0.9
+ 548010p -0.3
+ 550000p -0.3
+ 550010p 0.9
+ 552000p 0.9
+ 552010p -0.3
+ 554000p -0.3
+ 554010p 0.9
+ 556000p 0.9
+ 556010p -0.3
+ 558000p -0.3
+ 558010p 0.9
+ 560000p 0.9
+ 560010p -0.3
+ 562000p -0.3
+ 562010p 0.9
+ 564000p 0.9
+ 564010p -0.3
+ 566000p -0.3
+ 566010p 0.9
+ 568000p 0.9
+ 568010p -0.3
+ 570000p -0.3
+ 570010p 0.9
+ 572000p 0.9
+ 572010p -0.3
+ 574000p -0.3
+ 574010p 0.9
+ 576000p 0.9
+ 576010p -0.3
+ 578000p -0.3
+ 578010p 0.9
+ 580000p 0.9
+ 580010p -0.3
+ 582000p -0.3
+ 582010p 0.9
+ 584000p 0.9
+ 584010p -0.3
+ 586000p -0.3
+ 586010p 0.9
+ 588000p 0.9
+ 588010p -0.3
+ 590000p -0.3
+ 590010p 0.9
+ 592000p 0.9
+ 592010p -0.3
+ 594000p -0.3
+ 594010p 0.9
+ 596000p 0.9
+ 596010p -0.3
+ 598000p -0.3
+ 598010p 0.9
+ 600000p 0.9
+ 600010p -0.3
+ 602000p -0.3
+ 602010p 0.9
+ 604000p 0.9
+ 604010p -0.3
+ 606000p -0.3
+ 606010p 0.9
+ 608000p 0.9
+ 608010p -0.3
+ 610000p -0.3
+ 610010p 0.9
+ 612000p 0.9
+ 612010p -0.3
+ 614000p -0.3
+ 614010p 0.9
+ 616000p 0.9
+ 616010p -0.3
+ 618000p -0.3
+ 618010p 0.9
+ 620000p 0.9
+ 620010p -0.3
+ 622000p -0.3
+ 622010p 0.9
+ 624000p 0.9
+ 624010p -0.3
+ 626000p -0.3
+ 626010p 0.9
+ 628000p 0.9
+ 628010p -0.3
+ 630000p -0.3
+ 630010p 0.9
+ 632000p 0.9
+ 632010p -0.3
+ 634000p -0.3
+ 634010p 0.9
+ 636000p 0.9
+ 636010p -0.3
+ 638000p -0.3
+ 638010p 0.9
+ 640000p 0.9
+ 640010p -0.3
+ 642000p -0.3
+ 642010p 0.9
+ 644000p 0.9
+ 644010p -0.3
+ 646000p -0.3
+ 646010p 0.9
+ 648000p 0.9
+ 648010p -0.3
+ 650000p -0.3
+ 650010p 0.9
+ 652000p 0.9
+ 652010p -0.3
+ 654000p -0.3
+ 654010p 0.9
+ 656000p 0.9
+ 656010p -0.3
+ 658000p -0.3
+ 658010p 0.9
+ 660000p 0.9
+ 660010p -0.3
+ 662000p -0.3
+ 662010p 0.9
+ 664000p 0.9
+ 664010p -0.3
+ 666000p -0.3
+ 666010p 0.9
+ 668000p 0.9
+ 668010p -0.3
+ 670000p -0.3
+ 670010p 0.9
+ 672000p 0.9
+ 672010p -0.3
+ 674000p -0.3
+ 674010p 0.9
+ 676000p 0.9
+ 676010p -0.3
+ 678000p -0.3
+ 678010p 0.9
+ 680000p 0.9
+ 680010p -0.3
+ 682000p -0.3
+ 682010p 0.9
+ 684000p 0.9
+ 684010p -0.3
+ 686000p -0.3
+ 686010p 0.9
+ 688000p 0.9
+ 688010p -0.3
+ 690000p -0.3
+ 690010p 0.9
+ 692000p 0.9
+ 692010p -0.3
+ 694000p -0.3
+ 694010p 0.9
+ 696000p 0.9
+ 696010p -0.3
+ 698000p -0.3
+ 698010p 0.9
+ 700000p 0.9
+ 700010p -0.3
+ 702000p -0.3
+ 702010p 0.9
+ 704000p 0.9
+ 704010p -0.3
+ 706000p -0.3
+ 706010p 0.9
+ 708000p 0.9
+ 708010p -0.3
+ 710000p -0.3
+ 710010p 0.9
+ 712000p 0.9
+ 712010p -0.3
+ 714000p -0.3
+ 714010p 0.9
+ 716000p 0.9
+ 716010p -0.3
+ 718000p -0.3
+ 718010p 0.9
+ 720000p 0.9
+ 720010p -0.3
+ 722000p -0.3
+ 722010p 0.9
+ 724000p 0.9
+ 724010p -0.3
+ 726000p -0.3
+ 726010p 0.9
+ 728000p 0.9
+ 728010p -0.3
+ 730000p -0.3
+ 730010p 0.9
+ 732000p 0.9
+ 732010p -0.3
+ 734000p -0.3
+ 734010p 0.9
+ 736000p 0.9
+ 736010p -0.3
+ 738000p -0.3
+ 738010p 0.9
+ 740000p 0.9
+ 740010p -0.3
+ 742000p -0.3
+ 742010p 0.9
+ 744000p 0.9
+ 744010p -0.3
+ 746000p -0.3
+ 746010p 0.9
+ 748000p 0.9
+ 748010p -0.3
+ 750000p -0.3
+ 750010p 0.9
+ 752000p 0.9
+ 752010p -0.3
+ 754000p -0.3
+ 754010p 0.9
+ 756000p 0.9
+ 756010p -0.3
+ 758000p -0.3
+ 758010p 0.9
+ 760000p 0.9
+ 760010p -0.3
+ 762000p -0.3
+ 762010p 0.9
+ 764000p 0.9
+ 764010p -0.3
+ 766000p -0.3
+ 766010p 0.9
+ 768000p 0.9
+ 768010p -0.3
+ 770000p -0.3
+ 770010p 0.9
+ 772000p 0.9
+ 772010p -0.3
+ 774000p -0.3
+ 774010p 0.9
+ 776000p 0.9
+ 776010p -0.3
+ 778000p -0.3
+ 778010p 0.9
+ 780000p 0.9
+ 780010p -0.3
+ 782000p -0.3
+ 782010p 0.9
+ 784000p 0.9
+ 784010p -0.3
+ 786000p -0.3
+ 786010p 0.9
+ 788000p 0.9
+ 788010p -0.3
+ 790000p -0.3
+ 790010p 0.9
+ 792000p 0.9
+ 792010p -0.3
+ 794000p -0.3
+ 794010p 0.9
+ 796000p 0.9
+ 796010p -0.3
+ 798000p -0.3
+ 798010p 0.9
+ 800000p 0.9
+ 800010p -0.3
+ 802000p -0.3
+ 802010p 0.9
+ 804000p 0.9
+ 804010p -0.3
+ 806000p -0.3
+ 806010p 0.9
+ 808000p 0.9
+ 808010p -0.3
+ 810000p -0.3
+ 810010p 0.9
+ 812000p 0.9
+ 812010p -0.3
+ 814000p -0.3
+ 814010p 0.9
+ 816000p 0.9
+ 816010p -0.3
+ 818000p -0.3
+ 818010p 0.9
+ 820000p 0.9
+ 820010p -0.3
+ 822000p -0.3
+ 822010p 0.9
+ 824000p 0.9
+ 824010p -0.3
+ 826000p -0.3
+ 826010p 0.9
+ 828000p 0.9
+ 828010p -0.3
+ 830000p -0.3
+ 830010p 0.9
+ 832000p 0.9
+ 832010p -0.3
+ 834000p -0.3
+ 834010p 0.9
+ 836000p 0.9
+ 836010p -0.3
+ 838000p -0.3
+ 838010p 0.9
+ 840000p 0.9
+ 840010p -0.3
+ 842000p -0.3
+ 842010p 0.9
+ 844000p 0.9
+ 844010p -0.3
+ 846000p -0.3
+ 846010p 0.9
+ 848000p 0.9
+ 848010p -0.3
+ 850000p -0.3
+ 850010p 0.9
+ 852000p 0.9
+ 852010p -0.3
+ 854000p -0.3
+ 854010p 0.9
+ 856000p 0.9
+ 856010p -0.3
+ 858000p -0.3
+ 858010p 0.9
+ 860000p 0.9
+ 860010p -0.3
+ 862000p -0.3
+ 862010p 0.9
+ 864000p 0.9
+ 864010p -0.3
+ 866000p -0.3
+ 866010p 0.9
+ 868000p 0.9
+ 868010p -0.3
+ 870000p -0.3
+ 870010p 0.9
+ 872000p 0.9
+ 872010p -0.3
+ 874000p -0.3
+ 874010p 0.9
+ 876000p 0.9
+ 876010p -0.3
+ 878000p -0.3
+ 878010p 0.9
+ 880000p 0.9
+ 880010p -0.3
+ 882000p -0.3
+ 882010p 0.9
+ 884000p 0.9
+ 884010p -0.3
+ 886000p -0.3
+ 886010p 0.9
+ 888000p 0.9
+ 888010p -0.3
+ 890000p -0.3
+ 890010p 0.9
+ 892000p 0.9
+ 892010p -0.3
+ 894000p -0.3
+ 894010p 0.9
+ 896000p 0.9
+ 896010p -0.3
+ 898000p -0.3
+ 898010p 0.9
+ 900000p 0.9
+ 900010p -0.3
+ 902000p -0.3
+ 902010p 0.9
+ 904000p 0.9
+ 904010p -0.3
+ 906000p -0.3
+ 906010p 0.9
+ 908000p 0.9
+ 908010p -0.3
+ 910000p -0.3
+ 910010p 0.9
+ 912000p 0.9
+ 912010p -0.3
+ 914000p -0.3
+ 914010p 0.9
+ 916000p 0.9
+ 916010p -0.3
+ 918000p -0.3
+ 918010p 0.9
+ 920000p 0.9
+ 920010p -0.3
+ 922000p -0.3
+ 922010p 0.9
+ 924000p 0.9
+ 924010p -0.3
+ 926000p -0.3
+ 926010p 0.9
+ 928000p 0.9
+ 928010p -0.3
+ 930000p -0.3
+ 930010p 0.9
+ 932000p 0.9
+ 932010p -0.3
+ 934000p -0.3
+ 934010p 0.9
+ 936000p 0.9
+ 936010p -0.3
+ 938000p -0.3
+ 938010p 0.9
+ 940000p 0.9
+ 940010p -0.3
+ 942000p -0.3
+ 942010p 0.9
+ 944000p 0.9
+ 944010p -0.3
+ 946000p -0.3
+ 946010p 0.9
+ 948000p 0.9
+ 948010p -0.3
+ 950000p -0.3
+ 950010p 0.9
+ 952000p 0.9
+ 952010p -0.3
+ 954000p -0.3
+ 954010p 0.9
+ 956000p 0.9
+ 956010p -0.3
+ 958000p -0.3
+ 958010p 0.9
+ 960000p 0.9
+ 960010p -0.3
+ 962000p -0.3
+ 962010p 0.9
+ 964000p 0.9
+ 964010p -0.3
+ 966000p -0.3
+ 966010p 0.9
+ 968000p 0.9
+ 968010p -0.3
+ 970000p -0.3
+ 970010p 0.9
+ 972000p 0.9
+ 972010p -0.3
+ 974000p -0.3
+ 974010p 0.9
+ 976000p 0.9
+ 976010p -0.3
+ 978000p -0.3
+ 978010p 0.9
+ 980000p 0.9
+ 980010p -0.3
+ 982000p -0.3
+ 982010p 0.9
+ 984000p 0.9
+ 984010p -0.3
+ 986000p -0.3
+ 986010p 0.9
+ 988000p 0.9
+ 988010p -0.3
+ 990000p -0.3
+ 990010p 0.9
+ 992000p 0.9
+ 992010p -0.3
+ 994000p -0.3
+ 994010p 0.9
+ 996000p 0.9
+ 996010p -0.3
+ 998000p -0.3
+ 998010p 0.9
+ 1000000p 0.9
+ 1000010p -0.3
+ 1002000p -0.3
+ 1002010p 0.9
+ 1004000p 0.9
+ 1004010p -0.3
+ 1006000p -0.3
+ 1006010p 0.9
+ 1008000p 0.9
+ 1008010p -0.3
+ 1010000p -0.3
+ 1010010p 0.9
+ 1012000p 0.9
+ 1012010p -0.3
+ 1014000p -0.3
+ 1014010p 0.9
+ 1016000p 0.9
+ 1016010p -0.3
+ 1018000p -0.3
+ 1018010p 0.9
+ 1020000p 0.9
+ 1020010p -0.3
+ 1022000p -0.3
+ 1022010p 0.9
+ 1024000p 0.9
+ 1024010p -0.3
+ 1026000p -0.3
+ 1026010p 0.9
+ 1028000p 0.9
+ 1028010p -0.3
+ 1030000p -0.3
+ 1030010p 0.9
+ 1032000p 0.9
+ 1032010p -0.3
+ 1034000p -0.3
+ 1034010p 0.9
+ 1036000p 0.9
+ 1036010p -0.3
+ 1038000p -0.3
+ 1038010p 0.9
+ 1040000p 0.9
+ 1040010p -0.3
+ 1042000p -0.3
+ 1042010p 0.9
+ 1044000p 0.9
+ 1044010p -0.3
+ 1046000p -0.3
+ 1046010p 0.9
+ 1048000p 0.9
+ 1048010p -0.3
+ 1050000p -0.3
+ 1050010p 0.9
+ 1052000p 0.9
+ 1052010p -0.3
+ 1054000p -0.3
+ 1054010p 0.9
+ 1056000p 0.9
+ 1056010p -0.3
+ 1058000p -0.3
+ 1058010p 0.9
+ 1060000p 0.9
+ 1060010p -0.3
+ 1062000p -0.3
+ 1062010p 0.9
+ 1064000p 0.9
+ 1064010p -0.3
+ 1066000p -0.3
+ 1066010p 0.9
+ 1068000p 0.9
+ 1068010p -0.3
+ 1070000p -0.3
+ 1070010p 0.9
+ 1072000p 0.9
+ 1072010p -0.3
+ 1074000p -0.3
+ 1074010p 0.9
+ 1076000p 0.9
+ 1076010p -0.3
+ 1078000p -0.3
+ 1078010p 0.9
+ 1080000p 0.9
+ 1080010p -0.3
+ 1082000p -0.3
+ 1082010p 0.9
+ 1084000p 0.9
+ 1084010p -0.3
+ 1086000p -0.3
+ 1086010p 0.9
+ 1088000p 0.9
+ 1088010p -0.3
+ 1090000p -0.3
+ 1090010p 0.9
+ 1092000p 0.9
+ 1092010p -0.3
+ 1094000p -0.3
+ 1094010p 0.9
+ 1096000p 0.9
+ 1096010p -0.3
+ 1098000p -0.3
+ 1098010p 0.9
+ 1100000p 0.9
+ 1100010p -0.3
+ 1102000p -0.3
+ 1102010p 0.9
+ 1104000p 0.9
+ 1104010p -0.3
+ 1106000p -0.3
+ 1106010p 0.9
+ 1108000p 0.9
+ 1108010p -0.3
+ 1110000p -0.3
+ 1110010p 0.9
+ 1112000p 0.9
+ 1112010p -0.3
+ 1114000p -0.3
+ 1114010p 0.9
+ 1116000p 0.9
+ 1116010p -0.3
+ 1118000p -0.3
+ 1118010p 0.9
+ 1120000p 0.9
+ 1120010p -0.3
+ 1122000p -0.3
+ 1122010p 0.9
+ 1124000p 0.9
+ 1124010p -0.3
+ 1126000p -0.3
+ 1126010p 0.9
+ 1128000p 0.9
+ 1128010p -0.3
+ 1130000p -0.3
+ 1130010p 0.9
+ 1132000p 0.9
+ 1132010p -0.3
+ 1134000p -0.3
+ 1134010p 0.9
+ 1136000p 0.9
+ 1136010p -0.3
+ 1138000p -0.3
+ 1138010p 0.9
+ 1140000p 0.9
+ 1140010p -0.3
+ 1142000p -0.3
+ 1142010p 0.9
+ 1144000p 0.9
+ 1144010p -0.3
+ 1146000p -0.3
+ 1146010p 0.9
+ 1148000p 0.9
+ 1148010p -0.3
+ 1150000p -0.3
+ 1150010p 0.9
+ 1152000p 0.9
+ 1152010p -0.3
+ 1154000p -0.3
+ 1154010p 0.9
+ 1156000p 0.9
+ 1156010p -0.3
+ 1158000p -0.3
+ 1158010p 0.9
+ 1160000p 0.9
+ 1160010p -0.3
+ 1162000p -0.3
+ 1162010p 0.9
+ 1164000p 0.9
+ 1164010p -0.3
+ 1166000p -0.3
+ 1166010p 0.9
+ 1168000p 0.9
+ 1168010p -0.3
+ 1170000p -0.3
+ 1170010p 0.9
+ 1172000p 0.9
+ 1172010p -0.3
+ 1174000p -0.3
+ 1174010p 0.9
+ 1176000p 0.9
+ 1176010p -0.3
+ 1178000p -0.3
+ 1178010p 0.9
+ 1180000p 0.9
+ 1180010p -0.3
+ 1182000p -0.3
+ 1182010p 0.9
+ 1184000p 0.9
+ 1184010p -0.3
+ 1186000p -0.3
+ 1186010p 0.9
+ 1188000p 0.9
+ 1188010p -0.3
+ 1190000p -0.3
+ 1190010p 0.9
+ 1192000p 0.9
+ 1192010p -0.3
+ 1194000p -0.3
+ 1194010p 0.9
+ 1196000p 0.9
+ 1196010p -0.3
+ 1198000p -0.3
+ 1198010p 0.9
+ 1200000p 0.9
+ 1200010p -0.3
+ 1202000p -0.3
+ 1202010p 0.9
+ 1204000p 0.9
+ 1204010p -0.3
+ 1206000p -0.3
+ 1206010p 0.9
+ 1208000p 0.9
+ 1208010p -0.3
+ 1210000p -0.3
+ 1210010p 0.9
+ 1212000p 0.9
+ 1212010p -0.3
+ 1214000p -0.3
+ 1214010p 0.9
+ 1216000p 0.9
+ 1216010p -0.3
+ 1218000p -0.3
+ 1218010p 0.9
+ 1220000p 0.9
+ 1220010p -0.3
+ 1222000p -0.3
+ 1222010p 0.9
+ 1224000p 0.9
+ 1224010p -0.3
+ 1226000p -0.3
+ 1226010p 0.9
+ 1228000p 0.9
+ 1228010p -0.3
+ 1230000p -0.3
+ 1230010p 0.9
+ 1232000p 0.9
+ 1232010p -0.3
+ 1234000p -0.3
+ 1234010p 0.9
+ 1236000p 0.9
+ 1236010p -0.3
+ 1238000p -0.3
+ 1238010p 0.9
+ 1240000p 0.9
+ 1240010p -0.3
+ 1242000p -0.3
+ 1242010p 0.9
+ 1244000p 0.9
+ 1244010p -0.3
+ 1246000p -0.3
+ 1246010p 0.9
+ 1248000p 0.9
+ 1248010p -0.3
+ 1250000p -0.3
+ 1250010p 0.9
+ 1252000p 0.9
+ 1252010p -0.3
+ 1254000p -0.3
+ 1254010p 0.9
+ 1256000p 0.9
+ 1256010p -0.3
+ 1258000p -0.3
+ 1258010p 0.9
+ 1260000p 0.9
+ 1260010p -0.3
+ 1262000p -0.3
+ 1262010p 0.9
+ 1264000p 0.9
+ 1264010p -0.3
+ 1266000p -0.3
+ 1266010p 0.9
+ 1268000p 0.9
+ 1268010p -0.3
+ 1270000p -0.3
+ 1270010p 0.9
+ 1272000p 0.9
+ 1272010p -0.3
+ 1274000p -0.3
+ 1274010p 0.9
+ 1276000p 0.9
+ 1276010p -0.3
+ 1278000p -0.3
+ 1278010p 0.9
+ 1280000p 0.9
+ 1280010p -0.3
+ 1282000p -0.3
+ 1282010p 0.9
+ 1284000p 0.9
+ 1284010p -0.3
+ 1286000p -0.3
+ 1286010p 0.9
+ 1288000p 0.9
+ 1288010p -0.3
+ 1290000p -0.3
+ 1290010p 0.9
+ 1292000p 0.9
+ 1292010p -0.3
+ 1294000p -0.3
+ 1294010p 0.9
+ 1296000p 0.9
+ 1296010p -0.3
+ 1298000p -0.3
+ 1298010p 0.9
+ 1300000p 0.9
+ 1300010p -0.3
+ 1302000p -0.3
+ 1302010p 0.9
+ 1304000p 0.9
+ 1304010p -0.3
+ 1306000p -0.3
+ 1306010p 0.9
+ 1308000p 0.9
+ 1308010p -0.3
+ 1310000p -0.3
+ 1310010p 0.9
+ 1312000p 0.9
+ 1312010p -0.3
+ 1314000p -0.3
+ 1314010p 0.9
+ 1316000p 0.9
+ 1316010p -0.3
+ 1318000p -0.3
+ 1318010p 0.9
+ 1320000p 0.9
+ 1320010p -0.3
+ 1322000p -0.3
+ 1322010p 0.9
+ 1324000p 0.9
+ 1324010p -0.3
+ 1326000p -0.3
+ 1326010p 0.9
+ 1328000p 0.9
+ 1328010p -0.3
+ 1330000p -0.3
+ 1330010p 0.9
+ 1332000p 0.9
+ 1332010p -0.3
+ 1334000p -0.3
+ 1334010p 0.9
+ 1336000p 0.9
+ 1336010p -0.3
+ 1338000p -0.3
+ 1338010p 0.9
+ 1340000p 0.9
+ 1340010p -0.3
+ 1342000p -0.3
+ 1342010p 0.9
+ 1344000p 0.9
+ 1344010p -0.3
+ 1346000p -0.3
+ 1346010p 0.9
+ 1348000p 0.9
+ 1348010p -0.3
+ 1350000p -0.3
+ 1350010p 0.9
+ 1352000p 0.9
+ 1352010p -0.3
+ 1354000p -0.3
+ 1354010p 0.9
+ 1356000p 0.9
+ 1356010p -0.3
+ 1358000p -0.3
+ 1358010p 0.9
+ 1360000p 0.9
+ 1360010p -0.3
+ 1362000p -0.3
+ 1362010p 0.9
+ 1364000p 0.9
+ 1364010p -0.3
+ 1366000p -0.3
+ 1366010p 0.9
+ 1368000p 0.9
+ 1368010p -0.3
+ 1370000p -0.3
+ 1370010p 0.9
+ 1372000p 0.9
+ 1372010p -0.3
+ 1374000p -0.3
+ 1374010p 0.9
+ 1376000p 0.9
+ 1376010p -0.3
+ 1378000p -0.3
+ 1378010p 0.9
+ 1380000p 0.9
+ 1380010p -0.3
+ 1382000p -0.3
+ 1382010p 0.9
+ 1384000p 0.9
+ 1384010p -0.3
+ 1386000p -0.3
+ 1386010p 0.9
+ 1388000p 0.9
+ 1388010p -0.3
+ 1390000p -0.3
+ 1390010p 0.9
+ 1392000p 0.9
+ 1392010p -0.3
+ 1394000p -0.3
+ 1394010p 0.9
+ 1396000p 0.9
+ 1396010p -0.3
+ 1398000p -0.3
+ 1398010p 0.9
+ 1400000p 0.9
+ 1400010p -0.3
+ 1402000p -0.3
+ 1402010p 0.9
+ 1404000p 0.9
+ 1404010p -0.3
+ 1406000p -0.3
+ 1406010p 0.9
+ 1408000p 0.9
+ 1408010p -0.3
+ 1410000p -0.3
+ 1410010p 0.9
+ 1412000p 0.9
+ 1412010p -0.3
+ 1414000p -0.3
+ 1414010p 0.9
+ 1416000p 0.9
+ 1416010p -0.3
+ 1418000p -0.3
+ 1418010p 0.9
+ 1420000p 0.9
+ 1420010p -0.3
+ 1422000p -0.3
+ 1422010p 0.9
+ 1424000p 0.9
+ 1424010p -0.3
+ 1426000p -0.3
+ 1426010p 0.9
+ 1428000p 0.9
+ 1428010p -0.3
+ 1430000p -0.3
+ 1430010p 0.9
+ 1432000p 0.9
+ 1432010p -0.3
+ 1434000p -0.3
+ 1434010p 0.9
+ 1436000p 0.9
+ 1436010p -0.3
+ 1438000p -0.3
+ 1438010p 0.9
+ 1440000p 0.9
+ 1440010p -0.3
+ 1442000p -0.3
+ 1442010p 0.9
+ 1444000p 0.9
+ 1444010p -0.3
+ 1446000p -0.3
+ 1446010p 0.9
+ 1448000p 0.9
+ 1448010p -0.3
+ 1450000p -0.3
+ 1450010p 0.9
+ 1452000p 0.9
+ 1452010p -0.3
+ 1454000p -0.3
+ 1454010p 0.9
+ 1456000p 0.9
+ 1456010p -0.3
+ 1458000p -0.3
+ 1458010p 0.9
+ 1460000p 0.9
+ 1460010p -0.3
+ 1462000p -0.3
+ 1462010p 0.9
+ 1464000p 0.9
+ 1464010p -0.3
+ 1466000p -0.3
+ 1466010p 0.9
+ 1468000p 0.9
+ 1468010p -0.3
+ 1470000p -0.3
+ 1470010p 0.9
+ 1472000p 0.9
+ 1472010p -0.3
+ 1474000p -0.3
+ 1474010p 0.9
+ 1476000p 0.9
+ 1476010p -0.3
+ 1478000p -0.3
+ 1478010p 0.9
+ 1480000p 0.9
+ 1480010p -0.3
+ 1482000p -0.3
+ 1482010p 0.9
+ 1484000p 0.9
+ 1484010p -0.3
+ 1486000p -0.3
+ 1486010p 0.9
+ 1488000p 0.9
+ 1488010p -0.3
+ 1490000p -0.3
+ 1490010p 0.9
+ 1492000p 0.9
+ 1492010p -0.3
+ 1494000p -0.3
+ 1494010p 0.9
+ 1496000p 0.9
+ 1496010p -0.3
+ 1498000p -0.3
+ 1498010p 0.9
+ 1500000p 0.9
+ 1500010p -0.3
+ 1502000p -0.3
+ 1502010p 0.9
+ 1504000p 0.9
+ 1504010p -0.3
+ 1506000p -0.3
+ 1506010p 0.9
+ 1508000p 0.9
+ 1508010p -0.3
+ 1510000p -0.3
+ 1510010p 0.9
+ 1512000p 0.9
+ 1512010p -0.3
+ 1514000p -0.3
+ 1514010p 0.9
+ 1516000p 0.9
+ 1516010p -0.3
+ 1518000p -0.3
+ 1518010p 0.9
+ 1520000p 0.9
+ 1520010p -0.3
+ 1522000p -0.3
+ 1522010p 0.9
+ 1524000p 0.9
+ 1524010p -0.3
+ 1526000p -0.3
+ 1526010p 0.9
+ 1528000p 0.9
+ 1528010p -0.3
+ 1530000p -0.3
+ 1530010p 0.9
+ 1532000p 0.9
+ 1532010p -0.3
+ 1534000p -0.3
+ 1534010p 0.9
+ 1536000p 0.9
+ 1536010p -0.3
+ 1538000p -0.3
+ 1538010p 0.9
+ 1540000p 0.9
+ 1540010p -0.3
+ 1542000p -0.3
+ 1542010p 0.9
+ 1544000p 0.9
+ 1544010p -0.3
+ 1546000p -0.3
+ 1546010p 0.9
+ 1548000p 0.9
+ 1548010p -0.3
+ 1550000p -0.3
+ 1550010p 0.9
+ 1552000p 0.9
+ 1552010p -0.3
+ 1554000p -0.3
+ 1554010p 0.9
+ 1556000p 0.9
+ 1556010p -0.3
+ 1558000p -0.3
+ 1558010p 0.9
+ 1560000p 0.9
+ 1560010p -0.3
+ 1562000p -0.3
+ 1562010p 0.9
+ 1564000p 0.9
+ 1564010p -0.3
+ 1566000p -0.3
+ 1566010p 0.9
+ 1568000p 0.9
+ 1568010p -0.3
+ 1570000p -0.3
+ 1570010p 0.9
+ 1572000p 0.9
+ 1572010p -0.3
+ 1574000p -0.3
+ 1574010p 0.9
+ 1576000p 0.9
+ 1576010p -0.3
+ 1578000p -0.3
+ 1578010p 0.9
+ 1580000p 0.9
+ 1580010p -0.3
+ 1582000p -0.3
+ 1582010p 0.9
+ 1584000p 0.9
+ 1584010p -0.3
+ 1586000p -0.3
+ 1586010p 0.9
+ 1588000p 0.9
+ 1588010p -0.3
+ 1590000p -0.3
+ 1590010p 0.9
+ 1592000p 0.9
+ 1592010p -0.3
+ 1594000p -0.3
+ 1594010p 0.9
+ 1596000p 0.9
+ 1596010p -0.3
+ 1598000p -0.3
+ 1598010p 0.9
+ 1600000p 0.9
+ 1600010p -0.3
+ 1602000p -0.3
+ 1602010p 0.9
+ 1604000p 0.9
+ 1604010p -0.3
+ 1606000p -0.3
+ 1606010p 0.9
+ 1608000p 0.9
+ 1608010p -0.3
+ 1610000p -0.3
+ 1610010p 0.9
+ 1612000p 0.9
+ 1612010p -0.3
+ 1614000p -0.3
+ 1614010p 0.9
+ 1616000p 0.9
+ 1616010p -0.3
+ 1618000p -0.3
+ 1618010p 0.9
+ 1620000p 0.9
+ 1620010p -0.3
+ 1622000p -0.3
+ 1622010p 0.9
+ 1624000p 0.9
+ 1624010p -0.3
+ 1626000p -0.3
+ 1626010p 0.9
+ 1628000p 0.9
+ 1628010p -0.3
+ 1630000p -0.3
+ 1630010p 0.9
+ 1632000p 0.9
+ 1632010p -0.3
+ 1634000p -0.3
+ 1634010p 0.9
+ 1636000p 0.9
+ 1636010p -0.3
+ 1638000p -0.3
+ 1638010p 0.9
+ 1640000p 0.9
+ 1640010p -0.3
+ 1642000p -0.3
+ 1642010p 0.9
+ 1644000p 0.9
+ 1644010p -0.3
+ 1646000p -0.3
+ 1646010p 0.9
+ 1648000p 0.9
+ 1648010p -0.3
+ 1650000p -0.3
+ 1650010p 0.9
+ 1652000p 0.9
+ 1652010p -0.3
+ 1654000p -0.3
+ 1654010p 0.9
+ 1656000p 0.9
+ 1656010p -0.3
+ 1658000p -0.3
+ 1658010p 0.9
+ 1660000p 0.9
+ 1660010p -0.3
+ 1662000p -0.3
+ 1662010p 0.9
+ 1664000p 0.9
+ 1664010p -0.3
+ 1666000p -0.3
+ 1666010p 0.9
+ 1668000p 0.9
+ 1668010p -0.3
+ 1670000p -0.3
+ 1670010p 0.9
+ 1672000p 0.9
+ 1672010p -0.3
+ 1674000p -0.3
+ 1674010p 0.9
+ 1676000p 0.9
+ 1676010p -0.3
+ 1678000p -0.3
+ 1678010p 0.9
+ 1680000p 0.9
+ 1680010p -0.3
+ 1682000p -0.3
+ 1682010p 0.9
+ 1684000p 0.9
+ 1684010p -0.3
+ 1686000p -0.3
+ 1686010p 0.9
+ 1688000p 0.9
+ 1688010p -0.3
+ 1690000p -0.3
+ 1690010p 0.9
+ 1692000p 0.9
+ 1692010p -0.3
+ 1694000p -0.3
+ 1694010p 0.9
+ 1696000p 0.9
+ 1696010p -0.3
+ 1698000p -0.3
+ 1698010p 0.9
+ 1700000p 0.9
+ 1700010p -0.3
+ 1702000p -0.3
+ 1702010p 0.9
+ 1704000p 0.9
+ 1704010p -0.3
+ 1706000p -0.3
+ 1706010p 0.9
+ 1708000p 0.9
+ 1708010p -0.3
+ 1710000p -0.3
+ 1710010p 0.9
+ 1712000p 0.9
+ 1712010p -0.3
+ 1714000p -0.3
+ 1714010p 0.9
+ 1716000p 0.9
+ 1716010p -0.3
+ 1718000p -0.3
+ 1718010p 0.9
+ 1720000p 0.9
+ 1720010p -0.3
+ 1722000p -0.3
+ 1722010p 0.9
+ 1724000p 0.9
+ 1724010p -0.3
+ 1726000p -0.3
+ 1726010p 0.9
+ 1728000p 0.9
+ 1728010p -0.3
+ 1730000p -0.3
+ 1730010p 0.9
+ 1732000p 0.9
+ 1732010p -0.3
+ 1734000p -0.3
+ 1734010p 0.9
+ 1736000p 0.9
+ 1736010p -0.3
+ 1738000p -0.3
+ 1738010p 0.9
+ 1740000p 0.9
+ 1740010p -0.3
+ 1742000p -0.3
+ 1742010p 0.9
+ 1744000p 0.9
+ 1744010p -0.3
+ 1746000p -0.3
+ 1746010p 0.9
+ 1748000p 0.9
+ 1748010p -0.3
+ 1750000p -0.3
+ 1750010p 0.9
+ 1752000p 0.9
+ 1752010p -0.3
+ 1754000p -0.3
+ 1754010p 0.9
+ 1756000p 0.9
+ 1756010p -0.3
+ 1758000p -0.3
+ 1758010p 0.9
+ 1760000p 0.9
+ 1760010p -0.3
+ 1762000p -0.3
+ 1762010p 0.9
+ 1764000p 0.9
+ 1764010p -0.3
+ 1766000p -0.3
+ 1766010p 0.9
+ 1768000p 0.9
+ 1768010p -0.3
+ 1770000p -0.3
+ 1770010p 0.9
+ 1772000p 0.9
+ 1772010p -0.3
+ 1774000p -0.3
+ 1774010p 0.9
+ 1776000p 0.9
+ 1776010p -0.3
+ 1778000p -0.3
+ 1778010p 0.9
+ 1780000p 0.9
+ 1780010p -0.3
+ 1782000p -0.3
+ 1782010p 0.9
+ 1784000p 0.9
+ 1784010p -0.3
+ 1786000p -0.3
+ 1786010p 0.9
+ 1788000p 0.9
+ 1788010p -0.3
+ 1790000p -0.3
+ 1790010p 0.9
+ 1792000p 0.9
+ 1792010p -0.3
+ 1794000p -0.3
+ 1794010p 0.9
+ 1796000p 0.9
+ 1796010p -0.3
+ 1798000p -0.3
+ 1798010p 0.9
+ 1800000p 0.9
+ 1800010p -0.3
+ 1802000p -0.3
+ 1802010p 0.9
+ 1804000p 0.9
+ 1804010p -0.3
+ 1806000p -0.3
+ 1806010p 0.9
+ 1808000p 0.9
+ 1808010p -0.3
+ 1810000p -0.3
+ 1810010p 0.9
+ 1812000p 0.9
+ 1812010p -0.3
+ 1814000p -0.3
+ 1814010p 0.9
+ 1816000p 0.9
+ 1816010p -0.3
+ 1818000p -0.3
+ 1818010p 0.9
+ 1820000p 0.9
+ 1820010p -0.3
+ 1822000p -0.3
+ 1822010p 0.9
+ 1824000p 0.9
+ 1824010p -0.3
+ 1826000p -0.3
+ 1826010p 0.9
+ 1828000p 0.9
+ 1828010p -0.3
+ 1830000p -0.3
+ 1830010p 0.9
+ 1832000p 0.9
+ 1832010p -0.3
+ 1834000p -0.3
+ 1834010p 0.9
+ 1836000p 0.9
+ 1836010p -0.3
+ 1838000p -0.3
+ 1838010p 0.9
+ 1840000p 0.9
+ 1840010p -0.3
+ 1842000p -0.3
+ 1842010p 0.9
+ 1844000p 0.9
+ 1844010p -0.3
+ 1846000p -0.3
+ 1846010p 0.9
+ 1848000p 0.9
+ 1848010p -0.3
+ 1850000p -0.3
+ 1850010p 0.9
+ 1852000p 0.9
+ 1852010p -0.3
+ 1854000p -0.3
+ 1854010p 0.9
+ 1856000p 0.9
+ 1856010p -0.3
+ 1858000p -0.3
+ 1858010p 0.9
+ 1860000p 0.9
+ 1860010p -0.3
+ 1862000p -0.3
+ 1862010p 0.9
+ 1864000p 0.9
+ 1864010p -0.3
+ 1866000p -0.3
+ 1866010p 0.9
+ 1868000p 0.9
+ 1868010p -0.3
+ 1870000p -0.3
+ 1870010p 0.9
+ 1872000p 0.9
+ 1872010p -0.3
+ 1874000p -0.3
+ 1874010p 0.9
+ 1876000p 0.9
+ 1876010p -0.3
+ 1878000p -0.3
+ 1878010p 0.9
+ 1880000p 0.9
+ 1880010p -0.3
+ 1882000p -0.3
+ 1882010p 0.9
+ 1884000p 0.9
+ 1884010p -0.3
+ 1886000p -0.3
+ 1886010p 0.9
+ 1888000p 0.9
+ 1888010p -0.3
+ 1890000p -0.3
+ 1890010p 0.9
+ 1892000p 0.9
+ 1892010p -0.3
+ 1894000p -0.3
+ 1894010p 0.9
+ 1896000p 0.9
+ 1896010p -0.3
+ 1898000p -0.3
+ 1898010p 0.9
+ 1900000p 0.9
+ 1900010p -0.3
+ 1902000p -0.3
+ 1902010p 0.9
+ 1904000p 0.9
+ 1904010p -0.3
+ 1906000p -0.3
+ 1906010p 0.9
+ 1908000p 0.9
+ 1908010p -0.3
+ 1910000p -0.3
+ 1910010p 0.9
+ 1912000p 0.9
+ 1912010p -0.3
+ 1914000p -0.3
+ 1914010p 0.9
+ 1916000p 0.9
+ 1916010p -0.3
+ 1918000p -0.3
+ 1918010p 0.9
+ 1920000p 0.9
+ 1920010p -0.3
+ 1922000p -0.3
+ 1922010p 0.9
+ 1924000p 0.9
+ 1924010p -0.3
+ 1926000p -0.3
+ 1926010p 0.9
+ 1928000p 0.9
+ 1928010p -0.3
+ 1930000p -0.3
+ 1930010p 0.9
+ 1932000p 0.9
+ 1932010p -0.3
+ 1934000p -0.3
+ 1934010p 0.9
+ 1936000p 0.9
+ 1936010p -0.3
+ 1938000p -0.3
+ 1938010p 0.9
+ 1940000p 0.9
+ 1940010p -0.3
+ 1942000p -0.3
+ 1942010p 0.9
+ 1944000p 0.9
+ 1944010p -0.3
+ 1946000p -0.3
+ 1946010p 0.9
+ 1948000p 0.9
+ 1948010p -0.3
+ 1950000p -0.3
+ 1950010p 0.9
+ 1952000p 0.9
+ 1952010p -0.3
+ 1954000p -0.3
+ 1954010p 0.9
+ 1956000p 0.9
+ 1956010p -0.3
+ 1958000p -0.3
+ 1958010p 0.9
+ 1960000p 0.9
+ 1960010p -0.3
+ 1962000p -0.3
+ 1962010p 0.9
+ 1964000p 0.9
+ 1964010p -0.3
+ 1966000p -0.3
+ 1966010p 0.9
+ 1968000p 0.9
+ 1968010p -0.3
+ 1970000p -0.3
+ 1970010p 0.9
+ 1972000p 0.9
+ 1972010p -0.3
+ 1974000p -0.3
+ 1974010p 0.9
+ 1976000p 0.9
+ 1976010p -0.3
+ 1978000p -0.3
+ 1978010p 0.9
+ 1980000p 0.9
+ 1980010p -0.3
+ 1982000p -0.3
+ 1982010p 0.9
+ 1984000p 0.9
+ 1984010p -0.3
+ 1986000p -0.3
+ 1986010p 0.9
+ 1988000p 0.9
+ 1988010p -0.3
+ 1990000p -0.3
+ 1990010p 0.9
+ 1992000p 0.9
+ 1992010p -0.3
+ 1994000p -0.3
+ 1994010p 0.9
+ 1996000p 0.9
+ 1996010p -0.3
+ 1998000p -0.3
+ 1998010p 0.9
+ 2000000p 0.9
+ 2000010p -0.3
+ 2002000p -0.3
+ 2002010p 0.9
+ 2004000p 0.9
+ 2004010p -0.3
+ 2006000p -0.3
+ 2006010p 0.9
+ 2008000p 0.9
+ 2008010p -0.3
+ 2010000p -0.3
+ 2010010p 0.9
+ 2012000p 0.9
+ 2012010p -0.3
+ 2014000p -0.3
+ 2014010p 0.9
+ 2016000p 0.9
+ 2016010p -0.3
+ 2018000p -0.3
+ 2018010p 0.9
+ 2020000p 0.9
+ 2020010p -0.3
+ 2022000p -0.3
+ 2022010p 0.9
+ 2024000p 0.9
+ 2024010p -0.3
+ 2026000p -0.3
+ 2026010p 0.9
+ 2028000p 0.9
+ 2028010p -0.3
+ 2030000p -0.3
+ 2030010p 0.9
+ 2032000p 0.9
+ 2032010p -0.3
+ 2034000p -0.3
+ 2034010p 0.9
+ 2036000p 0.9
+ 2036010p -0.3
+ 2038000p -0.3
+ 2038010p 0.9
+ 2040000p 0.9
+ 2040010p -0.3
+ 2042000p -0.3
+ 2042010p 0.9
+ 2044000p 0.9
+ 2044010p -0.3
+ 2046000p -0.3
+ 2046010p 0.9
+ 2048000p 0.9
+ 2048010p -0.3
+ \]
V_data_24 (Data\\<24\\> gnd!) vsource type=pwl wave=\[
+ 0    0.9
+ 2000p 0.9
+ 2010p -0.3
+ 4000p -0.3
+ 4010p 0.9
+ 6000p 0.9
+ 6010p -0.3
+ 8000p -0.3
+ 8010p 0.9
+ 10000p 0.9
+ 10010p -0.3
+ 12000p -0.3
+ 12010p 0.9
+ 14000p 0.9
+ 14010p -0.3
+ 16000p -0.3
+ 16010p 0.9
+ 18000p 0.9
+ 18010p -0.3
+ 20000p -0.3
+ 20010p 0.9
+ 22000p 0.9
+ 22010p -0.3
+ 24000p -0.3
+ 24010p 0.9
+ 26000p 0.9
+ 26010p -0.3
+ 28000p -0.3
+ 28010p 0.9
+ 30000p 0.9
+ 30010p -0.3
+ 32000p -0.3
+ 32010p 0.9
+ 34000p 0.9
+ 34010p -0.3
+ 36000p -0.3
+ 36010p 0.9
+ 38000p 0.9
+ 38010p -0.3
+ 40000p -0.3
+ 40010p 0.9
+ 42000p 0.9
+ 42010p -0.3
+ 44000p -0.3
+ 44010p 0.9
+ 46000p 0.9
+ 46010p -0.3
+ 48000p -0.3
+ 48010p 0.9
+ 50000p 0.9
+ 50010p -0.3
+ 52000p -0.3
+ 52010p 0.9
+ 54000p 0.9
+ 54010p -0.3
+ 56000p -0.3
+ 56010p 0.9
+ 58000p 0.9
+ 58010p -0.3
+ 60000p -0.3
+ 60010p 0.9
+ 62000p 0.9
+ 62010p -0.3
+ 64000p -0.3
+ 64010p 0.9
+ 66000p 0.9
+ 66010p -0.3
+ 68000p -0.3
+ 68010p 0.9
+ 70000p 0.9
+ 70010p -0.3
+ 72000p -0.3
+ 72010p 0.9
+ 74000p 0.9
+ 74010p -0.3
+ 76000p -0.3
+ 76010p 0.9
+ 78000p 0.9
+ 78010p -0.3
+ 80000p -0.3
+ 80010p 0.9
+ 82000p 0.9
+ 82010p -0.3
+ 84000p -0.3
+ 84010p 0.9
+ 86000p 0.9
+ 86010p -0.3
+ 88000p -0.3
+ 88010p 0.9
+ 90000p 0.9
+ 90010p -0.3
+ 92000p -0.3
+ 92010p 0.9
+ 94000p 0.9
+ 94010p -0.3
+ 96000p -0.3
+ 96010p 0.9
+ 98000p 0.9
+ 98010p -0.3
+ 100000p -0.3
+ 100010p 0.9
+ 102000p 0.9
+ 102010p -0.3
+ 104000p -0.3
+ 104010p 0.9
+ 106000p 0.9
+ 106010p -0.3
+ 108000p -0.3
+ 108010p 0.9
+ 110000p 0.9
+ 110010p -0.3
+ 112000p -0.3
+ 112010p 0.9
+ 114000p 0.9
+ 114010p -0.3
+ 116000p -0.3
+ 116010p 0.9
+ 118000p 0.9
+ 118010p -0.3
+ 120000p -0.3
+ 120010p 0.9
+ 122000p 0.9
+ 122010p -0.3
+ 124000p -0.3
+ 124010p 0.9
+ 126000p 0.9
+ 126010p -0.3
+ 128000p -0.3
+ 128010p 0.9
+ 130000p 0.9
+ 130010p -0.3
+ 132000p -0.3
+ 132010p 0.9
+ 134000p 0.9
+ 134010p -0.3
+ 136000p -0.3
+ 136010p 0.9
+ 138000p 0.9
+ 138010p -0.3
+ 140000p -0.3
+ 140010p 0.9
+ 142000p 0.9
+ 142010p -0.3
+ 144000p -0.3
+ 144010p 0.9
+ 146000p 0.9
+ 146010p -0.3
+ 148000p -0.3
+ 148010p 0.9
+ 150000p 0.9
+ 150010p -0.3
+ 152000p -0.3
+ 152010p 0.9
+ 154000p 0.9
+ 154010p -0.3
+ 156000p -0.3
+ 156010p 0.9
+ 158000p 0.9
+ 158010p -0.3
+ 160000p -0.3
+ 160010p 0.9
+ 162000p 0.9
+ 162010p -0.3
+ 164000p -0.3
+ 164010p 0.9
+ 166000p 0.9
+ 166010p -0.3
+ 168000p -0.3
+ 168010p 0.9
+ 170000p 0.9
+ 170010p -0.3
+ 172000p -0.3
+ 172010p 0.9
+ 174000p 0.9
+ 174010p -0.3
+ 176000p -0.3
+ 176010p 0.9
+ 178000p 0.9
+ 178010p -0.3
+ 180000p -0.3
+ 180010p 0.9
+ 182000p 0.9
+ 182010p -0.3
+ 184000p -0.3
+ 184010p 0.9
+ 186000p 0.9
+ 186010p -0.3
+ 188000p -0.3
+ 188010p 0.9
+ 190000p 0.9
+ 190010p -0.3
+ 192000p -0.3
+ 192010p 0.9
+ 194000p 0.9
+ 194010p -0.3
+ 196000p -0.3
+ 196010p 0.9
+ 198000p 0.9
+ 198010p -0.3
+ 200000p -0.3
+ 200010p 0.9
+ 202000p 0.9
+ 202010p -0.3
+ 204000p -0.3
+ 204010p 0.9
+ 206000p 0.9
+ 206010p -0.3
+ 208000p -0.3
+ 208010p 0.9
+ 210000p 0.9
+ 210010p -0.3
+ 212000p -0.3
+ 212010p 0.9
+ 214000p 0.9
+ 214010p -0.3
+ 216000p -0.3
+ 216010p 0.9
+ 218000p 0.9
+ 218010p -0.3
+ 220000p -0.3
+ 220010p 0.9
+ 222000p 0.9
+ 222010p -0.3
+ 224000p -0.3
+ 224010p 0.9
+ 226000p 0.9
+ 226010p -0.3
+ 228000p -0.3
+ 228010p 0.9
+ 230000p 0.9
+ 230010p -0.3
+ 232000p -0.3
+ 232010p 0.9
+ 234000p 0.9
+ 234010p -0.3
+ 236000p -0.3
+ 236010p 0.9
+ 238000p 0.9
+ 238010p -0.3
+ 240000p -0.3
+ 240010p 0.9
+ 242000p 0.9
+ 242010p -0.3
+ 244000p -0.3
+ 244010p 0.9
+ 246000p 0.9
+ 246010p -0.3
+ 248000p -0.3
+ 248010p 0.9
+ 250000p 0.9
+ 250010p -0.3
+ 252000p -0.3
+ 252010p 0.9
+ 254000p 0.9
+ 254010p -0.3
+ 256000p -0.3
+ 256010p 0.9
+ 258000p 0.9
+ 258010p -0.3
+ 260000p -0.3
+ 260010p 0.9
+ 262000p 0.9
+ 262010p -0.3
+ 264000p -0.3
+ 264010p 0.9
+ 266000p 0.9
+ 266010p -0.3
+ 268000p -0.3
+ 268010p 0.9
+ 270000p 0.9
+ 270010p -0.3
+ 272000p -0.3
+ 272010p 0.9
+ 274000p 0.9
+ 274010p -0.3
+ 276000p -0.3
+ 276010p 0.9
+ 278000p 0.9
+ 278010p -0.3
+ 280000p -0.3
+ 280010p 0.9
+ 282000p 0.9
+ 282010p -0.3
+ 284000p -0.3
+ 284010p 0.9
+ 286000p 0.9
+ 286010p -0.3
+ 288000p -0.3
+ 288010p 0.9
+ 290000p 0.9
+ 290010p -0.3
+ 292000p -0.3
+ 292010p 0.9
+ 294000p 0.9
+ 294010p -0.3
+ 296000p -0.3
+ 296010p 0.9
+ 298000p 0.9
+ 298010p -0.3
+ 300000p -0.3
+ 300010p 0.9
+ 302000p 0.9
+ 302010p -0.3
+ 304000p -0.3
+ 304010p 0.9
+ 306000p 0.9
+ 306010p -0.3
+ 308000p -0.3
+ 308010p 0.9
+ 310000p 0.9
+ 310010p -0.3
+ 312000p -0.3
+ 312010p 0.9
+ 314000p 0.9
+ 314010p -0.3
+ 316000p -0.3
+ 316010p 0.9
+ 318000p 0.9
+ 318010p -0.3
+ 320000p -0.3
+ 320010p 0.9
+ 322000p 0.9
+ 322010p -0.3
+ 324000p -0.3
+ 324010p 0.9
+ 326000p 0.9
+ 326010p -0.3
+ 328000p -0.3
+ 328010p 0.9
+ 330000p 0.9
+ 330010p -0.3
+ 332000p -0.3
+ 332010p 0.9
+ 334000p 0.9
+ 334010p -0.3
+ 336000p -0.3
+ 336010p 0.9
+ 338000p 0.9
+ 338010p -0.3
+ 340000p -0.3
+ 340010p 0.9
+ 342000p 0.9
+ 342010p -0.3
+ 344000p -0.3
+ 344010p 0.9
+ 346000p 0.9
+ 346010p -0.3
+ 348000p -0.3
+ 348010p 0.9
+ 350000p 0.9
+ 350010p -0.3
+ 352000p -0.3
+ 352010p 0.9
+ 354000p 0.9
+ 354010p -0.3
+ 356000p -0.3
+ 356010p 0.9
+ 358000p 0.9
+ 358010p -0.3
+ 360000p -0.3
+ 360010p 0.9
+ 362000p 0.9
+ 362010p -0.3
+ 364000p -0.3
+ 364010p 0.9
+ 366000p 0.9
+ 366010p -0.3
+ 368000p -0.3
+ 368010p 0.9
+ 370000p 0.9
+ 370010p -0.3
+ 372000p -0.3
+ 372010p 0.9
+ 374000p 0.9
+ 374010p -0.3
+ 376000p -0.3
+ 376010p 0.9
+ 378000p 0.9
+ 378010p -0.3
+ 380000p -0.3
+ 380010p 0.9
+ 382000p 0.9
+ 382010p -0.3
+ 384000p -0.3
+ 384010p 0.9
+ 386000p 0.9
+ 386010p -0.3
+ 388000p -0.3
+ 388010p 0.9
+ 390000p 0.9
+ 390010p -0.3
+ 392000p -0.3
+ 392010p 0.9
+ 394000p 0.9
+ 394010p -0.3
+ 396000p -0.3
+ 396010p 0.9
+ 398000p 0.9
+ 398010p -0.3
+ 400000p -0.3
+ 400010p 0.9
+ 402000p 0.9
+ 402010p -0.3
+ 404000p -0.3
+ 404010p 0.9
+ 406000p 0.9
+ 406010p -0.3
+ 408000p -0.3
+ 408010p 0.9
+ 410000p 0.9
+ 410010p -0.3
+ 412000p -0.3
+ 412010p 0.9
+ 414000p 0.9
+ 414010p -0.3
+ 416000p -0.3
+ 416010p 0.9
+ 418000p 0.9
+ 418010p -0.3
+ 420000p -0.3
+ 420010p 0.9
+ 422000p 0.9
+ 422010p -0.3
+ 424000p -0.3
+ 424010p 0.9
+ 426000p 0.9
+ 426010p -0.3
+ 428000p -0.3
+ 428010p 0.9
+ 430000p 0.9
+ 430010p -0.3
+ 432000p -0.3
+ 432010p 0.9
+ 434000p 0.9
+ 434010p -0.3
+ 436000p -0.3
+ 436010p 0.9
+ 438000p 0.9
+ 438010p -0.3
+ 440000p -0.3
+ 440010p 0.9
+ 442000p 0.9
+ 442010p -0.3
+ 444000p -0.3
+ 444010p 0.9
+ 446000p 0.9
+ 446010p -0.3
+ 448000p -0.3
+ 448010p 0.9
+ 450000p 0.9
+ 450010p -0.3
+ 452000p -0.3
+ 452010p 0.9
+ 454000p 0.9
+ 454010p -0.3
+ 456000p -0.3
+ 456010p 0.9
+ 458000p 0.9
+ 458010p -0.3
+ 460000p -0.3
+ 460010p 0.9
+ 462000p 0.9
+ 462010p -0.3
+ 464000p -0.3
+ 464010p 0.9
+ 466000p 0.9
+ 466010p -0.3
+ 468000p -0.3
+ 468010p 0.9
+ 470000p 0.9
+ 470010p -0.3
+ 472000p -0.3
+ 472010p 0.9
+ 474000p 0.9
+ 474010p -0.3
+ 476000p -0.3
+ 476010p 0.9
+ 478000p 0.9
+ 478010p -0.3
+ 480000p -0.3
+ 480010p 0.9
+ 482000p 0.9
+ 482010p -0.3
+ 484000p -0.3
+ 484010p 0.9
+ 486000p 0.9
+ 486010p -0.3
+ 488000p -0.3
+ 488010p 0.9
+ 490000p 0.9
+ 490010p -0.3
+ 492000p -0.3
+ 492010p 0.9
+ 494000p 0.9
+ 494010p -0.3
+ 496000p -0.3
+ 496010p 0.9
+ 498000p 0.9
+ 498010p -0.3
+ 500000p -0.3
+ 500010p 0.9
+ 502000p 0.9
+ 502010p -0.3
+ 504000p -0.3
+ 504010p 0.9
+ 506000p 0.9
+ 506010p -0.3
+ 508000p -0.3
+ 508010p 0.9
+ 510000p 0.9
+ 510010p -0.3
+ 512000p -0.3
+ 512010p 0.9
+ 514000p 0.9
+ 514010p -0.3
+ 516000p -0.3
+ 516010p 0.9
+ 518000p 0.9
+ 518010p -0.3
+ 520000p -0.3
+ 520010p 0.9
+ 522000p 0.9
+ 522010p -0.3
+ 524000p -0.3
+ 524010p 0.9
+ 526000p 0.9
+ 526010p -0.3
+ 528000p -0.3
+ 528010p 0.9
+ 530000p 0.9
+ 530010p -0.3
+ 532000p -0.3
+ 532010p 0.9
+ 534000p 0.9
+ 534010p -0.3
+ 536000p -0.3
+ 536010p 0.9
+ 538000p 0.9
+ 538010p -0.3
+ 540000p -0.3
+ 540010p 0.9
+ 542000p 0.9
+ 542010p -0.3
+ 544000p -0.3
+ 544010p 0.9
+ 546000p 0.9
+ 546010p -0.3
+ 548000p -0.3
+ 548010p 0.9
+ 550000p 0.9
+ 550010p -0.3
+ 552000p -0.3
+ 552010p 0.9
+ 554000p 0.9
+ 554010p -0.3
+ 556000p -0.3
+ 556010p 0.9
+ 558000p 0.9
+ 558010p -0.3
+ 560000p -0.3
+ 560010p 0.9
+ 562000p 0.9
+ 562010p -0.3
+ 564000p -0.3
+ 564010p 0.9
+ 566000p 0.9
+ 566010p -0.3
+ 568000p -0.3
+ 568010p 0.9
+ 570000p 0.9
+ 570010p -0.3
+ 572000p -0.3
+ 572010p 0.9
+ 574000p 0.9
+ 574010p -0.3
+ 576000p -0.3
+ 576010p 0.9
+ 578000p 0.9
+ 578010p -0.3
+ 580000p -0.3
+ 580010p 0.9
+ 582000p 0.9
+ 582010p -0.3
+ 584000p -0.3
+ 584010p 0.9
+ 586000p 0.9
+ 586010p -0.3
+ 588000p -0.3
+ 588010p 0.9
+ 590000p 0.9
+ 590010p -0.3
+ 592000p -0.3
+ 592010p 0.9
+ 594000p 0.9
+ 594010p -0.3
+ 596000p -0.3
+ 596010p 0.9
+ 598000p 0.9
+ 598010p -0.3
+ 600000p -0.3
+ 600010p 0.9
+ 602000p 0.9
+ 602010p -0.3
+ 604000p -0.3
+ 604010p 0.9
+ 606000p 0.9
+ 606010p -0.3
+ 608000p -0.3
+ 608010p 0.9
+ 610000p 0.9
+ 610010p -0.3
+ 612000p -0.3
+ 612010p 0.9
+ 614000p 0.9
+ 614010p -0.3
+ 616000p -0.3
+ 616010p 0.9
+ 618000p 0.9
+ 618010p -0.3
+ 620000p -0.3
+ 620010p 0.9
+ 622000p 0.9
+ 622010p -0.3
+ 624000p -0.3
+ 624010p 0.9
+ 626000p 0.9
+ 626010p -0.3
+ 628000p -0.3
+ 628010p 0.9
+ 630000p 0.9
+ 630010p -0.3
+ 632000p -0.3
+ 632010p 0.9
+ 634000p 0.9
+ 634010p -0.3
+ 636000p -0.3
+ 636010p 0.9
+ 638000p 0.9
+ 638010p -0.3
+ 640000p -0.3
+ 640010p 0.9
+ 642000p 0.9
+ 642010p -0.3
+ 644000p -0.3
+ 644010p 0.9
+ 646000p 0.9
+ 646010p -0.3
+ 648000p -0.3
+ 648010p 0.9
+ 650000p 0.9
+ 650010p -0.3
+ 652000p -0.3
+ 652010p 0.9
+ 654000p 0.9
+ 654010p -0.3
+ 656000p -0.3
+ 656010p 0.9
+ 658000p 0.9
+ 658010p -0.3
+ 660000p -0.3
+ 660010p 0.9
+ 662000p 0.9
+ 662010p -0.3
+ 664000p -0.3
+ 664010p 0.9
+ 666000p 0.9
+ 666010p -0.3
+ 668000p -0.3
+ 668010p 0.9
+ 670000p 0.9
+ 670010p -0.3
+ 672000p -0.3
+ 672010p 0.9
+ 674000p 0.9
+ 674010p -0.3
+ 676000p -0.3
+ 676010p 0.9
+ 678000p 0.9
+ 678010p -0.3
+ 680000p -0.3
+ 680010p 0.9
+ 682000p 0.9
+ 682010p -0.3
+ 684000p -0.3
+ 684010p 0.9
+ 686000p 0.9
+ 686010p -0.3
+ 688000p -0.3
+ 688010p 0.9
+ 690000p 0.9
+ 690010p -0.3
+ 692000p -0.3
+ 692010p 0.9
+ 694000p 0.9
+ 694010p -0.3
+ 696000p -0.3
+ 696010p 0.9
+ 698000p 0.9
+ 698010p -0.3
+ 700000p -0.3
+ 700010p 0.9
+ 702000p 0.9
+ 702010p -0.3
+ 704000p -0.3
+ 704010p 0.9
+ 706000p 0.9
+ 706010p -0.3
+ 708000p -0.3
+ 708010p 0.9
+ 710000p 0.9
+ 710010p -0.3
+ 712000p -0.3
+ 712010p 0.9
+ 714000p 0.9
+ 714010p -0.3
+ 716000p -0.3
+ 716010p 0.9
+ 718000p 0.9
+ 718010p -0.3
+ 720000p -0.3
+ 720010p 0.9
+ 722000p 0.9
+ 722010p -0.3
+ 724000p -0.3
+ 724010p 0.9
+ 726000p 0.9
+ 726010p -0.3
+ 728000p -0.3
+ 728010p 0.9
+ 730000p 0.9
+ 730010p -0.3
+ 732000p -0.3
+ 732010p 0.9
+ 734000p 0.9
+ 734010p -0.3
+ 736000p -0.3
+ 736010p 0.9
+ 738000p 0.9
+ 738010p -0.3
+ 740000p -0.3
+ 740010p 0.9
+ 742000p 0.9
+ 742010p -0.3
+ 744000p -0.3
+ 744010p 0.9
+ 746000p 0.9
+ 746010p -0.3
+ 748000p -0.3
+ 748010p 0.9
+ 750000p 0.9
+ 750010p -0.3
+ 752000p -0.3
+ 752010p 0.9
+ 754000p 0.9
+ 754010p -0.3
+ 756000p -0.3
+ 756010p 0.9
+ 758000p 0.9
+ 758010p -0.3
+ 760000p -0.3
+ 760010p 0.9
+ 762000p 0.9
+ 762010p -0.3
+ 764000p -0.3
+ 764010p 0.9
+ 766000p 0.9
+ 766010p -0.3
+ 768000p -0.3
+ 768010p 0.9
+ 770000p 0.9
+ 770010p -0.3
+ 772000p -0.3
+ 772010p 0.9
+ 774000p 0.9
+ 774010p -0.3
+ 776000p -0.3
+ 776010p 0.9
+ 778000p 0.9
+ 778010p -0.3
+ 780000p -0.3
+ 780010p 0.9
+ 782000p 0.9
+ 782010p -0.3
+ 784000p -0.3
+ 784010p 0.9
+ 786000p 0.9
+ 786010p -0.3
+ 788000p -0.3
+ 788010p 0.9
+ 790000p 0.9
+ 790010p -0.3
+ 792000p -0.3
+ 792010p 0.9
+ 794000p 0.9
+ 794010p -0.3
+ 796000p -0.3
+ 796010p 0.9
+ 798000p 0.9
+ 798010p -0.3
+ 800000p -0.3
+ 800010p 0.9
+ 802000p 0.9
+ 802010p -0.3
+ 804000p -0.3
+ 804010p 0.9
+ 806000p 0.9
+ 806010p -0.3
+ 808000p -0.3
+ 808010p 0.9
+ 810000p 0.9
+ 810010p -0.3
+ 812000p -0.3
+ 812010p 0.9
+ 814000p 0.9
+ 814010p -0.3
+ 816000p -0.3
+ 816010p 0.9
+ 818000p 0.9
+ 818010p -0.3
+ 820000p -0.3
+ 820010p 0.9
+ 822000p 0.9
+ 822010p -0.3
+ 824000p -0.3
+ 824010p 0.9
+ 826000p 0.9
+ 826010p -0.3
+ 828000p -0.3
+ 828010p 0.9
+ 830000p 0.9
+ 830010p -0.3
+ 832000p -0.3
+ 832010p 0.9
+ 834000p 0.9
+ 834010p -0.3
+ 836000p -0.3
+ 836010p 0.9
+ 838000p 0.9
+ 838010p -0.3
+ 840000p -0.3
+ 840010p 0.9
+ 842000p 0.9
+ 842010p -0.3
+ 844000p -0.3
+ 844010p 0.9
+ 846000p 0.9
+ 846010p -0.3
+ 848000p -0.3
+ 848010p 0.9
+ 850000p 0.9
+ 850010p -0.3
+ 852000p -0.3
+ 852010p 0.9
+ 854000p 0.9
+ 854010p -0.3
+ 856000p -0.3
+ 856010p 0.9
+ 858000p 0.9
+ 858010p -0.3
+ 860000p -0.3
+ 860010p 0.9
+ 862000p 0.9
+ 862010p -0.3
+ 864000p -0.3
+ 864010p 0.9
+ 866000p 0.9
+ 866010p -0.3
+ 868000p -0.3
+ 868010p 0.9
+ 870000p 0.9
+ 870010p -0.3
+ 872000p -0.3
+ 872010p 0.9
+ 874000p 0.9
+ 874010p -0.3
+ 876000p -0.3
+ 876010p 0.9
+ 878000p 0.9
+ 878010p -0.3
+ 880000p -0.3
+ 880010p 0.9
+ 882000p 0.9
+ 882010p -0.3
+ 884000p -0.3
+ 884010p 0.9
+ 886000p 0.9
+ 886010p -0.3
+ 888000p -0.3
+ 888010p 0.9
+ 890000p 0.9
+ 890010p -0.3
+ 892000p -0.3
+ 892010p 0.9
+ 894000p 0.9
+ 894010p -0.3
+ 896000p -0.3
+ 896010p 0.9
+ 898000p 0.9
+ 898010p -0.3
+ 900000p -0.3
+ 900010p 0.9
+ 902000p 0.9
+ 902010p -0.3
+ 904000p -0.3
+ 904010p 0.9
+ 906000p 0.9
+ 906010p -0.3
+ 908000p -0.3
+ 908010p 0.9
+ 910000p 0.9
+ 910010p -0.3
+ 912000p -0.3
+ 912010p 0.9
+ 914000p 0.9
+ 914010p -0.3
+ 916000p -0.3
+ 916010p 0.9
+ 918000p 0.9
+ 918010p -0.3
+ 920000p -0.3
+ 920010p 0.9
+ 922000p 0.9
+ 922010p -0.3
+ 924000p -0.3
+ 924010p 0.9
+ 926000p 0.9
+ 926010p -0.3
+ 928000p -0.3
+ 928010p 0.9
+ 930000p 0.9
+ 930010p -0.3
+ 932000p -0.3
+ 932010p 0.9
+ 934000p 0.9
+ 934010p -0.3
+ 936000p -0.3
+ 936010p 0.9
+ 938000p 0.9
+ 938010p -0.3
+ 940000p -0.3
+ 940010p 0.9
+ 942000p 0.9
+ 942010p -0.3
+ 944000p -0.3
+ 944010p 0.9
+ 946000p 0.9
+ 946010p -0.3
+ 948000p -0.3
+ 948010p 0.9
+ 950000p 0.9
+ 950010p -0.3
+ 952000p -0.3
+ 952010p 0.9
+ 954000p 0.9
+ 954010p -0.3
+ 956000p -0.3
+ 956010p 0.9
+ 958000p 0.9
+ 958010p -0.3
+ 960000p -0.3
+ 960010p 0.9
+ 962000p 0.9
+ 962010p -0.3
+ 964000p -0.3
+ 964010p 0.9
+ 966000p 0.9
+ 966010p -0.3
+ 968000p -0.3
+ 968010p 0.9
+ 970000p 0.9
+ 970010p -0.3
+ 972000p -0.3
+ 972010p 0.9
+ 974000p 0.9
+ 974010p -0.3
+ 976000p -0.3
+ 976010p 0.9
+ 978000p 0.9
+ 978010p -0.3
+ 980000p -0.3
+ 980010p 0.9
+ 982000p 0.9
+ 982010p -0.3
+ 984000p -0.3
+ 984010p 0.9
+ 986000p 0.9
+ 986010p -0.3
+ 988000p -0.3
+ 988010p 0.9
+ 990000p 0.9
+ 990010p -0.3
+ 992000p -0.3
+ 992010p 0.9
+ 994000p 0.9
+ 994010p -0.3
+ 996000p -0.3
+ 996010p 0.9
+ 998000p 0.9
+ 998010p -0.3
+ 1000000p -0.3
+ 1000010p 0.9
+ 1002000p 0.9
+ 1002010p -0.3
+ 1004000p -0.3
+ 1004010p 0.9
+ 1006000p 0.9
+ 1006010p -0.3
+ 1008000p -0.3
+ 1008010p 0.9
+ 1010000p 0.9
+ 1010010p -0.3
+ 1012000p -0.3
+ 1012010p 0.9
+ 1014000p 0.9
+ 1014010p -0.3
+ 1016000p -0.3
+ 1016010p 0.9
+ 1018000p 0.9
+ 1018010p -0.3
+ 1020000p -0.3
+ 1020010p 0.9
+ 1022000p 0.9
+ 1022010p -0.3
+ 1024000p -0.3
+ 1024010p 0.9
+ 1026000p 0.9
+ 1026010p -0.3
+ 1028000p -0.3
+ 1028010p 0.9
+ 1030000p 0.9
+ 1030010p -0.3
+ 1032000p -0.3
+ 1032010p 0.9
+ 1034000p 0.9
+ 1034010p -0.3
+ 1036000p -0.3
+ 1036010p 0.9
+ 1038000p 0.9
+ 1038010p -0.3
+ 1040000p -0.3
+ 1040010p 0.9
+ 1042000p 0.9
+ 1042010p -0.3
+ 1044000p -0.3
+ 1044010p 0.9
+ 1046000p 0.9
+ 1046010p -0.3
+ 1048000p -0.3
+ 1048010p 0.9
+ 1050000p 0.9
+ 1050010p -0.3
+ 1052000p -0.3
+ 1052010p 0.9
+ 1054000p 0.9
+ 1054010p -0.3
+ 1056000p -0.3
+ 1056010p 0.9
+ 1058000p 0.9
+ 1058010p -0.3
+ 1060000p -0.3
+ 1060010p 0.9
+ 1062000p 0.9
+ 1062010p -0.3
+ 1064000p -0.3
+ 1064010p 0.9
+ 1066000p 0.9
+ 1066010p -0.3
+ 1068000p -0.3
+ 1068010p 0.9
+ 1070000p 0.9
+ 1070010p -0.3
+ 1072000p -0.3
+ 1072010p 0.9
+ 1074000p 0.9
+ 1074010p -0.3
+ 1076000p -0.3
+ 1076010p 0.9
+ 1078000p 0.9
+ 1078010p -0.3
+ 1080000p -0.3
+ 1080010p 0.9
+ 1082000p 0.9
+ 1082010p -0.3
+ 1084000p -0.3
+ 1084010p 0.9
+ 1086000p 0.9
+ 1086010p -0.3
+ 1088000p -0.3
+ 1088010p 0.9
+ 1090000p 0.9
+ 1090010p -0.3
+ 1092000p -0.3
+ 1092010p 0.9
+ 1094000p 0.9
+ 1094010p -0.3
+ 1096000p -0.3
+ 1096010p 0.9
+ 1098000p 0.9
+ 1098010p -0.3
+ 1100000p -0.3
+ 1100010p 0.9
+ 1102000p 0.9
+ 1102010p -0.3
+ 1104000p -0.3
+ 1104010p 0.9
+ 1106000p 0.9
+ 1106010p -0.3
+ 1108000p -0.3
+ 1108010p 0.9
+ 1110000p 0.9
+ 1110010p -0.3
+ 1112000p -0.3
+ 1112010p 0.9
+ 1114000p 0.9
+ 1114010p -0.3
+ 1116000p -0.3
+ 1116010p 0.9
+ 1118000p 0.9
+ 1118010p -0.3
+ 1120000p -0.3
+ 1120010p 0.9
+ 1122000p 0.9
+ 1122010p -0.3
+ 1124000p -0.3
+ 1124010p 0.9
+ 1126000p 0.9
+ 1126010p -0.3
+ 1128000p -0.3
+ 1128010p 0.9
+ 1130000p 0.9
+ 1130010p -0.3
+ 1132000p -0.3
+ 1132010p 0.9
+ 1134000p 0.9
+ 1134010p -0.3
+ 1136000p -0.3
+ 1136010p 0.9
+ 1138000p 0.9
+ 1138010p -0.3
+ 1140000p -0.3
+ 1140010p 0.9
+ 1142000p 0.9
+ 1142010p -0.3
+ 1144000p -0.3
+ 1144010p 0.9
+ 1146000p 0.9
+ 1146010p -0.3
+ 1148000p -0.3
+ 1148010p 0.9
+ 1150000p 0.9
+ 1150010p -0.3
+ 1152000p -0.3
+ 1152010p 0.9
+ 1154000p 0.9
+ 1154010p -0.3
+ 1156000p -0.3
+ 1156010p 0.9
+ 1158000p 0.9
+ 1158010p -0.3
+ 1160000p -0.3
+ 1160010p 0.9
+ 1162000p 0.9
+ 1162010p -0.3
+ 1164000p -0.3
+ 1164010p 0.9
+ 1166000p 0.9
+ 1166010p -0.3
+ 1168000p -0.3
+ 1168010p 0.9
+ 1170000p 0.9
+ 1170010p -0.3
+ 1172000p -0.3
+ 1172010p 0.9
+ 1174000p 0.9
+ 1174010p -0.3
+ 1176000p -0.3
+ 1176010p 0.9
+ 1178000p 0.9
+ 1178010p -0.3
+ 1180000p -0.3
+ 1180010p 0.9
+ 1182000p 0.9
+ 1182010p -0.3
+ 1184000p -0.3
+ 1184010p 0.9
+ 1186000p 0.9
+ 1186010p -0.3
+ 1188000p -0.3
+ 1188010p 0.9
+ 1190000p 0.9
+ 1190010p -0.3
+ 1192000p -0.3
+ 1192010p 0.9
+ 1194000p 0.9
+ 1194010p -0.3
+ 1196000p -0.3
+ 1196010p 0.9
+ 1198000p 0.9
+ 1198010p -0.3
+ 1200000p -0.3
+ 1200010p 0.9
+ 1202000p 0.9
+ 1202010p -0.3
+ 1204000p -0.3
+ 1204010p 0.9
+ 1206000p 0.9
+ 1206010p -0.3
+ 1208000p -0.3
+ 1208010p 0.9
+ 1210000p 0.9
+ 1210010p -0.3
+ 1212000p -0.3
+ 1212010p 0.9
+ 1214000p 0.9
+ 1214010p -0.3
+ 1216000p -0.3
+ 1216010p 0.9
+ 1218000p 0.9
+ 1218010p -0.3
+ 1220000p -0.3
+ 1220010p 0.9
+ 1222000p 0.9
+ 1222010p -0.3
+ 1224000p -0.3
+ 1224010p 0.9
+ 1226000p 0.9
+ 1226010p -0.3
+ 1228000p -0.3
+ 1228010p 0.9
+ 1230000p 0.9
+ 1230010p -0.3
+ 1232000p -0.3
+ 1232010p 0.9
+ 1234000p 0.9
+ 1234010p -0.3
+ 1236000p -0.3
+ 1236010p 0.9
+ 1238000p 0.9
+ 1238010p -0.3
+ 1240000p -0.3
+ 1240010p 0.9
+ 1242000p 0.9
+ 1242010p -0.3
+ 1244000p -0.3
+ 1244010p 0.9
+ 1246000p 0.9
+ 1246010p -0.3
+ 1248000p -0.3
+ 1248010p 0.9
+ 1250000p 0.9
+ 1250010p -0.3
+ 1252000p -0.3
+ 1252010p 0.9
+ 1254000p 0.9
+ 1254010p -0.3
+ 1256000p -0.3
+ 1256010p 0.9
+ 1258000p 0.9
+ 1258010p -0.3
+ 1260000p -0.3
+ 1260010p 0.9
+ 1262000p 0.9
+ 1262010p -0.3
+ 1264000p -0.3
+ 1264010p 0.9
+ 1266000p 0.9
+ 1266010p -0.3
+ 1268000p -0.3
+ 1268010p 0.9
+ 1270000p 0.9
+ 1270010p -0.3
+ 1272000p -0.3
+ 1272010p 0.9
+ 1274000p 0.9
+ 1274010p -0.3
+ 1276000p -0.3
+ 1276010p 0.9
+ 1278000p 0.9
+ 1278010p -0.3
+ 1280000p -0.3
+ 1280010p 0.9
+ 1282000p 0.9
+ 1282010p -0.3
+ 1284000p -0.3
+ 1284010p 0.9
+ 1286000p 0.9
+ 1286010p -0.3
+ 1288000p -0.3
+ 1288010p 0.9
+ 1290000p 0.9
+ 1290010p -0.3
+ 1292000p -0.3
+ 1292010p 0.9
+ 1294000p 0.9
+ 1294010p -0.3
+ 1296000p -0.3
+ 1296010p 0.9
+ 1298000p 0.9
+ 1298010p -0.3
+ 1300000p -0.3
+ 1300010p 0.9
+ 1302000p 0.9
+ 1302010p -0.3
+ 1304000p -0.3
+ 1304010p 0.9
+ 1306000p 0.9
+ 1306010p -0.3
+ 1308000p -0.3
+ 1308010p 0.9
+ 1310000p 0.9
+ 1310010p -0.3
+ 1312000p -0.3
+ 1312010p 0.9
+ 1314000p 0.9
+ 1314010p -0.3
+ 1316000p -0.3
+ 1316010p 0.9
+ 1318000p 0.9
+ 1318010p -0.3
+ 1320000p -0.3
+ 1320010p 0.9
+ 1322000p 0.9
+ 1322010p -0.3
+ 1324000p -0.3
+ 1324010p 0.9
+ 1326000p 0.9
+ 1326010p -0.3
+ 1328000p -0.3
+ 1328010p 0.9
+ 1330000p 0.9
+ 1330010p -0.3
+ 1332000p -0.3
+ 1332010p 0.9
+ 1334000p 0.9
+ 1334010p -0.3
+ 1336000p -0.3
+ 1336010p 0.9
+ 1338000p 0.9
+ 1338010p -0.3
+ 1340000p -0.3
+ 1340010p 0.9
+ 1342000p 0.9
+ 1342010p -0.3
+ 1344000p -0.3
+ 1344010p 0.9
+ 1346000p 0.9
+ 1346010p -0.3
+ 1348000p -0.3
+ 1348010p 0.9
+ 1350000p 0.9
+ 1350010p -0.3
+ 1352000p -0.3
+ 1352010p 0.9
+ 1354000p 0.9
+ 1354010p -0.3
+ 1356000p -0.3
+ 1356010p 0.9
+ 1358000p 0.9
+ 1358010p -0.3
+ 1360000p -0.3
+ 1360010p 0.9
+ 1362000p 0.9
+ 1362010p -0.3
+ 1364000p -0.3
+ 1364010p 0.9
+ 1366000p 0.9
+ 1366010p -0.3
+ 1368000p -0.3
+ 1368010p 0.9
+ 1370000p 0.9
+ 1370010p -0.3
+ 1372000p -0.3
+ 1372010p 0.9
+ 1374000p 0.9
+ 1374010p -0.3
+ 1376000p -0.3
+ 1376010p 0.9
+ 1378000p 0.9
+ 1378010p -0.3
+ 1380000p -0.3
+ 1380010p 0.9
+ 1382000p 0.9
+ 1382010p -0.3
+ 1384000p -0.3
+ 1384010p 0.9
+ 1386000p 0.9
+ 1386010p -0.3
+ 1388000p -0.3
+ 1388010p 0.9
+ 1390000p 0.9
+ 1390010p -0.3
+ 1392000p -0.3
+ 1392010p 0.9
+ 1394000p 0.9
+ 1394010p -0.3
+ 1396000p -0.3
+ 1396010p 0.9
+ 1398000p 0.9
+ 1398010p -0.3
+ 1400000p -0.3
+ 1400010p 0.9
+ 1402000p 0.9
+ 1402010p -0.3
+ 1404000p -0.3
+ 1404010p 0.9
+ 1406000p 0.9
+ 1406010p -0.3
+ 1408000p -0.3
+ 1408010p 0.9
+ 1410000p 0.9
+ 1410010p -0.3
+ 1412000p -0.3
+ 1412010p 0.9
+ 1414000p 0.9
+ 1414010p -0.3
+ 1416000p -0.3
+ 1416010p 0.9
+ 1418000p 0.9
+ 1418010p -0.3
+ 1420000p -0.3
+ 1420010p 0.9
+ 1422000p 0.9
+ 1422010p -0.3
+ 1424000p -0.3
+ 1424010p 0.9
+ 1426000p 0.9
+ 1426010p -0.3
+ 1428000p -0.3
+ 1428010p 0.9
+ 1430000p 0.9
+ 1430010p -0.3
+ 1432000p -0.3
+ 1432010p 0.9
+ 1434000p 0.9
+ 1434010p -0.3
+ 1436000p -0.3
+ 1436010p 0.9
+ 1438000p 0.9
+ 1438010p -0.3
+ 1440000p -0.3
+ 1440010p 0.9
+ 1442000p 0.9
+ 1442010p -0.3
+ 1444000p -0.3
+ 1444010p 0.9
+ 1446000p 0.9
+ 1446010p -0.3
+ 1448000p -0.3
+ 1448010p 0.9
+ 1450000p 0.9
+ 1450010p -0.3
+ 1452000p -0.3
+ 1452010p 0.9
+ 1454000p 0.9
+ 1454010p -0.3
+ 1456000p -0.3
+ 1456010p 0.9
+ 1458000p 0.9
+ 1458010p -0.3
+ 1460000p -0.3
+ 1460010p 0.9
+ 1462000p 0.9
+ 1462010p -0.3
+ 1464000p -0.3
+ 1464010p 0.9
+ 1466000p 0.9
+ 1466010p -0.3
+ 1468000p -0.3
+ 1468010p 0.9
+ 1470000p 0.9
+ 1470010p -0.3
+ 1472000p -0.3
+ 1472010p 0.9
+ 1474000p 0.9
+ 1474010p -0.3
+ 1476000p -0.3
+ 1476010p 0.9
+ 1478000p 0.9
+ 1478010p -0.3
+ 1480000p -0.3
+ 1480010p 0.9
+ 1482000p 0.9
+ 1482010p -0.3
+ 1484000p -0.3
+ 1484010p 0.9
+ 1486000p 0.9
+ 1486010p -0.3
+ 1488000p -0.3
+ 1488010p 0.9
+ 1490000p 0.9
+ 1490010p -0.3
+ 1492000p -0.3
+ 1492010p 0.9
+ 1494000p 0.9
+ 1494010p -0.3
+ 1496000p -0.3
+ 1496010p 0.9
+ 1498000p 0.9
+ 1498010p -0.3
+ 1500000p -0.3
+ 1500010p 0.9
+ 1502000p 0.9
+ 1502010p -0.3
+ 1504000p -0.3
+ 1504010p 0.9
+ 1506000p 0.9
+ 1506010p -0.3
+ 1508000p -0.3
+ 1508010p 0.9
+ 1510000p 0.9
+ 1510010p -0.3
+ 1512000p -0.3
+ 1512010p 0.9
+ 1514000p 0.9
+ 1514010p -0.3
+ 1516000p -0.3
+ 1516010p 0.9
+ 1518000p 0.9
+ 1518010p -0.3
+ 1520000p -0.3
+ 1520010p 0.9
+ 1522000p 0.9
+ 1522010p -0.3
+ 1524000p -0.3
+ 1524010p 0.9
+ 1526000p 0.9
+ 1526010p -0.3
+ 1528000p -0.3
+ 1528010p 0.9
+ 1530000p 0.9
+ 1530010p -0.3
+ 1532000p -0.3
+ 1532010p 0.9
+ 1534000p 0.9
+ 1534010p -0.3
+ 1536000p -0.3
+ 1536010p 0.9
+ 1538000p 0.9
+ 1538010p -0.3
+ 1540000p -0.3
+ 1540010p 0.9
+ 1542000p 0.9
+ 1542010p -0.3
+ 1544000p -0.3
+ 1544010p 0.9
+ 1546000p 0.9
+ 1546010p -0.3
+ 1548000p -0.3
+ 1548010p 0.9
+ 1550000p 0.9
+ 1550010p -0.3
+ 1552000p -0.3
+ 1552010p 0.9
+ 1554000p 0.9
+ 1554010p -0.3
+ 1556000p -0.3
+ 1556010p 0.9
+ 1558000p 0.9
+ 1558010p -0.3
+ 1560000p -0.3
+ 1560010p 0.9
+ 1562000p 0.9
+ 1562010p -0.3
+ 1564000p -0.3
+ 1564010p 0.9
+ 1566000p 0.9
+ 1566010p -0.3
+ 1568000p -0.3
+ 1568010p 0.9
+ 1570000p 0.9
+ 1570010p -0.3
+ 1572000p -0.3
+ 1572010p 0.9
+ 1574000p 0.9
+ 1574010p -0.3
+ 1576000p -0.3
+ 1576010p 0.9
+ 1578000p 0.9
+ 1578010p -0.3
+ 1580000p -0.3
+ 1580010p 0.9
+ 1582000p 0.9
+ 1582010p -0.3
+ 1584000p -0.3
+ 1584010p 0.9
+ 1586000p 0.9
+ 1586010p -0.3
+ 1588000p -0.3
+ 1588010p 0.9
+ 1590000p 0.9
+ 1590010p -0.3
+ 1592000p -0.3
+ 1592010p 0.9
+ 1594000p 0.9
+ 1594010p -0.3
+ 1596000p -0.3
+ 1596010p 0.9
+ 1598000p 0.9
+ 1598010p -0.3
+ 1600000p -0.3
+ 1600010p 0.9
+ 1602000p 0.9
+ 1602010p -0.3
+ 1604000p -0.3
+ 1604010p 0.9
+ 1606000p 0.9
+ 1606010p -0.3
+ 1608000p -0.3
+ 1608010p 0.9
+ 1610000p 0.9
+ 1610010p -0.3
+ 1612000p -0.3
+ 1612010p 0.9
+ 1614000p 0.9
+ 1614010p -0.3
+ 1616000p -0.3
+ 1616010p 0.9
+ 1618000p 0.9
+ 1618010p -0.3
+ 1620000p -0.3
+ 1620010p 0.9
+ 1622000p 0.9
+ 1622010p -0.3
+ 1624000p -0.3
+ 1624010p 0.9
+ 1626000p 0.9
+ 1626010p -0.3
+ 1628000p -0.3
+ 1628010p 0.9
+ 1630000p 0.9
+ 1630010p -0.3
+ 1632000p -0.3
+ 1632010p 0.9
+ 1634000p 0.9
+ 1634010p -0.3
+ 1636000p -0.3
+ 1636010p 0.9
+ 1638000p 0.9
+ 1638010p -0.3
+ 1640000p -0.3
+ 1640010p 0.9
+ 1642000p 0.9
+ 1642010p -0.3
+ 1644000p -0.3
+ 1644010p 0.9
+ 1646000p 0.9
+ 1646010p -0.3
+ 1648000p -0.3
+ 1648010p 0.9
+ 1650000p 0.9
+ 1650010p -0.3
+ 1652000p -0.3
+ 1652010p 0.9
+ 1654000p 0.9
+ 1654010p -0.3
+ 1656000p -0.3
+ 1656010p 0.9
+ 1658000p 0.9
+ 1658010p -0.3
+ 1660000p -0.3
+ 1660010p 0.9
+ 1662000p 0.9
+ 1662010p -0.3
+ 1664000p -0.3
+ 1664010p 0.9
+ 1666000p 0.9
+ 1666010p -0.3
+ 1668000p -0.3
+ 1668010p 0.9
+ 1670000p 0.9
+ 1670010p -0.3
+ 1672000p -0.3
+ 1672010p 0.9
+ 1674000p 0.9
+ 1674010p -0.3
+ 1676000p -0.3
+ 1676010p 0.9
+ 1678000p 0.9
+ 1678010p -0.3
+ 1680000p -0.3
+ 1680010p 0.9
+ 1682000p 0.9
+ 1682010p -0.3
+ 1684000p -0.3
+ 1684010p 0.9
+ 1686000p 0.9
+ 1686010p -0.3
+ 1688000p -0.3
+ 1688010p 0.9
+ 1690000p 0.9
+ 1690010p -0.3
+ 1692000p -0.3
+ 1692010p 0.9
+ 1694000p 0.9
+ 1694010p -0.3
+ 1696000p -0.3
+ 1696010p 0.9
+ 1698000p 0.9
+ 1698010p -0.3
+ 1700000p -0.3
+ 1700010p 0.9
+ 1702000p 0.9
+ 1702010p -0.3
+ 1704000p -0.3
+ 1704010p 0.9
+ 1706000p 0.9
+ 1706010p -0.3
+ 1708000p -0.3
+ 1708010p 0.9
+ 1710000p 0.9
+ 1710010p -0.3
+ 1712000p -0.3
+ 1712010p 0.9
+ 1714000p 0.9
+ 1714010p -0.3
+ 1716000p -0.3
+ 1716010p 0.9
+ 1718000p 0.9
+ 1718010p -0.3
+ 1720000p -0.3
+ 1720010p 0.9
+ 1722000p 0.9
+ 1722010p -0.3
+ 1724000p -0.3
+ 1724010p 0.9
+ 1726000p 0.9
+ 1726010p -0.3
+ 1728000p -0.3
+ 1728010p 0.9
+ 1730000p 0.9
+ 1730010p -0.3
+ 1732000p -0.3
+ 1732010p 0.9
+ 1734000p 0.9
+ 1734010p -0.3
+ 1736000p -0.3
+ 1736010p 0.9
+ 1738000p 0.9
+ 1738010p -0.3
+ 1740000p -0.3
+ 1740010p 0.9
+ 1742000p 0.9
+ 1742010p -0.3
+ 1744000p -0.3
+ 1744010p 0.9
+ 1746000p 0.9
+ 1746010p -0.3
+ 1748000p -0.3
+ 1748010p 0.9
+ 1750000p 0.9
+ 1750010p -0.3
+ 1752000p -0.3
+ 1752010p 0.9
+ 1754000p 0.9
+ 1754010p -0.3
+ 1756000p -0.3
+ 1756010p 0.9
+ 1758000p 0.9
+ 1758010p -0.3
+ 1760000p -0.3
+ 1760010p 0.9
+ 1762000p 0.9
+ 1762010p -0.3
+ 1764000p -0.3
+ 1764010p 0.9
+ 1766000p 0.9
+ 1766010p -0.3
+ 1768000p -0.3
+ 1768010p 0.9
+ 1770000p 0.9
+ 1770010p -0.3
+ 1772000p -0.3
+ 1772010p 0.9
+ 1774000p 0.9
+ 1774010p -0.3
+ 1776000p -0.3
+ 1776010p 0.9
+ 1778000p 0.9
+ 1778010p -0.3
+ 1780000p -0.3
+ 1780010p 0.9
+ 1782000p 0.9
+ 1782010p -0.3
+ 1784000p -0.3
+ 1784010p 0.9
+ 1786000p 0.9
+ 1786010p -0.3
+ 1788000p -0.3
+ 1788010p 0.9
+ 1790000p 0.9
+ 1790010p -0.3
+ 1792000p -0.3
+ 1792010p 0.9
+ 1794000p 0.9
+ 1794010p -0.3
+ 1796000p -0.3
+ 1796010p 0.9
+ 1798000p 0.9
+ 1798010p -0.3
+ 1800000p -0.3
+ 1800010p 0.9
+ 1802000p 0.9
+ 1802010p -0.3
+ 1804000p -0.3
+ 1804010p 0.9
+ 1806000p 0.9
+ 1806010p -0.3
+ 1808000p -0.3
+ 1808010p 0.9
+ 1810000p 0.9
+ 1810010p -0.3
+ 1812000p -0.3
+ 1812010p 0.9
+ 1814000p 0.9
+ 1814010p -0.3
+ 1816000p -0.3
+ 1816010p 0.9
+ 1818000p 0.9
+ 1818010p -0.3
+ 1820000p -0.3
+ 1820010p 0.9
+ 1822000p 0.9
+ 1822010p -0.3
+ 1824000p -0.3
+ 1824010p 0.9
+ 1826000p 0.9
+ 1826010p -0.3
+ 1828000p -0.3
+ 1828010p 0.9
+ 1830000p 0.9
+ 1830010p -0.3
+ 1832000p -0.3
+ 1832010p 0.9
+ 1834000p 0.9
+ 1834010p -0.3
+ 1836000p -0.3
+ 1836010p 0.9
+ 1838000p 0.9
+ 1838010p -0.3
+ 1840000p -0.3
+ 1840010p 0.9
+ 1842000p 0.9
+ 1842010p -0.3
+ 1844000p -0.3
+ 1844010p 0.9
+ 1846000p 0.9
+ 1846010p -0.3
+ 1848000p -0.3
+ 1848010p 0.9
+ 1850000p 0.9
+ 1850010p -0.3
+ 1852000p -0.3
+ 1852010p 0.9
+ 1854000p 0.9
+ 1854010p -0.3
+ 1856000p -0.3
+ 1856010p 0.9
+ 1858000p 0.9
+ 1858010p -0.3
+ 1860000p -0.3
+ 1860010p 0.9
+ 1862000p 0.9
+ 1862010p -0.3
+ 1864000p -0.3
+ 1864010p 0.9
+ 1866000p 0.9
+ 1866010p -0.3
+ 1868000p -0.3
+ 1868010p 0.9
+ 1870000p 0.9
+ 1870010p -0.3
+ 1872000p -0.3
+ 1872010p 0.9
+ 1874000p 0.9
+ 1874010p -0.3
+ 1876000p -0.3
+ 1876010p 0.9
+ 1878000p 0.9
+ 1878010p -0.3
+ 1880000p -0.3
+ 1880010p 0.9
+ 1882000p 0.9
+ 1882010p -0.3
+ 1884000p -0.3
+ 1884010p 0.9
+ 1886000p 0.9
+ 1886010p -0.3
+ 1888000p -0.3
+ 1888010p 0.9
+ 1890000p 0.9
+ 1890010p -0.3
+ 1892000p -0.3
+ 1892010p 0.9
+ 1894000p 0.9
+ 1894010p -0.3
+ 1896000p -0.3
+ 1896010p 0.9
+ 1898000p 0.9
+ 1898010p -0.3
+ 1900000p -0.3
+ 1900010p 0.9
+ 1902000p 0.9
+ 1902010p -0.3
+ 1904000p -0.3
+ 1904010p 0.9
+ 1906000p 0.9
+ 1906010p -0.3
+ 1908000p -0.3
+ 1908010p 0.9
+ 1910000p 0.9
+ 1910010p -0.3
+ 1912000p -0.3
+ 1912010p 0.9
+ 1914000p 0.9
+ 1914010p -0.3
+ 1916000p -0.3
+ 1916010p 0.9
+ 1918000p 0.9
+ 1918010p -0.3
+ 1920000p -0.3
+ 1920010p 0.9
+ 1922000p 0.9
+ 1922010p -0.3
+ 1924000p -0.3
+ 1924010p 0.9
+ 1926000p 0.9
+ 1926010p -0.3
+ 1928000p -0.3
+ 1928010p 0.9
+ 1930000p 0.9
+ 1930010p -0.3
+ 1932000p -0.3
+ 1932010p 0.9
+ 1934000p 0.9
+ 1934010p -0.3
+ 1936000p -0.3
+ 1936010p 0.9
+ 1938000p 0.9
+ 1938010p -0.3
+ 1940000p -0.3
+ 1940010p 0.9
+ 1942000p 0.9
+ 1942010p -0.3
+ 1944000p -0.3
+ 1944010p 0.9
+ 1946000p 0.9
+ 1946010p -0.3
+ 1948000p -0.3
+ 1948010p 0.9
+ 1950000p 0.9
+ 1950010p -0.3
+ 1952000p -0.3
+ 1952010p 0.9
+ 1954000p 0.9
+ 1954010p -0.3
+ 1956000p -0.3
+ 1956010p 0.9
+ 1958000p 0.9
+ 1958010p -0.3
+ 1960000p -0.3
+ 1960010p 0.9
+ 1962000p 0.9
+ 1962010p -0.3
+ 1964000p -0.3
+ 1964010p 0.9
+ 1966000p 0.9
+ 1966010p -0.3
+ 1968000p -0.3
+ 1968010p 0.9
+ 1970000p 0.9
+ 1970010p -0.3
+ 1972000p -0.3
+ 1972010p 0.9
+ 1974000p 0.9
+ 1974010p -0.3
+ 1976000p -0.3
+ 1976010p 0.9
+ 1978000p 0.9
+ 1978010p -0.3
+ 1980000p -0.3
+ 1980010p 0.9
+ 1982000p 0.9
+ 1982010p -0.3
+ 1984000p -0.3
+ 1984010p 0.9
+ 1986000p 0.9
+ 1986010p -0.3
+ 1988000p -0.3
+ 1988010p 0.9
+ 1990000p 0.9
+ 1990010p -0.3
+ 1992000p -0.3
+ 1992010p 0.9
+ 1994000p 0.9
+ 1994010p -0.3
+ 1996000p -0.3
+ 1996010p 0.9
+ 1998000p 0.9
+ 1998010p -0.3
+ 2000000p -0.3
+ 2000010p 0.9
+ 2002000p 0.9
+ 2002010p -0.3
+ 2004000p -0.3
+ 2004010p 0.9
+ 2006000p 0.9
+ 2006010p -0.3
+ 2008000p -0.3
+ 2008010p 0.9
+ 2010000p 0.9
+ 2010010p -0.3
+ 2012000p -0.3
+ 2012010p 0.9
+ 2014000p 0.9
+ 2014010p -0.3
+ 2016000p -0.3
+ 2016010p 0.9
+ 2018000p 0.9
+ 2018010p -0.3
+ 2020000p -0.3
+ 2020010p 0.9
+ 2022000p 0.9
+ 2022010p -0.3
+ 2024000p -0.3
+ 2024010p 0.9
+ 2026000p 0.9
+ 2026010p -0.3
+ 2028000p -0.3
+ 2028010p 0.9
+ 2030000p 0.9
+ 2030010p -0.3
+ 2032000p -0.3
+ 2032010p 0.9
+ 2034000p 0.9
+ 2034010p -0.3
+ 2036000p -0.3
+ 2036010p 0.9
+ 2038000p 0.9
+ 2038010p -0.3
+ 2040000p -0.3
+ 2040010p 0.9
+ 2042000p 0.9
+ 2042010p -0.3
+ 2044000p -0.3
+ 2044010p 0.9
+ 2046000p 0.9
+ 2046010p -0.3
+ 2048000p -0.3
+ 2048010p 0.9
+ \]
V_data_bar_24 (Data_bar\\<24\\> gnd!) vsource type=pwl wave=\[
+ 0    -0.3
+ 2000p -0.3
+ 2010p 0.9
+ 4000p 0.9
+ 4010p -0.3
+ 6000p -0.3
+ 6010p 0.9
+ 8000p 0.9
+ 8010p -0.3
+ 10000p -0.3
+ 10010p 0.9
+ 12000p 0.9
+ 12010p -0.3
+ 14000p -0.3
+ 14010p 0.9
+ 16000p 0.9
+ 16010p -0.3
+ 18000p -0.3
+ 18010p 0.9
+ 20000p 0.9
+ 20010p -0.3
+ 22000p -0.3
+ 22010p 0.9
+ 24000p 0.9
+ 24010p -0.3
+ 26000p -0.3
+ 26010p 0.9
+ 28000p 0.9
+ 28010p -0.3
+ 30000p -0.3
+ 30010p 0.9
+ 32000p 0.9
+ 32010p -0.3
+ 34000p -0.3
+ 34010p 0.9
+ 36000p 0.9
+ 36010p -0.3
+ 38000p -0.3
+ 38010p 0.9
+ 40000p 0.9
+ 40010p -0.3
+ 42000p -0.3
+ 42010p 0.9
+ 44000p 0.9
+ 44010p -0.3
+ 46000p -0.3
+ 46010p 0.9
+ 48000p 0.9
+ 48010p -0.3
+ 50000p -0.3
+ 50010p 0.9
+ 52000p 0.9
+ 52010p -0.3
+ 54000p -0.3
+ 54010p 0.9
+ 56000p 0.9
+ 56010p -0.3
+ 58000p -0.3
+ 58010p 0.9
+ 60000p 0.9
+ 60010p -0.3
+ 62000p -0.3
+ 62010p 0.9
+ 64000p 0.9
+ 64010p -0.3
+ 66000p -0.3
+ 66010p 0.9
+ 68000p 0.9
+ 68010p -0.3
+ 70000p -0.3
+ 70010p 0.9
+ 72000p 0.9
+ 72010p -0.3
+ 74000p -0.3
+ 74010p 0.9
+ 76000p 0.9
+ 76010p -0.3
+ 78000p -0.3
+ 78010p 0.9
+ 80000p 0.9
+ 80010p -0.3
+ 82000p -0.3
+ 82010p 0.9
+ 84000p 0.9
+ 84010p -0.3
+ 86000p -0.3
+ 86010p 0.9
+ 88000p 0.9
+ 88010p -0.3
+ 90000p -0.3
+ 90010p 0.9
+ 92000p 0.9
+ 92010p -0.3
+ 94000p -0.3
+ 94010p 0.9
+ 96000p 0.9
+ 96010p -0.3
+ 98000p -0.3
+ 98010p 0.9
+ 100000p 0.9
+ 100010p -0.3
+ 102000p -0.3
+ 102010p 0.9
+ 104000p 0.9
+ 104010p -0.3
+ 106000p -0.3
+ 106010p 0.9
+ 108000p 0.9
+ 108010p -0.3
+ 110000p -0.3
+ 110010p 0.9
+ 112000p 0.9
+ 112010p -0.3
+ 114000p -0.3
+ 114010p 0.9
+ 116000p 0.9
+ 116010p -0.3
+ 118000p -0.3
+ 118010p 0.9
+ 120000p 0.9
+ 120010p -0.3
+ 122000p -0.3
+ 122010p 0.9
+ 124000p 0.9
+ 124010p -0.3
+ 126000p -0.3
+ 126010p 0.9
+ 128000p 0.9
+ 128010p -0.3
+ 130000p -0.3
+ 130010p 0.9
+ 132000p 0.9
+ 132010p -0.3
+ 134000p -0.3
+ 134010p 0.9
+ 136000p 0.9
+ 136010p -0.3
+ 138000p -0.3
+ 138010p 0.9
+ 140000p 0.9
+ 140010p -0.3
+ 142000p -0.3
+ 142010p 0.9
+ 144000p 0.9
+ 144010p -0.3
+ 146000p -0.3
+ 146010p 0.9
+ 148000p 0.9
+ 148010p -0.3
+ 150000p -0.3
+ 150010p 0.9
+ 152000p 0.9
+ 152010p -0.3
+ 154000p -0.3
+ 154010p 0.9
+ 156000p 0.9
+ 156010p -0.3
+ 158000p -0.3
+ 158010p 0.9
+ 160000p 0.9
+ 160010p -0.3
+ 162000p -0.3
+ 162010p 0.9
+ 164000p 0.9
+ 164010p -0.3
+ 166000p -0.3
+ 166010p 0.9
+ 168000p 0.9
+ 168010p -0.3
+ 170000p -0.3
+ 170010p 0.9
+ 172000p 0.9
+ 172010p -0.3
+ 174000p -0.3
+ 174010p 0.9
+ 176000p 0.9
+ 176010p -0.3
+ 178000p -0.3
+ 178010p 0.9
+ 180000p 0.9
+ 180010p -0.3
+ 182000p -0.3
+ 182010p 0.9
+ 184000p 0.9
+ 184010p -0.3
+ 186000p -0.3
+ 186010p 0.9
+ 188000p 0.9
+ 188010p -0.3
+ 190000p -0.3
+ 190010p 0.9
+ 192000p 0.9
+ 192010p -0.3
+ 194000p -0.3
+ 194010p 0.9
+ 196000p 0.9
+ 196010p -0.3
+ 198000p -0.3
+ 198010p 0.9
+ 200000p 0.9
+ 200010p -0.3
+ 202000p -0.3
+ 202010p 0.9
+ 204000p 0.9
+ 204010p -0.3
+ 206000p -0.3
+ 206010p 0.9
+ 208000p 0.9
+ 208010p -0.3
+ 210000p -0.3
+ 210010p 0.9
+ 212000p 0.9
+ 212010p -0.3
+ 214000p -0.3
+ 214010p 0.9
+ 216000p 0.9
+ 216010p -0.3
+ 218000p -0.3
+ 218010p 0.9
+ 220000p 0.9
+ 220010p -0.3
+ 222000p -0.3
+ 222010p 0.9
+ 224000p 0.9
+ 224010p -0.3
+ 226000p -0.3
+ 226010p 0.9
+ 228000p 0.9
+ 228010p -0.3
+ 230000p -0.3
+ 230010p 0.9
+ 232000p 0.9
+ 232010p -0.3
+ 234000p -0.3
+ 234010p 0.9
+ 236000p 0.9
+ 236010p -0.3
+ 238000p -0.3
+ 238010p 0.9
+ 240000p 0.9
+ 240010p -0.3
+ 242000p -0.3
+ 242010p 0.9
+ 244000p 0.9
+ 244010p -0.3
+ 246000p -0.3
+ 246010p 0.9
+ 248000p 0.9
+ 248010p -0.3
+ 250000p -0.3
+ 250010p 0.9
+ 252000p 0.9
+ 252010p -0.3
+ 254000p -0.3
+ 254010p 0.9
+ 256000p 0.9
+ 256010p -0.3
+ 258000p -0.3
+ 258010p 0.9
+ 260000p 0.9
+ 260010p -0.3
+ 262000p -0.3
+ 262010p 0.9
+ 264000p 0.9
+ 264010p -0.3
+ 266000p -0.3
+ 266010p 0.9
+ 268000p 0.9
+ 268010p -0.3
+ 270000p -0.3
+ 270010p 0.9
+ 272000p 0.9
+ 272010p -0.3
+ 274000p -0.3
+ 274010p 0.9
+ 276000p 0.9
+ 276010p -0.3
+ 278000p -0.3
+ 278010p 0.9
+ 280000p 0.9
+ 280010p -0.3
+ 282000p -0.3
+ 282010p 0.9
+ 284000p 0.9
+ 284010p -0.3
+ 286000p -0.3
+ 286010p 0.9
+ 288000p 0.9
+ 288010p -0.3
+ 290000p -0.3
+ 290010p 0.9
+ 292000p 0.9
+ 292010p -0.3
+ 294000p -0.3
+ 294010p 0.9
+ 296000p 0.9
+ 296010p -0.3
+ 298000p -0.3
+ 298010p 0.9
+ 300000p 0.9
+ 300010p -0.3
+ 302000p -0.3
+ 302010p 0.9
+ 304000p 0.9
+ 304010p -0.3
+ 306000p -0.3
+ 306010p 0.9
+ 308000p 0.9
+ 308010p -0.3
+ 310000p -0.3
+ 310010p 0.9
+ 312000p 0.9
+ 312010p -0.3
+ 314000p -0.3
+ 314010p 0.9
+ 316000p 0.9
+ 316010p -0.3
+ 318000p -0.3
+ 318010p 0.9
+ 320000p 0.9
+ 320010p -0.3
+ 322000p -0.3
+ 322010p 0.9
+ 324000p 0.9
+ 324010p -0.3
+ 326000p -0.3
+ 326010p 0.9
+ 328000p 0.9
+ 328010p -0.3
+ 330000p -0.3
+ 330010p 0.9
+ 332000p 0.9
+ 332010p -0.3
+ 334000p -0.3
+ 334010p 0.9
+ 336000p 0.9
+ 336010p -0.3
+ 338000p -0.3
+ 338010p 0.9
+ 340000p 0.9
+ 340010p -0.3
+ 342000p -0.3
+ 342010p 0.9
+ 344000p 0.9
+ 344010p -0.3
+ 346000p -0.3
+ 346010p 0.9
+ 348000p 0.9
+ 348010p -0.3
+ 350000p -0.3
+ 350010p 0.9
+ 352000p 0.9
+ 352010p -0.3
+ 354000p -0.3
+ 354010p 0.9
+ 356000p 0.9
+ 356010p -0.3
+ 358000p -0.3
+ 358010p 0.9
+ 360000p 0.9
+ 360010p -0.3
+ 362000p -0.3
+ 362010p 0.9
+ 364000p 0.9
+ 364010p -0.3
+ 366000p -0.3
+ 366010p 0.9
+ 368000p 0.9
+ 368010p -0.3
+ 370000p -0.3
+ 370010p 0.9
+ 372000p 0.9
+ 372010p -0.3
+ 374000p -0.3
+ 374010p 0.9
+ 376000p 0.9
+ 376010p -0.3
+ 378000p -0.3
+ 378010p 0.9
+ 380000p 0.9
+ 380010p -0.3
+ 382000p -0.3
+ 382010p 0.9
+ 384000p 0.9
+ 384010p -0.3
+ 386000p -0.3
+ 386010p 0.9
+ 388000p 0.9
+ 388010p -0.3
+ 390000p -0.3
+ 390010p 0.9
+ 392000p 0.9
+ 392010p -0.3
+ 394000p -0.3
+ 394010p 0.9
+ 396000p 0.9
+ 396010p -0.3
+ 398000p -0.3
+ 398010p 0.9
+ 400000p 0.9
+ 400010p -0.3
+ 402000p -0.3
+ 402010p 0.9
+ 404000p 0.9
+ 404010p -0.3
+ 406000p -0.3
+ 406010p 0.9
+ 408000p 0.9
+ 408010p -0.3
+ 410000p -0.3
+ 410010p 0.9
+ 412000p 0.9
+ 412010p -0.3
+ 414000p -0.3
+ 414010p 0.9
+ 416000p 0.9
+ 416010p -0.3
+ 418000p -0.3
+ 418010p 0.9
+ 420000p 0.9
+ 420010p -0.3
+ 422000p -0.3
+ 422010p 0.9
+ 424000p 0.9
+ 424010p -0.3
+ 426000p -0.3
+ 426010p 0.9
+ 428000p 0.9
+ 428010p -0.3
+ 430000p -0.3
+ 430010p 0.9
+ 432000p 0.9
+ 432010p -0.3
+ 434000p -0.3
+ 434010p 0.9
+ 436000p 0.9
+ 436010p -0.3
+ 438000p -0.3
+ 438010p 0.9
+ 440000p 0.9
+ 440010p -0.3
+ 442000p -0.3
+ 442010p 0.9
+ 444000p 0.9
+ 444010p -0.3
+ 446000p -0.3
+ 446010p 0.9
+ 448000p 0.9
+ 448010p -0.3
+ 450000p -0.3
+ 450010p 0.9
+ 452000p 0.9
+ 452010p -0.3
+ 454000p -0.3
+ 454010p 0.9
+ 456000p 0.9
+ 456010p -0.3
+ 458000p -0.3
+ 458010p 0.9
+ 460000p 0.9
+ 460010p -0.3
+ 462000p -0.3
+ 462010p 0.9
+ 464000p 0.9
+ 464010p -0.3
+ 466000p -0.3
+ 466010p 0.9
+ 468000p 0.9
+ 468010p -0.3
+ 470000p -0.3
+ 470010p 0.9
+ 472000p 0.9
+ 472010p -0.3
+ 474000p -0.3
+ 474010p 0.9
+ 476000p 0.9
+ 476010p -0.3
+ 478000p -0.3
+ 478010p 0.9
+ 480000p 0.9
+ 480010p -0.3
+ 482000p -0.3
+ 482010p 0.9
+ 484000p 0.9
+ 484010p -0.3
+ 486000p -0.3
+ 486010p 0.9
+ 488000p 0.9
+ 488010p -0.3
+ 490000p -0.3
+ 490010p 0.9
+ 492000p 0.9
+ 492010p -0.3
+ 494000p -0.3
+ 494010p 0.9
+ 496000p 0.9
+ 496010p -0.3
+ 498000p -0.3
+ 498010p 0.9
+ 500000p 0.9
+ 500010p -0.3
+ 502000p -0.3
+ 502010p 0.9
+ 504000p 0.9
+ 504010p -0.3
+ 506000p -0.3
+ 506010p 0.9
+ 508000p 0.9
+ 508010p -0.3
+ 510000p -0.3
+ 510010p 0.9
+ 512000p 0.9
+ 512010p -0.3
+ 514000p -0.3
+ 514010p 0.9
+ 516000p 0.9
+ 516010p -0.3
+ 518000p -0.3
+ 518010p 0.9
+ 520000p 0.9
+ 520010p -0.3
+ 522000p -0.3
+ 522010p 0.9
+ 524000p 0.9
+ 524010p -0.3
+ 526000p -0.3
+ 526010p 0.9
+ 528000p 0.9
+ 528010p -0.3
+ 530000p -0.3
+ 530010p 0.9
+ 532000p 0.9
+ 532010p -0.3
+ 534000p -0.3
+ 534010p 0.9
+ 536000p 0.9
+ 536010p -0.3
+ 538000p -0.3
+ 538010p 0.9
+ 540000p 0.9
+ 540010p -0.3
+ 542000p -0.3
+ 542010p 0.9
+ 544000p 0.9
+ 544010p -0.3
+ 546000p -0.3
+ 546010p 0.9
+ 548000p 0.9
+ 548010p -0.3
+ 550000p -0.3
+ 550010p 0.9
+ 552000p 0.9
+ 552010p -0.3
+ 554000p -0.3
+ 554010p 0.9
+ 556000p 0.9
+ 556010p -0.3
+ 558000p -0.3
+ 558010p 0.9
+ 560000p 0.9
+ 560010p -0.3
+ 562000p -0.3
+ 562010p 0.9
+ 564000p 0.9
+ 564010p -0.3
+ 566000p -0.3
+ 566010p 0.9
+ 568000p 0.9
+ 568010p -0.3
+ 570000p -0.3
+ 570010p 0.9
+ 572000p 0.9
+ 572010p -0.3
+ 574000p -0.3
+ 574010p 0.9
+ 576000p 0.9
+ 576010p -0.3
+ 578000p -0.3
+ 578010p 0.9
+ 580000p 0.9
+ 580010p -0.3
+ 582000p -0.3
+ 582010p 0.9
+ 584000p 0.9
+ 584010p -0.3
+ 586000p -0.3
+ 586010p 0.9
+ 588000p 0.9
+ 588010p -0.3
+ 590000p -0.3
+ 590010p 0.9
+ 592000p 0.9
+ 592010p -0.3
+ 594000p -0.3
+ 594010p 0.9
+ 596000p 0.9
+ 596010p -0.3
+ 598000p -0.3
+ 598010p 0.9
+ 600000p 0.9
+ 600010p -0.3
+ 602000p -0.3
+ 602010p 0.9
+ 604000p 0.9
+ 604010p -0.3
+ 606000p -0.3
+ 606010p 0.9
+ 608000p 0.9
+ 608010p -0.3
+ 610000p -0.3
+ 610010p 0.9
+ 612000p 0.9
+ 612010p -0.3
+ 614000p -0.3
+ 614010p 0.9
+ 616000p 0.9
+ 616010p -0.3
+ 618000p -0.3
+ 618010p 0.9
+ 620000p 0.9
+ 620010p -0.3
+ 622000p -0.3
+ 622010p 0.9
+ 624000p 0.9
+ 624010p -0.3
+ 626000p -0.3
+ 626010p 0.9
+ 628000p 0.9
+ 628010p -0.3
+ 630000p -0.3
+ 630010p 0.9
+ 632000p 0.9
+ 632010p -0.3
+ 634000p -0.3
+ 634010p 0.9
+ 636000p 0.9
+ 636010p -0.3
+ 638000p -0.3
+ 638010p 0.9
+ 640000p 0.9
+ 640010p -0.3
+ 642000p -0.3
+ 642010p 0.9
+ 644000p 0.9
+ 644010p -0.3
+ 646000p -0.3
+ 646010p 0.9
+ 648000p 0.9
+ 648010p -0.3
+ 650000p -0.3
+ 650010p 0.9
+ 652000p 0.9
+ 652010p -0.3
+ 654000p -0.3
+ 654010p 0.9
+ 656000p 0.9
+ 656010p -0.3
+ 658000p -0.3
+ 658010p 0.9
+ 660000p 0.9
+ 660010p -0.3
+ 662000p -0.3
+ 662010p 0.9
+ 664000p 0.9
+ 664010p -0.3
+ 666000p -0.3
+ 666010p 0.9
+ 668000p 0.9
+ 668010p -0.3
+ 670000p -0.3
+ 670010p 0.9
+ 672000p 0.9
+ 672010p -0.3
+ 674000p -0.3
+ 674010p 0.9
+ 676000p 0.9
+ 676010p -0.3
+ 678000p -0.3
+ 678010p 0.9
+ 680000p 0.9
+ 680010p -0.3
+ 682000p -0.3
+ 682010p 0.9
+ 684000p 0.9
+ 684010p -0.3
+ 686000p -0.3
+ 686010p 0.9
+ 688000p 0.9
+ 688010p -0.3
+ 690000p -0.3
+ 690010p 0.9
+ 692000p 0.9
+ 692010p -0.3
+ 694000p -0.3
+ 694010p 0.9
+ 696000p 0.9
+ 696010p -0.3
+ 698000p -0.3
+ 698010p 0.9
+ 700000p 0.9
+ 700010p -0.3
+ 702000p -0.3
+ 702010p 0.9
+ 704000p 0.9
+ 704010p -0.3
+ 706000p -0.3
+ 706010p 0.9
+ 708000p 0.9
+ 708010p -0.3
+ 710000p -0.3
+ 710010p 0.9
+ 712000p 0.9
+ 712010p -0.3
+ 714000p -0.3
+ 714010p 0.9
+ 716000p 0.9
+ 716010p -0.3
+ 718000p -0.3
+ 718010p 0.9
+ 720000p 0.9
+ 720010p -0.3
+ 722000p -0.3
+ 722010p 0.9
+ 724000p 0.9
+ 724010p -0.3
+ 726000p -0.3
+ 726010p 0.9
+ 728000p 0.9
+ 728010p -0.3
+ 730000p -0.3
+ 730010p 0.9
+ 732000p 0.9
+ 732010p -0.3
+ 734000p -0.3
+ 734010p 0.9
+ 736000p 0.9
+ 736010p -0.3
+ 738000p -0.3
+ 738010p 0.9
+ 740000p 0.9
+ 740010p -0.3
+ 742000p -0.3
+ 742010p 0.9
+ 744000p 0.9
+ 744010p -0.3
+ 746000p -0.3
+ 746010p 0.9
+ 748000p 0.9
+ 748010p -0.3
+ 750000p -0.3
+ 750010p 0.9
+ 752000p 0.9
+ 752010p -0.3
+ 754000p -0.3
+ 754010p 0.9
+ 756000p 0.9
+ 756010p -0.3
+ 758000p -0.3
+ 758010p 0.9
+ 760000p 0.9
+ 760010p -0.3
+ 762000p -0.3
+ 762010p 0.9
+ 764000p 0.9
+ 764010p -0.3
+ 766000p -0.3
+ 766010p 0.9
+ 768000p 0.9
+ 768010p -0.3
+ 770000p -0.3
+ 770010p 0.9
+ 772000p 0.9
+ 772010p -0.3
+ 774000p -0.3
+ 774010p 0.9
+ 776000p 0.9
+ 776010p -0.3
+ 778000p -0.3
+ 778010p 0.9
+ 780000p 0.9
+ 780010p -0.3
+ 782000p -0.3
+ 782010p 0.9
+ 784000p 0.9
+ 784010p -0.3
+ 786000p -0.3
+ 786010p 0.9
+ 788000p 0.9
+ 788010p -0.3
+ 790000p -0.3
+ 790010p 0.9
+ 792000p 0.9
+ 792010p -0.3
+ 794000p -0.3
+ 794010p 0.9
+ 796000p 0.9
+ 796010p -0.3
+ 798000p -0.3
+ 798010p 0.9
+ 800000p 0.9
+ 800010p -0.3
+ 802000p -0.3
+ 802010p 0.9
+ 804000p 0.9
+ 804010p -0.3
+ 806000p -0.3
+ 806010p 0.9
+ 808000p 0.9
+ 808010p -0.3
+ 810000p -0.3
+ 810010p 0.9
+ 812000p 0.9
+ 812010p -0.3
+ 814000p -0.3
+ 814010p 0.9
+ 816000p 0.9
+ 816010p -0.3
+ 818000p -0.3
+ 818010p 0.9
+ 820000p 0.9
+ 820010p -0.3
+ 822000p -0.3
+ 822010p 0.9
+ 824000p 0.9
+ 824010p -0.3
+ 826000p -0.3
+ 826010p 0.9
+ 828000p 0.9
+ 828010p -0.3
+ 830000p -0.3
+ 830010p 0.9
+ 832000p 0.9
+ 832010p -0.3
+ 834000p -0.3
+ 834010p 0.9
+ 836000p 0.9
+ 836010p -0.3
+ 838000p -0.3
+ 838010p 0.9
+ 840000p 0.9
+ 840010p -0.3
+ 842000p -0.3
+ 842010p 0.9
+ 844000p 0.9
+ 844010p -0.3
+ 846000p -0.3
+ 846010p 0.9
+ 848000p 0.9
+ 848010p -0.3
+ 850000p -0.3
+ 850010p 0.9
+ 852000p 0.9
+ 852010p -0.3
+ 854000p -0.3
+ 854010p 0.9
+ 856000p 0.9
+ 856010p -0.3
+ 858000p -0.3
+ 858010p 0.9
+ 860000p 0.9
+ 860010p -0.3
+ 862000p -0.3
+ 862010p 0.9
+ 864000p 0.9
+ 864010p -0.3
+ 866000p -0.3
+ 866010p 0.9
+ 868000p 0.9
+ 868010p -0.3
+ 870000p -0.3
+ 870010p 0.9
+ 872000p 0.9
+ 872010p -0.3
+ 874000p -0.3
+ 874010p 0.9
+ 876000p 0.9
+ 876010p -0.3
+ 878000p -0.3
+ 878010p 0.9
+ 880000p 0.9
+ 880010p -0.3
+ 882000p -0.3
+ 882010p 0.9
+ 884000p 0.9
+ 884010p -0.3
+ 886000p -0.3
+ 886010p 0.9
+ 888000p 0.9
+ 888010p -0.3
+ 890000p -0.3
+ 890010p 0.9
+ 892000p 0.9
+ 892010p -0.3
+ 894000p -0.3
+ 894010p 0.9
+ 896000p 0.9
+ 896010p -0.3
+ 898000p -0.3
+ 898010p 0.9
+ 900000p 0.9
+ 900010p -0.3
+ 902000p -0.3
+ 902010p 0.9
+ 904000p 0.9
+ 904010p -0.3
+ 906000p -0.3
+ 906010p 0.9
+ 908000p 0.9
+ 908010p -0.3
+ 910000p -0.3
+ 910010p 0.9
+ 912000p 0.9
+ 912010p -0.3
+ 914000p -0.3
+ 914010p 0.9
+ 916000p 0.9
+ 916010p -0.3
+ 918000p -0.3
+ 918010p 0.9
+ 920000p 0.9
+ 920010p -0.3
+ 922000p -0.3
+ 922010p 0.9
+ 924000p 0.9
+ 924010p -0.3
+ 926000p -0.3
+ 926010p 0.9
+ 928000p 0.9
+ 928010p -0.3
+ 930000p -0.3
+ 930010p 0.9
+ 932000p 0.9
+ 932010p -0.3
+ 934000p -0.3
+ 934010p 0.9
+ 936000p 0.9
+ 936010p -0.3
+ 938000p -0.3
+ 938010p 0.9
+ 940000p 0.9
+ 940010p -0.3
+ 942000p -0.3
+ 942010p 0.9
+ 944000p 0.9
+ 944010p -0.3
+ 946000p -0.3
+ 946010p 0.9
+ 948000p 0.9
+ 948010p -0.3
+ 950000p -0.3
+ 950010p 0.9
+ 952000p 0.9
+ 952010p -0.3
+ 954000p -0.3
+ 954010p 0.9
+ 956000p 0.9
+ 956010p -0.3
+ 958000p -0.3
+ 958010p 0.9
+ 960000p 0.9
+ 960010p -0.3
+ 962000p -0.3
+ 962010p 0.9
+ 964000p 0.9
+ 964010p -0.3
+ 966000p -0.3
+ 966010p 0.9
+ 968000p 0.9
+ 968010p -0.3
+ 970000p -0.3
+ 970010p 0.9
+ 972000p 0.9
+ 972010p -0.3
+ 974000p -0.3
+ 974010p 0.9
+ 976000p 0.9
+ 976010p -0.3
+ 978000p -0.3
+ 978010p 0.9
+ 980000p 0.9
+ 980010p -0.3
+ 982000p -0.3
+ 982010p 0.9
+ 984000p 0.9
+ 984010p -0.3
+ 986000p -0.3
+ 986010p 0.9
+ 988000p 0.9
+ 988010p -0.3
+ 990000p -0.3
+ 990010p 0.9
+ 992000p 0.9
+ 992010p -0.3
+ 994000p -0.3
+ 994010p 0.9
+ 996000p 0.9
+ 996010p -0.3
+ 998000p -0.3
+ 998010p 0.9
+ 1000000p 0.9
+ 1000010p -0.3
+ 1002000p -0.3
+ 1002010p 0.9
+ 1004000p 0.9
+ 1004010p -0.3
+ 1006000p -0.3
+ 1006010p 0.9
+ 1008000p 0.9
+ 1008010p -0.3
+ 1010000p -0.3
+ 1010010p 0.9
+ 1012000p 0.9
+ 1012010p -0.3
+ 1014000p -0.3
+ 1014010p 0.9
+ 1016000p 0.9
+ 1016010p -0.3
+ 1018000p -0.3
+ 1018010p 0.9
+ 1020000p 0.9
+ 1020010p -0.3
+ 1022000p -0.3
+ 1022010p 0.9
+ 1024000p 0.9
+ 1024010p -0.3
+ 1026000p -0.3
+ 1026010p 0.9
+ 1028000p 0.9
+ 1028010p -0.3
+ 1030000p -0.3
+ 1030010p 0.9
+ 1032000p 0.9
+ 1032010p -0.3
+ 1034000p -0.3
+ 1034010p 0.9
+ 1036000p 0.9
+ 1036010p -0.3
+ 1038000p -0.3
+ 1038010p 0.9
+ 1040000p 0.9
+ 1040010p -0.3
+ 1042000p -0.3
+ 1042010p 0.9
+ 1044000p 0.9
+ 1044010p -0.3
+ 1046000p -0.3
+ 1046010p 0.9
+ 1048000p 0.9
+ 1048010p -0.3
+ 1050000p -0.3
+ 1050010p 0.9
+ 1052000p 0.9
+ 1052010p -0.3
+ 1054000p -0.3
+ 1054010p 0.9
+ 1056000p 0.9
+ 1056010p -0.3
+ 1058000p -0.3
+ 1058010p 0.9
+ 1060000p 0.9
+ 1060010p -0.3
+ 1062000p -0.3
+ 1062010p 0.9
+ 1064000p 0.9
+ 1064010p -0.3
+ 1066000p -0.3
+ 1066010p 0.9
+ 1068000p 0.9
+ 1068010p -0.3
+ 1070000p -0.3
+ 1070010p 0.9
+ 1072000p 0.9
+ 1072010p -0.3
+ 1074000p -0.3
+ 1074010p 0.9
+ 1076000p 0.9
+ 1076010p -0.3
+ 1078000p -0.3
+ 1078010p 0.9
+ 1080000p 0.9
+ 1080010p -0.3
+ 1082000p -0.3
+ 1082010p 0.9
+ 1084000p 0.9
+ 1084010p -0.3
+ 1086000p -0.3
+ 1086010p 0.9
+ 1088000p 0.9
+ 1088010p -0.3
+ 1090000p -0.3
+ 1090010p 0.9
+ 1092000p 0.9
+ 1092010p -0.3
+ 1094000p -0.3
+ 1094010p 0.9
+ 1096000p 0.9
+ 1096010p -0.3
+ 1098000p -0.3
+ 1098010p 0.9
+ 1100000p 0.9
+ 1100010p -0.3
+ 1102000p -0.3
+ 1102010p 0.9
+ 1104000p 0.9
+ 1104010p -0.3
+ 1106000p -0.3
+ 1106010p 0.9
+ 1108000p 0.9
+ 1108010p -0.3
+ 1110000p -0.3
+ 1110010p 0.9
+ 1112000p 0.9
+ 1112010p -0.3
+ 1114000p -0.3
+ 1114010p 0.9
+ 1116000p 0.9
+ 1116010p -0.3
+ 1118000p -0.3
+ 1118010p 0.9
+ 1120000p 0.9
+ 1120010p -0.3
+ 1122000p -0.3
+ 1122010p 0.9
+ 1124000p 0.9
+ 1124010p -0.3
+ 1126000p -0.3
+ 1126010p 0.9
+ 1128000p 0.9
+ 1128010p -0.3
+ 1130000p -0.3
+ 1130010p 0.9
+ 1132000p 0.9
+ 1132010p -0.3
+ 1134000p -0.3
+ 1134010p 0.9
+ 1136000p 0.9
+ 1136010p -0.3
+ 1138000p -0.3
+ 1138010p 0.9
+ 1140000p 0.9
+ 1140010p -0.3
+ 1142000p -0.3
+ 1142010p 0.9
+ 1144000p 0.9
+ 1144010p -0.3
+ 1146000p -0.3
+ 1146010p 0.9
+ 1148000p 0.9
+ 1148010p -0.3
+ 1150000p -0.3
+ 1150010p 0.9
+ 1152000p 0.9
+ 1152010p -0.3
+ 1154000p -0.3
+ 1154010p 0.9
+ 1156000p 0.9
+ 1156010p -0.3
+ 1158000p -0.3
+ 1158010p 0.9
+ 1160000p 0.9
+ 1160010p -0.3
+ 1162000p -0.3
+ 1162010p 0.9
+ 1164000p 0.9
+ 1164010p -0.3
+ 1166000p -0.3
+ 1166010p 0.9
+ 1168000p 0.9
+ 1168010p -0.3
+ 1170000p -0.3
+ 1170010p 0.9
+ 1172000p 0.9
+ 1172010p -0.3
+ 1174000p -0.3
+ 1174010p 0.9
+ 1176000p 0.9
+ 1176010p -0.3
+ 1178000p -0.3
+ 1178010p 0.9
+ 1180000p 0.9
+ 1180010p -0.3
+ 1182000p -0.3
+ 1182010p 0.9
+ 1184000p 0.9
+ 1184010p -0.3
+ 1186000p -0.3
+ 1186010p 0.9
+ 1188000p 0.9
+ 1188010p -0.3
+ 1190000p -0.3
+ 1190010p 0.9
+ 1192000p 0.9
+ 1192010p -0.3
+ 1194000p -0.3
+ 1194010p 0.9
+ 1196000p 0.9
+ 1196010p -0.3
+ 1198000p -0.3
+ 1198010p 0.9
+ 1200000p 0.9
+ 1200010p -0.3
+ 1202000p -0.3
+ 1202010p 0.9
+ 1204000p 0.9
+ 1204010p -0.3
+ 1206000p -0.3
+ 1206010p 0.9
+ 1208000p 0.9
+ 1208010p -0.3
+ 1210000p -0.3
+ 1210010p 0.9
+ 1212000p 0.9
+ 1212010p -0.3
+ 1214000p -0.3
+ 1214010p 0.9
+ 1216000p 0.9
+ 1216010p -0.3
+ 1218000p -0.3
+ 1218010p 0.9
+ 1220000p 0.9
+ 1220010p -0.3
+ 1222000p -0.3
+ 1222010p 0.9
+ 1224000p 0.9
+ 1224010p -0.3
+ 1226000p -0.3
+ 1226010p 0.9
+ 1228000p 0.9
+ 1228010p -0.3
+ 1230000p -0.3
+ 1230010p 0.9
+ 1232000p 0.9
+ 1232010p -0.3
+ 1234000p -0.3
+ 1234010p 0.9
+ 1236000p 0.9
+ 1236010p -0.3
+ 1238000p -0.3
+ 1238010p 0.9
+ 1240000p 0.9
+ 1240010p -0.3
+ 1242000p -0.3
+ 1242010p 0.9
+ 1244000p 0.9
+ 1244010p -0.3
+ 1246000p -0.3
+ 1246010p 0.9
+ 1248000p 0.9
+ 1248010p -0.3
+ 1250000p -0.3
+ 1250010p 0.9
+ 1252000p 0.9
+ 1252010p -0.3
+ 1254000p -0.3
+ 1254010p 0.9
+ 1256000p 0.9
+ 1256010p -0.3
+ 1258000p -0.3
+ 1258010p 0.9
+ 1260000p 0.9
+ 1260010p -0.3
+ 1262000p -0.3
+ 1262010p 0.9
+ 1264000p 0.9
+ 1264010p -0.3
+ 1266000p -0.3
+ 1266010p 0.9
+ 1268000p 0.9
+ 1268010p -0.3
+ 1270000p -0.3
+ 1270010p 0.9
+ 1272000p 0.9
+ 1272010p -0.3
+ 1274000p -0.3
+ 1274010p 0.9
+ 1276000p 0.9
+ 1276010p -0.3
+ 1278000p -0.3
+ 1278010p 0.9
+ 1280000p 0.9
+ 1280010p -0.3
+ 1282000p -0.3
+ 1282010p 0.9
+ 1284000p 0.9
+ 1284010p -0.3
+ 1286000p -0.3
+ 1286010p 0.9
+ 1288000p 0.9
+ 1288010p -0.3
+ 1290000p -0.3
+ 1290010p 0.9
+ 1292000p 0.9
+ 1292010p -0.3
+ 1294000p -0.3
+ 1294010p 0.9
+ 1296000p 0.9
+ 1296010p -0.3
+ 1298000p -0.3
+ 1298010p 0.9
+ 1300000p 0.9
+ 1300010p -0.3
+ 1302000p -0.3
+ 1302010p 0.9
+ 1304000p 0.9
+ 1304010p -0.3
+ 1306000p -0.3
+ 1306010p 0.9
+ 1308000p 0.9
+ 1308010p -0.3
+ 1310000p -0.3
+ 1310010p 0.9
+ 1312000p 0.9
+ 1312010p -0.3
+ 1314000p -0.3
+ 1314010p 0.9
+ 1316000p 0.9
+ 1316010p -0.3
+ 1318000p -0.3
+ 1318010p 0.9
+ 1320000p 0.9
+ 1320010p -0.3
+ 1322000p -0.3
+ 1322010p 0.9
+ 1324000p 0.9
+ 1324010p -0.3
+ 1326000p -0.3
+ 1326010p 0.9
+ 1328000p 0.9
+ 1328010p -0.3
+ 1330000p -0.3
+ 1330010p 0.9
+ 1332000p 0.9
+ 1332010p -0.3
+ 1334000p -0.3
+ 1334010p 0.9
+ 1336000p 0.9
+ 1336010p -0.3
+ 1338000p -0.3
+ 1338010p 0.9
+ 1340000p 0.9
+ 1340010p -0.3
+ 1342000p -0.3
+ 1342010p 0.9
+ 1344000p 0.9
+ 1344010p -0.3
+ 1346000p -0.3
+ 1346010p 0.9
+ 1348000p 0.9
+ 1348010p -0.3
+ 1350000p -0.3
+ 1350010p 0.9
+ 1352000p 0.9
+ 1352010p -0.3
+ 1354000p -0.3
+ 1354010p 0.9
+ 1356000p 0.9
+ 1356010p -0.3
+ 1358000p -0.3
+ 1358010p 0.9
+ 1360000p 0.9
+ 1360010p -0.3
+ 1362000p -0.3
+ 1362010p 0.9
+ 1364000p 0.9
+ 1364010p -0.3
+ 1366000p -0.3
+ 1366010p 0.9
+ 1368000p 0.9
+ 1368010p -0.3
+ 1370000p -0.3
+ 1370010p 0.9
+ 1372000p 0.9
+ 1372010p -0.3
+ 1374000p -0.3
+ 1374010p 0.9
+ 1376000p 0.9
+ 1376010p -0.3
+ 1378000p -0.3
+ 1378010p 0.9
+ 1380000p 0.9
+ 1380010p -0.3
+ 1382000p -0.3
+ 1382010p 0.9
+ 1384000p 0.9
+ 1384010p -0.3
+ 1386000p -0.3
+ 1386010p 0.9
+ 1388000p 0.9
+ 1388010p -0.3
+ 1390000p -0.3
+ 1390010p 0.9
+ 1392000p 0.9
+ 1392010p -0.3
+ 1394000p -0.3
+ 1394010p 0.9
+ 1396000p 0.9
+ 1396010p -0.3
+ 1398000p -0.3
+ 1398010p 0.9
+ 1400000p 0.9
+ 1400010p -0.3
+ 1402000p -0.3
+ 1402010p 0.9
+ 1404000p 0.9
+ 1404010p -0.3
+ 1406000p -0.3
+ 1406010p 0.9
+ 1408000p 0.9
+ 1408010p -0.3
+ 1410000p -0.3
+ 1410010p 0.9
+ 1412000p 0.9
+ 1412010p -0.3
+ 1414000p -0.3
+ 1414010p 0.9
+ 1416000p 0.9
+ 1416010p -0.3
+ 1418000p -0.3
+ 1418010p 0.9
+ 1420000p 0.9
+ 1420010p -0.3
+ 1422000p -0.3
+ 1422010p 0.9
+ 1424000p 0.9
+ 1424010p -0.3
+ 1426000p -0.3
+ 1426010p 0.9
+ 1428000p 0.9
+ 1428010p -0.3
+ 1430000p -0.3
+ 1430010p 0.9
+ 1432000p 0.9
+ 1432010p -0.3
+ 1434000p -0.3
+ 1434010p 0.9
+ 1436000p 0.9
+ 1436010p -0.3
+ 1438000p -0.3
+ 1438010p 0.9
+ 1440000p 0.9
+ 1440010p -0.3
+ 1442000p -0.3
+ 1442010p 0.9
+ 1444000p 0.9
+ 1444010p -0.3
+ 1446000p -0.3
+ 1446010p 0.9
+ 1448000p 0.9
+ 1448010p -0.3
+ 1450000p -0.3
+ 1450010p 0.9
+ 1452000p 0.9
+ 1452010p -0.3
+ 1454000p -0.3
+ 1454010p 0.9
+ 1456000p 0.9
+ 1456010p -0.3
+ 1458000p -0.3
+ 1458010p 0.9
+ 1460000p 0.9
+ 1460010p -0.3
+ 1462000p -0.3
+ 1462010p 0.9
+ 1464000p 0.9
+ 1464010p -0.3
+ 1466000p -0.3
+ 1466010p 0.9
+ 1468000p 0.9
+ 1468010p -0.3
+ 1470000p -0.3
+ 1470010p 0.9
+ 1472000p 0.9
+ 1472010p -0.3
+ 1474000p -0.3
+ 1474010p 0.9
+ 1476000p 0.9
+ 1476010p -0.3
+ 1478000p -0.3
+ 1478010p 0.9
+ 1480000p 0.9
+ 1480010p -0.3
+ 1482000p -0.3
+ 1482010p 0.9
+ 1484000p 0.9
+ 1484010p -0.3
+ 1486000p -0.3
+ 1486010p 0.9
+ 1488000p 0.9
+ 1488010p -0.3
+ 1490000p -0.3
+ 1490010p 0.9
+ 1492000p 0.9
+ 1492010p -0.3
+ 1494000p -0.3
+ 1494010p 0.9
+ 1496000p 0.9
+ 1496010p -0.3
+ 1498000p -0.3
+ 1498010p 0.9
+ 1500000p 0.9
+ 1500010p -0.3
+ 1502000p -0.3
+ 1502010p 0.9
+ 1504000p 0.9
+ 1504010p -0.3
+ 1506000p -0.3
+ 1506010p 0.9
+ 1508000p 0.9
+ 1508010p -0.3
+ 1510000p -0.3
+ 1510010p 0.9
+ 1512000p 0.9
+ 1512010p -0.3
+ 1514000p -0.3
+ 1514010p 0.9
+ 1516000p 0.9
+ 1516010p -0.3
+ 1518000p -0.3
+ 1518010p 0.9
+ 1520000p 0.9
+ 1520010p -0.3
+ 1522000p -0.3
+ 1522010p 0.9
+ 1524000p 0.9
+ 1524010p -0.3
+ 1526000p -0.3
+ 1526010p 0.9
+ 1528000p 0.9
+ 1528010p -0.3
+ 1530000p -0.3
+ 1530010p 0.9
+ 1532000p 0.9
+ 1532010p -0.3
+ 1534000p -0.3
+ 1534010p 0.9
+ 1536000p 0.9
+ 1536010p -0.3
+ 1538000p -0.3
+ 1538010p 0.9
+ 1540000p 0.9
+ 1540010p -0.3
+ 1542000p -0.3
+ 1542010p 0.9
+ 1544000p 0.9
+ 1544010p -0.3
+ 1546000p -0.3
+ 1546010p 0.9
+ 1548000p 0.9
+ 1548010p -0.3
+ 1550000p -0.3
+ 1550010p 0.9
+ 1552000p 0.9
+ 1552010p -0.3
+ 1554000p -0.3
+ 1554010p 0.9
+ 1556000p 0.9
+ 1556010p -0.3
+ 1558000p -0.3
+ 1558010p 0.9
+ 1560000p 0.9
+ 1560010p -0.3
+ 1562000p -0.3
+ 1562010p 0.9
+ 1564000p 0.9
+ 1564010p -0.3
+ 1566000p -0.3
+ 1566010p 0.9
+ 1568000p 0.9
+ 1568010p -0.3
+ 1570000p -0.3
+ 1570010p 0.9
+ 1572000p 0.9
+ 1572010p -0.3
+ 1574000p -0.3
+ 1574010p 0.9
+ 1576000p 0.9
+ 1576010p -0.3
+ 1578000p -0.3
+ 1578010p 0.9
+ 1580000p 0.9
+ 1580010p -0.3
+ 1582000p -0.3
+ 1582010p 0.9
+ 1584000p 0.9
+ 1584010p -0.3
+ 1586000p -0.3
+ 1586010p 0.9
+ 1588000p 0.9
+ 1588010p -0.3
+ 1590000p -0.3
+ 1590010p 0.9
+ 1592000p 0.9
+ 1592010p -0.3
+ 1594000p -0.3
+ 1594010p 0.9
+ 1596000p 0.9
+ 1596010p -0.3
+ 1598000p -0.3
+ 1598010p 0.9
+ 1600000p 0.9
+ 1600010p -0.3
+ 1602000p -0.3
+ 1602010p 0.9
+ 1604000p 0.9
+ 1604010p -0.3
+ 1606000p -0.3
+ 1606010p 0.9
+ 1608000p 0.9
+ 1608010p -0.3
+ 1610000p -0.3
+ 1610010p 0.9
+ 1612000p 0.9
+ 1612010p -0.3
+ 1614000p -0.3
+ 1614010p 0.9
+ 1616000p 0.9
+ 1616010p -0.3
+ 1618000p -0.3
+ 1618010p 0.9
+ 1620000p 0.9
+ 1620010p -0.3
+ 1622000p -0.3
+ 1622010p 0.9
+ 1624000p 0.9
+ 1624010p -0.3
+ 1626000p -0.3
+ 1626010p 0.9
+ 1628000p 0.9
+ 1628010p -0.3
+ 1630000p -0.3
+ 1630010p 0.9
+ 1632000p 0.9
+ 1632010p -0.3
+ 1634000p -0.3
+ 1634010p 0.9
+ 1636000p 0.9
+ 1636010p -0.3
+ 1638000p -0.3
+ 1638010p 0.9
+ 1640000p 0.9
+ 1640010p -0.3
+ 1642000p -0.3
+ 1642010p 0.9
+ 1644000p 0.9
+ 1644010p -0.3
+ 1646000p -0.3
+ 1646010p 0.9
+ 1648000p 0.9
+ 1648010p -0.3
+ 1650000p -0.3
+ 1650010p 0.9
+ 1652000p 0.9
+ 1652010p -0.3
+ 1654000p -0.3
+ 1654010p 0.9
+ 1656000p 0.9
+ 1656010p -0.3
+ 1658000p -0.3
+ 1658010p 0.9
+ 1660000p 0.9
+ 1660010p -0.3
+ 1662000p -0.3
+ 1662010p 0.9
+ 1664000p 0.9
+ 1664010p -0.3
+ 1666000p -0.3
+ 1666010p 0.9
+ 1668000p 0.9
+ 1668010p -0.3
+ 1670000p -0.3
+ 1670010p 0.9
+ 1672000p 0.9
+ 1672010p -0.3
+ 1674000p -0.3
+ 1674010p 0.9
+ 1676000p 0.9
+ 1676010p -0.3
+ 1678000p -0.3
+ 1678010p 0.9
+ 1680000p 0.9
+ 1680010p -0.3
+ 1682000p -0.3
+ 1682010p 0.9
+ 1684000p 0.9
+ 1684010p -0.3
+ 1686000p -0.3
+ 1686010p 0.9
+ 1688000p 0.9
+ 1688010p -0.3
+ 1690000p -0.3
+ 1690010p 0.9
+ 1692000p 0.9
+ 1692010p -0.3
+ 1694000p -0.3
+ 1694010p 0.9
+ 1696000p 0.9
+ 1696010p -0.3
+ 1698000p -0.3
+ 1698010p 0.9
+ 1700000p 0.9
+ 1700010p -0.3
+ 1702000p -0.3
+ 1702010p 0.9
+ 1704000p 0.9
+ 1704010p -0.3
+ 1706000p -0.3
+ 1706010p 0.9
+ 1708000p 0.9
+ 1708010p -0.3
+ 1710000p -0.3
+ 1710010p 0.9
+ 1712000p 0.9
+ 1712010p -0.3
+ 1714000p -0.3
+ 1714010p 0.9
+ 1716000p 0.9
+ 1716010p -0.3
+ 1718000p -0.3
+ 1718010p 0.9
+ 1720000p 0.9
+ 1720010p -0.3
+ 1722000p -0.3
+ 1722010p 0.9
+ 1724000p 0.9
+ 1724010p -0.3
+ 1726000p -0.3
+ 1726010p 0.9
+ 1728000p 0.9
+ 1728010p -0.3
+ 1730000p -0.3
+ 1730010p 0.9
+ 1732000p 0.9
+ 1732010p -0.3
+ 1734000p -0.3
+ 1734010p 0.9
+ 1736000p 0.9
+ 1736010p -0.3
+ 1738000p -0.3
+ 1738010p 0.9
+ 1740000p 0.9
+ 1740010p -0.3
+ 1742000p -0.3
+ 1742010p 0.9
+ 1744000p 0.9
+ 1744010p -0.3
+ 1746000p -0.3
+ 1746010p 0.9
+ 1748000p 0.9
+ 1748010p -0.3
+ 1750000p -0.3
+ 1750010p 0.9
+ 1752000p 0.9
+ 1752010p -0.3
+ 1754000p -0.3
+ 1754010p 0.9
+ 1756000p 0.9
+ 1756010p -0.3
+ 1758000p -0.3
+ 1758010p 0.9
+ 1760000p 0.9
+ 1760010p -0.3
+ 1762000p -0.3
+ 1762010p 0.9
+ 1764000p 0.9
+ 1764010p -0.3
+ 1766000p -0.3
+ 1766010p 0.9
+ 1768000p 0.9
+ 1768010p -0.3
+ 1770000p -0.3
+ 1770010p 0.9
+ 1772000p 0.9
+ 1772010p -0.3
+ 1774000p -0.3
+ 1774010p 0.9
+ 1776000p 0.9
+ 1776010p -0.3
+ 1778000p -0.3
+ 1778010p 0.9
+ 1780000p 0.9
+ 1780010p -0.3
+ 1782000p -0.3
+ 1782010p 0.9
+ 1784000p 0.9
+ 1784010p -0.3
+ 1786000p -0.3
+ 1786010p 0.9
+ 1788000p 0.9
+ 1788010p -0.3
+ 1790000p -0.3
+ 1790010p 0.9
+ 1792000p 0.9
+ 1792010p -0.3
+ 1794000p -0.3
+ 1794010p 0.9
+ 1796000p 0.9
+ 1796010p -0.3
+ 1798000p -0.3
+ 1798010p 0.9
+ 1800000p 0.9
+ 1800010p -0.3
+ 1802000p -0.3
+ 1802010p 0.9
+ 1804000p 0.9
+ 1804010p -0.3
+ 1806000p -0.3
+ 1806010p 0.9
+ 1808000p 0.9
+ 1808010p -0.3
+ 1810000p -0.3
+ 1810010p 0.9
+ 1812000p 0.9
+ 1812010p -0.3
+ 1814000p -0.3
+ 1814010p 0.9
+ 1816000p 0.9
+ 1816010p -0.3
+ 1818000p -0.3
+ 1818010p 0.9
+ 1820000p 0.9
+ 1820010p -0.3
+ 1822000p -0.3
+ 1822010p 0.9
+ 1824000p 0.9
+ 1824010p -0.3
+ 1826000p -0.3
+ 1826010p 0.9
+ 1828000p 0.9
+ 1828010p -0.3
+ 1830000p -0.3
+ 1830010p 0.9
+ 1832000p 0.9
+ 1832010p -0.3
+ 1834000p -0.3
+ 1834010p 0.9
+ 1836000p 0.9
+ 1836010p -0.3
+ 1838000p -0.3
+ 1838010p 0.9
+ 1840000p 0.9
+ 1840010p -0.3
+ 1842000p -0.3
+ 1842010p 0.9
+ 1844000p 0.9
+ 1844010p -0.3
+ 1846000p -0.3
+ 1846010p 0.9
+ 1848000p 0.9
+ 1848010p -0.3
+ 1850000p -0.3
+ 1850010p 0.9
+ 1852000p 0.9
+ 1852010p -0.3
+ 1854000p -0.3
+ 1854010p 0.9
+ 1856000p 0.9
+ 1856010p -0.3
+ 1858000p -0.3
+ 1858010p 0.9
+ 1860000p 0.9
+ 1860010p -0.3
+ 1862000p -0.3
+ 1862010p 0.9
+ 1864000p 0.9
+ 1864010p -0.3
+ 1866000p -0.3
+ 1866010p 0.9
+ 1868000p 0.9
+ 1868010p -0.3
+ 1870000p -0.3
+ 1870010p 0.9
+ 1872000p 0.9
+ 1872010p -0.3
+ 1874000p -0.3
+ 1874010p 0.9
+ 1876000p 0.9
+ 1876010p -0.3
+ 1878000p -0.3
+ 1878010p 0.9
+ 1880000p 0.9
+ 1880010p -0.3
+ 1882000p -0.3
+ 1882010p 0.9
+ 1884000p 0.9
+ 1884010p -0.3
+ 1886000p -0.3
+ 1886010p 0.9
+ 1888000p 0.9
+ 1888010p -0.3
+ 1890000p -0.3
+ 1890010p 0.9
+ 1892000p 0.9
+ 1892010p -0.3
+ 1894000p -0.3
+ 1894010p 0.9
+ 1896000p 0.9
+ 1896010p -0.3
+ 1898000p -0.3
+ 1898010p 0.9
+ 1900000p 0.9
+ 1900010p -0.3
+ 1902000p -0.3
+ 1902010p 0.9
+ 1904000p 0.9
+ 1904010p -0.3
+ 1906000p -0.3
+ 1906010p 0.9
+ 1908000p 0.9
+ 1908010p -0.3
+ 1910000p -0.3
+ 1910010p 0.9
+ 1912000p 0.9
+ 1912010p -0.3
+ 1914000p -0.3
+ 1914010p 0.9
+ 1916000p 0.9
+ 1916010p -0.3
+ 1918000p -0.3
+ 1918010p 0.9
+ 1920000p 0.9
+ 1920010p -0.3
+ 1922000p -0.3
+ 1922010p 0.9
+ 1924000p 0.9
+ 1924010p -0.3
+ 1926000p -0.3
+ 1926010p 0.9
+ 1928000p 0.9
+ 1928010p -0.3
+ 1930000p -0.3
+ 1930010p 0.9
+ 1932000p 0.9
+ 1932010p -0.3
+ 1934000p -0.3
+ 1934010p 0.9
+ 1936000p 0.9
+ 1936010p -0.3
+ 1938000p -0.3
+ 1938010p 0.9
+ 1940000p 0.9
+ 1940010p -0.3
+ 1942000p -0.3
+ 1942010p 0.9
+ 1944000p 0.9
+ 1944010p -0.3
+ 1946000p -0.3
+ 1946010p 0.9
+ 1948000p 0.9
+ 1948010p -0.3
+ 1950000p -0.3
+ 1950010p 0.9
+ 1952000p 0.9
+ 1952010p -0.3
+ 1954000p -0.3
+ 1954010p 0.9
+ 1956000p 0.9
+ 1956010p -0.3
+ 1958000p -0.3
+ 1958010p 0.9
+ 1960000p 0.9
+ 1960010p -0.3
+ 1962000p -0.3
+ 1962010p 0.9
+ 1964000p 0.9
+ 1964010p -0.3
+ 1966000p -0.3
+ 1966010p 0.9
+ 1968000p 0.9
+ 1968010p -0.3
+ 1970000p -0.3
+ 1970010p 0.9
+ 1972000p 0.9
+ 1972010p -0.3
+ 1974000p -0.3
+ 1974010p 0.9
+ 1976000p 0.9
+ 1976010p -0.3
+ 1978000p -0.3
+ 1978010p 0.9
+ 1980000p 0.9
+ 1980010p -0.3
+ 1982000p -0.3
+ 1982010p 0.9
+ 1984000p 0.9
+ 1984010p -0.3
+ 1986000p -0.3
+ 1986010p 0.9
+ 1988000p 0.9
+ 1988010p -0.3
+ 1990000p -0.3
+ 1990010p 0.9
+ 1992000p 0.9
+ 1992010p -0.3
+ 1994000p -0.3
+ 1994010p 0.9
+ 1996000p 0.9
+ 1996010p -0.3
+ 1998000p -0.3
+ 1998010p 0.9
+ 2000000p 0.9
+ 2000010p -0.3
+ 2002000p -0.3
+ 2002010p 0.9
+ 2004000p 0.9
+ 2004010p -0.3
+ 2006000p -0.3
+ 2006010p 0.9
+ 2008000p 0.9
+ 2008010p -0.3
+ 2010000p -0.3
+ 2010010p 0.9
+ 2012000p 0.9
+ 2012010p -0.3
+ 2014000p -0.3
+ 2014010p 0.9
+ 2016000p 0.9
+ 2016010p -0.3
+ 2018000p -0.3
+ 2018010p 0.9
+ 2020000p 0.9
+ 2020010p -0.3
+ 2022000p -0.3
+ 2022010p 0.9
+ 2024000p 0.9
+ 2024010p -0.3
+ 2026000p -0.3
+ 2026010p 0.9
+ 2028000p 0.9
+ 2028010p -0.3
+ 2030000p -0.3
+ 2030010p 0.9
+ 2032000p 0.9
+ 2032010p -0.3
+ 2034000p -0.3
+ 2034010p 0.9
+ 2036000p 0.9
+ 2036010p -0.3
+ 2038000p -0.3
+ 2038010p 0.9
+ 2040000p 0.9
+ 2040010p -0.3
+ 2042000p -0.3
+ 2042010p 0.9
+ 2044000p 0.9
+ 2044010p -0.3
+ 2046000p -0.3
+ 2046010p 0.9
+ 2048000p 0.9
+ 2048010p -0.3
+ \]
V_data_25 (Data\\<25\\> gnd!) vsource type=pwl wave=\[
+ 0    0.9
+ 2000p 0.9
+ 2010p -0.3
+ 4000p -0.3
+ 4010p 0.9
+ 6000p 0.9
+ 6010p -0.3
+ 8000p -0.3
+ 8010p 0.9
+ 10000p 0.9
+ 10010p -0.3
+ 12000p -0.3
+ 12010p 0.9
+ 14000p 0.9
+ 14010p -0.3
+ 16000p -0.3
+ 16010p 0.9
+ 18000p 0.9
+ 18010p -0.3
+ 20000p -0.3
+ 20010p 0.9
+ 22000p 0.9
+ 22010p -0.3
+ 24000p -0.3
+ 24010p 0.9
+ 26000p 0.9
+ 26010p -0.3
+ 28000p -0.3
+ 28010p 0.9
+ 30000p 0.9
+ 30010p -0.3
+ 32000p -0.3
+ 32010p 0.9
+ 34000p 0.9
+ 34010p -0.3
+ 36000p -0.3
+ 36010p 0.9
+ 38000p 0.9
+ 38010p -0.3
+ 40000p -0.3
+ 40010p 0.9
+ 42000p 0.9
+ 42010p -0.3
+ 44000p -0.3
+ 44010p 0.9
+ 46000p 0.9
+ 46010p -0.3
+ 48000p -0.3
+ 48010p 0.9
+ 50000p 0.9
+ 50010p -0.3
+ 52000p -0.3
+ 52010p 0.9
+ 54000p 0.9
+ 54010p -0.3
+ 56000p -0.3
+ 56010p 0.9
+ 58000p 0.9
+ 58010p -0.3
+ 60000p -0.3
+ 60010p 0.9
+ 62000p 0.9
+ 62010p -0.3
+ 64000p -0.3
+ 64010p 0.9
+ 66000p 0.9
+ 66010p -0.3
+ 68000p -0.3
+ 68010p 0.9
+ 70000p 0.9
+ 70010p -0.3
+ 72000p -0.3
+ 72010p 0.9
+ 74000p 0.9
+ 74010p -0.3
+ 76000p -0.3
+ 76010p 0.9
+ 78000p 0.9
+ 78010p -0.3
+ 80000p -0.3
+ 80010p 0.9
+ 82000p 0.9
+ 82010p -0.3
+ 84000p -0.3
+ 84010p 0.9
+ 86000p 0.9
+ 86010p -0.3
+ 88000p -0.3
+ 88010p 0.9
+ 90000p 0.9
+ 90010p -0.3
+ 92000p -0.3
+ 92010p 0.9
+ 94000p 0.9
+ 94010p -0.3
+ 96000p -0.3
+ 96010p 0.9
+ 98000p 0.9
+ 98010p -0.3
+ 100000p -0.3
+ 100010p 0.9
+ 102000p 0.9
+ 102010p -0.3
+ 104000p -0.3
+ 104010p 0.9
+ 106000p 0.9
+ 106010p -0.3
+ 108000p -0.3
+ 108010p 0.9
+ 110000p 0.9
+ 110010p -0.3
+ 112000p -0.3
+ 112010p 0.9
+ 114000p 0.9
+ 114010p -0.3
+ 116000p -0.3
+ 116010p 0.9
+ 118000p 0.9
+ 118010p -0.3
+ 120000p -0.3
+ 120010p 0.9
+ 122000p 0.9
+ 122010p -0.3
+ 124000p -0.3
+ 124010p 0.9
+ 126000p 0.9
+ 126010p -0.3
+ 128000p -0.3
+ 128010p 0.9
+ 130000p 0.9
+ 130010p -0.3
+ 132000p -0.3
+ 132010p 0.9
+ 134000p 0.9
+ 134010p -0.3
+ 136000p -0.3
+ 136010p 0.9
+ 138000p 0.9
+ 138010p -0.3
+ 140000p -0.3
+ 140010p 0.9
+ 142000p 0.9
+ 142010p -0.3
+ 144000p -0.3
+ 144010p 0.9
+ 146000p 0.9
+ 146010p -0.3
+ 148000p -0.3
+ 148010p 0.9
+ 150000p 0.9
+ 150010p -0.3
+ 152000p -0.3
+ 152010p 0.9
+ 154000p 0.9
+ 154010p -0.3
+ 156000p -0.3
+ 156010p 0.9
+ 158000p 0.9
+ 158010p -0.3
+ 160000p -0.3
+ 160010p 0.9
+ 162000p 0.9
+ 162010p -0.3
+ 164000p -0.3
+ 164010p 0.9
+ 166000p 0.9
+ 166010p -0.3
+ 168000p -0.3
+ 168010p 0.9
+ 170000p 0.9
+ 170010p -0.3
+ 172000p -0.3
+ 172010p 0.9
+ 174000p 0.9
+ 174010p -0.3
+ 176000p -0.3
+ 176010p 0.9
+ 178000p 0.9
+ 178010p -0.3
+ 180000p -0.3
+ 180010p 0.9
+ 182000p 0.9
+ 182010p -0.3
+ 184000p -0.3
+ 184010p 0.9
+ 186000p 0.9
+ 186010p -0.3
+ 188000p -0.3
+ 188010p 0.9
+ 190000p 0.9
+ 190010p -0.3
+ 192000p -0.3
+ 192010p 0.9
+ 194000p 0.9
+ 194010p -0.3
+ 196000p -0.3
+ 196010p 0.9
+ 198000p 0.9
+ 198010p -0.3
+ 200000p -0.3
+ 200010p 0.9
+ 202000p 0.9
+ 202010p -0.3
+ 204000p -0.3
+ 204010p 0.9
+ 206000p 0.9
+ 206010p -0.3
+ 208000p -0.3
+ 208010p 0.9
+ 210000p 0.9
+ 210010p -0.3
+ 212000p -0.3
+ 212010p 0.9
+ 214000p 0.9
+ 214010p -0.3
+ 216000p -0.3
+ 216010p 0.9
+ 218000p 0.9
+ 218010p -0.3
+ 220000p -0.3
+ 220010p 0.9
+ 222000p 0.9
+ 222010p -0.3
+ 224000p -0.3
+ 224010p 0.9
+ 226000p 0.9
+ 226010p -0.3
+ 228000p -0.3
+ 228010p 0.9
+ 230000p 0.9
+ 230010p -0.3
+ 232000p -0.3
+ 232010p 0.9
+ 234000p 0.9
+ 234010p -0.3
+ 236000p -0.3
+ 236010p 0.9
+ 238000p 0.9
+ 238010p -0.3
+ 240000p -0.3
+ 240010p 0.9
+ 242000p 0.9
+ 242010p -0.3
+ 244000p -0.3
+ 244010p 0.9
+ 246000p 0.9
+ 246010p -0.3
+ 248000p -0.3
+ 248010p 0.9
+ 250000p 0.9
+ 250010p -0.3
+ 252000p -0.3
+ 252010p 0.9
+ 254000p 0.9
+ 254010p -0.3
+ 256000p -0.3
+ 256010p 0.9
+ 258000p 0.9
+ 258010p -0.3
+ 260000p -0.3
+ 260010p 0.9
+ 262000p 0.9
+ 262010p -0.3
+ 264000p -0.3
+ 264010p 0.9
+ 266000p 0.9
+ 266010p -0.3
+ 268000p -0.3
+ 268010p 0.9
+ 270000p 0.9
+ 270010p -0.3
+ 272000p -0.3
+ 272010p 0.9
+ 274000p 0.9
+ 274010p -0.3
+ 276000p -0.3
+ 276010p 0.9
+ 278000p 0.9
+ 278010p -0.3
+ 280000p -0.3
+ 280010p 0.9
+ 282000p 0.9
+ 282010p -0.3
+ 284000p -0.3
+ 284010p 0.9
+ 286000p 0.9
+ 286010p -0.3
+ 288000p -0.3
+ 288010p 0.9
+ 290000p 0.9
+ 290010p -0.3
+ 292000p -0.3
+ 292010p 0.9
+ 294000p 0.9
+ 294010p -0.3
+ 296000p -0.3
+ 296010p 0.9
+ 298000p 0.9
+ 298010p -0.3
+ 300000p -0.3
+ 300010p 0.9
+ 302000p 0.9
+ 302010p -0.3
+ 304000p -0.3
+ 304010p 0.9
+ 306000p 0.9
+ 306010p -0.3
+ 308000p -0.3
+ 308010p 0.9
+ 310000p 0.9
+ 310010p -0.3
+ 312000p -0.3
+ 312010p 0.9
+ 314000p 0.9
+ 314010p -0.3
+ 316000p -0.3
+ 316010p 0.9
+ 318000p 0.9
+ 318010p -0.3
+ 320000p -0.3
+ 320010p 0.9
+ 322000p 0.9
+ 322010p -0.3
+ 324000p -0.3
+ 324010p 0.9
+ 326000p 0.9
+ 326010p -0.3
+ 328000p -0.3
+ 328010p 0.9
+ 330000p 0.9
+ 330010p -0.3
+ 332000p -0.3
+ 332010p 0.9
+ 334000p 0.9
+ 334010p -0.3
+ 336000p -0.3
+ 336010p 0.9
+ 338000p 0.9
+ 338010p -0.3
+ 340000p -0.3
+ 340010p 0.9
+ 342000p 0.9
+ 342010p -0.3
+ 344000p -0.3
+ 344010p 0.9
+ 346000p 0.9
+ 346010p -0.3
+ 348000p -0.3
+ 348010p 0.9
+ 350000p 0.9
+ 350010p -0.3
+ 352000p -0.3
+ 352010p 0.9
+ 354000p 0.9
+ 354010p -0.3
+ 356000p -0.3
+ 356010p 0.9
+ 358000p 0.9
+ 358010p -0.3
+ 360000p -0.3
+ 360010p 0.9
+ 362000p 0.9
+ 362010p -0.3
+ 364000p -0.3
+ 364010p 0.9
+ 366000p 0.9
+ 366010p -0.3
+ 368000p -0.3
+ 368010p 0.9
+ 370000p 0.9
+ 370010p -0.3
+ 372000p -0.3
+ 372010p 0.9
+ 374000p 0.9
+ 374010p -0.3
+ 376000p -0.3
+ 376010p 0.9
+ 378000p 0.9
+ 378010p -0.3
+ 380000p -0.3
+ 380010p 0.9
+ 382000p 0.9
+ 382010p -0.3
+ 384000p -0.3
+ 384010p 0.9
+ 386000p 0.9
+ 386010p -0.3
+ 388000p -0.3
+ 388010p 0.9
+ 390000p 0.9
+ 390010p -0.3
+ 392000p -0.3
+ 392010p 0.9
+ 394000p 0.9
+ 394010p -0.3
+ 396000p -0.3
+ 396010p 0.9
+ 398000p 0.9
+ 398010p -0.3
+ 400000p -0.3
+ 400010p 0.9
+ 402000p 0.9
+ 402010p -0.3
+ 404000p -0.3
+ 404010p 0.9
+ 406000p 0.9
+ 406010p -0.3
+ 408000p -0.3
+ 408010p 0.9
+ 410000p 0.9
+ 410010p -0.3
+ 412000p -0.3
+ 412010p 0.9
+ 414000p 0.9
+ 414010p -0.3
+ 416000p -0.3
+ 416010p 0.9
+ 418000p 0.9
+ 418010p -0.3
+ 420000p -0.3
+ 420010p 0.9
+ 422000p 0.9
+ 422010p -0.3
+ 424000p -0.3
+ 424010p 0.9
+ 426000p 0.9
+ 426010p -0.3
+ 428000p -0.3
+ 428010p 0.9
+ 430000p 0.9
+ 430010p -0.3
+ 432000p -0.3
+ 432010p 0.9
+ 434000p 0.9
+ 434010p -0.3
+ 436000p -0.3
+ 436010p 0.9
+ 438000p 0.9
+ 438010p -0.3
+ 440000p -0.3
+ 440010p 0.9
+ 442000p 0.9
+ 442010p -0.3
+ 444000p -0.3
+ 444010p 0.9
+ 446000p 0.9
+ 446010p -0.3
+ 448000p -0.3
+ 448010p 0.9
+ 450000p 0.9
+ 450010p -0.3
+ 452000p -0.3
+ 452010p 0.9
+ 454000p 0.9
+ 454010p -0.3
+ 456000p -0.3
+ 456010p 0.9
+ 458000p 0.9
+ 458010p -0.3
+ 460000p -0.3
+ 460010p 0.9
+ 462000p 0.9
+ 462010p -0.3
+ 464000p -0.3
+ 464010p 0.9
+ 466000p 0.9
+ 466010p -0.3
+ 468000p -0.3
+ 468010p 0.9
+ 470000p 0.9
+ 470010p -0.3
+ 472000p -0.3
+ 472010p 0.9
+ 474000p 0.9
+ 474010p -0.3
+ 476000p -0.3
+ 476010p 0.9
+ 478000p 0.9
+ 478010p -0.3
+ 480000p -0.3
+ 480010p 0.9
+ 482000p 0.9
+ 482010p -0.3
+ 484000p -0.3
+ 484010p 0.9
+ 486000p 0.9
+ 486010p -0.3
+ 488000p -0.3
+ 488010p 0.9
+ 490000p 0.9
+ 490010p -0.3
+ 492000p -0.3
+ 492010p 0.9
+ 494000p 0.9
+ 494010p -0.3
+ 496000p -0.3
+ 496010p 0.9
+ 498000p 0.9
+ 498010p -0.3
+ 500000p -0.3
+ 500010p 0.9
+ 502000p 0.9
+ 502010p -0.3
+ 504000p -0.3
+ 504010p 0.9
+ 506000p 0.9
+ 506010p -0.3
+ 508000p -0.3
+ 508010p 0.9
+ 510000p 0.9
+ 510010p -0.3
+ 512000p -0.3
+ 512010p 0.9
+ 514000p 0.9
+ 514010p -0.3
+ 516000p -0.3
+ 516010p 0.9
+ 518000p 0.9
+ 518010p -0.3
+ 520000p -0.3
+ 520010p 0.9
+ 522000p 0.9
+ 522010p -0.3
+ 524000p -0.3
+ 524010p 0.9
+ 526000p 0.9
+ 526010p -0.3
+ 528000p -0.3
+ 528010p 0.9
+ 530000p 0.9
+ 530010p -0.3
+ 532000p -0.3
+ 532010p 0.9
+ 534000p 0.9
+ 534010p -0.3
+ 536000p -0.3
+ 536010p 0.9
+ 538000p 0.9
+ 538010p -0.3
+ 540000p -0.3
+ 540010p 0.9
+ 542000p 0.9
+ 542010p -0.3
+ 544000p -0.3
+ 544010p 0.9
+ 546000p 0.9
+ 546010p -0.3
+ 548000p -0.3
+ 548010p 0.9
+ 550000p 0.9
+ 550010p -0.3
+ 552000p -0.3
+ 552010p 0.9
+ 554000p 0.9
+ 554010p -0.3
+ 556000p -0.3
+ 556010p 0.9
+ 558000p 0.9
+ 558010p -0.3
+ 560000p -0.3
+ 560010p 0.9
+ 562000p 0.9
+ 562010p -0.3
+ 564000p -0.3
+ 564010p 0.9
+ 566000p 0.9
+ 566010p -0.3
+ 568000p -0.3
+ 568010p 0.9
+ 570000p 0.9
+ 570010p -0.3
+ 572000p -0.3
+ 572010p 0.9
+ 574000p 0.9
+ 574010p -0.3
+ 576000p -0.3
+ 576010p 0.9
+ 578000p 0.9
+ 578010p -0.3
+ 580000p -0.3
+ 580010p 0.9
+ 582000p 0.9
+ 582010p -0.3
+ 584000p -0.3
+ 584010p 0.9
+ 586000p 0.9
+ 586010p -0.3
+ 588000p -0.3
+ 588010p 0.9
+ 590000p 0.9
+ 590010p -0.3
+ 592000p -0.3
+ 592010p 0.9
+ 594000p 0.9
+ 594010p -0.3
+ 596000p -0.3
+ 596010p 0.9
+ 598000p 0.9
+ 598010p -0.3
+ 600000p -0.3
+ 600010p 0.9
+ 602000p 0.9
+ 602010p -0.3
+ 604000p -0.3
+ 604010p 0.9
+ 606000p 0.9
+ 606010p -0.3
+ 608000p -0.3
+ 608010p 0.9
+ 610000p 0.9
+ 610010p -0.3
+ 612000p -0.3
+ 612010p 0.9
+ 614000p 0.9
+ 614010p -0.3
+ 616000p -0.3
+ 616010p 0.9
+ 618000p 0.9
+ 618010p -0.3
+ 620000p -0.3
+ 620010p 0.9
+ 622000p 0.9
+ 622010p -0.3
+ 624000p -0.3
+ 624010p 0.9
+ 626000p 0.9
+ 626010p -0.3
+ 628000p -0.3
+ 628010p 0.9
+ 630000p 0.9
+ 630010p -0.3
+ 632000p -0.3
+ 632010p 0.9
+ 634000p 0.9
+ 634010p -0.3
+ 636000p -0.3
+ 636010p 0.9
+ 638000p 0.9
+ 638010p -0.3
+ 640000p -0.3
+ 640010p 0.9
+ 642000p 0.9
+ 642010p -0.3
+ 644000p -0.3
+ 644010p 0.9
+ 646000p 0.9
+ 646010p -0.3
+ 648000p -0.3
+ 648010p 0.9
+ 650000p 0.9
+ 650010p -0.3
+ 652000p -0.3
+ 652010p 0.9
+ 654000p 0.9
+ 654010p -0.3
+ 656000p -0.3
+ 656010p 0.9
+ 658000p 0.9
+ 658010p -0.3
+ 660000p -0.3
+ 660010p 0.9
+ 662000p 0.9
+ 662010p -0.3
+ 664000p -0.3
+ 664010p 0.9
+ 666000p 0.9
+ 666010p -0.3
+ 668000p -0.3
+ 668010p 0.9
+ 670000p 0.9
+ 670010p -0.3
+ 672000p -0.3
+ 672010p 0.9
+ 674000p 0.9
+ 674010p -0.3
+ 676000p -0.3
+ 676010p 0.9
+ 678000p 0.9
+ 678010p -0.3
+ 680000p -0.3
+ 680010p 0.9
+ 682000p 0.9
+ 682010p -0.3
+ 684000p -0.3
+ 684010p 0.9
+ 686000p 0.9
+ 686010p -0.3
+ 688000p -0.3
+ 688010p 0.9
+ 690000p 0.9
+ 690010p -0.3
+ 692000p -0.3
+ 692010p 0.9
+ 694000p 0.9
+ 694010p -0.3
+ 696000p -0.3
+ 696010p 0.9
+ 698000p 0.9
+ 698010p -0.3
+ 700000p -0.3
+ 700010p 0.9
+ 702000p 0.9
+ 702010p -0.3
+ 704000p -0.3
+ 704010p 0.9
+ 706000p 0.9
+ 706010p -0.3
+ 708000p -0.3
+ 708010p 0.9
+ 710000p 0.9
+ 710010p -0.3
+ 712000p -0.3
+ 712010p 0.9
+ 714000p 0.9
+ 714010p -0.3
+ 716000p -0.3
+ 716010p 0.9
+ 718000p 0.9
+ 718010p -0.3
+ 720000p -0.3
+ 720010p 0.9
+ 722000p 0.9
+ 722010p -0.3
+ 724000p -0.3
+ 724010p 0.9
+ 726000p 0.9
+ 726010p -0.3
+ 728000p -0.3
+ 728010p 0.9
+ 730000p 0.9
+ 730010p -0.3
+ 732000p -0.3
+ 732010p 0.9
+ 734000p 0.9
+ 734010p -0.3
+ 736000p -0.3
+ 736010p 0.9
+ 738000p 0.9
+ 738010p -0.3
+ 740000p -0.3
+ 740010p 0.9
+ 742000p 0.9
+ 742010p -0.3
+ 744000p -0.3
+ 744010p 0.9
+ 746000p 0.9
+ 746010p -0.3
+ 748000p -0.3
+ 748010p 0.9
+ 750000p 0.9
+ 750010p -0.3
+ 752000p -0.3
+ 752010p 0.9
+ 754000p 0.9
+ 754010p -0.3
+ 756000p -0.3
+ 756010p 0.9
+ 758000p 0.9
+ 758010p -0.3
+ 760000p -0.3
+ 760010p 0.9
+ 762000p 0.9
+ 762010p -0.3
+ 764000p -0.3
+ 764010p 0.9
+ 766000p 0.9
+ 766010p -0.3
+ 768000p -0.3
+ 768010p 0.9
+ 770000p 0.9
+ 770010p -0.3
+ 772000p -0.3
+ 772010p 0.9
+ 774000p 0.9
+ 774010p -0.3
+ 776000p -0.3
+ 776010p 0.9
+ 778000p 0.9
+ 778010p -0.3
+ 780000p -0.3
+ 780010p 0.9
+ 782000p 0.9
+ 782010p -0.3
+ 784000p -0.3
+ 784010p 0.9
+ 786000p 0.9
+ 786010p -0.3
+ 788000p -0.3
+ 788010p 0.9
+ 790000p 0.9
+ 790010p -0.3
+ 792000p -0.3
+ 792010p 0.9
+ 794000p 0.9
+ 794010p -0.3
+ 796000p -0.3
+ 796010p 0.9
+ 798000p 0.9
+ 798010p -0.3
+ 800000p -0.3
+ 800010p 0.9
+ 802000p 0.9
+ 802010p -0.3
+ 804000p -0.3
+ 804010p 0.9
+ 806000p 0.9
+ 806010p -0.3
+ 808000p -0.3
+ 808010p 0.9
+ 810000p 0.9
+ 810010p -0.3
+ 812000p -0.3
+ 812010p 0.9
+ 814000p 0.9
+ 814010p -0.3
+ 816000p -0.3
+ 816010p 0.9
+ 818000p 0.9
+ 818010p -0.3
+ 820000p -0.3
+ 820010p 0.9
+ 822000p 0.9
+ 822010p -0.3
+ 824000p -0.3
+ 824010p 0.9
+ 826000p 0.9
+ 826010p -0.3
+ 828000p -0.3
+ 828010p 0.9
+ 830000p 0.9
+ 830010p -0.3
+ 832000p -0.3
+ 832010p 0.9
+ 834000p 0.9
+ 834010p -0.3
+ 836000p -0.3
+ 836010p 0.9
+ 838000p 0.9
+ 838010p -0.3
+ 840000p -0.3
+ 840010p 0.9
+ 842000p 0.9
+ 842010p -0.3
+ 844000p -0.3
+ 844010p 0.9
+ 846000p 0.9
+ 846010p -0.3
+ 848000p -0.3
+ 848010p 0.9
+ 850000p 0.9
+ 850010p -0.3
+ 852000p -0.3
+ 852010p 0.9
+ 854000p 0.9
+ 854010p -0.3
+ 856000p -0.3
+ 856010p 0.9
+ 858000p 0.9
+ 858010p -0.3
+ 860000p -0.3
+ 860010p 0.9
+ 862000p 0.9
+ 862010p -0.3
+ 864000p -0.3
+ 864010p 0.9
+ 866000p 0.9
+ 866010p -0.3
+ 868000p -0.3
+ 868010p 0.9
+ 870000p 0.9
+ 870010p -0.3
+ 872000p -0.3
+ 872010p 0.9
+ 874000p 0.9
+ 874010p -0.3
+ 876000p -0.3
+ 876010p 0.9
+ 878000p 0.9
+ 878010p -0.3
+ 880000p -0.3
+ 880010p 0.9
+ 882000p 0.9
+ 882010p -0.3
+ 884000p -0.3
+ 884010p 0.9
+ 886000p 0.9
+ 886010p -0.3
+ 888000p -0.3
+ 888010p 0.9
+ 890000p 0.9
+ 890010p -0.3
+ 892000p -0.3
+ 892010p 0.9
+ 894000p 0.9
+ 894010p -0.3
+ 896000p -0.3
+ 896010p 0.9
+ 898000p 0.9
+ 898010p -0.3
+ 900000p -0.3
+ 900010p 0.9
+ 902000p 0.9
+ 902010p -0.3
+ 904000p -0.3
+ 904010p 0.9
+ 906000p 0.9
+ 906010p -0.3
+ 908000p -0.3
+ 908010p 0.9
+ 910000p 0.9
+ 910010p -0.3
+ 912000p -0.3
+ 912010p 0.9
+ 914000p 0.9
+ 914010p -0.3
+ 916000p -0.3
+ 916010p 0.9
+ 918000p 0.9
+ 918010p -0.3
+ 920000p -0.3
+ 920010p 0.9
+ 922000p 0.9
+ 922010p -0.3
+ 924000p -0.3
+ 924010p 0.9
+ 926000p 0.9
+ 926010p -0.3
+ 928000p -0.3
+ 928010p 0.9
+ 930000p 0.9
+ 930010p -0.3
+ 932000p -0.3
+ 932010p 0.9
+ 934000p 0.9
+ 934010p -0.3
+ 936000p -0.3
+ 936010p 0.9
+ 938000p 0.9
+ 938010p -0.3
+ 940000p -0.3
+ 940010p 0.9
+ 942000p 0.9
+ 942010p -0.3
+ 944000p -0.3
+ 944010p 0.9
+ 946000p 0.9
+ 946010p -0.3
+ 948000p -0.3
+ 948010p 0.9
+ 950000p 0.9
+ 950010p -0.3
+ 952000p -0.3
+ 952010p 0.9
+ 954000p 0.9
+ 954010p -0.3
+ 956000p -0.3
+ 956010p 0.9
+ 958000p 0.9
+ 958010p -0.3
+ 960000p -0.3
+ 960010p 0.9
+ 962000p 0.9
+ 962010p -0.3
+ 964000p -0.3
+ 964010p 0.9
+ 966000p 0.9
+ 966010p -0.3
+ 968000p -0.3
+ 968010p 0.9
+ 970000p 0.9
+ 970010p -0.3
+ 972000p -0.3
+ 972010p 0.9
+ 974000p 0.9
+ 974010p -0.3
+ 976000p -0.3
+ 976010p 0.9
+ 978000p 0.9
+ 978010p -0.3
+ 980000p -0.3
+ 980010p 0.9
+ 982000p 0.9
+ 982010p -0.3
+ 984000p -0.3
+ 984010p 0.9
+ 986000p 0.9
+ 986010p -0.3
+ 988000p -0.3
+ 988010p 0.9
+ 990000p 0.9
+ 990010p -0.3
+ 992000p -0.3
+ 992010p 0.9
+ 994000p 0.9
+ 994010p -0.3
+ 996000p -0.3
+ 996010p 0.9
+ 998000p 0.9
+ 998010p -0.3
+ 1000000p -0.3
+ 1000010p 0.9
+ 1002000p 0.9
+ 1002010p -0.3
+ 1004000p -0.3
+ 1004010p 0.9
+ 1006000p 0.9
+ 1006010p -0.3
+ 1008000p -0.3
+ 1008010p 0.9
+ 1010000p 0.9
+ 1010010p -0.3
+ 1012000p -0.3
+ 1012010p 0.9
+ 1014000p 0.9
+ 1014010p -0.3
+ 1016000p -0.3
+ 1016010p 0.9
+ 1018000p 0.9
+ 1018010p -0.3
+ 1020000p -0.3
+ 1020010p 0.9
+ 1022000p 0.9
+ 1022010p -0.3
+ 1024000p -0.3
+ 1024010p 0.9
+ 1026000p 0.9
+ 1026010p -0.3
+ 1028000p -0.3
+ 1028010p 0.9
+ 1030000p 0.9
+ 1030010p -0.3
+ 1032000p -0.3
+ 1032010p 0.9
+ 1034000p 0.9
+ 1034010p -0.3
+ 1036000p -0.3
+ 1036010p 0.9
+ 1038000p 0.9
+ 1038010p -0.3
+ 1040000p -0.3
+ 1040010p 0.9
+ 1042000p 0.9
+ 1042010p -0.3
+ 1044000p -0.3
+ 1044010p 0.9
+ 1046000p 0.9
+ 1046010p -0.3
+ 1048000p -0.3
+ 1048010p 0.9
+ 1050000p 0.9
+ 1050010p -0.3
+ 1052000p -0.3
+ 1052010p 0.9
+ 1054000p 0.9
+ 1054010p -0.3
+ 1056000p -0.3
+ 1056010p 0.9
+ 1058000p 0.9
+ 1058010p -0.3
+ 1060000p -0.3
+ 1060010p 0.9
+ 1062000p 0.9
+ 1062010p -0.3
+ 1064000p -0.3
+ 1064010p 0.9
+ 1066000p 0.9
+ 1066010p -0.3
+ 1068000p -0.3
+ 1068010p 0.9
+ 1070000p 0.9
+ 1070010p -0.3
+ 1072000p -0.3
+ 1072010p 0.9
+ 1074000p 0.9
+ 1074010p -0.3
+ 1076000p -0.3
+ 1076010p 0.9
+ 1078000p 0.9
+ 1078010p -0.3
+ 1080000p -0.3
+ 1080010p 0.9
+ 1082000p 0.9
+ 1082010p -0.3
+ 1084000p -0.3
+ 1084010p 0.9
+ 1086000p 0.9
+ 1086010p -0.3
+ 1088000p -0.3
+ 1088010p 0.9
+ 1090000p 0.9
+ 1090010p -0.3
+ 1092000p -0.3
+ 1092010p 0.9
+ 1094000p 0.9
+ 1094010p -0.3
+ 1096000p -0.3
+ 1096010p 0.9
+ 1098000p 0.9
+ 1098010p -0.3
+ 1100000p -0.3
+ 1100010p 0.9
+ 1102000p 0.9
+ 1102010p -0.3
+ 1104000p -0.3
+ 1104010p 0.9
+ 1106000p 0.9
+ 1106010p -0.3
+ 1108000p -0.3
+ 1108010p 0.9
+ 1110000p 0.9
+ 1110010p -0.3
+ 1112000p -0.3
+ 1112010p 0.9
+ 1114000p 0.9
+ 1114010p -0.3
+ 1116000p -0.3
+ 1116010p 0.9
+ 1118000p 0.9
+ 1118010p -0.3
+ 1120000p -0.3
+ 1120010p 0.9
+ 1122000p 0.9
+ 1122010p -0.3
+ 1124000p -0.3
+ 1124010p 0.9
+ 1126000p 0.9
+ 1126010p -0.3
+ 1128000p -0.3
+ 1128010p 0.9
+ 1130000p 0.9
+ 1130010p -0.3
+ 1132000p -0.3
+ 1132010p 0.9
+ 1134000p 0.9
+ 1134010p -0.3
+ 1136000p -0.3
+ 1136010p 0.9
+ 1138000p 0.9
+ 1138010p -0.3
+ 1140000p -0.3
+ 1140010p 0.9
+ 1142000p 0.9
+ 1142010p -0.3
+ 1144000p -0.3
+ 1144010p 0.9
+ 1146000p 0.9
+ 1146010p -0.3
+ 1148000p -0.3
+ 1148010p 0.9
+ 1150000p 0.9
+ 1150010p -0.3
+ 1152000p -0.3
+ 1152010p 0.9
+ 1154000p 0.9
+ 1154010p -0.3
+ 1156000p -0.3
+ 1156010p 0.9
+ 1158000p 0.9
+ 1158010p -0.3
+ 1160000p -0.3
+ 1160010p 0.9
+ 1162000p 0.9
+ 1162010p -0.3
+ 1164000p -0.3
+ 1164010p 0.9
+ 1166000p 0.9
+ 1166010p -0.3
+ 1168000p -0.3
+ 1168010p 0.9
+ 1170000p 0.9
+ 1170010p -0.3
+ 1172000p -0.3
+ 1172010p 0.9
+ 1174000p 0.9
+ 1174010p -0.3
+ 1176000p -0.3
+ 1176010p 0.9
+ 1178000p 0.9
+ 1178010p -0.3
+ 1180000p -0.3
+ 1180010p 0.9
+ 1182000p 0.9
+ 1182010p -0.3
+ 1184000p -0.3
+ 1184010p 0.9
+ 1186000p 0.9
+ 1186010p -0.3
+ 1188000p -0.3
+ 1188010p 0.9
+ 1190000p 0.9
+ 1190010p -0.3
+ 1192000p -0.3
+ 1192010p 0.9
+ 1194000p 0.9
+ 1194010p -0.3
+ 1196000p -0.3
+ 1196010p 0.9
+ 1198000p 0.9
+ 1198010p -0.3
+ 1200000p -0.3
+ 1200010p 0.9
+ 1202000p 0.9
+ 1202010p -0.3
+ 1204000p -0.3
+ 1204010p 0.9
+ 1206000p 0.9
+ 1206010p -0.3
+ 1208000p -0.3
+ 1208010p 0.9
+ 1210000p 0.9
+ 1210010p -0.3
+ 1212000p -0.3
+ 1212010p 0.9
+ 1214000p 0.9
+ 1214010p -0.3
+ 1216000p -0.3
+ 1216010p 0.9
+ 1218000p 0.9
+ 1218010p -0.3
+ 1220000p -0.3
+ 1220010p 0.9
+ 1222000p 0.9
+ 1222010p -0.3
+ 1224000p -0.3
+ 1224010p 0.9
+ 1226000p 0.9
+ 1226010p -0.3
+ 1228000p -0.3
+ 1228010p 0.9
+ 1230000p 0.9
+ 1230010p -0.3
+ 1232000p -0.3
+ 1232010p 0.9
+ 1234000p 0.9
+ 1234010p -0.3
+ 1236000p -0.3
+ 1236010p 0.9
+ 1238000p 0.9
+ 1238010p -0.3
+ 1240000p -0.3
+ 1240010p 0.9
+ 1242000p 0.9
+ 1242010p -0.3
+ 1244000p -0.3
+ 1244010p 0.9
+ 1246000p 0.9
+ 1246010p -0.3
+ 1248000p -0.3
+ 1248010p 0.9
+ 1250000p 0.9
+ 1250010p -0.3
+ 1252000p -0.3
+ 1252010p 0.9
+ 1254000p 0.9
+ 1254010p -0.3
+ 1256000p -0.3
+ 1256010p 0.9
+ 1258000p 0.9
+ 1258010p -0.3
+ 1260000p -0.3
+ 1260010p 0.9
+ 1262000p 0.9
+ 1262010p -0.3
+ 1264000p -0.3
+ 1264010p 0.9
+ 1266000p 0.9
+ 1266010p -0.3
+ 1268000p -0.3
+ 1268010p 0.9
+ 1270000p 0.9
+ 1270010p -0.3
+ 1272000p -0.3
+ 1272010p 0.9
+ 1274000p 0.9
+ 1274010p -0.3
+ 1276000p -0.3
+ 1276010p 0.9
+ 1278000p 0.9
+ 1278010p -0.3
+ 1280000p -0.3
+ 1280010p 0.9
+ 1282000p 0.9
+ 1282010p -0.3
+ 1284000p -0.3
+ 1284010p 0.9
+ 1286000p 0.9
+ 1286010p -0.3
+ 1288000p -0.3
+ 1288010p 0.9
+ 1290000p 0.9
+ 1290010p -0.3
+ 1292000p -0.3
+ 1292010p 0.9
+ 1294000p 0.9
+ 1294010p -0.3
+ 1296000p -0.3
+ 1296010p 0.9
+ 1298000p 0.9
+ 1298010p -0.3
+ 1300000p -0.3
+ 1300010p 0.9
+ 1302000p 0.9
+ 1302010p -0.3
+ 1304000p -0.3
+ 1304010p 0.9
+ 1306000p 0.9
+ 1306010p -0.3
+ 1308000p -0.3
+ 1308010p 0.9
+ 1310000p 0.9
+ 1310010p -0.3
+ 1312000p -0.3
+ 1312010p 0.9
+ 1314000p 0.9
+ 1314010p -0.3
+ 1316000p -0.3
+ 1316010p 0.9
+ 1318000p 0.9
+ 1318010p -0.3
+ 1320000p -0.3
+ 1320010p 0.9
+ 1322000p 0.9
+ 1322010p -0.3
+ 1324000p -0.3
+ 1324010p 0.9
+ 1326000p 0.9
+ 1326010p -0.3
+ 1328000p -0.3
+ 1328010p 0.9
+ 1330000p 0.9
+ 1330010p -0.3
+ 1332000p -0.3
+ 1332010p 0.9
+ 1334000p 0.9
+ 1334010p -0.3
+ 1336000p -0.3
+ 1336010p 0.9
+ 1338000p 0.9
+ 1338010p -0.3
+ 1340000p -0.3
+ 1340010p 0.9
+ 1342000p 0.9
+ 1342010p -0.3
+ 1344000p -0.3
+ 1344010p 0.9
+ 1346000p 0.9
+ 1346010p -0.3
+ 1348000p -0.3
+ 1348010p 0.9
+ 1350000p 0.9
+ 1350010p -0.3
+ 1352000p -0.3
+ 1352010p 0.9
+ 1354000p 0.9
+ 1354010p -0.3
+ 1356000p -0.3
+ 1356010p 0.9
+ 1358000p 0.9
+ 1358010p -0.3
+ 1360000p -0.3
+ 1360010p 0.9
+ 1362000p 0.9
+ 1362010p -0.3
+ 1364000p -0.3
+ 1364010p 0.9
+ 1366000p 0.9
+ 1366010p -0.3
+ 1368000p -0.3
+ 1368010p 0.9
+ 1370000p 0.9
+ 1370010p -0.3
+ 1372000p -0.3
+ 1372010p 0.9
+ 1374000p 0.9
+ 1374010p -0.3
+ 1376000p -0.3
+ 1376010p 0.9
+ 1378000p 0.9
+ 1378010p -0.3
+ 1380000p -0.3
+ 1380010p 0.9
+ 1382000p 0.9
+ 1382010p -0.3
+ 1384000p -0.3
+ 1384010p 0.9
+ 1386000p 0.9
+ 1386010p -0.3
+ 1388000p -0.3
+ 1388010p 0.9
+ 1390000p 0.9
+ 1390010p -0.3
+ 1392000p -0.3
+ 1392010p 0.9
+ 1394000p 0.9
+ 1394010p -0.3
+ 1396000p -0.3
+ 1396010p 0.9
+ 1398000p 0.9
+ 1398010p -0.3
+ 1400000p -0.3
+ 1400010p 0.9
+ 1402000p 0.9
+ 1402010p -0.3
+ 1404000p -0.3
+ 1404010p 0.9
+ 1406000p 0.9
+ 1406010p -0.3
+ 1408000p -0.3
+ 1408010p 0.9
+ 1410000p 0.9
+ 1410010p -0.3
+ 1412000p -0.3
+ 1412010p 0.9
+ 1414000p 0.9
+ 1414010p -0.3
+ 1416000p -0.3
+ 1416010p 0.9
+ 1418000p 0.9
+ 1418010p -0.3
+ 1420000p -0.3
+ 1420010p 0.9
+ 1422000p 0.9
+ 1422010p -0.3
+ 1424000p -0.3
+ 1424010p 0.9
+ 1426000p 0.9
+ 1426010p -0.3
+ 1428000p -0.3
+ 1428010p 0.9
+ 1430000p 0.9
+ 1430010p -0.3
+ 1432000p -0.3
+ 1432010p 0.9
+ 1434000p 0.9
+ 1434010p -0.3
+ 1436000p -0.3
+ 1436010p 0.9
+ 1438000p 0.9
+ 1438010p -0.3
+ 1440000p -0.3
+ 1440010p 0.9
+ 1442000p 0.9
+ 1442010p -0.3
+ 1444000p -0.3
+ 1444010p 0.9
+ 1446000p 0.9
+ 1446010p -0.3
+ 1448000p -0.3
+ 1448010p 0.9
+ 1450000p 0.9
+ 1450010p -0.3
+ 1452000p -0.3
+ 1452010p 0.9
+ 1454000p 0.9
+ 1454010p -0.3
+ 1456000p -0.3
+ 1456010p 0.9
+ 1458000p 0.9
+ 1458010p -0.3
+ 1460000p -0.3
+ 1460010p 0.9
+ 1462000p 0.9
+ 1462010p -0.3
+ 1464000p -0.3
+ 1464010p 0.9
+ 1466000p 0.9
+ 1466010p -0.3
+ 1468000p -0.3
+ 1468010p 0.9
+ 1470000p 0.9
+ 1470010p -0.3
+ 1472000p -0.3
+ 1472010p 0.9
+ 1474000p 0.9
+ 1474010p -0.3
+ 1476000p -0.3
+ 1476010p 0.9
+ 1478000p 0.9
+ 1478010p -0.3
+ 1480000p -0.3
+ 1480010p 0.9
+ 1482000p 0.9
+ 1482010p -0.3
+ 1484000p -0.3
+ 1484010p 0.9
+ 1486000p 0.9
+ 1486010p -0.3
+ 1488000p -0.3
+ 1488010p 0.9
+ 1490000p 0.9
+ 1490010p -0.3
+ 1492000p -0.3
+ 1492010p 0.9
+ 1494000p 0.9
+ 1494010p -0.3
+ 1496000p -0.3
+ 1496010p 0.9
+ 1498000p 0.9
+ 1498010p -0.3
+ 1500000p -0.3
+ 1500010p 0.9
+ 1502000p 0.9
+ 1502010p -0.3
+ 1504000p -0.3
+ 1504010p 0.9
+ 1506000p 0.9
+ 1506010p -0.3
+ 1508000p -0.3
+ 1508010p 0.9
+ 1510000p 0.9
+ 1510010p -0.3
+ 1512000p -0.3
+ 1512010p 0.9
+ 1514000p 0.9
+ 1514010p -0.3
+ 1516000p -0.3
+ 1516010p 0.9
+ 1518000p 0.9
+ 1518010p -0.3
+ 1520000p -0.3
+ 1520010p 0.9
+ 1522000p 0.9
+ 1522010p -0.3
+ 1524000p -0.3
+ 1524010p 0.9
+ 1526000p 0.9
+ 1526010p -0.3
+ 1528000p -0.3
+ 1528010p 0.9
+ 1530000p 0.9
+ 1530010p -0.3
+ 1532000p -0.3
+ 1532010p 0.9
+ 1534000p 0.9
+ 1534010p -0.3
+ 1536000p -0.3
+ 1536010p 0.9
+ 1538000p 0.9
+ 1538010p -0.3
+ 1540000p -0.3
+ 1540010p 0.9
+ 1542000p 0.9
+ 1542010p -0.3
+ 1544000p -0.3
+ 1544010p 0.9
+ 1546000p 0.9
+ 1546010p -0.3
+ 1548000p -0.3
+ 1548010p 0.9
+ 1550000p 0.9
+ 1550010p -0.3
+ 1552000p -0.3
+ 1552010p 0.9
+ 1554000p 0.9
+ 1554010p -0.3
+ 1556000p -0.3
+ 1556010p 0.9
+ 1558000p 0.9
+ 1558010p -0.3
+ 1560000p -0.3
+ 1560010p 0.9
+ 1562000p 0.9
+ 1562010p -0.3
+ 1564000p -0.3
+ 1564010p 0.9
+ 1566000p 0.9
+ 1566010p -0.3
+ 1568000p -0.3
+ 1568010p 0.9
+ 1570000p 0.9
+ 1570010p -0.3
+ 1572000p -0.3
+ 1572010p 0.9
+ 1574000p 0.9
+ 1574010p -0.3
+ 1576000p -0.3
+ 1576010p 0.9
+ 1578000p 0.9
+ 1578010p -0.3
+ 1580000p -0.3
+ 1580010p 0.9
+ 1582000p 0.9
+ 1582010p -0.3
+ 1584000p -0.3
+ 1584010p 0.9
+ 1586000p 0.9
+ 1586010p -0.3
+ 1588000p -0.3
+ 1588010p 0.9
+ 1590000p 0.9
+ 1590010p -0.3
+ 1592000p -0.3
+ 1592010p 0.9
+ 1594000p 0.9
+ 1594010p -0.3
+ 1596000p -0.3
+ 1596010p 0.9
+ 1598000p 0.9
+ 1598010p -0.3
+ 1600000p -0.3
+ 1600010p 0.9
+ 1602000p 0.9
+ 1602010p -0.3
+ 1604000p -0.3
+ 1604010p 0.9
+ 1606000p 0.9
+ 1606010p -0.3
+ 1608000p -0.3
+ 1608010p 0.9
+ 1610000p 0.9
+ 1610010p -0.3
+ 1612000p -0.3
+ 1612010p 0.9
+ 1614000p 0.9
+ 1614010p -0.3
+ 1616000p -0.3
+ 1616010p 0.9
+ 1618000p 0.9
+ 1618010p -0.3
+ 1620000p -0.3
+ 1620010p 0.9
+ 1622000p 0.9
+ 1622010p -0.3
+ 1624000p -0.3
+ 1624010p 0.9
+ 1626000p 0.9
+ 1626010p -0.3
+ 1628000p -0.3
+ 1628010p 0.9
+ 1630000p 0.9
+ 1630010p -0.3
+ 1632000p -0.3
+ 1632010p 0.9
+ 1634000p 0.9
+ 1634010p -0.3
+ 1636000p -0.3
+ 1636010p 0.9
+ 1638000p 0.9
+ 1638010p -0.3
+ 1640000p -0.3
+ 1640010p 0.9
+ 1642000p 0.9
+ 1642010p -0.3
+ 1644000p -0.3
+ 1644010p 0.9
+ 1646000p 0.9
+ 1646010p -0.3
+ 1648000p -0.3
+ 1648010p 0.9
+ 1650000p 0.9
+ 1650010p -0.3
+ 1652000p -0.3
+ 1652010p 0.9
+ 1654000p 0.9
+ 1654010p -0.3
+ 1656000p -0.3
+ 1656010p 0.9
+ 1658000p 0.9
+ 1658010p -0.3
+ 1660000p -0.3
+ 1660010p 0.9
+ 1662000p 0.9
+ 1662010p -0.3
+ 1664000p -0.3
+ 1664010p 0.9
+ 1666000p 0.9
+ 1666010p -0.3
+ 1668000p -0.3
+ 1668010p 0.9
+ 1670000p 0.9
+ 1670010p -0.3
+ 1672000p -0.3
+ 1672010p 0.9
+ 1674000p 0.9
+ 1674010p -0.3
+ 1676000p -0.3
+ 1676010p 0.9
+ 1678000p 0.9
+ 1678010p -0.3
+ 1680000p -0.3
+ 1680010p 0.9
+ 1682000p 0.9
+ 1682010p -0.3
+ 1684000p -0.3
+ 1684010p 0.9
+ 1686000p 0.9
+ 1686010p -0.3
+ 1688000p -0.3
+ 1688010p 0.9
+ 1690000p 0.9
+ 1690010p -0.3
+ 1692000p -0.3
+ 1692010p 0.9
+ 1694000p 0.9
+ 1694010p -0.3
+ 1696000p -0.3
+ 1696010p 0.9
+ 1698000p 0.9
+ 1698010p -0.3
+ 1700000p -0.3
+ 1700010p 0.9
+ 1702000p 0.9
+ 1702010p -0.3
+ 1704000p -0.3
+ 1704010p 0.9
+ 1706000p 0.9
+ 1706010p -0.3
+ 1708000p -0.3
+ 1708010p 0.9
+ 1710000p 0.9
+ 1710010p -0.3
+ 1712000p -0.3
+ 1712010p 0.9
+ 1714000p 0.9
+ 1714010p -0.3
+ 1716000p -0.3
+ 1716010p 0.9
+ 1718000p 0.9
+ 1718010p -0.3
+ 1720000p -0.3
+ 1720010p 0.9
+ 1722000p 0.9
+ 1722010p -0.3
+ 1724000p -0.3
+ 1724010p 0.9
+ 1726000p 0.9
+ 1726010p -0.3
+ 1728000p -0.3
+ 1728010p 0.9
+ 1730000p 0.9
+ 1730010p -0.3
+ 1732000p -0.3
+ 1732010p 0.9
+ 1734000p 0.9
+ 1734010p -0.3
+ 1736000p -0.3
+ 1736010p 0.9
+ 1738000p 0.9
+ 1738010p -0.3
+ 1740000p -0.3
+ 1740010p 0.9
+ 1742000p 0.9
+ 1742010p -0.3
+ 1744000p -0.3
+ 1744010p 0.9
+ 1746000p 0.9
+ 1746010p -0.3
+ 1748000p -0.3
+ 1748010p 0.9
+ 1750000p 0.9
+ 1750010p -0.3
+ 1752000p -0.3
+ 1752010p 0.9
+ 1754000p 0.9
+ 1754010p -0.3
+ 1756000p -0.3
+ 1756010p 0.9
+ 1758000p 0.9
+ 1758010p -0.3
+ 1760000p -0.3
+ 1760010p 0.9
+ 1762000p 0.9
+ 1762010p -0.3
+ 1764000p -0.3
+ 1764010p 0.9
+ 1766000p 0.9
+ 1766010p -0.3
+ 1768000p -0.3
+ 1768010p 0.9
+ 1770000p 0.9
+ 1770010p -0.3
+ 1772000p -0.3
+ 1772010p 0.9
+ 1774000p 0.9
+ 1774010p -0.3
+ 1776000p -0.3
+ 1776010p 0.9
+ 1778000p 0.9
+ 1778010p -0.3
+ 1780000p -0.3
+ 1780010p 0.9
+ 1782000p 0.9
+ 1782010p -0.3
+ 1784000p -0.3
+ 1784010p 0.9
+ 1786000p 0.9
+ 1786010p -0.3
+ 1788000p -0.3
+ 1788010p 0.9
+ 1790000p 0.9
+ 1790010p -0.3
+ 1792000p -0.3
+ 1792010p 0.9
+ 1794000p 0.9
+ 1794010p -0.3
+ 1796000p -0.3
+ 1796010p 0.9
+ 1798000p 0.9
+ 1798010p -0.3
+ 1800000p -0.3
+ 1800010p 0.9
+ 1802000p 0.9
+ 1802010p -0.3
+ 1804000p -0.3
+ 1804010p 0.9
+ 1806000p 0.9
+ 1806010p -0.3
+ 1808000p -0.3
+ 1808010p 0.9
+ 1810000p 0.9
+ 1810010p -0.3
+ 1812000p -0.3
+ 1812010p 0.9
+ 1814000p 0.9
+ 1814010p -0.3
+ 1816000p -0.3
+ 1816010p 0.9
+ 1818000p 0.9
+ 1818010p -0.3
+ 1820000p -0.3
+ 1820010p 0.9
+ 1822000p 0.9
+ 1822010p -0.3
+ 1824000p -0.3
+ 1824010p 0.9
+ 1826000p 0.9
+ 1826010p -0.3
+ 1828000p -0.3
+ 1828010p 0.9
+ 1830000p 0.9
+ 1830010p -0.3
+ 1832000p -0.3
+ 1832010p 0.9
+ 1834000p 0.9
+ 1834010p -0.3
+ 1836000p -0.3
+ 1836010p 0.9
+ 1838000p 0.9
+ 1838010p -0.3
+ 1840000p -0.3
+ 1840010p 0.9
+ 1842000p 0.9
+ 1842010p -0.3
+ 1844000p -0.3
+ 1844010p 0.9
+ 1846000p 0.9
+ 1846010p -0.3
+ 1848000p -0.3
+ 1848010p 0.9
+ 1850000p 0.9
+ 1850010p -0.3
+ 1852000p -0.3
+ 1852010p 0.9
+ 1854000p 0.9
+ 1854010p -0.3
+ 1856000p -0.3
+ 1856010p 0.9
+ 1858000p 0.9
+ 1858010p -0.3
+ 1860000p -0.3
+ 1860010p 0.9
+ 1862000p 0.9
+ 1862010p -0.3
+ 1864000p -0.3
+ 1864010p 0.9
+ 1866000p 0.9
+ 1866010p -0.3
+ 1868000p -0.3
+ 1868010p 0.9
+ 1870000p 0.9
+ 1870010p -0.3
+ 1872000p -0.3
+ 1872010p 0.9
+ 1874000p 0.9
+ 1874010p -0.3
+ 1876000p -0.3
+ 1876010p 0.9
+ 1878000p 0.9
+ 1878010p -0.3
+ 1880000p -0.3
+ 1880010p 0.9
+ 1882000p 0.9
+ 1882010p -0.3
+ 1884000p -0.3
+ 1884010p 0.9
+ 1886000p 0.9
+ 1886010p -0.3
+ 1888000p -0.3
+ 1888010p 0.9
+ 1890000p 0.9
+ 1890010p -0.3
+ 1892000p -0.3
+ 1892010p 0.9
+ 1894000p 0.9
+ 1894010p -0.3
+ 1896000p -0.3
+ 1896010p 0.9
+ 1898000p 0.9
+ 1898010p -0.3
+ 1900000p -0.3
+ 1900010p 0.9
+ 1902000p 0.9
+ 1902010p -0.3
+ 1904000p -0.3
+ 1904010p 0.9
+ 1906000p 0.9
+ 1906010p -0.3
+ 1908000p -0.3
+ 1908010p 0.9
+ 1910000p 0.9
+ 1910010p -0.3
+ 1912000p -0.3
+ 1912010p 0.9
+ 1914000p 0.9
+ 1914010p -0.3
+ 1916000p -0.3
+ 1916010p 0.9
+ 1918000p 0.9
+ 1918010p -0.3
+ 1920000p -0.3
+ 1920010p 0.9
+ 1922000p 0.9
+ 1922010p -0.3
+ 1924000p -0.3
+ 1924010p 0.9
+ 1926000p 0.9
+ 1926010p -0.3
+ 1928000p -0.3
+ 1928010p 0.9
+ 1930000p 0.9
+ 1930010p -0.3
+ 1932000p -0.3
+ 1932010p 0.9
+ 1934000p 0.9
+ 1934010p -0.3
+ 1936000p -0.3
+ 1936010p 0.9
+ 1938000p 0.9
+ 1938010p -0.3
+ 1940000p -0.3
+ 1940010p 0.9
+ 1942000p 0.9
+ 1942010p -0.3
+ 1944000p -0.3
+ 1944010p 0.9
+ 1946000p 0.9
+ 1946010p -0.3
+ 1948000p -0.3
+ 1948010p 0.9
+ 1950000p 0.9
+ 1950010p -0.3
+ 1952000p -0.3
+ 1952010p 0.9
+ 1954000p 0.9
+ 1954010p -0.3
+ 1956000p -0.3
+ 1956010p 0.9
+ 1958000p 0.9
+ 1958010p -0.3
+ 1960000p -0.3
+ 1960010p 0.9
+ 1962000p 0.9
+ 1962010p -0.3
+ 1964000p -0.3
+ 1964010p 0.9
+ 1966000p 0.9
+ 1966010p -0.3
+ 1968000p -0.3
+ 1968010p 0.9
+ 1970000p 0.9
+ 1970010p -0.3
+ 1972000p -0.3
+ 1972010p 0.9
+ 1974000p 0.9
+ 1974010p -0.3
+ 1976000p -0.3
+ 1976010p 0.9
+ 1978000p 0.9
+ 1978010p -0.3
+ 1980000p -0.3
+ 1980010p 0.9
+ 1982000p 0.9
+ 1982010p -0.3
+ 1984000p -0.3
+ 1984010p 0.9
+ 1986000p 0.9
+ 1986010p -0.3
+ 1988000p -0.3
+ 1988010p 0.9
+ 1990000p 0.9
+ 1990010p -0.3
+ 1992000p -0.3
+ 1992010p 0.9
+ 1994000p 0.9
+ 1994010p -0.3
+ 1996000p -0.3
+ 1996010p 0.9
+ 1998000p 0.9
+ 1998010p -0.3
+ 2000000p -0.3
+ 2000010p 0.9
+ 2002000p 0.9
+ 2002010p -0.3
+ 2004000p -0.3
+ 2004010p 0.9
+ 2006000p 0.9
+ 2006010p -0.3
+ 2008000p -0.3
+ 2008010p 0.9
+ 2010000p 0.9
+ 2010010p -0.3
+ 2012000p -0.3
+ 2012010p 0.9
+ 2014000p 0.9
+ 2014010p -0.3
+ 2016000p -0.3
+ 2016010p 0.9
+ 2018000p 0.9
+ 2018010p -0.3
+ 2020000p -0.3
+ 2020010p 0.9
+ 2022000p 0.9
+ 2022010p -0.3
+ 2024000p -0.3
+ 2024010p 0.9
+ 2026000p 0.9
+ 2026010p -0.3
+ 2028000p -0.3
+ 2028010p 0.9
+ 2030000p 0.9
+ 2030010p -0.3
+ 2032000p -0.3
+ 2032010p 0.9
+ 2034000p 0.9
+ 2034010p -0.3
+ 2036000p -0.3
+ 2036010p 0.9
+ 2038000p 0.9
+ 2038010p -0.3
+ 2040000p -0.3
+ 2040010p 0.9
+ 2042000p 0.9
+ 2042010p -0.3
+ 2044000p -0.3
+ 2044010p 0.9
+ 2046000p 0.9
+ 2046010p -0.3
+ 2048000p -0.3
+ 2048010p 0.9
+ \]
V_data_bar_25 (Data_bar\\<25\\> gnd!) vsource type=pwl wave=\[
+ 0    -0.3
+ 2000p -0.3
+ 2010p 0.9
+ 4000p 0.9
+ 4010p -0.3
+ 6000p -0.3
+ 6010p 0.9
+ 8000p 0.9
+ 8010p -0.3
+ 10000p -0.3
+ 10010p 0.9
+ 12000p 0.9
+ 12010p -0.3
+ 14000p -0.3
+ 14010p 0.9
+ 16000p 0.9
+ 16010p -0.3
+ 18000p -0.3
+ 18010p 0.9
+ 20000p 0.9
+ 20010p -0.3
+ 22000p -0.3
+ 22010p 0.9
+ 24000p 0.9
+ 24010p -0.3
+ 26000p -0.3
+ 26010p 0.9
+ 28000p 0.9
+ 28010p -0.3
+ 30000p -0.3
+ 30010p 0.9
+ 32000p 0.9
+ 32010p -0.3
+ 34000p -0.3
+ 34010p 0.9
+ 36000p 0.9
+ 36010p -0.3
+ 38000p -0.3
+ 38010p 0.9
+ 40000p 0.9
+ 40010p -0.3
+ 42000p -0.3
+ 42010p 0.9
+ 44000p 0.9
+ 44010p -0.3
+ 46000p -0.3
+ 46010p 0.9
+ 48000p 0.9
+ 48010p -0.3
+ 50000p -0.3
+ 50010p 0.9
+ 52000p 0.9
+ 52010p -0.3
+ 54000p -0.3
+ 54010p 0.9
+ 56000p 0.9
+ 56010p -0.3
+ 58000p -0.3
+ 58010p 0.9
+ 60000p 0.9
+ 60010p -0.3
+ 62000p -0.3
+ 62010p 0.9
+ 64000p 0.9
+ 64010p -0.3
+ 66000p -0.3
+ 66010p 0.9
+ 68000p 0.9
+ 68010p -0.3
+ 70000p -0.3
+ 70010p 0.9
+ 72000p 0.9
+ 72010p -0.3
+ 74000p -0.3
+ 74010p 0.9
+ 76000p 0.9
+ 76010p -0.3
+ 78000p -0.3
+ 78010p 0.9
+ 80000p 0.9
+ 80010p -0.3
+ 82000p -0.3
+ 82010p 0.9
+ 84000p 0.9
+ 84010p -0.3
+ 86000p -0.3
+ 86010p 0.9
+ 88000p 0.9
+ 88010p -0.3
+ 90000p -0.3
+ 90010p 0.9
+ 92000p 0.9
+ 92010p -0.3
+ 94000p -0.3
+ 94010p 0.9
+ 96000p 0.9
+ 96010p -0.3
+ 98000p -0.3
+ 98010p 0.9
+ 100000p 0.9
+ 100010p -0.3
+ 102000p -0.3
+ 102010p 0.9
+ 104000p 0.9
+ 104010p -0.3
+ 106000p -0.3
+ 106010p 0.9
+ 108000p 0.9
+ 108010p -0.3
+ 110000p -0.3
+ 110010p 0.9
+ 112000p 0.9
+ 112010p -0.3
+ 114000p -0.3
+ 114010p 0.9
+ 116000p 0.9
+ 116010p -0.3
+ 118000p -0.3
+ 118010p 0.9
+ 120000p 0.9
+ 120010p -0.3
+ 122000p -0.3
+ 122010p 0.9
+ 124000p 0.9
+ 124010p -0.3
+ 126000p -0.3
+ 126010p 0.9
+ 128000p 0.9
+ 128010p -0.3
+ 130000p -0.3
+ 130010p 0.9
+ 132000p 0.9
+ 132010p -0.3
+ 134000p -0.3
+ 134010p 0.9
+ 136000p 0.9
+ 136010p -0.3
+ 138000p -0.3
+ 138010p 0.9
+ 140000p 0.9
+ 140010p -0.3
+ 142000p -0.3
+ 142010p 0.9
+ 144000p 0.9
+ 144010p -0.3
+ 146000p -0.3
+ 146010p 0.9
+ 148000p 0.9
+ 148010p -0.3
+ 150000p -0.3
+ 150010p 0.9
+ 152000p 0.9
+ 152010p -0.3
+ 154000p -0.3
+ 154010p 0.9
+ 156000p 0.9
+ 156010p -0.3
+ 158000p -0.3
+ 158010p 0.9
+ 160000p 0.9
+ 160010p -0.3
+ 162000p -0.3
+ 162010p 0.9
+ 164000p 0.9
+ 164010p -0.3
+ 166000p -0.3
+ 166010p 0.9
+ 168000p 0.9
+ 168010p -0.3
+ 170000p -0.3
+ 170010p 0.9
+ 172000p 0.9
+ 172010p -0.3
+ 174000p -0.3
+ 174010p 0.9
+ 176000p 0.9
+ 176010p -0.3
+ 178000p -0.3
+ 178010p 0.9
+ 180000p 0.9
+ 180010p -0.3
+ 182000p -0.3
+ 182010p 0.9
+ 184000p 0.9
+ 184010p -0.3
+ 186000p -0.3
+ 186010p 0.9
+ 188000p 0.9
+ 188010p -0.3
+ 190000p -0.3
+ 190010p 0.9
+ 192000p 0.9
+ 192010p -0.3
+ 194000p -0.3
+ 194010p 0.9
+ 196000p 0.9
+ 196010p -0.3
+ 198000p -0.3
+ 198010p 0.9
+ 200000p 0.9
+ 200010p -0.3
+ 202000p -0.3
+ 202010p 0.9
+ 204000p 0.9
+ 204010p -0.3
+ 206000p -0.3
+ 206010p 0.9
+ 208000p 0.9
+ 208010p -0.3
+ 210000p -0.3
+ 210010p 0.9
+ 212000p 0.9
+ 212010p -0.3
+ 214000p -0.3
+ 214010p 0.9
+ 216000p 0.9
+ 216010p -0.3
+ 218000p -0.3
+ 218010p 0.9
+ 220000p 0.9
+ 220010p -0.3
+ 222000p -0.3
+ 222010p 0.9
+ 224000p 0.9
+ 224010p -0.3
+ 226000p -0.3
+ 226010p 0.9
+ 228000p 0.9
+ 228010p -0.3
+ 230000p -0.3
+ 230010p 0.9
+ 232000p 0.9
+ 232010p -0.3
+ 234000p -0.3
+ 234010p 0.9
+ 236000p 0.9
+ 236010p -0.3
+ 238000p -0.3
+ 238010p 0.9
+ 240000p 0.9
+ 240010p -0.3
+ 242000p -0.3
+ 242010p 0.9
+ 244000p 0.9
+ 244010p -0.3
+ 246000p -0.3
+ 246010p 0.9
+ 248000p 0.9
+ 248010p -0.3
+ 250000p -0.3
+ 250010p 0.9
+ 252000p 0.9
+ 252010p -0.3
+ 254000p -0.3
+ 254010p 0.9
+ 256000p 0.9
+ 256010p -0.3
+ 258000p -0.3
+ 258010p 0.9
+ 260000p 0.9
+ 260010p -0.3
+ 262000p -0.3
+ 262010p 0.9
+ 264000p 0.9
+ 264010p -0.3
+ 266000p -0.3
+ 266010p 0.9
+ 268000p 0.9
+ 268010p -0.3
+ 270000p -0.3
+ 270010p 0.9
+ 272000p 0.9
+ 272010p -0.3
+ 274000p -0.3
+ 274010p 0.9
+ 276000p 0.9
+ 276010p -0.3
+ 278000p -0.3
+ 278010p 0.9
+ 280000p 0.9
+ 280010p -0.3
+ 282000p -0.3
+ 282010p 0.9
+ 284000p 0.9
+ 284010p -0.3
+ 286000p -0.3
+ 286010p 0.9
+ 288000p 0.9
+ 288010p -0.3
+ 290000p -0.3
+ 290010p 0.9
+ 292000p 0.9
+ 292010p -0.3
+ 294000p -0.3
+ 294010p 0.9
+ 296000p 0.9
+ 296010p -0.3
+ 298000p -0.3
+ 298010p 0.9
+ 300000p 0.9
+ 300010p -0.3
+ 302000p -0.3
+ 302010p 0.9
+ 304000p 0.9
+ 304010p -0.3
+ 306000p -0.3
+ 306010p 0.9
+ 308000p 0.9
+ 308010p -0.3
+ 310000p -0.3
+ 310010p 0.9
+ 312000p 0.9
+ 312010p -0.3
+ 314000p -0.3
+ 314010p 0.9
+ 316000p 0.9
+ 316010p -0.3
+ 318000p -0.3
+ 318010p 0.9
+ 320000p 0.9
+ 320010p -0.3
+ 322000p -0.3
+ 322010p 0.9
+ 324000p 0.9
+ 324010p -0.3
+ 326000p -0.3
+ 326010p 0.9
+ 328000p 0.9
+ 328010p -0.3
+ 330000p -0.3
+ 330010p 0.9
+ 332000p 0.9
+ 332010p -0.3
+ 334000p -0.3
+ 334010p 0.9
+ 336000p 0.9
+ 336010p -0.3
+ 338000p -0.3
+ 338010p 0.9
+ 340000p 0.9
+ 340010p -0.3
+ 342000p -0.3
+ 342010p 0.9
+ 344000p 0.9
+ 344010p -0.3
+ 346000p -0.3
+ 346010p 0.9
+ 348000p 0.9
+ 348010p -0.3
+ 350000p -0.3
+ 350010p 0.9
+ 352000p 0.9
+ 352010p -0.3
+ 354000p -0.3
+ 354010p 0.9
+ 356000p 0.9
+ 356010p -0.3
+ 358000p -0.3
+ 358010p 0.9
+ 360000p 0.9
+ 360010p -0.3
+ 362000p -0.3
+ 362010p 0.9
+ 364000p 0.9
+ 364010p -0.3
+ 366000p -0.3
+ 366010p 0.9
+ 368000p 0.9
+ 368010p -0.3
+ 370000p -0.3
+ 370010p 0.9
+ 372000p 0.9
+ 372010p -0.3
+ 374000p -0.3
+ 374010p 0.9
+ 376000p 0.9
+ 376010p -0.3
+ 378000p -0.3
+ 378010p 0.9
+ 380000p 0.9
+ 380010p -0.3
+ 382000p -0.3
+ 382010p 0.9
+ 384000p 0.9
+ 384010p -0.3
+ 386000p -0.3
+ 386010p 0.9
+ 388000p 0.9
+ 388010p -0.3
+ 390000p -0.3
+ 390010p 0.9
+ 392000p 0.9
+ 392010p -0.3
+ 394000p -0.3
+ 394010p 0.9
+ 396000p 0.9
+ 396010p -0.3
+ 398000p -0.3
+ 398010p 0.9
+ 400000p 0.9
+ 400010p -0.3
+ 402000p -0.3
+ 402010p 0.9
+ 404000p 0.9
+ 404010p -0.3
+ 406000p -0.3
+ 406010p 0.9
+ 408000p 0.9
+ 408010p -0.3
+ 410000p -0.3
+ 410010p 0.9
+ 412000p 0.9
+ 412010p -0.3
+ 414000p -0.3
+ 414010p 0.9
+ 416000p 0.9
+ 416010p -0.3
+ 418000p -0.3
+ 418010p 0.9
+ 420000p 0.9
+ 420010p -0.3
+ 422000p -0.3
+ 422010p 0.9
+ 424000p 0.9
+ 424010p -0.3
+ 426000p -0.3
+ 426010p 0.9
+ 428000p 0.9
+ 428010p -0.3
+ 430000p -0.3
+ 430010p 0.9
+ 432000p 0.9
+ 432010p -0.3
+ 434000p -0.3
+ 434010p 0.9
+ 436000p 0.9
+ 436010p -0.3
+ 438000p -0.3
+ 438010p 0.9
+ 440000p 0.9
+ 440010p -0.3
+ 442000p -0.3
+ 442010p 0.9
+ 444000p 0.9
+ 444010p -0.3
+ 446000p -0.3
+ 446010p 0.9
+ 448000p 0.9
+ 448010p -0.3
+ 450000p -0.3
+ 450010p 0.9
+ 452000p 0.9
+ 452010p -0.3
+ 454000p -0.3
+ 454010p 0.9
+ 456000p 0.9
+ 456010p -0.3
+ 458000p -0.3
+ 458010p 0.9
+ 460000p 0.9
+ 460010p -0.3
+ 462000p -0.3
+ 462010p 0.9
+ 464000p 0.9
+ 464010p -0.3
+ 466000p -0.3
+ 466010p 0.9
+ 468000p 0.9
+ 468010p -0.3
+ 470000p -0.3
+ 470010p 0.9
+ 472000p 0.9
+ 472010p -0.3
+ 474000p -0.3
+ 474010p 0.9
+ 476000p 0.9
+ 476010p -0.3
+ 478000p -0.3
+ 478010p 0.9
+ 480000p 0.9
+ 480010p -0.3
+ 482000p -0.3
+ 482010p 0.9
+ 484000p 0.9
+ 484010p -0.3
+ 486000p -0.3
+ 486010p 0.9
+ 488000p 0.9
+ 488010p -0.3
+ 490000p -0.3
+ 490010p 0.9
+ 492000p 0.9
+ 492010p -0.3
+ 494000p -0.3
+ 494010p 0.9
+ 496000p 0.9
+ 496010p -0.3
+ 498000p -0.3
+ 498010p 0.9
+ 500000p 0.9
+ 500010p -0.3
+ 502000p -0.3
+ 502010p 0.9
+ 504000p 0.9
+ 504010p -0.3
+ 506000p -0.3
+ 506010p 0.9
+ 508000p 0.9
+ 508010p -0.3
+ 510000p -0.3
+ 510010p 0.9
+ 512000p 0.9
+ 512010p -0.3
+ 514000p -0.3
+ 514010p 0.9
+ 516000p 0.9
+ 516010p -0.3
+ 518000p -0.3
+ 518010p 0.9
+ 520000p 0.9
+ 520010p -0.3
+ 522000p -0.3
+ 522010p 0.9
+ 524000p 0.9
+ 524010p -0.3
+ 526000p -0.3
+ 526010p 0.9
+ 528000p 0.9
+ 528010p -0.3
+ 530000p -0.3
+ 530010p 0.9
+ 532000p 0.9
+ 532010p -0.3
+ 534000p -0.3
+ 534010p 0.9
+ 536000p 0.9
+ 536010p -0.3
+ 538000p -0.3
+ 538010p 0.9
+ 540000p 0.9
+ 540010p -0.3
+ 542000p -0.3
+ 542010p 0.9
+ 544000p 0.9
+ 544010p -0.3
+ 546000p -0.3
+ 546010p 0.9
+ 548000p 0.9
+ 548010p -0.3
+ 550000p -0.3
+ 550010p 0.9
+ 552000p 0.9
+ 552010p -0.3
+ 554000p -0.3
+ 554010p 0.9
+ 556000p 0.9
+ 556010p -0.3
+ 558000p -0.3
+ 558010p 0.9
+ 560000p 0.9
+ 560010p -0.3
+ 562000p -0.3
+ 562010p 0.9
+ 564000p 0.9
+ 564010p -0.3
+ 566000p -0.3
+ 566010p 0.9
+ 568000p 0.9
+ 568010p -0.3
+ 570000p -0.3
+ 570010p 0.9
+ 572000p 0.9
+ 572010p -0.3
+ 574000p -0.3
+ 574010p 0.9
+ 576000p 0.9
+ 576010p -0.3
+ 578000p -0.3
+ 578010p 0.9
+ 580000p 0.9
+ 580010p -0.3
+ 582000p -0.3
+ 582010p 0.9
+ 584000p 0.9
+ 584010p -0.3
+ 586000p -0.3
+ 586010p 0.9
+ 588000p 0.9
+ 588010p -0.3
+ 590000p -0.3
+ 590010p 0.9
+ 592000p 0.9
+ 592010p -0.3
+ 594000p -0.3
+ 594010p 0.9
+ 596000p 0.9
+ 596010p -0.3
+ 598000p -0.3
+ 598010p 0.9
+ 600000p 0.9
+ 600010p -0.3
+ 602000p -0.3
+ 602010p 0.9
+ 604000p 0.9
+ 604010p -0.3
+ 606000p -0.3
+ 606010p 0.9
+ 608000p 0.9
+ 608010p -0.3
+ 610000p -0.3
+ 610010p 0.9
+ 612000p 0.9
+ 612010p -0.3
+ 614000p -0.3
+ 614010p 0.9
+ 616000p 0.9
+ 616010p -0.3
+ 618000p -0.3
+ 618010p 0.9
+ 620000p 0.9
+ 620010p -0.3
+ 622000p -0.3
+ 622010p 0.9
+ 624000p 0.9
+ 624010p -0.3
+ 626000p -0.3
+ 626010p 0.9
+ 628000p 0.9
+ 628010p -0.3
+ 630000p -0.3
+ 630010p 0.9
+ 632000p 0.9
+ 632010p -0.3
+ 634000p -0.3
+ 634010p 0.9
+ 636000p 0.9
+ 636010p -0.3
+ 638000p -0.3
+ 638010p 0.9
+ 640000p 0.9
+ 640010p -0.3
+ 642000p -0.3
+ 642010p 0.9
+ 644000p 0.9
+ 644010p -0.3
+ 646000p -0.3
+ 646010p 0.9
+ 648000p 0.9
+ 648010p -0.3
+ 650000p -0.3
+ 650010p 0.9
+ 652000p 0.9
+ 652010p -0.3
+ 654000p -0.3
+ 654010p 0.9
+ 656000p 0.9
+ 656010p -0.3
+ 658000p -0.3
+ 658010p 0.9
+ 660000p 0.9
+ 660010p -0.3
+ 662000p -0.3
+ 662010p 0.9
+ 664000p 0.9
+ 664010p -0.3
+ 666000p -0.3
+ 666010p 0.9
+ 668000p 0.9
+ 668010p -0.3
+ 670000p -0.3
+ 670010p 0.9
+ 672000p 0.9
+ 672010p -0.3
+ 674000p -0.3
+ 674010p 0.9
+ 676000p 0.9
+ 676010p -0.3
+ 678000p -0.3
+ 678010p 0.9
+ 680000p 0.9
+ 680010p -0.3
+ 682000p -0.3
+ 682010p 0.9
+ 684000p 0.9
+ 684010p -0.3
+ 686000p -0.3
+ 686010p 0.9
+ 688000p 0.9
+ 688010p -0.3
+ 690000p -0.3
+ 690010p 0.9
+ 692000p 0.9
+ 692010p -0.3
+ 694000p -0.3
+ 694010p 0.9
+ 696000p 0.9
+ 696010p -0.3
+ 698000p -0.3
+ 698010p 0.9
+ 700000p 0.9
+ 700010p -0.3
+ 702000p -0.3
+ 702010p 0.9
+ 704000p 0.9
+ 704010p -0.3
+ 706000p -0.3
+ 706010p 0.9
+ 708000p 0.9
+ 708010p -0.3
+ 710000p -0.3
+ 710010p 0.9
+ 712000p 0.9
+ 712010p -0.3
+ 714000p -0.3
+ 714010p 0.9
+ 716000p 0.9
+ 716010p -0.3
+ 718000p -0.3
+ 718010p 0.9
+ 720000p 0.9
+ 720010p -0.3
+ 722000p -0.3
+ 722010p 0.9
+ 724000p 0.9
+ 724010p -0.3
+ 726000p -0.3
+ 726010p 0.9
+ 728000p 0.9
+ 728010p -0.3
+ 730000p -0.3
+ 730010p 0.9
+ 732000p 0.9
+ 732010p -0.3
+ 734000p -0.3
+ 734010p 0.9
+ 736000p 0.9
+ 736010p -0.3
+ 738000p -0.3
+ 738010p 0.9
+ 740000p 0.9
+ 740010p -0.3
+ 742000p -0.3
+ 742010p 0.9
+ 744000p 0.9
+ 744010p -0.3
+ 746000p -0.3
+ 746010p 0.9
+ 748000p 0.9
+ 748010p -0.3
+ 750000p -0.3
+ 750010p 0.9
+ 752000p 0.9
+ 752010p -0.3
+ 754000p -0.3
+ 754010p 0.9
+ 756000p 0.9
+ 756010p -0.3
+ 758000p -0.3
+ 758010p 0.9
+ 760000p 0.9
+ 760010p -0.3
+ 762000p -0.3
+ 762010p 0.9
+ 764000p 0.9
+ 764010p -0.3
+ 766000p -0.3
+ 766010p 0.9
+ 768000p 0.9
+ 768010p -0.3
+ 770000p -0.3
+ 770010p 0.9
+ 772000p 0.9
+ 772010p -0.3
+ 774000p -0.3
+ 774010p 0.9
+ 776000p 0.9
+ 776010p -0.3
+ 778000p -0.3
+ 778010p 0.9
+ 780000p 0.9
+ 780010p -0.3
+ 782000p -0.3
+ 782010p 0.9
+ 784000p 0.9
+ 784010p -0.3
+ 786000p -0.3
+ 786010p 0.9
+ 788000p 0.9
+ 788010p -0.3
+ 790000p -0.3
+ 790010p 0.9
+ 792000p 0.9
+ 792010p -0.3
+ 794000p -0.3
+ 794010p 0.9
+ 796000p 0.9
+ 796010p -0.3
+ 798000p -0.3
+ 798010p 0.9
+ 800000p 0.9
+ 800010p -0.3
+ 802000p -0.3
+ 802010p 0.9
+ 804000p 0.9
+ 804010p -0.3
+ 806000p -0.3
+ 806010p 0.9
+ 808000p 0.9
+ 808010p -0.3
+ 810000p -0.3
+ 810010p 0.9
+ 812000p 0.9
+ 812010p -0.3
+ 814000p -0.3
+ 814010p 0.9
+ 816000p 0.9
+ 816010p -0.3
+ 818000p -0.3
+ 818010p 0.9
+ 820000p 0.9
+ 820010p -0.3
+ 822000p -0.3
+ 822010p 0.9
+ 824000p 0.9
+ 824010p -0.3
+ 826000p -0.3
+ 826010p 0.9
+ 828000p 0.9
+ 828010p -0.3
+ 830000p -0.3
+ 830010p 0.9
+ 832000p 0.9
+ 832010p -0.3
+ 834000p -0.3
+ 834010p 0.9
+ 836000p 0.9
+ 836010p -0.3
+ 838000p -0.3
+ 838010p 0.9
+ 840000p 0.9
+ 840010p -0.3
+ 842000p -0.3
+ 842010p 0.9
+ 844000p 0.9
+ 844010p -0.3
+ 846000p -0.3
+ 846010p 0.9
+ 848000p 0.9
+ 848010p -0.3
+ 850000p -0.3
+ 850010p 0.9
+ 852000p 0.9
+ 852010p -0.3
+ 854000p -0.3
+ 854010p 0.9
+ 856000p 0.9
+ 856010p -0.3
+ 858000p -0.3
+ 858010p 0.9
+ 860000p 0.9
+ 860010p -0.3
+ 862000p -0.3
+ 862010p 0.9
+ 864000p 0.9
+ 864010p -0.3
+ 866000p -0.3
+ 866010p 0.9
+ 868000p 0.9
+ 868010p -0.3
+ 870000p -0.3
+ 870010p 0.9
+ 872000p 0.9
+ 872010p -0.3
+ 874000p -0.3
+ 874010p 0.9
+ 876000p 0.9
+ 876010p -0.3
+ 878000p -0.3
+ 878010p 0.9
+ 880000p 0.9
+ 880010p -0.3
+ 882000p -0.3
+ 882010p 0.9
+ 884000p 0.9
+ 884010p -0.3
+ 886000p -0.3
+ 886010p 0.9
+ 888000p 0.9
+ 888010p -0.3
+ 890000p -0.3
+ 890010p 0.9
+ 892000p 0.9
+ 892010p -0.3
+ 894000p -0.3
+ 894010p 0.9
+ 896000p 0.9
+ 896010p -0.3
+ 898000p -0.3
+ 898010p 0.9
+ 900000p 0.9
+ 900010p -0.3
+ 902000p -0.3
+ 902010p 0.9
+ 904000p 0.9
+ 904010p -0.3
+ 906000p -0.3
+ 906010p 0.9
+ 908000p 0.9
+ 908010p -0.3
+ 910000p -0.3
+ 910010p 0.9
+ 912000p 0.9
+ 912010p -0.3
+ 914000p -0.3
+ 914010p 0.9
+ 916000p 0.9
+ 916010p -0.3
+ 918000p -0.3
+ 918010p 0.9
+ 920000p 0.9
+ 920010p -0.3
+ 922000p -0.3
+ 922010p 0.9
+ 924000p 0.9
+ 924010p -0.3
+ 926000p -0.3
+ 926010p 0.9
+ 928000p 0.9
+ 928010p -0.3
+ 930000p -0.3
+ 930010p 0.9
+ 932000p 0.9
+ 932010p -0.3
+ 934000p -0.3
+ 934010p 0.9
+ 936000p 0.9
+ 936010p -0.3
+ 938000p -0.3
+ 938010p 0.9
+ 940000p 0.9
+ 940010p -0.3
+ 942000p -0.3
+ 942010p 0.9
+ 944000p 0.9
+ 944010p -0.3
+ 946000p -0.3
+ 946010p 0.9
+ 948000p 0.9
+ 948010p -0.3
+ 950000p -0.3
+ 950010p 0.9
+ 952000p 0.9
+ 952010p -0.3
+ 954000p -0.3
+ 954010p 0.9
+ 956000p 0.9
+ 956010p -0.3
+ 958000p -0.3
+ 958010p 0.9
+ 960000p 0.9
+ 960010p -0.3
+ 962000p -0.3
+ 962010p 0.9
+ 964000p 0.9
+ 964010p -0.3
+ 966000p -0.3
+ 966010p 0.9
+ 968000p 0.9
+ 968010p -0.3
+ 970000p -0.3
+ 970010p 0.9
+ 972000p 0.9
+ 972010p -0.3
+ 974000p -0.3
+ 974010p 0.9
+ 976000p 0.9
+ 976010p -0.3
+ 978000p -0.3
+ 978010p 0.9
+ 980000p 0.9
+ 980010p -0.3
+ 982000p -0.3
+ 982010p 0.9
+ 984000p 0.9
+ 984010p -0.3
+ 986000p -0.3
+ 986010p 0.9
+ 988000p 0.9
+ 988010p -0.3
+ 990000p -0.3
+ 990010p 0.9
+ 992000p 0.9
+ 992010p -0.3
+ 994000p -0.3
+ 994010p 0.9
+ 996000p 0.9
+ 996010p -0.3
+ 998000p -0.3
+ 998010p 0.9
+ 1000000p 0.9
+ 1000010p -0.3
+ 1002000p -0.3
+ 1002010p 0.9
+ 1004000p 0.9
+ 1004010p -0.3
+ 1006000p -0.3
+ 1006010p 0.9
+ 1008000p 0.9
+ 1008010p -0.3
+ 1010000p -0.3
+ 1010010p 0.9
+ 1012000p 0.9
+ 1012010p -0.3
+ 1014000p -0.3
+ 1014010p 0.9
+ 1016000p 0.9
+ 1016010p -0.3
+ 1018000p -0.3
+ 1018010p 0.9
+ 1020000p 0.9
+ 1020010p -0.3
+ 1022000p -0.3
+ 1022010p 0.9
+ 1024000p 0.9
+ 1024010p -0.3
+ 1026000p -0.3
+ 1026010p 0.9
+ 1028000p 0.9
+ 1028010p -0.3
+ 1030000p -0.3
+ 1030010p 0.9
+ 1032000p 0.9
+ 1032010p -0.3
+ 1034000p -0.3
+ 1034010p 0.9
+ 1036000p 0.9
+ 1036010p -0.3
+ 1038000p -0.3
+ 1038010p 0.9
+ 1040000p 0.9
+ 1040010p -0.3
+ 1042000p -0.3
+ 1042010p 0.9
+ 1044000p 0.9
+ 1044010p -0.3
+ 1046000p -0.3
+ 1046010p 0.9
+ 1048000p 0.9
+ 1048010p -0.3
+ 1050000p -0.3
+ 1050010p 0.9
+ 1052000p 0.9
+ 1052010p -0.3
+ 1054000p -0.3
+ 1054010p 0.9
+ 1056000p 0.9
+ 1056010p -0.3
+ 1058000p -0.3
+ 1058010p 0.9
+ 1060000p 0.9
+ 1060010p -0.3
+ 1062000p -0.3
+ 1062010p 0.9
+ 1064000p 0.9
+ 1064010p -0.3
+ 1066000p -0.3
+ 1066010p 0.9
+ 1068000p 0.9
+ 1068010p -0.3
+ 1070000p -0.3
+ 1070010p 0.9
+ 1072000p 0.9
+ 1072010p -0.3
+ 1074000p -0.3
+ 1074010p 0.9
+ 1076000p 0.9
+ 1076010p -0.3
+ 1078000p -0.3
+ 1078010p 0.9
+ 1080000p 0.9
+ 1080010p -0.3
+ 1082000p -0.3
+ 1082010p 0.9
+ 1084000p 0.9
+ 1084010p -0.3
+ 1086000p -0.3
+ 1086010p 0.9
+ 1088000p 0.9
+ 1088010p -0.3
+ 1090000p -0.3
+ 1090010p 0.9
+ 1092000p 0.9
+ 1092010p -0.3
+ 1094000p -0.3
+ 1094010p 0.9
+ 1096000p 0.9
+ 1096010p -0.3
+ 1098000p -0.3
+ 1098010p 0.9
+ 1100000p 0.9
+ 1100010p -0.3
+ 1102000p -0.3
+ 1102010p 0.9
+ 1104000p 0.9
+ 1104010p -0.3
+ 1106000p -0.3
+ 1106010p 0.9
+ 1108000p 0.9
+ 1108010p -0.3
+ 1110000p -0.3
+ 1110010p 0.9
+ 1112000p 0.9
+ 1112010p -0.3
+ 1114000p -0.3
+ 1114010p 0.9
+ 1116000p 0.9
+ 1116010p -0.3
+ 1118000p -0.3
+ 1118010p 0.9
+ 1120000p 0.9
+ 1120010p -0.3
+ 1122000p -0.3
+ 1122010p 0.9
+ 1124000p 0.9
+ 1124010p -0.3
+ 1126000p -0.3
+ 1126010p 0.9
+ 1128000p 0.9
+ 1128010p -0.3
+ 1130000p -0.3
+ 1130010p 0.9
+ 1132000p 0.9
+ 1132010p -0.3
+ 1134000p -0.3
+ 1134010p 0.9
+ 1136000p 0.9
+ 1136010p -0.3
+ 1138000p -0.3
+ 1138010p 0.9
+ 1140000p 0.9
+ 1140010p -0.3
+ 1142000p -0.3
+ 1142010p 0.9
+ 1144000p 0.9
+ 1144010p -0.3
+ 1146000p -0.3
+ 1146010p 0.9
+ 1148000p 0.9
+ 1148010p -0.3
+ 1150000p -0.3
+ 1150010p 0.9
+ 1152000p 0.9
+ 1152010p -0.3
+ 1154000p -0.3
+ 1154010p 0.9
+ 1156000p 0.9
+ 1156010p -0.3
+ 1158000p -0.3
+ 1158010p 0.9
+ 1160000p 0.9
+ 1160010p -0.3
+ 1162000p -0.3
+ 1162010p 0.9
+ 1164000p 0.9
+ 1164010p -0.3
+ 1166000p -0.3
+ 1166010p 0.9
+ 1168000p 0.9
+ 1168010p -0.3
+ 1170000p -0.3
+ 1170010p 0.9
+ 1172000p 0.9
+ 1172010p -0.3
+ 1174000p -0.3
+ 1174010p 0.9
+ 1176000p 0.9
+ 1176010p -0.3
+ 1178000p -0.3
+ 1178010p 0.9
+ 1180000p 0.9
+ 1180010p -0.3
+ 1182000p -0.3
+ 1182010p 0.9
+ 1184000p 0.9
+ 1184010p -0.3
+ 1186000p -0.3
+ 1186010p 0.9
+ 1188000p 0.9
+ 1188010p -0.3
+ 1190000p -0.3
+ 1190010p 0.9
+ 1192000p 0.9
+ 1192010p -0.3
+ 1194000p -0.3
+ 1194010p 0.9
+ 1196000p 0.9
+ 1196010p -0.3
+ 1198000p -0.3
+ 1198010p 0.9
+ 1200000p 0.9
+ 1200010p -0.3
+ 1202000p -0.3
+ 1202010p 0.9
+ 1204000p 0.9
+ 1204010p -0.3
+ 1206000p -0.3
+ 1206010p 0.9
+ 1208000p 0.9
+ 1208010p -0.3
+ 1210000p -0.3
+ 1210010p 0.9
+ 1212000p 0.9
+ 1212010p -0.3
+ 1214000p -0.3
+ 1214010p 0.9
+ 1216000p 0.9
+ 1216010p -0.3
+ 1218000p -0.3
+ 1218010p 0.9
+ 1220000p 0.9
+ 1220010p -0.3
+ 1222000p -0.3
+ 1222010p 0.9
+ 1224000p 0.9
+ 1224010p -0.3
+ 1226000p -0.3
+ 1226010p 0.9
+ 1228000p 0.9
+ 1228010p -0.3
+ 1230000p -0.3
+ 1230010p 0.9
+ 1232000p 0.9
+ 1232010p -0.3
+ 1234000p -0.3
+ 1234010p 0.9
+ 1236000p 0.9
+ 1236010p -0.3
+ 1238000p -0.3
+ 1238010p 0.9
+ 1240000p 0.9
+ 1240010p -0.3
+ 1242000p -0.3
+ 1242010p 0.9
+ 1244000p 0.9
+ 1244010p -0.3
+ 1246000p -0.3
+ 1246010p 0.9
+ 1248000p 0.9
+ 1248010p -0.3
+ 1250000p -0.3
+ 1250010p 0.9
+ 1252000p 0.9
+ 1252010p -0.3
+ 1254000p -0.3
+ 1254010p 0.9
+ 1256000p 0.9
+ 1256010p -0.3
+ 1258000p -0.3
+ 1258010p 0.9
+ 1260000p 0.9
+ 1260010p -0.3
+ 1262000p -0.3
+ 1262010p 0.9
+ 1264000p 0.9
+ 1264010p -0.3
+ 1266000p -0.3
+ 1266010p 0.9
+ 1268000p 0.9
+ 1268010p -0.3
+ 1270000p -0.3
+ 1270010p 0.9
+ 1272000p 0.9
+ 1272010p -0.3
+ 1274000p -0.3
+ 1274010p 0.9
+ 1276000p 0.9
+ 1276010p -0.3
+ 1278000p -0.3
+ 1278010p 0.9
+ 1280000p 0.9
+ 1280010p -0.3
+ 1282000p -0.3
+ 1282010p 0.9
+ 1284000p 0.9
+ 1284010p -0.3
+ 1286000p -0.3
+ 1286010p 0.9
+ 1288000p 0.9
+ 1288010p -0.3
+ 1290000p -0.3
+ 1290010p 0.9
+ 1292000p 0.9
+ 1292010p -0.3
+ 1294000p -0.3
+ 1294010p 0.9
+ 1296000p 0.9
+ 1296010p -0.3
+ 1298000p -0.3
+ 1298010p 0.9
+ 1300000p 0.9
+ 1300010p -0.3
+ 1302000p -0.3
+ 1302010p 0.9
+ 1304000p 0.9
+ 1304010p -0.3
+ 1306000p -0.3
+ 1306010p 0.9
+ 1308000p 0.9
+ 1308010p -0.3
+ 1310000p -0.3
+ 1310010p 0.9
+ 1312000p 0.9
+ 1312010p -0.3
+ 1314000p -0.3
+ 1314010p 0.9
+ 1316000p 0.9
+ 1316010p -0.3
+ 1318000p -0.3
+ 1318010p 0.9
+ 1320000p 0.9
+ 1320010p -0.3
+ 1322000p -0.3
+ 1322010p 0.9
+ 1324000p 0.9
+ 1324010p -0.3
+ 1326000p -0.3
+ 1326010p 0.9
+ 1328000p 0.9
+ 1328010p -0.3
+ 1330000p -0.3
+ 1330010p 0.9
+ 1332000p 0.9
+ 1332010p -0.3
+ 1334000p -0.3
+ 1334010p 0.9
+ 1336000p 0.9
+ 1336010p -0.3
+ 1338000p -0.3
+ 1338010p 0.9
+ 1340000p 0.9
+ 1340010p -0.3
+ 1342000p -0.3
+ 1342010p 0.9
+ 1344000p 0.9
+ 1344010p -0.3
+ 1346000p -0.3
+ 1346010p 0.9
+ 1348000p 0.9
+ 1348010p -0.3
+ 1350000p -0.3
+ 1350010p 0.9
+ 1352000p 0.9
+ 1352010p -0.3
+ 1354000p -0.3
+ 1354010p 0.9
+ 1356000p 0.9
+ 1356010p -0.3
+ 1358000p -0.3
+ 1358010p 0.9
+ 1360000p 0.9
+ 1360010p -0.3
+ 1362000p -0.3
+ 1362010p 0.9
+ 1364000p 0.9
+ 1364010p -0.3
+ 1366000p -0.3
+ 1366010p 0.9
+ 1368000p 0.9
+ 1368010p -0.3
+ 1370000p -0.3
+ 1370010p 0.9
+ 1372000p 0.9
+ 1372010p -0.3
+ 1374000p -0.3
+ 1374010p 0.9
+ 1376000p 0.9
+ 1376010p -0.3
+ 1378000p -0.3
+ 1378010p 0.9
+ 1380000p 0.9
+ 1380010p -0.3
+ 1382000p -0.3
+ 1382010p 0.9
+ 1384000p 0.9
+ 1384010p -0.3
+ 1386000p -0.3
+ 1386010p 0.9
+ 1388000p 0.9
+ 1388010p -0.3
+ 1390000p -0.3
+ 1390010p 0.9
+ 1392000p 0.9
+ 1392010p -0.3
+ 1394000p -0.3
+ 1394010p 0.9
+ 1396000p 0.9
+ 1396010p -0.3
+ 1398000p -0.3
+ 1398010p 0.9
+ 1400000p 0.9
+ 1400010p -0.3
+ 1402000p -0.3
+ 1402010p 0.9
+ 1404000p 0.9
+ 1404010p -0.3
+ 1406000p -0.3
+ 1406010p 0.9
+ 1408000p 0.9
+ 1408010p -0.3
+ 1410000p -0.3
+ 1410010p 0.9
+ 1412000p 0.9
+ 1412010p -0.3
+ 1414000p -0.3
+ 1414010p 0.9
+ 1416000p 0.9
+ 1416010p -0.3
+ 1418000p -0.3
+ 1418010p 0.9
+ 1420000p 0.9
+ 1420010p -0.3
+ 1422000p -0.3
+ 1422010p 0.9
+ 1424000p 0.9
+ 1424010p -0.3
+ 1426000p -0.3
+ 1426010p 0.9
+ 1428000p 0.9
+ 1428010p -0.3
+ 1430000p -0.3
+ 1430010p 0.9
+ 1432000p 0.9
+ 1432010p -0.3
+ 1434000p -0.3
+ 1434010p 0.9
+ 1436000p 0.9
+ 1436010p -0.3
+ 1438000p -0.3
+ 1438010p 0.9
+ 1440000p 0.9
+ 1440010p -0.3
+ 1442000p -0.3
+ 1442010p 0.9
+ 1444000p 0.9
+ 1444010p -0.3
+ 1446000p -0.3
+ 1446010p 0.9
+ 1448000p 0.9
+ 1448010p -0.3
+ 1450000p -0.3
+ 1450010p 0.9
+ 1452000p 0.9
+ 1452010p -0.3
+ 1454000p -0.3
+ 1454010p 0.9
+ 1456000p 0.9
+ 1456010p -0.3
+ 1458000p -0.3
+ 1458010p 0.9
+ 1460000p 0.9
+ 1460010p -0.3
+ 1462000p -0.3
+ 1462010p 0.9
+ 1464000p 0.9
+ 1464010p -0.3
+ 1466000p -0.3
+ 1466010p 0.9
+ 1468000p 0.9
+ 1468010p -0.3
+ 1470000p -0.3
+ 1470010p 0.9
+ 1472000p 0.9
+ 1472010p -0.3
+ 1474000p -0.3
+ 1474010p 0.9
+ 1476000p 0.9
+ 1476010p -0.3
+ 1478000p -0.3
+ 1478010p 0.9
+ 1480000p 0.9
+ 1480010p -0.3
+ 1482000p -0.3
+ 1482010p 0.9
+ 1484000p 0.9
+ 1484010p -0.3
+ 1486000p -0.3
+ 1486010p 0.9
+ 1488000p 0.9
+ 1488010p -0.3
+ 1490000p -0.3
+ 1490010p 0.9
+ 1492000p 0.9
+ 1492010p -0.3
+ 1494000p -0.3
+ 1494010p 0.9
+ 1496000p 0.9
+ 1496010p -0.3
+ 1498000p -0.3
+ 1498010p 0.9
+ 1500000p 0.9
+ 1500010p -0.3
+ 1502000p -0.3
+ 1502010p 0.9
+ 1504000p 0.9
+ 1504010p -0.3
+ 1506000p -0.3
+ 1506010p 0.9
+ 1508000p 0.9
+ 1508010p -0.3
+ 1510000p -0.3
+ 1510010p 0.9
+ 1512000p 0.9
+ 1512010p -0.3
+ 1514000p -0.3
+ 1514010p 0.9
+ 1516000p 0.9
+ 1516010p -0.3
+ 1518000p -0.3
+ 1518010p 0.9
+ 1520000p 0.9
+ 1520010p -0.3
+ 1522000p -0.3
+ 1522010p 0.9
+ 1524000p 0.9
+ 1524010p -0.3
+ 1526000p -0.3
+ 1526010p 0.9
+ 1528000p 0.9
+ 1528010p -0.3
+ 1530000p -0.3
+ 1530010p 0.9
+ 1532000p 0.9
+ 1532010p -0.3
+ 1534000p -0.3
+ 1534010p 0.9
+ 1536000p 0.9
+ 1536010p -0.3
+ 1538000p -0.3
+ 1538010p 0.9
+ 1540000p 0.9
+ 1540010p -0.3
+ 1542000p -0.3
+ 1542010p 0.9
+ 1544000p 0.9
+ 1544010p -0.3
+ 1546000p -0.3
+ 1546010p 0.9
+ 1548000p 0.9
+ 1548010p -0.3
+ 1550000p -0.3
+ 1550010p 0.9
+ 1552000p 0.9
+ 1552010p -0.3
+ 1554000p -0.3
+ 1554010p 0.9
+ 1556000p 0.9
+ 1556010p -0.3
+ 1558000p -0.3
+ 1558010p 0.9
+ 1560000p 0.9
+ 1560010p -0.3
+ 1562000p -0.3
+ 1562010p 0.9
+ 1564000p 0.9
+ 1564010p -0.3
+ 1566000p -0.3
+ 1566010p 0.9
+ 1568000p 0.9
+ 1568010p -0.3
+ 1570000p -0.3
+ 1570010p 0.9
+ 1572000p 0.9
+ 1572010p -0.3
+ 1574000p -0.3
+ 1574010p 0.9
+ 1576000p 0.9
+ 1576010p -0.3
+ 1578000p -0.3
+ 1578010p 0.9
+ 1580000p 0.9
+ 1580010p -0.3
+ 1582000p -0.3
+ 1582010p 0.9
+ 1584000p 0.9
+ 1584010p -0.3
+ 1586000p -0.3
+ 1586010p 0.9
+ 1588000p 0.9
+ 1588010p -0.3
+ 1590000p -0.3
+ 1590010p 0.9
+ 1592000p 0.9
+ 1592010p -0.3
+ 1594000p -0.3
+ 1594010p 0.9
+ 1596000p 0.9
+ 1596010p -0.3
+ 1598000p -0.3
+ 1598010p 0.9
+ 1600000p 0.9
+ 1600010p -0.3
+ 1602000p -0.3
+ 1602010p 0.9
+ 1604000p 0.9
+ 1604010p -0.3
+ 1606000p -0.3
+ 1606010p 0.9
+ 1608000p 0.9
+ 1608010p -0.3
+ 1610000p -0.3
+ 1610010p 0.9
+ 1612000p 0.9
+ 1612010p -0.3
+ 1614000p -0.3
+ 1614010p 0.9
+ 1616000p 0.9
+ 1616010p -0.3
+ 1618000p -0.3
+ 1618010p 0.9
+ 1620000p 0.9
+ 1620010p -0.3
+ 1622000p -0.3
+ 1622010p 0.9
+ 1624000p 0.9
+ 1624010p -0.3
+ 1626000p -0.3
+ 1626010p 0.9
+ 1628000p 0.9
+ 1628010p -0.3
+ 1630000p -0.3
+ 1630010p 0.9
+ 1632000p 0.9
+ 1632010p -0.3
+ 1634000p -0.3
+ 1634010p 0.9
+ 1636000p 0.9
+ 1636010p -0.3
+ 1638000p -0.3
+ 1638010p 0.9
+ 1640000p 0.9
+ 1640010p -0.3
+ 1642000p -0.3
+ 1642010p 0.9
+ 1644000p 0.9
+ 1644010p -0.3
+ 1646000p -0.3
+ 1646010p 0.9
+ 1648000p 0.9
+ 1648010p -0.3
+ 1650000p -0.3
+ 1650010p 0.9
+ 1652000p 0.9
+ 1652010p -0.3
+ 1654000p -0.3
+ 1654010p 0.9
+ 1656000p 0.9
+ 1656010p -0.3
+ 1658000p -0.3
+ 1658010p 0.9
+ 1660000p 0.9
+ 1660010p -0.3
+ 1662000p -0.3
+ 1662010p 0.9
+ 1664000p 0.9
+ 1664010p -0.3
+ 1666000p -0.3
+ 1666010p 0.9
+ 1668000p 0.9
+ 1668010p -0.3
+ 1670000p -0.3
+ 1670010p 0.9
+ 1672000p 0.9
+ 1672010p -0.3
+ 1674000p -0.3
+ 1674010p 0.9
+ 1676000p 0.9
+ 1676010p -0.3
+ 1678000p -0.3
+ 1678010p 0.9
+ 1680000p 0.9
+ 1680010p -0.3
+ 1682000p -0.3
+ 1682010p 0.9
+ 1684000p 0.9
+ 1684010p -0.3
+ 1686000p -0.3
+ 1686010p 0.9
+ 1688000p 0.9
+ 1688010p -0.3
+ 1690000p -0.3
+ 1690010p 0.9
+ 1692000p 0.9
+ 1692010p -0.3
+ 1694000p -0.3
+ 1694010p 0.9
+ 1696000p 0.9
+ 1696010p -0.3
+ 1698000p -0.3
+ 1698010p 0.9
+ 1700000p 0.9
+ 1700010p -0.3
+ 1702000p -0.3
+ 1702010p 0.9
+ 1704000p 0.9
+ 1704010p -0.3
+ 1706000p -0.3
+ 1706010p 0.9
+ 1708000p 0.9
+ 1708010p -0.3
+ 1710000p -0.3
+ 1710010p 0.9
+ 1712000p 0.9
+ 1712010p -0.3
+ 1714000p -0.3
+ 1714010p 0.9
+ 1716000p 0.9
+ 1716010p -0.3
+ 1718000p -0.3
+ 1718010p 0.9
+ 1720000p 0.9
+ 1720010p -0.3
+ 1722000p -0.3
+ 1722010p 0.9
+ 1724000p 0.9
+ 1724010p -0.3
+ 1726000p -0.3
+ 1726010p 0.9
+ 1728000p 0.9
+ 1728010p -0.3
+ 1730000p -0.3
+ 1730010p 0.9
+ 1732000p 0.9
+ 1732010p -0.3
+ 1734000p -0.3
+ 1734010p 0.9
+ 1736000p 0.9
+ 1736010p -0.3
+ 1738000p -0.3
+ 1738010p 0.9
+ 1740000p 0.9
+ 1740010p -0.3
+ 1742000p -0.3
+ 1742010p 0.9
+ 1744000p 0.9
+ 1744010p -0.3
+ 1746000p -0.3
+ 1746010p 0.9
+ 1748000p 0.9
+ 1748010p -0.3
+ 1750000p -0.3
+ 1750010p 0.9
+ 1752000p 0.9
+ 1752010p -0.3
+ 1754000p -0.3
+ 1754010p 0.9
+ 1756000p 0.9
+ 1756010p -0.3
+ 1758000p -0.3
+ 1758010p 0.9
+ 1760000p 0.9
+ 1760010p -0.3
+ 1762000p -0.3
+ 1762010p 0.9
+ 1764000p 0.9
+ 1764010p -0.3
+ 1766000p -0.3
+ 1766010p 0.9
+ 1768000p 0.9
+ 1768010p -0.3
+ 1770000p -0.3
+ 1770010p 0.9
+ 1772000p 0.9
+ 1772010p -0.3
+ 1774000p -0.3
+ 1774010p 0.9
+ 1776000p 0.9
+ 1776010p -0.3
+ 1778000p -0.3
+ 1778010p 0.9
+ 1780000p 0.9
+ 1780010p -0.3
+ 1782000p -0.3
+ 1782010p 0.9
+ 1784000p 0.9
+ 1784010p -0.3
+ 1786000p -0.3
+ 1786010p 0.9
+ 1788000p 0.9
+ 1788010p -0.3
+ 1790000p -0.3
+ 1790010p 0.9
+ 1792000p 0.9
+ 1792010p -0.3
+ 1794000p -0.3
+ 1794010p 0.9
+ 1796000p 0.9
+ 1796010p -0.3
+ 1798000p -0.3
+ 1798010p 0.9
+ 1800000p 0.9
+ 1800010p -0.3
+ 1802000p -0.3
+ 1802010p 0.9
+ 1804000p 0.9
+ 1804010p -0.3
+ 1806000p -0.3
+ 1806010p 0.9
+ 1808000p 0.9
+ 1808010p -0.3
+ 1810000p -0.3
+ 1810010p 0.9
+ 1812000p 0.9
+ 1812010p -0.3
+ 1814000p -0.3
+ 1814010p 0.9
+ 1816000p 0.9
+ 1816010p -0.3
+ 1818000p -0.3
+ 1818010p 0.9
+ 1820000p 0.9
+ 1820010p -0.3
+ 1822000p -0.3
+ 1822010p 0.9
+ 1824000p 0.9
+ 1824010p -0.3
+ 1826000p -0.3
+ 1826010p 0.9
+ 1828000p 0.9
+ 1828010p -0.3
+ 1830000p -0.3
+ 1830010p 0.9
+ 1832000p 0.9
+ 1832010p -0.3
+ 1834000p -0.3
+ 1834010p 0.9
+ 1836000p 0.9
+ 1836010p -0.3
+ 1838000p -0.3
+ 1838010p 0.9
+ 1840000p 0.9
+ 1840010p -0.3
+ 1842000p -0.3
+ 1842010p 0.9
+ 1844000p 0.9
+ 1844010p -0.3
+ 1846000p -0.3
+ 1846010p 0.9
+ 1848000p 0.9
+ 1848010p -0.3
+ 1850000p -0.3
+ 1850010p 0.9
+ 1852000p 0.9
+ 1852010p -0.3
+ 1854000p -0.3
+ 1854010p 0.9
+ 1856000p 0.9
+ 1856010p -0.3
+ 1858000p -0.3
+ 1858010p 0.9
+ 1860000p 0.9
+ 1860010p -0.3
+ 1862000p -0.3
+ 1862010p 0.9
+ 1864000p 0.9
+ 1864010p -0.3
+ 1866000p -0.3
+ 1866010p 0.9
+ 1868000p 0.9
+ 1868010p -0.3
+ 1870000p -0.3
+ 1870010p 0.9
+ 1872000p 0.9
+ 1872010p -0.3
+ 1874000p -0.3
+ 1874010p 0.9
+ 1876000p 0.9
+ 1876010p -0.3
+ 1878000p -0.3
+ 1878010p 0.9
+ 1880000p 0.9
+ 1880010p -0.3
+ 1882000p -0.3
+ 1882010p 0.9
+ 1884000p 0.9
+ 1884010p -0.3
+ 1886000p -0.3
+ 1886010p 0.9
+ 1888000p 0.9
+ 1888010p -0.3
+ 1890000p -0.3
+ 1890010p 0.9
+ 1892000p 0.9
+ 1892010p -0.3
+ 1894000p -0.3
+ 1894010p 0.9
+ 1896000p 0.9
+ 1896010p -0.3
+ 1898000p -0.3
+ 1898010p 0.9
+ 1900000p 0.9
+ 1900010p -0.3
+ 1902000p -0.3
+ 1902010p 0.9
+ 1904000p 0.9
+ 1904010p -0.3
+ 1906000p -0.3
+ 1906010p 0.9
+ 1908000p 0.9
+ 1908010p -0.3
+ 1910000p -0.3
+ 1910010p 0.9
+ 1912000p 0.9
+ 1912010p -0.3
+ 1914000p -0.3
+ 1914010p 0.9
+ 1916000p 0.9
+ 1916010p -0.3
+ 1918000p -0.3
+ 1918010p 0.9
+ 1920000p 0.9
+ 1920010p -0.3
+ 1922000p -0.3
+ 1922010p 0.9
+ 1924000p 0.9
+ 1924010p -0.3
+ 1926000p -0.3
+ 1926010p 0.9
+ 1928000p 0.9
+ 1928010p -0.3
+ 1930000p -0.3
+ 1930010p 0.9
+ 1932000p 0.9
+ 1932010p -0.3
+ 1934000p -0.3
+ 1934010p 0.9
+ 1936000p 0.9
+ 1936010p -0.3
+ 1938000p -0.3
+ 1938010p 0.9
+ 1940000p 0.9
+ 1940010p -0.3
+ 1942000p -0.3
+ 1942010p 0.9
+ 1944000p 0.9
+ 1944010p -0.3
+ 1946000p -0.3
+ 1946010p 0.9
+ 1948000p 0.9
+ 1948010p -0.3
+ 1950000p -0.3
+ 1950010p 0.9
+ 1952000p 0.9
+ 1952010p -0.3
+ 1954000p -0.3
+ 1954010p 0.9
+ 1956000p 0.9
+ 1956010p -0.3
+ 1958000p -0.3
+ 1958010p 0.9
+ 1960000p 0.9
+ 1960010p -0.3
+ 1962000p -0.3
+ 1962010p 0.9
+ 1964000p 0.9
+ 1964010p -0.3
+ 1966000p -0.3
+ 1966010p 0.9
+ 1968000p 0.9
+ 1968010p -0.3
+ 1970000p -0.3
+ 1970010p 0.9
+ 1972000p 0.9
+ 1972010p -0.3
+ 1974000p -0.3
+ 1974010p 0.9
+ 1976000p 0.9
+ 1976010p -0.3
+ 1978000p -0.3
+ 1978010p 0.9
+ 1980000p 0.9
+ 1980010p -0.3
+ 1982000p -0.3
+ 1982010p 0.9
+ 1984000p 0.9
+ 1984010p -0.3
+ 1986000p -0.3
+ 1986010p 0.9
+ 1988000p 0.9
+ 1988010p -0.3
+ 1990000p -0.3
+ 1990010p 0.9
+ 1992000p 0.9
+ 1992010p -0.3
+ 1994000p -0.3
+ 1994010p 0.9
+ 1996000p 0.9
+ 1996010p -0.3
+ 1998000p -0.3
+ 1998010p 0.9
+ 2000000p 0.9
+ 2000010p -0.3
+ 2002000p -0.3
+ 2002010p 0.9
+ 2004000p 0.9
+ 2004010p -0.3
+ 2006000p -0.3
+ 2006010p 0.9
+ 2008000p 0.9
+ 2008010p -0.3
+ 2010000p -0.3
+ 2010010p 0.9
+ 2012000p 0.9
+ 2012010p -0.3
+ 2014000p -0.3
+ 2014010p 0.9
+ 2016000p 0.9
+ 2016010p -0.3
+ 2018000p -0.3
+ 2018010p 0.9
+ 2020000p 0.9
+ 2020010p -0.3
+ 2022000p -0.3
+ 2022010p 0.9
+ 2024000p 0.9
+ 2024010p -0.3
+ 2026000p -0.3
+ 2026010p 0.9
+ 2028000p 0.9
+ 2028010p -0.3
+ 2030000p -0.3
+ 2030010p 0.9
+ 2032000p 0.9
+ 2032010p -0.3
+ 2034000p -0.3
+ 2034010p 0.9
+ 2036000p 0.9
+ 2036010p -0.3
+ 2038000p -0.3
+ 2038010p 0.9
+ 2040000p 0.9
+ 2040010p -0.3
+ 2042000p -0.3
+ 2042010p 0.9
+ 2044000p 0.9
+ 2044010p -0.3
+ 2046000p -0.3
+ 2046010p 0.9
+ 2048000p 0.9
+ 2048010p -0.3
+ \]
V_data_26 (Data\\<26\\> gnd!) vsource type=pwl wave=\[
+ 0    0.9
+ 2000p 0.9
+ 2010p -0.3
+ 4000p -0.3
+ 4010p 0.9
+ 6000p 0.9
+ 6010p -0.3
+ 8000p -0.3
+ 8010p 0.9
+ 10000p 0.9
+ 10010p -0.3
+ 12000p -0.3
+ 12010p 0.9
+ 14000p 0.9
+ 14010p -0.3
+ 16000p -0.3
+ 16010p 0.9
+ 18000p 0.9
+ 18010p -0.3
+ 20000p -0.3
+ 20010p 0.9
+ 22000p 0.9
+ 22010p -0.3
+ 24000p -0.3
+ 24010p 0.9
+ 26000p 0.9
+ 26010p -0.3
+ 28000p -0.3
+ 28010p 0.9
+ 30000p 0.9
+ 30010p -0.3
+ 32000p -0.3
+ 32010p 0.9
+ 34000p 0.9
+ 34010p -0.3
+ 36000p -0.3
+ 36010p 0.9
+ 38000p 0.9
+ 38010p -0.3
+ 40000p -0.3
+ 40010p 0.9
+ 42000p 0.9
+ 42010p -0.3
+ 44000p -0.3
+ 44010p 0.9
+ 46000p 0.9
+ 46010p -0.3
+ 48000p -0.3
+ 48010p 0.9
+ 50000p 0.9
+ 50010p -0.3
+ 52000p -0.3
+ 52010p 0.9
+ 54000p 0.9
+ 54010p -0.3
+ 56000p -0.3
+ 56010p 0.9
+ 58000p 0.9
+ 58010p -0.3
+ 60000p -0.3
+ 60010p 0.9
+ 62000p 0.9
+ 62010p -0.3
+ 64000p -0.3
+ 64010p 0.9
+ 66000p 0.9
+ 66010p -0.3
+ 68000p -0.3
+ 68010p 0.9
+ 70000p 0.9
+ 70010p -0.3
+ 72000p -0.3
+ 72010p 0.9
+ 74000p 0.9
+ 74010p -0.3
+ 76000p -0.3
+ 76010p 0.9
+ 78000p 0.9
+ 78010p -0.3
+ 80000p -0.3
+ 80010p 0.9
+ 82000p 0.9
+ 82010p -0.3
+ 84000p -0.3
+ 84010p 0.9
+ 86000p 0.9
+ 86010p -0.3
+ 88000p -0.3
+ 88010p 0.9
+ 90000p 0.9
+ 90010p -0.3
+ 92000p -0.3
+ 92010p 0.9
+ 94000p 0.9
+ 94010p -0.3
+ 96000p -0.3
+ 96010p 0.9
+ 98000p 0.9
+ 98010p -0.3
+ 100000p -0.3
+ 100010p 0.9
+ 102000p 0.9
+ 102010p -0.3
+ 104000p -0.3
+ 104010p 0.9
+ 106000p 0.9
+ 106010p -0.3
+ 108000p -0.3
+ 108010p 0.9
+ 110000p 0.9
+ 110010p -0.3
+ 112000p -0.3
+ 112010p 0.9
+ 114000p 0.9
+ 114010p -0.3
+ 116000p -0.3
+ 116010p 0.9
+ 118000p 0.9
+ 118010p -0.3
+ 120000p -0.3
+ 120010p 0.9
+ 122000p 0.9
+ 122010p -0.3
+ 124000p -0.3
+ 124010p 0.9
+ 126000p 0.9
+ 126010p -0.3
+ 128000p -0.3
+ 128010p 0.9
+ 130000p 0.9
+ 130010p -0.3
+ 132000p -0.3
+ 132010p 0.9
+ 134000p 0.9
+ 134010p -0.3
+ 136000p -0.3
+ 136010p 0.9
+ 138000p 0.9
+ 138010p -0.3
+ 140000p -0.3
+ 140010p 0.9
+ 142000p 0.9
+ 142010p -0.3
+ 144000p -0.3
+ 144010p 0.9
+ 146000p 0.9
+ 146010p -0.3
+ 148000p -0.3
+ 148010p 0.9
+ 150000p 0.9
+ 150010p -0.3
+ 152000p -0.3
+ 152010p 0.9
+ 154000p 0.9
+ 154010p -0.3
+ 156000p -0.3
+ 156010p 0.9
+ 158000p 0.9
+ 158010p -0.3
+ 160000p -0.3
+ 160010p 0.9
+ 162000p 0.9
+ 162010p -0.3
+ 164000p -0.3
+ 164010p 0.9
+ 166000p 0.9
+ 166010p -0.3
+ 168000p -0.3
+ 168010p 0.9
+ 170000p 0.9
+ 170010p -0.3
+ 172000p -0.3
+ 172010p 0.9
+ 174000p 0.9
+ 174010p -0.3
+ 176000p -0.3
+ 176010p 0.9
+ 178000p 0.9
+ 178010p -0.3
+ 180000p -0.3
+ 180010p 0.9
+ 182000p 0.9
+ 182010p -0.3
+ 184000p -0.3
+ 184010p 0.9
+ 186000p 0.9
+ 186010p -0.3
+ 188000p -0.3
+ 188010p 0.9
+ 190000p 0.9
+ 190010p -0.3
+ 192000p -0.3
+ 192010p 0.9
+ 194000p 0.9
+ 194010p -0.3
+ 196000p -0.3
+ 196010p 0.9
+ 198000p 0.9
+ 198010p -0.3
+ 200000p -0.3
+ 200010p 0.9
+ 202000p 0.9
+ 202010p -0.3
+ 204000p -0.3
+ 204010p 0.9
+ 206000p 0.9
+ 206010p -0.3
+ 208000p -0.3
+ 208010p 0.9
+ 210000p 0.9
+ 210010p -0.3
+ 212000p -0.3
+ 212010p 0.9
+ 214000p 0.9
+ 214010p -0.3
+ 216000p -0.3
+ 216010p 0.9
+ 218000p 0.9
+ 218010p -0.3
+ 220000p -0.3
+ 220010p 0.9
+ 222000p 0.9
+ 222010p -0.3
+ 224000p -0.3
+ 224010p 0.9
+ 226000p 0.9
+ 226010p -0.3
+ 228000p -0.3
+ 228010p 0.9
+ 230000p 0.9
+ 230010p -0.3
+ 232000p -0.3
+ 232010p 0.9
+ 234000p 0.9
+ 234010p -0.3
+ 236000p -0.3
+ 236010p 0.9
+ 238000p 0.9
+ 238010p -0.3
+ 240000p -0.3
+ 240010p 0.9
+ 242000p 0.9
+ 242010p -0.3
+ 244000p -0.3
+ 244010p 0.9
+ 246000p 0.9
+ 246010p -0.3
+ 248000p -0.3
+ 248010p 0.9
+ 250000p 0.9
+ 250010p -0.3
+ 252000p -0.3
+ 252010p 0.9
+ 254000p 0.9
+ 254010p -0.3
+ 256000p -0.3
+ 256010p 0.9
+ 258000p 0.9
+ 258010p -0.3
+ 260000p -0.3
+ 260010p 0.9
+ 262000p 0.9
+ 262010p -0.3
+ 264000p -0.3
+ 264010p 0.9
+ 266000p 0.9
+ 266010p -0.3
+ 268000p -0.3
+ 268010p 0.9
+ 270000p 0.9
+ 270010p -0.3
+ 272000p -0.3
+ 272010p 0.9
+ 274000p 0.9
+ 274010p -0.3
+ 276000p -0.3
+ 276010p 0.9
+ 278000p 0.9
+ 278010p -0.3
+ 280000p -0.3
+ 280010p 0.9
+ 282000p 0.9
+ 282010p -0.3
+ 284000p -0.3
+ 284010p 0.9
+ 286000p 0.9
+ 286010p -0.3
+ 288000p -0.3
+ 288010p 0.9
+ 290000p 0.9
+ 290010p -0.3
+ 292000p -0.3
+ 292010p 0.9
+ 294000p 0.9
+ 294010p -0.3
+ 296000p -0.3
+ 296010p 0.9
+ 298000p 0.9
+ 298010p -0.3
+ 300000p -0.3
+ 300010p 0.9
+ 302000p 0.9
+ 302010p -0.3
+ 304000p -0.3
+ 304010p 0.9
+ 306000p 0.9
+ 306010p -0.3
+ 308000p -0.3
+ 308010p 0.9
+ 310000p 0.9
+ 310010p -0.3
+ 312000p -0.3
+ 312010p 0.9
+ 314000p 0.9
+ 314010p -0.3
+ 316000p -0.3
+ 316010p 0.9
+ 318000p 0.9
+ 318010p -0.3
+ 320000p -0.3
+ 320010p 0.9
+ 322000p 0.9
+ 322010p -0.3
+ 324000p -0.3
+ 324010p 0.9
+ 326000p 0.9
+ 326010p -0.3
+ 328000p -0.3
+ 328010p 0.9
+ 330000p 0.9
+ 330010p -0.3
+ 332000p -0.3
+ 332010p 0.9
+ 334000p 0.9
+ 334010p -0.3
+ 336000p -0.3
+ 336010p 0.9
+ 338000p 0.9
+ 338010p -0.3
+ 340000p -0.3
+ 340010p 0.9
+ 342000p 0.9
+ 342010p -0.3
+ 344000p -0.3
+ 344010p 0.9
+ 346000p 0.9
+ 346010p -0.3
+ 348000p -0.3
+ 348010p 0.9
+ 350000p 0.9
+ 350010p -0.3
+ 352000p -0.3
+ 352010p 0.9
+ 354000p 0.9
+ 354010p -0.3
+ 356000p -0.3
+ 356010p 0.9
+ 358000p 0.9
+ 358010p -0.3
+ 360000p -0.3
+ 360010p 0.9
+ 362000p 0.9
+ 362010p -0.3
+ 364000p -0.3
+ 364010p 0.9
+ 366000p 0.9
+ 366010p -0.3
+ 368000p -0.3
+ 368010p 0.9
+ 370000p 0.9
+ 370010p -0.3
+ 372000p -0.3
+ 372010p 0.9
+ 374000p 0.9
+ 374010p -0.3
+ 376000p -0.3
+ 376010p 0.9
+ 378000p 0.9
+ 378010p -0.3
+ 380000p -0.3
+ 380010p 0.9
+ 382000p 0.9
+ 382010p -0.3
+ 384000p -0.3
+ 384010p 0.9
+ 386000p 0.9
+ 386010p -0.3
+ 388000p -0.3
+ 388010p 0.9
+ 390000p 0.9
+ 390010p -0.3
+ 392000p -0.3
+ 392010p 0.9
+ 394000p 0.9
+ 394010p -0.3
+ 396000p -0.3
+ 396010p 0.9
+ 398000p 0.9
+ 398010p -0.3
+ 400000p -0.3
+ 400010p 0.9
+ 402000p 0.9
+ 402010p -0.3
+ 404000p -0.3
+ 404010p 0.9
+ 406000p 0.9
+ 406010p -0.3
+ 408000p -0.3
+ 408010p 0.9
+ 410000p 0.9
+ 410010p -0.3
+ 412000p -0.3
+ 412010p 0.9
+ 414000p 0.9
+ 414010p -0.3
+ 416000p -0.3
+ 416010p 0.9
+ 418000p 0.9
+ 418010p -0.3
+ 420000p -0.3
+ 420010p 0.9
+ 422000p 0.9
+ 422010p -0.3
+ 424000p -0.3
+ 424010p 0.9
+ 426000p 0.9
+ 426010p -0.3
+ 428000p -0.3
+ 428010p 0.9
+ 430000p 0.9
+ 430010p -0.3
+ 432000p -0.3
+ 432010p 0.9
+ 434000p 0.9
+ 434010p -0.3
+ 436000p -0.3
+ 436010p 0.9
+ 438000p 0.9
+ 438010p -0.3
+ 440000p -0.3
+ 440010p 0.9
+ 442000p 0.9
+ 442010p -0.3
+ 444000p -0.3
+ 444010p 0.9
+ 446000p 0.9
+ 446010p -0.3
+ 448000p -0.3
+ 448010p 0.9
+ 450000p 0.9
+ 450010p -0.3
+ 452000p -0.3
+ 452010p 0.9
+ 454000p 0.9
+ 454010p -0.3
+ 456000p -0.3
+ 456010p 0.9
+ 458000p 0.9
+ 458010p -0.3
+ 460000p -0.3
+ 460010p 0.9
+ 462000p 0.9
+ 462010p -0.3
+ 464000p -0.3
+ 464010p 0.9
+ 466000p 0.9
+ 466010p -0.3
+ 468000p -0.3
+ 468010p 0.9
+ 470000p 0.9
+ 470010p -0.3
+ 472000p -0.3
+ 472010p 0.9
+ 474000p 0.9
+ 474010p -0.3
+ 476000p -0.3
+ 476010p 0.9
+ 478000p 0.9
+ 478010p -0.3
+ 480000p -0.3
+ 480010p 0.9
+ 482000p 0.9
+ 482010p -0.3
+ 484000p -0.3
+ 484010p 0.9
+ 486000p 0.9
+ 486010p -0.3
+ 488000p -0.3
+ 488010p 0.9
+ 490000p 0.9
+ 490010p -0.3
+ 492000p -0.3
+ 492010p 0.9
+ 494000p 0.9
+ 494010p -0.3
+ 496000p -0.3
+ 496010p 0.9
+ 498000p 0.9
+ 498010p -0.3
+ 500000p -0.3
+ 500010p 0.9
+ 502000p 0.9
+ 502010p -0.3
+ 504000p -0.3
+ 504010p 0.9
+ 506000p 0.9
+ 506010p -0.3
+ 508000p -0.3
+ 508010p 0.9
+ 510000p 0.9
+ 510010p -0.3
+ 512000p -0.3
+ 512010p 0.9
+ 514000p 0.9
+ 514010p -0.3
+ 516000p -0.3
+ 516010p 0.9
+ 518000p 0.9
+ 518010p -0.3
+ 520000p -0.3
+ 520010p 0.9
+ 522000p 0.9
+ 522010p -0.3
+ 524000p -0.3
+ 524010p 0.9
+ 526000p 0.9
+ 526010p -0.3
+ 528000p -0.3
+ 528010p 0.9
+ 530000p 0.9
+ 530010p -0.3
+ 532000p -0.3
+ 532010p 0.9
+ 534000p 0.9
+ 534010p -0.3
+ 536000p -0.3
+ 536010p 0.9
+ 538000p 0.9
+ 538010p -0.3
+ 540000p -0.3
+ 540010p 0.9
+ 542000p 0.9
+ 542010p -0.3
+ 544000p -0.3
+ 544010p 0.9
+ 546000p 0.9
+ 546010p -0.3
+ 548000p -0.3
+ 548010p 0.9
+ 550000p 0.9
+ 550010p -0.3
+ 552000p -0.3
+ 552010p 0.9
+ 554000p 0.9
+ 554010p -0.3
+ 556000p -0.3
+ 556010p 0.9
+ 558000p 0.9
+ 558010p -0.3
+ 560000p -0.3
+ 560010p 0.9
+ 562000p 0.9
+ 562010p -0.3
+ 564000p -0.3
+ 564010p 0.9
+ 566000p 0.9
+ 566010p -0.3
+ 568000p -0.3
+ 568010p 0.9
+ 570000p 0.9
+ 570010p -0.3
+ 572000p -0.3
+ 572010p 0.9
+ 574000p 0.9
+ 574010p -0.3
+ 576000p -0.3
+ 576010p 0.9
+ 578000p 0.9
+ 578010p -0.3
+ 580000p -0.3
+ 580010p 0.9
+ 582000p 0.9
+ 582010p -0.3
+ 584000p -0.3
+ 584010p 0.9
+ 586000p 0.9
+ 586010p -0.3
+ 588000p -0.3
+ 588010p 0.9
+ 590000p 0.9
+ 590010p -0.3
+ 592000p -0.3
+ 592010p 0.9
+ 594000p 0.9
+ 594010p -0.3
+ 596000p -0.3
+ 596010p 0.9
+ 598000p 0.9
+ 598010p -0.3
+ 600000p -0.3
+ 600010p 0.9
+ 602000p 0.9
+ 602010p -0.3
+ 604000p -0.3
+ 604010p 0.9
+ 606000p 0.9
+ 606010p -0.3
+ 608000p -0.3
+ 608010p 0.9
+ 610000p 0.9
+ 610010p -0.3
+ 612000p -0.3
+ 612010p 0.9
+ 614000p 0.9
+ 614010p -0.3
+ 616000p -0.3
+ 616010p 0.9
+ 618000p 0.9
+ 618010p -0.3
+ 620000p -0.3
+ 620010p 0.9
+ 622000p 0.9
+ 622010p -0.3
+ 624000p -0.3
+ 624010p 0.9
+ 626000p 0.9
+ 626010p -0.3
+ 628000p -0.3
+ 628010p 0.9
+ 630000p 0.9
+ 630010p -0.3
+ 632000p -0.3
+ 632010p 0.9
+ 634000p 0.9
+ 634010p -0.3
+ 636000p -0.3
+ 636010p 0.9
+ 638000p 0.9
+ 638010p -0.3
+ 640000p -0.3
+ 640010p 0.9
+ 642000p 0.9
+ 642010p -0.3
+ 644000p -0.3
+ 644010p 0.9
+ 646000p 0.9
+ 646010p -0.3
+ 648000p -0.3
+ 648010p 0.9
+ 650000p 0.9
+ 650010p -0.3
+ 652000p -0.3
+ 652010p 0.9
+ 654000p 0.9
+ 654010p -0.3
+ 656000p -0.3
+ 656010p 0.9
+ 658000p 0.9
+ 658010p -0.3
+ 660000p -0.3
+ 660010p 0.9
+ 662000p 0.9
+ 662010p -0.3
+ 664000p -0.3
+ 664010p 0.9
+ 666000p 0.9
+ 666010p -0.3
+ 668000p -0.3
+ 668010p 0.9
+ 670000p 0.9
+ 670010p -0.3
+ 672000p -0.3
+ 672010p 0.9
+ 674000p 0.9
+ 674010p -0.3
+ 676000p -0.3
+ 676010p 0.9
+ 678000p 0.9
+ 678010p -0.3
+ 680000p -0.3
+ 680010p 0.9
+ 682000p 0.9
+ 682010p -0.3
+ 684000p -0.3
+ 684010p 0.9
+ 686000p 0.9
+ 686010p -0.3
+ 688000p -0.3
+ 688010p 0.9
+ 690000p 0.9
+ 690010p -0.3
+ 692000p -0.3
+ 692010p 0.9
+ 694000p 0.9
+ 694010p -0.3
+ 696000p -0.3
+ 696010p 0.9
+ 698000p 0.9
+ 698010p -0.3
+ 700000p -0.3
+ 700010p 0.9
+ 702000p 0.9
+ 702010p -0.3
+ 704000p -0.3
+ 704010p 0.9
+ 706000p 0.9
+ 706010p -0.3
+ 708000p -0.3
+ 708010p 0.9
+ 710000p 0.9
+ 710010p -0.3
+ 712000p -0.3
+ 712010p 0.9
+ 714000p 0.9
+ 714010p -0.3
+ 716000p -0.3
+ 716010p 0.9
+ 718000p 0.9
+ 718010p -0.3
+ 720000p -0.3
+ 720010p 0.9
+ 722000p 0.9
+ 722010p -0.3
+ 724000p -0.3
+ 724010p 0.9
+ 726000p 0.9
+ 726010p -0.3
+ 728000p -0.3
+ 728010p 0.9
+ 730000p 0.9
+ 730010p -0.3
+ 732000p -0.3
+ 732010p 0.9
+ 734000p 0.9
+ 734010p -0.3
+ 736000p -0.3
+ 736010p 0.9
+ 738000p 0.9
+ 738010p -0.3
+ 740000p -0.3
+ 740010p 0.9
+ 742000p 0.9
+ 742010p -0.3
+ 744000p -0.3
+ 744010p 0.9
+ 746000p 0.9
+ 746010p -0.3
+ 748000p -0.3
+ 748010p 0.9
+ 750000p 0.9
+ 750010p -0.3
+ 752000p -0.3
+ 752010p 0.9
+ 754000p 0.9
+ 754010p -0.3
+ 756000p -0.3
+ 756010p 0.9
+ 758000p 0.9
+ 758010p -0.3
+ 760000p -0.3
+ 760010p 0.9
+ 762000p 0.9
+ 762010p -0.3
+ 764000p -0.3
+ 764010p 0.9
+ 766000p 0.9
+ 766010p -0.3
+ 768000p -0.3
+ 768010p 0.9
+ 770000p 0.9
+ 770010p -0.3
+ 772000p -0.3
+ 772010p 0.9
+ 774000p 0.9
+ 774010p -0.3
+ 776000p -0.3
+ 776010p 0.9
+ 778000p 0.9
+ 778010p -0.3
+ 780000p -0.3
+ 780010p 0.9
+ 782000p 0.9
+ 782010p -0.3
+ 784000p -0.3
+ 784010p 0.9
+ 786000p 0.9
+ 786010p -0.3
+ 788000p -0.3
+ 788010p 0.9
+ 790000p 0.9
+ 790010p -0.3
+ 792000p -0.3
+ 792010p 0.9
+ 794000p 0.9
+ 794010p -0.3
+ 796000p -0.3
+ 796010p 0.9
+ 798000p 0.9
+ 798010p -0.3
+ 800000p -0.3
+ 800010p 0.9
+ 802000p 0.9
+ 802010p -0.3
+ 804000p -0.3
+ 804010p 0.9
+ 806000p 0.9
+ 806010p -0.3
+ 808000p -0.3
+ 808010p 0.9
+ 810000p 0.9
+ 810010p -0.3
+ 812000p -0.3
+ 812010p 0.9
+ 814000p 0.9
+ 814010p -0.3
+ 816000p -0.3
+ 816010p 0.9
+ 818000p 0.9
+ 818010p -0.3
+ 820000p -0.3
+ 820010p 0.9
+ 822000p 0.9
+ 822010p -0.3
+ 824000p -0.3
+ 824010p 0.9
+ 826000p 0.9
+ 826010p -0.3
+ 828000p -0.3
+ 828010p 0.9
+ 830000p 0.9
+ 830010p -0.3
+ 832000p -0.3
+ 832010p 0.9
+ 834000p 0.9
+ 834010p -0.3
+ 836000p -0.3
+ 836010p 0.9
+ 838000p 0.9
+ 838010p -0.3
+ 840000p -0.3
+ 840010p 0.9
+ 842000p 0.9
+ 842010p -0.3
+ 844000p -0.3
+ 844010p 0.9
+ 846000p 0.9
+ 846010p -0.3
+ 848000p -0.3
+ 848010p 0.9
+ 850000p 0.9
+ 850010p -0.3
+ 852000p -0.3
+ 852010p 0.9
+ 854000p 0.9
+ 854010p -0.3
+ 856000p -0.3
+ 856010p 0.9
+ 858000p 0.9
+ 858010p -0.3
+ 860000p -0.3
+ 860010p 0.9
+ 862000p 0.9
+ 862010p -0.3
+ 864000p -0.3
+ 864010p 0.9
+ 866000p 0.9
+ 866010p -0.3
+ 868000p -0.3
+ 868010p 0.9
+ 870000p 0.9
+ 870010p -0.3
+ 872000p -0.3
+ 872010p 0.9
+ 874000p 0.9
+ 874010p -0.3
+ 876000p -0.3
+ 876010p 0.9
+ 878000p 0.9
+ 878010p -0.3
+ 880000p -0.3
+ 880010p 0.9
+ 882000p 0.9
+ 882010p -0.3
+ 884000p -0.3
+ 884010p 0.9
+ 886000p 0.9
+ 886010p -0.3
+ 888000p -0.3
+ 888010p 0.9
+ 890000p 0.9
+ 890010p -0.3
+ 892000p -0.3
+ 892010p 0.9
+ 894000p 0.9
+ 894010p -0.3
+ 896000p -0.3
+ 896010p 0.9
+ 898000p 0.9
+ 898010p -0.3
+ 900000p -0.3
+ 900010p 0.9
+ 902000p 0.9
+ 902010p -0.3
+ 904000p -0.3
+ 904010p 0.9
+ 906000p 0.9
+ 906010p -0.3
+ 908000p -0.3
+ 908010p 0.9
+ 910000p 0.9
+ 910010p -0.3
+ 912000p -0.3
+ 912010p 0.9
+ 914000p 0.9
+ 914010p -0.3
+ 916000p -0.3
+ 916010p 0.9
+ 918000p 0.9
+ 918010p -0.3
+ 920000p -0.3
+ 920010p 0.9
+ 922000p 0.9
+ 922010p -0.3
+ 924000p -0.3
+ 924010p 0.9
+ 926000p 0.9
+ 926010p -0.3
+ 928000p -0.3
+ 928010p 0.9
+ 930000p 0.9
+ 930010p -0.3
+ 932000p -0.3
+ 932010p 0.9
+ 934000p 0.9
+ 934010p -0.3
+ 936000p -0.3
+ 936010p 0.9
+ 938000p 0.9
+ 938010p -0.3
+ 940000p -0.3
+ 940010p 0.9
+ 942000p 0.9
+ 942010p -0.3
+ 944000p -0.3
+ 944010p 0.9
+ 946000p 0.9
+ 946010p -0.3
+ 948000p -0.3
+ 948010p 0.9
+ 950000p 0.9
+ 950010p -0.3
+ 952000p -0.3
+ 952010p 0.9
+ 954000p 0.9
+ 954010p -0.3
+ 956000p -0.3
+ 956010p 0.9
+ 958000p 0.9
+ 958010p -0.3
+ 960000p -0.3
+ 960010p 0.9
+ 962000p 0.9
+ 962010p -0.3
+ 964000p -0.3
+ 964010p 0.9
+ 966000p 0.9
+ 966010p -0.3
+ 968000p -0.3
+ 968010p 0.9
+ 970000p 0.9
+ 970010p -0.3
+ 972000p -0.3
+ 972010p 0.9
+ 974000p 0.9
+ 974010p -0.3
+ 976000p -0.3
+ 976010p 0.9
+ 978000p 0.9
+ 978010p -0.3
+ 980000p -0.3
+ 980010p 0.9
+ 982000p 0.9
+ 982010p -0.3
+ 984000p -0.3
+ 984010p 0.9
+ 986000p 0.9
+ 986010p -0.3
+ 988000p -0.3
+ 988010p 0.9
+ 990000p 0.9
+ 990010p -0.3
+ 992000p -0.3
+ 992010p 0.9
+ 994000p 0.9
+ 994010p -0.3
+ 996000p -0.3
+ 996010p 0.9
+ 998000p 0.9
+ 998010p -0.3
+ 1000000p -0.3
+ 1000010p 0.9
+ 1002000p 0.9
+ 1002010p -0.3
+ 1004000p -0.3
+ 1004010p 0.9
+ 1006000p 0.9
+ 1006010p -0.3
+ 1008000p -0.3
+ 1008010p 0.9
+ 1010000p 0.9
+ 1010010p -0.3
+ 1012000p -0.3
+ 1012010p 0.9
+ 1014000p 0.9
+ 1014010p -0.3
+ 1016000p -0.3
+ 1016010p 0.9
+ 1018000p 0.9
+ 1018010p -0.3
+ 1020000p -0.3
+ 1020010p 0.9
+ 1022000p 0.9
+ 1022010p -0.3
+ 1024000p -0.3
+ 1024010p 0.9
+ 1026000p 0.9
+ 1026010p -0.3
+ 1028000p -0.3
+ 1028010p 0.9
+ 1030000p 0.9
+ 1030010p -0.3
+ 1032000p -0.3
+ 1032010p 0.9
+ 1034000p 0.9
+ 1034010p -0.3
+ 1036000p -0.3
+ 1036010p 0.9
+ 1038000p 0.9
+ 1038010p -0.3
+ 1040000p -0.3
+ 1040010p 0.9
+ 1042000p 0.9
+ 1042010p -0.3
+ 1044000p -0.3
+ 1044010p 0.9
+ 1046000p 0.9
+ 1046010p -0.3
+ 1048000p -0.3
+ 1048010p 0.9
+ 1050000p 0.9
+ 1050010p -0.3
+ 1052000p -0.3
+ 1052010p 0.9
+ 1054000p 0.9
+ 1054010p -0.3
+ 1056000p -0.3
+ 1056010p 0.9
+ 1058000p 0.9
+ 1058010p -0.3
+ 1060000p -0.3
+ 1060010p 0.9
+ 1062000p 0.9
+ 1062010p -0.3
+ 1064000p -0.3
+ 1064010p 0.9
+ 1066000p 0.9
+ 1066010p -0.3
+ 1068000p -0.3
+ 1068010p 0.9
+ 1070000p 0.9
+ 1070010p -0.3
+ 1072000p -0.3
+ 1072010p 0.9
+ 1074000p 0.9
+ 1074010p -0.3
+ 1076000p -0.3
+ 1076010p 0.9
+ 1078000p 0.9
+ 1078010p -0.3
+ 1080000p -0.3
+ 1080010p 0.9
+ 1082000p 0.9
+ 1082010p -0.3
+ 1084000p -0.3
+ 1084010p 0.9
+ 1086000p 0.9
+ 1086010p -0.3
+ 1088000p -0.3
+ 1088010p 0.9
+ 1090000p 0.9
+ 1090010p -0.3
+ 1092000p -0.3
+ 1092010p 0.9
+ 1094000p 0.9
+ 1094010p -0.3
+ 1096000p -0.3
+ 1096010p 0.9
+ 1098000p 0.9
+ 1098010p -0.3
+ 1100000p -0.3
+ 1100010p 0.9
+ 1102000p 0.9
+ 1102010p -0.3
+ 1104000p -0.3
+ 1104010p 0.9
+ 1106000p 0.9
+ 1106010p -0.3
+ 1108000p -0.3
+ 1108010p 0.9
+ 1110000p 0.9
+ 1110010p -0.3
+ 1112000p -0.3
+ 1112010p 0.9
+ 1114000p 0.9
+ 1114010p -0.3
+ 1116000p -0.3
+ 1116010p 0.9
+ 1118000p 0.9
+ 1118010p -0.3
+ 1120000p -0.3
+ 1120010p 0.9
+ 1122000p 0.9
+ 1122010p -0.3
+ 1124000p -0.3
+ 1124010p 0.9
+ 1126000p 0.9
+ 1126010p -0.3
+ 1128000p -0.3
+ 1128010p 0.9
+ 1130000p 0.9
+ 1130010p -0.3
+ 1132000p -0.3
+ 1132010p 0.9
+ 1134000p 0.9
+ 1134010p -0.3
+ 1136000p -0.3
+ 1136010p 0.9
+ 1138000p 0.9
+ 1138010p -0.3
+ 1140000p -0.3
+ 1140010p 0.9
+ 1142000p 0.9
+ 1142010p -0.3
+ 1144000p -0.3
+ 1144010p 0.9
+ 1146000p 0.9
+ 1146010p -0.3
+ 1148000p -0.3
+ 1148010p 0.9
+ 1150000p 0.9
+ 1150010p -0.3
+ 1152000p -0.3
+ 1152010p 0.9
+ 1154000p 0.9
+ 1154010p -0.3
+ 1156000p -0.3
+ 1156010p 0.9
+ 1158000p 0.9
+ 1158010p -0.3
+ 1160000p -0.3
+ 1160010p 0.9
+ 1162000p 0.9
+ 1162010p -0.3
+ 1164000p -0.3
+ 1164010p 0.9
+ 1166000p 0.9
+ 1166010p -0.3
+ 1168000p -0.3
+ 1168010p 0.9
+ 1170000p 0.9
+ 1170010p -0.3
+ 1172000p -0.3
+ 1172010p 0.9
+ 1174000p 0.9
+ 1174010p -0.3
+ 1176000p -0.3
+ 1176010p 0.9
+ 1178000p 0.9
+ 1178010p -0.3
+ 1180000p -0.3
+ 1180010p 0.9
+ 1182000p 0.9
+ 1182010p -0.3
+ 1184000p -0.3
+ 1184010p 0.9
+ 1186000p 0.9
+ 1186010p -0.3
+ 1188000p -0.3
+ 1188010p 0.9
+ 1190000p 0.9
+ 1190010p -0.3
+ 1192000p -0.3
+ 1192010p 0.9
+ 1194000p 0.9
+ 1194010p -0.3
+ 1196000p -0.3
+ 1196010p 0.9
+ 1198000p 0.9
+ 1198010p -0.3
+ 1200000p -0.3
+ 1200010p 0.9
+ 1202000p 0.9
+ 1202010p -0.3
+ 1204000p -0.3
+ 1204010p 0.9
+ 1206000p 0.9
+ 1206010p -0.3
+ 1208000p -0.3
+ 1208010p 0.9
+ 1210000p 0.9
+ 1210010p -0.3
+ 1212000p -0.3
+ 1212010p 0.9
+ 1214000p 0.9
+ 1214010p -0.3
+ 1216000p -0.3
+ 1216010p 0.9
+ 1218000p 0.9
+ 1218010p -0.3
+ 1220000p -0.3
+ 1220010p 0.9
+ 1222000p 0.9
+ 1222010p -0.3
+ 1224000p -0.3
+ 1224010p 0.9
+ 1226000p 0.9
+ 1226010p -0.3
+ 1228000p -0.3
+ 1228010p 0.9
+ 1230000p 0.9
+ 1230010p -0.3
+ 1232000p -0.3
+ 1232010p 0.9
+ 1234000p 0.9
+ 1234010p -0.3
+ 1236000p -0.3
+ 1236010p 0.9
+ 1238000p 0.9
+ 1238010p -0.3
+ 1240000p -0.3
+ 1240010p 0.9
+ 1242000p 0.9
+ 1242010p -0.3
+ 1244000p -0.3
+ 1244010p 0.9
+ 1246000p 0.9
+ 1246010p -0.3
+ 1248000p -0.3
+ 1248010p 0.9
+ 1250000p 0.9
+ 1250010p -0.3
+ 1252000p -0.3
+ 1252010p 0.9
+ 1254000p 0.9
+ 1254010p -0.3
+ 1256000p -0.3
+ 1256010p 0.9
+ 1258000p 0.9
+ 1258010p -0.3
+ 1260000p -0.3
+ 1260010p 0.9
+ 1262000p 0.9
+ 1262010p -0.3
+ 1264000p -0.3
+ 1264010p 0.9
+ 1266000p 0.9
+ 1266010p -0.3
+ 1268000p -0.3
+ 1268010p 0.9
+ 1270000p 0.9
+ 1270010p -0.3
+ 1272000p -0.3
+ 1272010p 0.9
+ 1274000p 0.9
+ 1274010p -0.3
+ 1276000p -0.3
+ 1276010p 0.9
+ 1278000p 0.9
+ 1278010p -0.3
+ 1280000p -0.3
+ 1280010p 0.9
+ 1282000p 0.9
+ 1282010p -0.3
+ 1284000p -0.3
+ 1284010p 0.9
+ 1286000p 0.9
+ 1286010p -0.3
+ 1288000p -0.3
+ 1288010p 0.9
+ 1290000p 0.9
+ 1290010p -0.3
+ 1292000p -0.3
+ 1292010p 0.9
+ 1294000p 0.9
+ 1294010p -0.3
+ 1296000p -0.3
+ 1296010p 0.9
+ 1298000p 0.9
+ 1298010p -0.3
+ 1300000p -0.3
+ 1300010p 0.9
+ 1302000p 0.9
+ 1302010p -0.3
+ 1304000p -0.3
+ 1304010p 0.9
+ 1306000p 0.9
+ 1306010p -0.3
+ 1308000p -0.3
+ 1308010p 0.9
+ 1310000p 0.9
+ 1310010p -0.3
+ 1312000p -0.3
+ 1312010p 0.9
+ 1314000p 0.9
+ 1314010p -0.3
+ 1316000p -0.3
+ 1316010p 0.9
+ 1318000p 0.9
+ 1318010p -0.3
+ 1320000p -0.3
+ 1320010p 0.9
+ 1322000p 0.9
+ 1322010p -0.3
+ 1324000p -0.3
+ 1324010p 0.9
+ 1326000p 0.9
+ 1326010p -0.3
+ 1328000p -0.3
+ 1328010p 0.9
+ 1330000p 0.9
+ 1330010p -0.3
+ 1332000p -0.3
+ 1332010p 0.9
+ 1334000p 0.9
+ 1334010p -0.3
+ 1336000p -0.3
+ 1336010p 0.9
+ 1338000p 0.9
+ 1338010p -0.3
+ 1340000p -0.3
+ 1340010p 0.9
+ 1342000p 0.9
+ 1342010p -0.3
+ 1344000p -0.3
+ 1344010p 0.9
+ 1346000p 0.9
+ 1346010p -0.3
+ 1348000p -0.3
+ 1348010p 0.9
+ 1350000p 0.9
+ 1350010p -0.3
+ 1352000p -0.3
+ 1352010p 0.9
+ 1354000p 0.9
+ 1354010p -0.3
+ 1356000p -0.3
+ 1356010p 0.9
+ 1358000p 0.9
+ 1358010p -0.3
+ 1360000p -0.3
+ 1360010p 0.9
+ 1362000p 0.9
+ 1362010p -0.3
+ 1364000p -0.3
+ 1364010p 0.9
+ 1366000p 0.9
+ 1366010p -0.3
+ 1368000p -0.3
+ 1368010p 0.9
+ 1370000p 0.9
+ 1370010p -0.3
+ 1372000p -0.3
+ 1372010p 0.9
+ 1374000p 0.9
+ 1374010p -0.3
+ 1376000p -0.3
+ 1376010p 0.9
+ 1378000p 0.9
+ 1378010p -0.3
+ 1380000p -0.3
+ 1380010p 0.9
+ 1382000p 0.9
+ 1382010p -0.3
+ 1384000p -0.3
+ 1384010p 0.9
+ 1386000p 0.9
+ 1386010p -0.3
+ 1388000p -0.3
+ 1388010p 0.9
+ 1390000p 0.9
+ 1390010p -0.3
+ 1392000p -0.3
+ 1392010p 0.9
+ 1394000p 0.9
+ 1394010p -0.3
+ 1396000p -0.3
+ 1396010p 0.9
+ 1398000p 0.9
+ 1398010p -0.3
+ 1400000p -0.3
+ 1400010p 0.9
+ 1402000p 0.9
+ 1402010p -0.3
+ 1404000p -0.3
+ 1404010p 0.9
+ 1406000p 0.9
+ 1406010p -0.3
+ 1408000p -0.3
+ 1408010p 0.9
+ 1410000p 0.9
+ 1410010p -0.3
+ 1412000p -0.3
+ 1412010p 0.9
+ 1414000p 0.9
+ 1414010p -0.3
+ 1416000p -0.3
+ 1416010p 0.9
+ 1418000p 0.9
+ 1418010p -0.3
+ 1420000p -0.3
+ 1420010p 0.9
+ 1422000p 0.9
+ 1422010p -0.3
+ 1424000p -0.3
+ 1424010p 0.9
+ 1426000p 0.9
+ 1426010p -0.3
+ 1428000p -0.3
+ 1428010p 0.9
+ 1430000p 0.9
+ 1430010p -0.3
+ 1432000p -0.3
+ 1432010p 0.9
+ 1434000p 0.9
+ 1434010p -0.3
+ 1436000p -0.3
+ 1436010p 0.9
+ 1438000p 0.9
+ 1438010p -0.3
+ 1440000p -0.3
+ 1440010p 0.9
+ 1442000p 0.9
+ 1442010p -0.3
+ 1444000p -0.3
+ 1444010p 0.9
+ 1446000p 0.9
+ 1446010p -0.3
+ 1448000p -0.3
+ 1448010p 0.9
+ 1450000p 0.9
+ 1450010p -0.3
+ 1452000p -0.3
+ 1452010p 0.9
+ 1454000p 0.9
+ 1454010p -0.3
+ 1456000p -0.3
+ 1456010p 0.9
+ 1458000p 0.9
+ 1458010p -0.3
+ 1460000p -0.3
+ 1460010p 0.9
+ 1462000p 0.9
+ 1462010p -0.3
+ 1464000p -0.3
+ 1464010p 0.9
+ 1466000p 0.9
+ 1466010p -0.3
+ 1468000p -0.3
+ 1468010p 0.9
+ 1470000p 0.9
+ 1470010p -0.3
+ 1472000p -0.3
+ 1472010p 0.9
+ 1474000p 0.9
+ 1474010p -0.3
+ 1476000p -0.3
+ 1476010p 0.9
+ 1478000p 0.9
+ 1478010p -0.3
+ 1480000p -0.3
+ 1480010p 0.9
+ 1482000p 0.9
+ 1482010p -0.3
+ 1484000p -0.3
+ 1484010p 0.9
+ 1486000p 0.9
+ 1486010p -0.3
+ 1488000p -0.3
+ 1488010p 0.9
+ 1490000p 0.9
+ 1490010p -0.3
+ 1492000p -0.3
+ 1492010p 0.9
+ 1494000p 0.9
+ 1494010p -0.3
+ 1496000p -0.3
+ 1496010p 0.9
+ 1498000p 0.9
+ 1498010p -0.3
+ 1500000p -0.3
+ 1500010p 0.9
+ 1502000p 0.9
+ 1502010p -0.3
+ 1504000p -0.3
+ 1504010p 0.9
+ 1506000p 0.9
+ 1506010p -0.3
+ 1508000p -0.3
+ 1508010p 0.9
+ 1510000p 0.9
+ 1510010p -0.3
+ 1512000p -0.3
+ 1512010p 0.9
+ 1514000p 0.9
+ 1514010p -0.3
+ 1516000p -0.3
+ 1516010p 0.9
+ 1518000p 0.9
+ 1518010p -0.3
+ 1520000p -0.3
+ 1520010p 0.9
+ 1522000p 0.9
+ 1522010p -0.3
+ 1524000p -0.3
+ 1524010p 0.9
+ 1526000p 0.9
+ 1526010p -0.3
+ 1528000p -0.3
+ 1528010p 0.9
+ 1530000p 0.9
+ 1530010p -0.3
+ 1532000p -0.3
+ 1532010p 0.9
+ 1534000p 0.9
+ 1534010p -0.3
+ 1536000p -0.3
+ 1536010p 0.9
+ 1538000p 0.9
+ 1538010p -0.3
+ 1540000p -0.3
+ 1540010p 0.9
+ 1542000p 0.9
+ 1542010p -0.3
+ 1544000p -0.3
+ 1544010p 0.9
+ 1546000p 0.9
+ 1546010p -0.3
+ 1548000p -0.3
+ 1548010p 0.9
+ 1550000p 0.9
+ 1550010p -0.3
+ 1552000p -0.3
+ 1552010p 0.9
+ 1554000p 0.9
+ 1554010p -0.3
+ 1556000p -0.3
+ 1556010p 0.9
+ 1558000p 0.9
+ 1558010p -0.3
+ 1560000p -0.3
+ 1560010p 0.9
+ 1562000p 0.9
+ 1562010p -0.3
+ 1564000p -0.3
+ 1564010p 0.9
+ 1566000p 0.9
+ 1566010p -0.3
+ 1568000p -0.3
+ 1568010p 0.9
+ 1570000p 0.9
+ 1570010p -0.3
+ 1572000p -0.3
+ 1572010p 0.9
+ 1574000p 0.9
+ 1574010p -0.3
+ 1576000p -0.3
+ 1576010p 0.9
+ 1578000p 0.9
+ 1578010p -0.3
+ 1580000p -0.3
+ 1580010p 0.9
+ 1582000p 0.9
+ 1582010p -0.3
+ 1584000p -0.3
+ 1584010p 0.9
+ 1586000p 0.9
+ 1586010p -0.3
+ 1588000p -0.3
+ 1588010p 0.9
+ 1590000p 0.9
+ 1590010p -0.3
+ 1592000p -0.3
+ 1592010p 0.9
+ 1594000p 0.9
+ 1594010p -0.3
+ 1596000p -0.3
+ 1596010p 0.9
+ 1598000p 0.9
+ 1598010p -0.3
+ 1600000p -0.3
+ 1600010p 0.9
+ 1602000p 0.9
+ 1602010p -0.3
+ 1604000p -0.3
+ 1604010p 0.9
+ 1606000p 0.9
+ 1606010p -0.3
+ 1608000p -0.3
+ 1608010p 0.9
+ 1610000p 0.9
+ 1610010p -0.3
+ 1612000p -0.3
+ 1612010p 0.9
+ 1614000p 0.9
+ 1614010p -0.3
+ 1616000p -0.3
+ 1616010p 0.9
+ 1618000p 0.9
+ 1618010p -0.3
+ 1620000p -0.3
+ 1620010p 0.9
+ 1622000p 0.9
+ 1622010p -0.3
+ 1624000p -0.3
+ 1624010p 0.9
+ 1626000p 0.9
+ 1626010p -0.3
+ 1628000p -0.3
+ 1628010p 0.9
+ 1630000p 0.9
+ 1630010p -0.3
+ 1632000p -0.3
+ 1632010p 0.9
+ 1634000p 0.9
+ 1634010p -0.3
+ 1636000p -0.3
+ 1636010p 0.9
+ 1638000p 0.9
+ 1638010p -0.3
+ 1640000p -0.3
+ 1640010p 0.9
+ 1642000p 0.9
+ 1642010p -0.3
+ 1644000p -0.3
+ 1644010p 0.9
+ 1646000p 0.9
+ 1646010p -0.3
+ 1648000p -0.3
+ 1648010p 0.9
+ 1650000p 0.9
+ 1650010p -0.3
+ 1652000p -0.3
+ 1652010p 0.9
+ 1654000p 0.9
+ 1654010p -0.3
+ 1656000p -0.3
+ 1656010p 0.9
+ 1658000p 0.9
+ 1658010p -0.3
+ 1660000p -0.3
+ 1660010p 0.9
+ 1662000p 0.9
+ 1662010p -0.3
+ 1664000p -0.3
+ 1664010p 0.9
+ 1666000p 0.9
+ 1666010p -0.3
+ 1668000p -0.3
+ 1668010p 0.9
+ 1670000p 0.9
+ 1670010p -0.3
+ 1672000p -0.3
+ 1672010p 0.9
+ 1674000p 0.9
+ 1674010p -0.3
+ 1676000p -0.3
+ 1676010p 0.9
+ 1678000p 0.9
+ 1678010p -0.3
+ 1680000p -0.3
+ 1680010p 0.9
+ 1682000p 0.9
+ 1682010p -0.3
+ 1684000p -0.3
+ 1684010p 0.9
+ 1686000p 0.9
+ 1686010p -0.3
+ 1688000p -0.3
+ 1688010p 0.9
+ 1690000p 0.9
+ 1690010p -0.3
+ 1692000p -0.3
+ 1692010p 0.9
+ 1694000p 0.9
+ 1694010p -0.3
+ 1696000p -0.3
+ 1696010p 0.9
+ 1698000p 0.9
+ 1698010p -0.3
+ 1700000p -0.3
+ 1700010p 0.9
+ 1702000p 0.9
+ 1702010p -0.3
+ 1704000p -0.3
+ 1704010p 0.9
+ 1706000p 0.9
+ 1706010p -0.3
+ 1708000p -0.3
+ 1708010p 0.9
+ 1710000p 0.9
+ 1710010p -0.3
+ 1712000p -0.3
+ 1712010p 0.9
+ 1714000p 0.9
+ 1714010p -0.3
+ 1716000p -0.3
+ 1716010p 0.9
+ 1718000p 0.9
+ 1718010p -0.3
+ 1720000p -0.3
+ 1720010p 0.9
+ 1722000p 0.9
+ 1722010p -0.3
+ 1724000p -0.3
+ 1724010p 0.9
+ 1726000p 0.9
+ 1726010p -0.3
+ 1728000p -0.3
+ 1728010p 0.9
+ 1730000p 0.9
+ 1730010p -0.3
+ 1732000p -0.3
+ 1732010p 0.9
+ 1734000p 0.9
+ 1734010p -0.3
+ 1736000p -0.3
+ 1736010p 0.9
+ 1738000p 0.9
+ 1738010p -0.3
+ 1740000p -0.3
+ 1740010p 0.9
+ 1742000p 0.9
+ 1742010p -0.3
+ 1744000p -0.3
+ 1744010p 0.9
+ 1746000p 0.9
+ 1746010p -0.3
+ 1748000p -0.3
+ 1748010p 0.9
+ 1750000p 0.9
+ 1750010p -0.3
+ 1752000p -0.3
+ 1752010p 0.9
+ 1754000p 0.9
+ 1754010p -0.3
+ 1756000p -0.3
+ 1756010p 0.9
+ 1758000p 0.9
+ 1758010p -0.3
+ 1760000p -0.3
+ 1760010p 0.9
+ 1762000p 0.9
+ 1762010p -0.3
+ 1764000p -0.3
+ 1764010p 0.9
+ 1766000p 0.9
+ 1766010p -0.3
+ 1768000p -0.3
+ 1768010p 0.9
+ 1770000p 0.9
+ 1770010p -0.3
+ 1772000p -0.3
+ 1772010p 0.9
+ 1774000p 0.9
+ 1774010p -0.3
+ 1776000p -0.3
+ 1776010p 0.9
+ 1778000p 0.9
+ 1778010p -0.3
+ 1780000p -0.3
+ 1780010p 0.9
+ 1782000p 0.9
+ 1782010p -0.3
+ 1784000p -0.3
+ 1784010p 0.9
+ 1786000p 0.9
+ 1786010p -0.3
+ 1788000p -0.3
+ 1788010p 0.9
+ 1790000p 0.9
+ 1790010p -0.3
+ 1792000p -0.3
+ 1792010p 0.9
+ 1794000p 0.9
+ 1794010p -0.3
+ 1796000p -0.3
+ 1796010p 0.9
+ 1798000p 0.9
+ 1798010p -0.3
+ 1800000p -0.3
+ 1800010p 0.9
+ 1802000p 0.9
+ 1802010p -0.3
+ 1804000p -0.3
+ 1804010p 0.9
+ 1806000p 0.9
+ 1806010p -0.3
+ 1808000p -0.3
+ 1808010p 0.9
+ 1810000p 0.9
+ 1810010p -0.3
+ 1812000p -0.3
+ 1812010p 0.9
+ 1814000p 0.9
+ 1814010p -0.3
+ 1816000p -0.3
+ 1816010p 0.9
+ 1818000p 0.9
+ 1818010p -0.3
+ 1820000p -0.3
+ 1820010p 0.9
+ 1822000p 0.9
+ 1822010p -0.3
+ 1824000p -0.3
+ 1824010p 0.9
+ 1826000p 0.9
+ 1826010p -0.3
+ 1828000p -0.3
+ 1828010p 0.9
+ 1830000p 0.9
+ 1830010p -0.3
+ 1832000p -0.3
+ 1832010p 0.9
+ 1834000p 0.9
+ 1834010p -0.3
+ 1836000p -0.3
+ 1836010p 0.9
+ 1838000p 0.9
+ 1838010p -0.3
+ 1840000p -0.3
+ 1840010p 0.9
+ 1842000p 0.9
+ 1842010p -0.3
+ 1844000p -0.3
+ 1844010p 0.9
+ 1846000p 0.9
+ 1846010p -0.3
+ 1848000p -0.3
+ 1848010p 0.9
+ 1850000p 0.9
+ 1850010p -0.3
+ 1852000p -0.3
+ 1852010p 0.9
+ 1854000p 0.9
+ 1854010p -0.3
+ 1856000p -0.3
+ 1856010p 0.9
+ 1858000p 0.9
+ 1858010p -0.3
+ 1860000p -0.3
+ 1860010p 0.9
+ 1862000p 0.9
+ 1862010p -0.3
+ 1864000p -0.3
+ 1864010p 0.9
+ 1866000p 0.9
+ 1866010p -0.3
+ 1868000p -0.3
+ 1868010p 0.9
+ 1870000p 0.9
+ 1870010p -0.3
+ 1872000p -0.3
+ 1872010p 0.9
+ 1874000p 0.9
+ 1874010p -0.3
+ 1876000p -0.3
+ 1876010p 0.9
+ 1878000p 0.9
+ 1878010p -0.3
+ 1880000p -0.3
+ 1880010p 0.9
+ 1882000p 0.9
+ 1882010p -0.3
+ 1884000p -0.3
+ 1884010p 0.9
+ 1886000p 0.9
+ 1886010p -0.3
+ 1888000p -0.3
+ 1888010p 0.9
+ 1890000p 0.9
+ 1890010p -0.3
+ 1892000p -0.3
+ 1892010p 0.9
+ 1894000p 0.9
+ 1894010p -0.3
+ 1896000p -0.3
+ 1896010p 0.9
+ 1898000p 0.9
+ 1898010p -0.3
+ 1900000p -0.3
+ 1900010p 0.9
+ 1902000p 0.9
+ 1902010p -0.3
+ 1904000p -0.3
+ 1904010p 0.9
+ 1906000p 0.9
+ 1906010p -0.3
+ 1908000p -0.3
+ 1908010p 0.9
+ 1910000p 0.9
+ 1910010p -0.3
+ 1912000p -0.3
+ 1912010p 0.9
+ 1914000p 0.9
+ 1914010p -0.3
+ 1916000p -0.3
+ 1916010p 0.9
+ 1918000p 0.9
+ 1918010p -0.3
+ 1920000p -0.3
+ 1920010p 0.9
+ 1922000p 0.9
+ 1922010p -0.3
+ 1924000p -0.3
+ 1924010p 0.9
+ 1926000p 0.9
+ 1926010p -0.3
+ 1928000p -0.3
+ 1928010p 0.9
+ 1930000p 0.9
+ 1930010p -0.3
+ 1932000p -0.3
+ 1932010p 0.9
+ 1934000p 0.9
+ 1934010p -0.3
+ 1936000p -0.3
+ 1936010p 0.9
+ 1938000p 0.9
+ 1938010p -0.3
+ 1940000p -0.3
+ 1940010p 0.9
+ 1942000p 0.9
+ 1942010p -0.3
+ 1944000p -0.3
+ 1944010p 0.9
+ 1946000p 0.9
+ 1946010p -0.3
+ 1948000p -0.3
+ 1948010p 0.9
+ 1950000p 0.9
+ 1950010p -0.3
+ 1952000p -0.3
+ 1952010p 0.9
+ 1954000p 0.9
+ 1954010p -0.3
+ 1956000p -0.3
+ 1956010p 0.9
+ 1958000p 0.9
+ 1958010p -0.3
+ 1960000p -0.3
+ 1960010p 0.9
+ 1962000p 0.9
+ 1962010p -0.3
+ 1964000p -0.3
+ 1964010p 0.9
+ 1966000p 0.9
+ 1966010p -0.3
+ 1968000p -0.3
+ 1968010p 0.9
+ 1970000p 0.9
+ 1970010p -0.3
+ 1972000p -0.3
+ 1972010p 0.9
+ 1974000p 0.9
+ 1974010p -0.3
+ 1976000p -0.3
+ 1976010p 0.9
+ 1978000p 0.9
+ 1978010p -0.3
+ 1980000p -0.3
+ 1980010p 0.9
+ 1982000p 0.9
+ 1982010p -0.3
+ 1984000p -0.3
+ 1984010p 0.9
+ 1986000p 0.9
+ 1986010p -0.3
+ 1988000p -0.3
+ 1988010p 0.9
+ 1990000p 0.9
+ 1990010p -0.3
+ 1992000p -0.3
+ 1992010p 0.9
+ 1994000p 0.9
+ 1994010p -0.3
+ 1996000p -0.3
+ 1996010p 0.9
+ 1998000p 0.9
+ 1998010p -0.3
+ 2000000p -0.3
+ 2000010p 0.9
+ 2002000p 0.9
+ 2002010p -0.3
+ 2004000p -0.3
+ 2004010p 0.9
+ 2006000p 0.9
+ 2006010p -0.3
+ 2008000p -0.3
+ 2008010p 0.9
+ 2010000p 0.9
+ 2010010p -0.3
+ 2012000p -0.3
+ 2012010p 0.9
+ 2014000p 0.9
+ 2014010p -0.3
+ 2016000p -0.3
+ 2016010p 0.9
+ 2018000p 0.9
+ 2018010p -0.3
+ 2020000p -0.3
+ 2020010p 0.9
+ 2022000p 0.9
+ 2022010p -0.3
+ 2024000p -0.3
+ 2024010p 0.9
+ 2026000p 0.9
+ 2026010p -0.3
+ 2028000p -0.3
+ 2028010p 0.9
+ 2030000p 0.9
+ 2030010p -0.3
+ 2032000p -0.3
+ 2032010p 0.9
+ 2034000p 0.9
+ 2034010p -0.3
+ 2036000p -0.3
+ 2036010p 0.9
+ 2038000p 0.9
+ 2038010p -0.3
+ 2040000p -0.3
+ 2040010p 0.9
+ 2042000p 0.9
+ 2042010p -0.3
+ 2044000p -0.3
+ 2044010p 0.9
+ 2046000p 0.9
+ 2046010p -0.3
+ 2048000p -0.3
+ 2048010p 0.9
+ \]
V_data_bar_26 (Data_bar\\<26\\> gnd!) vsource type=pwl wave=\[
+ 0    -0.3
+ 2000p -0.3
+ 2010p 0.9
+ 4000p 0.9
+ 4010p -0.3
+ 6000p -0.3
+ 6010p 0.9
+ 8000p 0.9
+ 8010p -0.3
+ 10000p -0.3
+ 10010p 0.9
+ 12000p 0.9
+ 12010p -0.3
+ 14000p -0.3
+ 14010p 0.9
+ 16000p 0.9
+ 16010p -0.3
+ 18000p -0.3
+ 18010p 0.9
+ 20000p 0.9
+ 20010p -0.3
+ 22000p -0.3
+ 22010p 0.9
+ 24000p 0.9
+ 24010p -0.3
+ 26000p -0.3
+ 26010p 0.9
+ 28000p 0.9
+ 28010p -0.3
+ 30000p -0.3
+ 30010p 0.9
+ 32000p 0.9
+ 32010p -0.3
+ 34000p -0.3
+ 34010p 0.9
+ 36000p 0.9
+ 36010p -0.3
+ 38000p -0.3
+ 38010p 0.9
+ 40000p 0.9
+ 40010p -0.3
+ 42000p -0.3
+ 42010p 0.9
+ 44000p 0.9
+ 44010p -0.3
+ 46000p -0.3
+ 46010p 0.9
+ 48000p 0.9
+ 48010p -0.3
+ 50000p -0.3
+ 50010p 0.9
+ 52000p 0.9
+ 52010p -0.3
+ 54000p -0.3
+ 54010p 0.9
+ 56000p 0.9
+ 56010p -0.3
+ 58000p -0.3
+ 58010p 0.9
+ 60000p 0.9
+ 60010p -0.3
+ 62000p -0.3
+ 62010p 0.9
+ 64000p 0.9
+ 64010p -0.3
+ 66000p -0.3
+ 66010p 0.9
+ 68000p 0.9
+ 68010p -0.3
+ 70000p -0.3
+ 70010p 0.9
+ 72000p 0.9
+ 72010p -0.3
+ 74000p -0.3
+ 74010p 0.9
+ 76000p 0.9
+ 76010p -0.3
+ 78000p -0.3
+ 78010p 0.9
+ 80000p 0.9
+ 80010p -0.3
+ 82000p -0.3
+ 82010p 0.9
+ 84000p 0.9
+ 84010p -0.3
+ 86000p -0.3
+ 86010p 0.9
+ 88000p 0.9
+ 88010p -0.3
+ 90000p -0.3
+ 90010p 0.9
+ 92000p 0.9
+ 92010p -0.3
+ 94000p -0.3
+ 94010p 0.9
+ 96000p 0.9
+ 96010p -0.3
+ 98000p -0.3
+ 98010p 0.9
+ 100000p 0.9
+ 100010p -0.3
+ 102000p -0.3
+ 102010p 0.9
+ 104000p 0.9
+ 104010p -0.3
+ 106000p -0.3
+ 106010p 0.9
+ 108000p 0.9
+ 108010p -0.3
+ 110000p -0.3
+ 110010p 0.9
+ 112000p 0.9
+ 112010p -0.3
+ 114000p -0.3
+ 114010p 0.9
+ 116000p 0.9
+ 116010p -0.3
+ 118000p -0.3
+ 118010p 0.9
+ 120000p 0.9
+ 120010p -0.3
+ 122000p -0.3
+ 122010p 0.9
+ 124000p 0.9
+ 124010p -0.3
+ 126000p -0.3
+ 126010p 0.9
+ 128000p 0.9
+ 128010p -0.3
+ 130000p -0.3
+ 130010p 0.9
+ 132000p 0.9
+ 132010p -0.3
+ 134000p -0.3
+ 134010p 0.9
+ 136000p 0.9
+ 136010p -0.3
+ 138000p -0.3
+ 138010p 0.9
+ 140000p 0.9
+ 140010p -0.3
+ 142000p -0.3
+ 142010p 0.9
+ 144000p 0.9
+ 144010p -0.3
+ 146000p -0.3
+ 146010p 0.9
+ 148000p 0.9
+ 148010p -0.3
+ 150000p -0.3
+ 150010p 0.9
+ 152000p 0.9
+ 152010p -0.3
+ 154000p -0.3
+ 154010p 0.9
+ 156000p 0.9
+ 156010p -0.3
+ 158000p -0.3
+ 158010p 0.9
+ 160000p 0.9
+ 160010p -0.3
+ 162000p -0.3
+ 162010p 0.9
+ 164000p 0.9
+ 164010p -0.3
+ 166000p -0.3
+ 166010p 0.9
+ 168000p 0.9
+ 168010p -0.3
+ 170000p -0.3
+ 170010p 0.9
+ 172000p 0.9
+ 172010p -0.3
+ 174000p -0.3
+ 174010p 0.9
+ 176000p 0.9
+ 176010p -0.3
+ 178000p -0.3
+ 178010p 0.9
+ 180000p 0.9
+ 180010p -0.3
+ 182000p -0.3
+ 182010p 0.9
+ 184000p 0.9
+ 184010p -0.3
+ 186000p -0.3
+ 186010p 0.9
+ 188000p 0.9
+ 188010p -0.3
+ 190000p -0.3
+ 190010p 0.9
+ 192000p 0.9
+ 192010p -0.3
+ 194000p -0.3
+ 194010p 0.9
+ 196000p 0.9
+ 196010p -0.3
+ 198000p -0.3
+ 198010p 0.9
+ 200000p 0.9
+ 200010p -0.3
+ 202000p -0.3
+ 202010p 0.9
+ 204000p 0.9
+ 204010p -0.3
+ 206000p -0.3
+ 206010p 0.9
+ 208000p 0.9
+ 208010p -0.3
+ 210000p -0.3
+ 210010p 0.9
+ 212000p 0.9
+ 212010p -0.3
+ 214000p -0.3
+ 214010p 0.9
+ 216000p 0.9
+ 216010p -0.3
+ 218000p -0.3
+ 218010p 0.9
+ 220000p 0.9
+ 220010p -0.3
+ 222000p -0.3
+ 222010p 0.9
+ 224000p 0.9
+ 224010p -0.3
+ 226000p -0.3
+ 226010p 0.9
+ 228000p 0.9
+ 228010p -0.3
+ 230000p -0.3
+ 230010p 0.9
+ 232000p 0.9
+ 232010p -0.3
+ 234000p -0.3
+ 234010p 0.9
+ 236000p 0.9
+ 236010p -0.3
+ 238000p -0.3
+ 238010p 0.9
+ 240000p 0.9
+ 240010p -0.3
+ 242000p -0.3
+ 242010p 0.9
+ 244000p 0.9
+ 244010p -0.3
+ 246000p -0.3
+ 246010p 0.9
+ 248000p 0.9
+ 248010p -0.3
+ 250000p -0.3
+ 250010p 0.9
+ 252000p 0.9
+ 252010p -0.3
+ 254000p -0.3
+ 254010p 0.9
+ 256000p 0.9
+ 256010p -0.3
+ 258000p -0.3
+ 258010p 0.9
+ 260000p 0.9
+ 260010p -0.3
+ 262000p -0.3
+ 262010p 0.9
+ 264000p 0.9
+ 264010p -0.3
+ 266000p -0.3
+ 266010p 0.9
+ 268000p 0.9
+ 268010p -0.3
+ 270000p -0.3
+ 270010p 0.9
+ 272000p 0.9
+ 272010p -0.3
+ 274000p -0.3
+ 274010p 0.9
+ 276000p 0.9
+ 276010p -0.3
+ 278000p -0.3
+ 278010p 0.9
+ 280000p 0.9
+ 280010p -0.3
+ 282000p -0.3
+ 282010p 0.9
+ 284000p 0.9
+ 284010p -0.3
+ 286000p -0.3
+ 286010p 0.9
+ 288000p 0.9
+ 288010p -0.3
+ 290000p -0.3
+ 290010p 0.9
+ 292000p 0.9
+ 292010p -0.3
+ 294000p -0.3
+ 294010p 0.9
+ 296000p 0.9
+ 296010p -0.3
+ 298000p -0.3
+ 298010p 0.9
+ 300000p 0.9
+ 300010p -0.3
+ 302000p -0.3
+ 302010p 0.9
+ 304000p 0.9
+ 304010p -0.3
+ 306000p -0.3
+ 306010p 0.9
+ 308000p 0.9
+ 308010p -0.3
+ 310000p -0.3
+ 310010p 0.9
+ 312000p 0.9
+ 312010p -0.3
+ 314000p -0.3
+ 314010p 0.9
+ 316000p 0.9
+ 316010p -0.3
+ 318000p -0.3
+ 318010p 0.9
+ 320000p 0.9
+ 320010p -0.3
+ 322000p -0.3
+ 322010p 0.9
+ 324000p 0.9
+ 324010p -0.3
+ 326000p -0.3
+ 326010p 0.9
+ 328000p 0.9
+ 328010p -0.3
+ 330000p -0.3
+ 330010p 0.9
+ 332000p 0.9
+ 332010p -0.3
+ 334000p -0.3
+ 334010p 0.9
+ 336000p 0.9
+ 336010p -0.3
+ 338000p -0.3
+ 338010p 0.9
+ 340000p 0.9
+ 340010p -0.3
+ 342000p -0.3
+ 342010p 0.9
+ 344000p 0.9
+ 344010p -0.3
+ 346000p -0.3
+ 346010p 0.9
+ 348000p 0.9
+ 348010p -0.3
+ 350000p -0.3
+ 350010p 0.9
+ 352000p 0.9
+ 352010p -0.3
+ 354000p -0.3
+ 354010p 0.9
+ 356000p 0.9
+ 356010p -0.3
+ 358000p -0.3
+ 358010p 0.9
+ 360000p 0.9
+ 360010p -0.3
+ 362000p -0.3
+ 362010p 0.9
+ 364000p 0.9
+ 364010p -0.3
+ 366000p -0.3
+ 366010p 0.9
+ 368000p 0.9
+ 368010p -0.3
+ 370000p -0.3
+ 370010p 0.9
+ 372000p 0.9
+ 372010p -0.3
+ 374000p -0.3
+ 374010p 0.9
+ 376000p 0.9
+ 376010p -0.3
+ 378000p -0.3
+ 378010p 0.9
+ 380000p 0.9
+ 380010p -0.3
+ 382000p -0.3
+ 382010p 0.9
+ 384000p 0.9
+ 384010p -0.3
+ 386000p -0.3
+ 386010p 0.9
+ 388000p 0.9
+ 388010p -0.3
+ 390000p -0.3
+ 390010p 0.9
+ 392000p 0.9
+ 392010p -0.3
+ 394000p -0.3
+ 394010p 0.9
+ 396000p 0.9
+ 396010p -0.3
+ 398000p -0.3
+ 398010p 0.9
+ 400000p 0.9
+ 400010p -0.3
+ 402000p -0.3
+ 402010p 0.9
+ 404000p 0.9
+ 404010p -0.3
+ 406000p -0.3
+ 406010p 0.9
+ 408000p 0.9
+ 408010p -0.3
+ 410000p -0.3
+ 410010p 0.9
+ 412000p 0.9
+ 412010p -0.3
+ 414000p -0.3
+ 414010p 0.9
+ 416000p 0.9
+ 416010p -0.3
+ 418000p -0.3
+ 418010p 0.9
+ 420000p 0.9
+ 420010p -0.3
+ 422000p -0.3
+ 422010p 0.9
+ 424000p 0.9
+ 424010p -0.3
+ 426000p -0.3
+ 426010p 0.9
+ 428000p 0.9
+ 428010p -0.3
+ 430000p -0.3
+ 430010p 0.9
+ 432000p 0.9
+ 432010p -0.3
+ 434000p -0.3
+ 434010p 0.9
+ 436000p 0.9
+ 436010p -0.3
+ 438000p -0.3
+ 438010p 0.9
+ 440000p 0.9
+ 440010p -0.3
+ 442000p -0.3
+ 442010p 0.9
+ 444000p 0.9
+ 444010p -0.3
+ 446000p -0.3
+ 446010p 0.9
+ 448000p 0.9
+ 448010p -0.3
+ 450000p -0.3
+ 450010p 0.9
+ 452000p 0.9
+ 452010p -0.3
+ 454000p -0.3
+ 454010p 0.9
+ 456000p 0.9
+ 456010p -0.3
+ 458000p -0.3
+ 458010p 0.9
+ 460000p 0.9
+ 460010p -0.3
+ 462000p -0.3
+ 462010p 0.9
+ 464000p 0.9
+ 464010p -0.3
+ 466000p -0.3
+ 466010p 0.9
+ 468000p 0.9
+ 468010p -0.3
+ 470000p -0.3
+ 470010p 0.9
+ 472000p 0.9
+ 472010p -0.3
+ 474000p -0.3
+ 474010p 0.9
+ 476000p 0.9
+ 476010p -0.3
+ 478000p -0.3
+ 478010p 0.9
+ 480000p 0.9
+ 480010p -0.3
+ 482000p -0.3
+ 482010p 0.9
+ 484000p 0.9
+ 484010p -0.3
+ 486000p -0.3
+ 486010p 0.9
+ 488000p 0.9
+ 488010p -0.3
+ 490000p -0.3
+ 490010p 0.9
+ 492000p 0.9
+ 492010p -0.3
+ 494000p -0.3
+ 494010p 0.9
+ 496000p 0.9
+ 496010p -0.3
+ 498000p -0.3
+ 498010p 0.9
+ 500000p 0.9
+ 500010p -0.3
+ 502000p -0.3
+ 502010p 0.9
+ 504000p 0.9
+ 504010p -0.3
+ 506000p -0.3
+ 506010p 0.9
+ 508000p 0.9
+ 508010p -0.3
+ 510000p -0.3
+ 510010p 0.9
+ 512000p 0.9
+ 512010p -0.3
+ 514000p -0.3
+ 514010p 0.9
+ 516000p 0.9
+ 516010p -0.3
+ 518000p -0.3
+ 518010p 0.9
+ 520000p 0.9
+ 520010p -0.3
+ 522000p -0.3
+ 522010p 0.9
+ 524000p 0.9
+ 524010p -0.3
+ 526000p -0.3
+ 526010p 0.9
+ 528000p 0.9
+ 528010p -0.3
+ 530000p -0.3
+ 530010p 0.9
+ 532000p 0.9
+ 532010p -0.3
+ 534000p -0.3
+ 534010p 0.9
+ 536000p 0.9
+ 536010p -0.3
+ 538000p -0.3
+ 538010p 0.9
+ 540000p 0.9
+ 540010p -0.3
+ 542000p -0.3
+ 542010p 0.9
+ 544000p 0.9
+ 544010p -0.3
+ 546000p -0.3
+ 546010p 0.9
+ 548000p 0.9
+ 548010p -0.3
+ 550000p -0.3
+ 550010p 0.9
+ 552000p 0.9
+ 552010p -0.3
+ 554000p -0.3
+ 554010p 0.9
+ 556000p 0.9
+ 556010p -0.3
+ 558000p -0.3
+ 558010p 0.9
+ 560000p 0.9
+ 560010p -0.3
+ 562000p -0.3
+ 562010p 0.9
+ 564000p 0.9
+ 564010p -0.3
+ 566000p -0.3
+ 566010p 0.9
+ 568000p 0.9
+ 568010p -0.3
+ 570000p -0.3
+ 570010p 0.9
+ 572000p 0.9
+ 572010p -0.3
+ 574000p -0.3
+ 574010p 0.9
+ 576000p 0.9
+ 576010p -0.3
+ 578000p -0.3
+ 578010p 0.9
+ 580000p 0.9
+ 580010p -0.3
+ 582000p -0.3
+ 582010p 0.9
+ 584000p 0.9
+ 584010p -0.3
+ 586000p -0.3
+ 586010p 0.9
+ 588000p 0.9
+ 588010p -0.3
+ 590000p -0.3
+ 590010p 0.9
+ 592000p 0.9
+ 592010p -0.3
+ 594000p -0.3
+ 594010p 0.9
+ 596000p 0.9
+ 596010p -0.3
+ 598000p -0.3
+ 598010p 0.9
+ 600000p 0.9
+ 600010p -0.3
+ 602000p -0.3
+ 602010p 0.9
+ 604000p 0.9
+ 604010p -0.3
+ 606000p -0.3
+ 606010p 0.9
+ 608000p 0.9
+ 608010p -0.3
+ 610000p -0.3
+ 610010p 0.9
+ 612000p 0.9
+ 612010p -0.3
+ 614000p -0.3
+ 614010p 0.9
+ 616000p 0.9
+ 616010p -0.3
+ 618000p -0.3
+ 618010p 0.9
+ 620000p 0.9
+ 620010p -0.3
+ 622000p -0.3
+ 622010p 0.9
+ 624000p 0.9
+ 624010p -0.3
+ 626000p -0.3
+ 626010p 0.9
+ 628000p 0.9
+ 628010p -0.3
+ 630000p -0.3
+ 630010p 0.9
+ 632000p 0.9
+ 632010p -0.3
+ 634000p -0.3
+ 634010p 0.9
+ 636000p 0.9
+ 636010p -0.3
+ 638000p -0.3
+ 638010p 0.9
+ 640000p 0.9
+ 640010p -0.3
+ 642000p -0.3
+ 642010p 0.9
+ 644000p 0.9
+ 644010p -0.3
+ 646000p -0.3
+ 646010p 0.9
+ 648000p 0.9
+ 648010p -0.3
+ 650000p -0.3
+ 650010p 0.9
+ 652000p 0.9
+ 652010p -0.3
+ 654000p -0.3
+ 654010p 0.9
+ 656000p 0.9
+ 656010p -0.3
+ 658000p -0.3
+ 658010p 0.9
+ 660000p 0.9
+ 660010p -0.3
+ 662000p -0.3
+ 662010p 0.9
+ 664000p 0.9
+ 664010p -0.3
+ 666000p -0.3
+ 666010p 0.9
+ 668000p 0.9
+ 668010p -0.3
+ 670000p -0.3
+ 670010p 0.9
+ 672000p 0.9
+ 672010p -0.3
+ 674000p -0.3
+ 674010p 0.9
+ 676000p 0.9
+ 676010p -0.3
+ 678000p -0.3
+ 678010p 0.9
+ 680000p 0.9
+ 680010p -0.3
+ 682000p -0.3
+ 682010p 0.9
+ 684000p 0.9
+ 684010p -0.3
+ 686000p -0.3
+ 686010p 0.9
+ 688000p 0.9
+ 688010p -0.3
+ 690000p -0.3
+ 690010p 0.9
+ 692000p 0.9
+ 692010p -0.3
+ 694000p -0.3
+ 694010p 0.9
+ 696000p 0.9
+ 696010p -0.3
+ 698000p -0.3
+ 698010p 0.9
+ 700000p 0.9
+ 700010p -0.3
+ 702000p -0.3
+ 702010p 0.9
+ 704000p 0.9
+ 704010p -0.3
+ 706000p -0.3
+ 706010p 0.9
+ 708000p 0.9
+ 708010p -0.3
+ 710000p -0.3
+ 710010p 0.9
+ 712000p 0.9
+ 712010p -0.3
+ 714000p -0.3
+ 714010p 0.9
+ 716000p 0.9
+ 716010p -0.3
+ 718000p -0.3
+ 718010p 0.9
+ 720000p 0.9
+ 720010p -0.3
+ 722000p -0.3
+ 722010p 0.9
+ 724000p 0.9
+ 724010p -0.3
+ 726000p -0.3
+ 726010p 0.9
+ 728000p 0.9
+ 728010p -0.3
+ 730000p -0.3
+ 730010p 0.9
+ 732000p 0.9
+ 732010p -0.3
+ 734000p -0.3
+ 734010p 0.9
+ 736000p 0.9
+ 736010p -0.3
+ 738000p -0.3
+ 738010p 0.9
+ 740000p 0.9
+ 740010p -0.3
+ 742000p -0.3
+ 742010p 0.9
+ 744000p 0.9
+ 744010p -0.3
+ 746000p -0.3
+ 746010p 0.9
+ 748000p 0.9
+ 748010p -0.3
+ 750000p -0.3
+ 750010p 0.9
+ 752000p 0.9
+ 752010p -0.3
+ 754000p -0.3
+ 754010p 0.9
+ 756000p 0.9
+ 756010p -0.3
+ 758000p -0.3
+ 758010p 0.9
+ 760000p 0.9
+ 760010p -0.3
+ 762000p -0.3
+ 762010p 0.9
+ 764000p 0.9
+ 764010p -0.3
+ 766000p -0.3
+ 766010p 0.9
+ 768000p 0.9
+ 768010p -0.3
+ 770000p -0.3
+ 770010p 0.9
+ 772000p 0.9
+ 772010p -0.3
+ 774000p -0.3
+ 774010p 0.9
+ 776000p 0.9
+ 776010p -0.3
+ 778000p -0.3
+ 778010p 0.9
+ 780000p 0.9
+ 780010p -0.3
+ 782000p -0.3
+ 782010p 0.9
+ 784000p 0.9
+ 784010p -0.3
+ 786000p -0.3
+ 786010p 0.9
+ 788000p 0.9
+ 788010p -0.3
+ 790000p -0.3
+ 790010p 0.9
+ 792000p 0.9
+ 792010p -0.3
+ 794000p -0.3
+ 794010p 0.9
+ 796000p 0.9
+ 796010p -0.3
+ 798000p -0.3
+ 798010p 0.9
+ 800000p 0.9
+ 800010p -0.3
+ 802000p -0.3
+ 802010p 0.9
+ 804000p 0.9
+ 804010p -0.3
+ 806000p -0.3
+ 806010p 0.9
+ 808000p 0.9
+ 808010p -0.3
+ 810000p -0.3
+ 810010p 0.9
+ 812000p 0.9
+ 812010p -0.3
+ 814000p -0.3
+ 814010p 0.9
+ 816000p 0.9
+ 816010p -0.3
+ 818000p -0.3
+ 818010p 0.9
+ 820000p 0.9
+ 820010p -0.3
+ 822000p -0.3
+ 822010p 0.9
+ 824000p 0.9
+ 824010p -0.3
+ 826000p -0.3
+ 826010p 0.9
+ 828000p 0.9
+ 828010p -0.3
+ 830000p -0.3
+ 830010p 0.9
+ 832000p 0.9
+ 832010p -0.3
+ 834000p -0.3
+ 834010p 0.9
+ 836000p 0.9
+ 836010p -0.3
+ 838000p -0.3
+ 838010p 0.9
+ 840000p 0.9
+ 840010p -0.3
+ 842000p -0.3
+ 842010p 0.9
+ 844000p 0.9
+ 844010p -0.3
+ 846000p -0.3
+ 846010p 0.9
+ 848000p 0.9
+ 848010p -0.3
+ 850000p -0.3
+ 850010p 0.9
+ 852000p 0.9
+ 852010p -0.3
+ 854000p -0.3
+ 854010p 0.9
+ 856000p 0.9
+ 856010p -0.3
+ 858000p -0.3
+ 858010p 0.9
+ 860000p 0.9
+ 860010p -0.3
+ 862000p -0.3
+ 862010p 0.9
+ 864000p 0.9
+ 864010p -0.3
+ 866000p -0.3
+ 866010p 0.9
+ 868000p 0.9
+ 868010p -0.3
+ 870000p -0.3
+ 870010p 0.9
+ 872000p 0.9
+ 872010p -0.3
+ 874000p -0.3
+ 874010p 0.9
+ 876000p 0.9
+ 876010p -0.3
+ 878000p -0.3
+ 878010p 0.9
+ 880000p 0.9
+ 880010p -0.3
+ 882000p -0.3
+ 882010p 0.9
+ 884000p 0.9
+ 884010p -0.3
+ 886000p -0.3
+ 886010p 0.9
+ 888000p 0.9
+ 888010p -0.3
+ 890000p -0.3
+ 890010p 0.9
+ 892000p 0.9
+ 892010p -0.3
+ 894000p -0.3
+ 894010p 0.9
+ 896000p 0.9
+ 896010p -0.3
+ 898000p -0.3
+ 898010p 0.9
+ 900000p 0.9
+ 900010p -0.3
+ 902000p -0.3
+ 902010p 0.9
+ 904000p 0.9
+ 904010p -0.3
+ 906000p -0.3
+ 906010p 0.9
+ 908000p 0.9
+ 908010p -0.3
+ 910000p -0.3
+ 910010p 0.9
+ 912000p 0.9
+ 912010p -0.3
+ 914000p -0.3
+ 914010p 0.9
+ 916000p 0.9
+ 916010p -0.3
+ 918000p -0.3
+ 918010p 0.9
+ 920000p 0.9
+ 920010p -0.3
+ 922000p -0.3
+ 922010p 0.9
+ 924000p 0.9
+ 924010p -0.3
+ 926000p -0.3
+ 926010p 0.9
+ 928000p 0.9
+ 928010p -0.3
+ 930000p -0.3
+ 930010p 0.9
+ 932000p 0.9
+ 932010p -0.3
+ 934000p -0.3
+ 934010p 0.9
+ 936000p 0.9
+ 936010p -0.3
+ 938000p -0.3
+ 938010p 0.9
+ 940000p 0.9
+ 940010p -0.3
+ 942000p -0.3
+ 942010p 0.9
+ 944000p 0.9
+ 944010p -0.3
+ 946000p -0.3
+ 946010p 0.9
+ 948000p 0.9
+ 948010p -0.3
+ 950000p -0.3
+ 950010p 0.9
+ 952000p 0.9
+ 952010p -0.3
+ 954000p -0.3
+ 954010p 0.9
+ 956000p 0.9
+ 956010p -0.3
+ 958000p -0.3
+ 958010p 0.9
+ 960000p 0.9
+ 960010p -0.3
+ 962000p -0.3
+ 962010p 0.9
+ 964000p 0.9
+ 964010p -0.3
+ 966000p -0.3
+ 966010p 0.9
+ 968000p 0.9
+ 968010p -0.3
+ 970000p -0.3
+ 970010p 0.9
+ 972000p 0.9
+ 972010p -0.3
+ 974000p -0.3
+ 974010p 0.9
+ 976000p 0.9
+ 976010p -0.3
+ 978000p -0.3
+ 978010p 0.9
+ 980000p 0.9
+ 980010p -0.3
+ 982000p -0.3
+ 982010p 0.9
+ 984000p 0.9
+ 984010p -0.3
+ 986000p -0.3
+ 986010p 0.9
+ 988000p 0.9
+ 988010p -0.3
+ 990000p -0.3
+ 990010p 0.9
+ 992000p 0.9
+ 992010p -0.3
+ 994000p -0.3
+ 994010p 0.9
+ 996000p 0.9
+ 996010p -0.3
+ 998000p -0.3
+ 998010p 0.9
+ 1000000p 0.9
+ 1000010p -0.3
+ 1002000p -0.3
+ 1002010p 0.9
+ 1004000p 0.9
+ 1004010p -0.3
+ 1006000p -0.3
+ 1006010p 0.9
+ 1008000p 0.9
+ 1008010p -0.3
+ 1010000p -0.3
+ 1010010p 0.9
+ 1012000p 0.9
+ 1012010p -0.3
+ 1014000p -0.3
+ 1014010p 0.9
+ 1016000p 0.9
+ 1016010p -0.3
+ 1018000p -0.3
+ 1018010p 0.9
+ 1020000p 0.9
+ 1020010p -0.3
+ 1022000p -0.3
+ 1022010p 0.9
+ 1024000p 0.9
+ 1024010p -0.3
+ 1026000p -0.3
+ 1026010p 0.9
+ 1028000p 0.9
+ 1028010p -0.3
+ 1030000p -0.3
+ 1030010p 0.9
+ 1032000p 0.9
+ 1032010p -0.3
+ 1034000p -0.3
+ 1034010p 0.9
+ 1036000p 0.9
+ 1036010p -0.3
+ 1038000p -0.3
+ 1038010p 0.9
+ 1040000p 0.9
+ 1040010p -0.3
+ 1042000p -0.3
+ 1042010p 0.9
+ 1044000p 0.9
+ 1044010p -0.3
+ 1046000p -0.3
+ 1046010p 0.9
+ 1048000p 0.9
+ 1048010p -0.3
+ 1050000p -0.3
+ 1050010p 0.9
+ 1052000p 0.9
+ 1052010p -0.3
+ 1054000p -0.3
+ 1054010p 0.9
+ 1056000p 0.9
+ 1056010p -0.3
+ 1058000p -0.3
+ 1058010p 0.9
+ 1060000p 0.9
+ 1060010p -0.3
+ 1062000p -0.3
+ 1062010p 0.9
+ 1064000p 0.9
+ 1064010p -0.3
+ 1066000p -0.3
+ 1066010p 0.9
+ 1068000p 0.9
+ 1068010p -0.3
+ 1070000p -0.3
+ 1070010p 0.9
+ 1072000p 0.9
+ 1072010p -0.3
+ 1074000p -0.3
+ 1074010p 0.9
+ 1076000p 0.9
+ 1076010p -0.3
+ 1078000p -0.3
+ 1078010p 0.9
+ 1080000p 0.9
+ 1080010p -0.3
+ 1082000p -0.3
+ 1082010p 0.9
+ 1084000p 0.9
+ 1084010p -0.3
+ 1086000p -0.3
+ 1086010p 0.9
+ 1088000p 0.9
+ 1088010p -0.3
+ 1090000p -0.3
+ 1090010p 0.9
+ 1092000p 0.9
+ 1092010p -0.3
+ 1094000p -0.3
+ 1094010p 0.9
+ 1096000p 0.9
+ 1096010p -0.3
+ 1098000p -0.3
+ 1098010p 0.9
+ 1100000p 0.9
+ 1100010p -0.3
+ 1102000p -0.3
+ 1102010p 0.9
+ 1104000p 0.9
+ 1104010p -0.3
+ 1106000p -0.3
+ 1106010p 0.9
+ 1108000p 0.9
+ 1108010p -0.3
+ 1110000p -0.3
+ 1110010p 0.9
+ 1112000p 0.9
+ 1112010p -0.3
+ 1114000p -0.3
+ 1114010p 0.9
+ 1116000p 0.9
+ 1116010p -0.3
+ 1118000p -0.3
+ 1118010p 0.9
+ 1120000p 0.9
+ 1120010p -0.3
+ 1122000p -0.3
+ 1122010p 0.9
+ 1124000p 0.9
+ 1124010p -0.3
+ 1126000p -0.3
+ 1126010p 0.9
+ 1128000p 0.9
+ 1128010p -0.3
+ 1130000p -0.3
+ 1130010p 0.9
+ 1132000p 0.9
+ 1132010p -0.3
+ 1134000p -0.3
+ 1134010p 0.9
+ 1136000p 0.9
+ 1136010p -0.3
+ 1138000p -0.3
+ 1138010p 0.9
+ 1140000p 0.9
+ 1140010p -0.3
+ 1142000p -0.3
+ 1142010p 0.9
+ 1144000p 0.9
+ 1144010p -0.3
+ 1146000p -0.3
+ 1146010p 0.9
+ 1148000p 0.9
+ 1148010p -0.3
+ 1150000p -0.3
+ 1150010p 0.9
+ 1152000p 0.9
+ 1152010p -0.3
+ 1154000p -0.3
+ 1154010p 0.9
+ 1156000p 0.9
+ 1156010p -0.3
+ 1158000p -0.3
+ 1158010p 0.9
+ 1160000p 0.9
+ 1160010p -0.3
+ 1162000p -0.3
+ 1162010p 0.9
+ 1164000p 0.9
+ 1164010p -0.3
+ 1166000p -0.3
+ 1166010p 0.9
+ 1168000p 0.9
+ 1168010p -0.3
+ 1170000p -0.3
+ 1170010p 0.9
+ 1172000p 0.9
+ 1172010p -0.3
+ 1174000p -0.3
+ 1174010p 0.9
+ 1176000p 0.9
+ 1176010p -0.3
+ 1178000p -0.3
+ 1178010p 0.9
+ 1180000p 0.9
+ 1180010p -0.3
+ 1182000p -0.3
+ 1182010p 0.9
+ 1184000p 0.9
+ 1184010p -0.3
+ 1186000p -0.3
+ 1186010p 0.9
+ 1188000p 0.9
+ 1188010p -0.3
+ 1190000p -0.3
+ 1190010p 0.9
+ 1192000p 0.9
+ 1192010p -0.3
+ 1194000p -0.3
+ 1194010p 0.9
+ 1196000p 0.9
+ 1196010p -0.3
+ 1198000p -0.3
+ 1198010p 0.9
+ 1200000p 0.9
+ 1200010p -0.3
+ 1202000p -0.3
+ 1202010p 0.9
+ 1204000p 0.9
+ 1204010p -0.3
+ 1206000p -0.3
+ 1206010p 0.9
+ 1208000p 0.9
+ 1208010p -0.3
+ 1210000p -0.3
+ 1210010p 0.9
+ 1212000p 0.9
+ 1212010p -0.3
+ 1214000p -0.3
+ 1214010p 0.9
+ 1216000p 0.9
+ 1216010p -0.3
+ 1218000p -0.3
+ 1218010p 0.9
+ 1220000p 0.9
+ 1220010p -0.3
+ 1222000p -0.3
+ 1222010p 0.9
+ 1224000p 0.9
+ 1224010p -0.3
+ 1226000p -0.3
+ 1226010p 0.9
+ 1228000p 0.9
+ 1228010p -0.3
+ 1230000p -0.3
+ 1230010p 0.9
+ 1232000p 0.9
+ 1232010p -0.3
+ 1234000p -0.3
+ 1234010p 0.9
+ 1236000p 0.9
+ 1236010p -0.3
+ 1238000p -0.3
+ 1238010p 0.9
+ 1240000p 0.9
+ 1240010p -0.3
+ 1242000p -0.3
+ 1242010p 0.9
+ 1244000p 0.9
+ 1244010p -0.3
+ 1246000p -0.3
+ 1246010p 0.9
+ 1248000p 0.9
+ 1248010p -0.3
+ 1250000p -0.3
+ 1250010p 0.9
+ 1252000p 0.9
+ 1252010p -0.3
+ 1254000p -0.3
+ 1254010p 0.9
+ 1256000p 0.9
+ 1256010p -0.3
+ 1258000p -0.3
+ 1258010p 0.9
+ 1260000p 0.9
+ 1260010p -0.3
+ 1262000p -0.3
+ 1262010p 0.9
+ 1264000p 0.9
+ 1264010p -0.3
+ 1266000p -0.3
+ 1266010p 0.9
+ 1268000p 0.9
+ 1268010p -0.3
+ 1270000p -0.3
+ 1270010p 0.9
+ 1272000p 0.9
+ 1272010p -0.3
+ 1274000p -0.3
+ 1274010p 0.9
+ 1276000p 0.9
+ 1276010p -0.3
+ 1278000p -0.3
+ 1278010p 0.9
+ 1280000p 0.9
+ 1280010p -0.3
+ 1282000p -0.3
+ 1282010p 0.9
+ 1284000p 0.9
+ 1284010p -0.3
+ 1286000p -0.3
+ 1286010p 0.9
+ 1288000p 0.9
+ 1288010p -0.3
+ 1290000p -0.3
+ 1290010p 0.9
+ 1292000p 0.9
+ 1292010p -0.3
+ 1294000p -0.3
+ 1294010p 0.9
+ 1296000p 0.9
+ 1296010p -0.3
+ 1298000p -0.3
+ 1298010p 0.9
+ 1300000p 0.9
+ 1300010p -0.3
+ 1302000p -0.3
+ 1302010p 0.9
+ 1304000p 0.9
+ 1304010p -0.3
+ 1306000p -0.3
+ 1306010p 0.9
+ 1308000p 0.9
+ 1308010p -0.3
+ 1310000p -0.3
+ 1310010p 0.9
+ 1312000p 0.9
+ 1312010p -0.3
+ 1314000p -0.3
+ 1314010p 0.9
+ 1316000p 0.9
+ 1316010p -0.3
+ 1318000p -0.3
+ 1318010p 0.9
+ 1320000p 0.9
+ 1320010p -0.3
+ 1322000p -0.3
+ 1322010p 0.9
+ 1324000p 0.9
+ 1324010p -0.3
+ 1326000p -0.3
+ 1326010p 0.9
+ 1328000p 0.9
+ 1328010p -0.3
+ 1330000p -0.3
+ 1330010p 0.9
+ 1332000p 0.9
+ 1332010p -0.3
+ 1334000p -0.3
+ 1334010p 0.9
+ 1336000p 0.9
+ 1336010p -0.3
+ 1338000p -0.3
+ 1338010p 0.9
+ 1340000p 0.9
+ 1340010p -0.3
+ 1342000p -0.3
+ 1342010p 0.9
+ 1344000p 0.9
+ 1344010p -0.3
+ 1346000p -0.3
+ 1346010p 0.9
+ 1348000p 0.9
+ 1348010p -0.3
+ 1350000p -0.3
+ 1350010p 0.9
+ 1352000p 0.9
+ 1352010p -0.3
+ 1354000p -0.3
+ 1354010p 0.9
+ 1356000p 0.9
+ 1356010p -0.3
+ 1358000p -0.3
+ 1358010p 0.9
+ 1360000p 0.9
+ 1360010p -0.3
+ 1362000p -0.3
+ 1362010p 0.9
+ 1364000p 0.9
+ 1364010p -0.3
+ 1366000p -0.3
+ 1366010p 0.9
+ 1368000p 0.9
+ 1368010p -0.3
+ 1370000p -0.3
+ 1370010p 0.9
+ 1372000p 0.9
+ 1372010p -0.3
+ 1374000p -0.3
+ 1374010p 0.9
+ 1376000p 0.9
+ 1376010p -0.3
+ 1378000p -0.3
+ 1378010p 0.9
+ 1380000p 0.9
+ 1380010p -0.3
+ 1382000p -0.3
+ 1382010p 0.9
+ 1384000p 0.9
+ 1384010p -0.3
+ 1386000p -0.3
+ 1386010p 0.9
+ 1388000p 0.9
+ 1388010p -0.3
+ 1390000p -0.3
+ 1390010p 0.9
+ 1392000p 0.9
+ 1392010p -0.3
+ 1394000p -0.3
+ 1394010p 0.9
+ 1396000p 0.9
+ 1396010p -0.3
+ 1398000p -0.3
+ 1398010p 0.9
+ 1400000p 0.9
+ 1400010p -0.3
+ 1402000p -0.3
+ 1402010p 0.9
+ 1404000p 0.9
+ 1404010p -0.3
+ 1406000p -0.3
+ 1406010p 0.9
+ 1408000p 0.9
+ 1408010p -0.3
+ 1410000p -0.3
+ 1410010p 0.9
+ 1412000p 0.9
+ 1412010p -0.3
+ 1414000p -0.3
+ 1414010p 0.9
+ 1416000p 0.9
+ 1416010p -0.3
+ 1418000p -0.3
+ 1418010p 0.9
+ 1420000p 0.9
+ 1420010p -0.3
+ 1422000p -0.3
+ 1422010p 0.9
+ 1424000p 0.9
+ 1424010p -0.3
+ 1426000p -0.3
+ 1426010p 0.9
+ 1428000p 0.9
+ 1428010p -0.3
+ 1430000p -0.3
+ 1430010p 0.9
+ 1432000p 0.9
+ 1432010p -0.3
+ 1434000p -0.3
+ 1434010p 0.9
+ 1436000p 0.9
+ 1436010p -0.3
+ 1438000p -0.3
+ 1438010p 0.9
+ 1440000p 0.9
+ 1440010p -0.3
+ 1442000p -0.3
+ 1442010p 0.9
+ 1444000p 0.9
+ 1444010p -0.3
+ 1446000p -0.3
+ 1446010p 0.9
+ 1448000p 0.9
+ 1448010p -0.3
+ 1450000p -0.3
+ 1450010p 0.9
+ 1452000p 0.9
+ 1452010p -0.3
+ 1454000p -0.3
+ 1454010p 0.9
+ 1456000p 0.9
+ 1456010p -0.3
+ 1458000p -0.3
+ 1458010p 0.9
+ 1460000p 0.9
+ 1460010p -0.3
+ 1462000p -0.3
+ 1462010p 0.9
+ 1464000p 0.9
+ 1464010p -0.3
+ 1466000p -0.3
+ 1466010p 0.9
+ 1468000p 0.9
+ 1468010p -0.3
+ 1470000p -0.3
+ 1470010p 0.9
+ 1472000p 0.9
+ 1472010p -0.3
+ 1474000p -0.3
+ 1474010p 0.9
+ 1476000p 0.9
+ 1476010p -0.3
+ 1478000p -0.3
+ 1478010p 0.9
+ 1480000p 0.9
+ 1480010p -0.3
+ 1482000p -0.3
+ 1482010p 0.9
+ 1484000p 0.9
+ 1484010p -0.3
+ 1486000p -0.3
+ 1486010p 0.9
+ 1488000p 0.9
+ 1488010p -0.3
+ 1490000p -0.3
+ 1490010p 0.9
+ 1492000p 0.9
+ 1492010p -0.3
+ 1494000p -0.3
+ 1494010p 0.9
+ 1496000p 0.9
+ 1496010p -0.3
+ 1498000p -0.3
+ 1498010p 0.9
+ 1500000p 0.9
+ 1500010p -0.3
+ 1502000p -0.3
+ 1502010p 0.9
+ 1504000p 0.9
+ 1504010p -0.3
+ 1506000p -0.3
+ 1506010p 0.9
+ 1508000p 0.9
+ 1508010p -0.3
+ 1510000p -0.3
+ 1510010p 0.9
+ 1512000p 0.9
+ 1512010p -0.3
+ 1514000p -0.3
+ 1514010p 0.9
+ 1516000p 0.9
+ 1516010p -0.3
+ 1518000p -0.3
+ 1518010p 0.9
+ 1520000p 0.9
+ 1520010p -0.3
+ 1522000p -0.3
+ 1522010p 0.9
+ 1524000p 0.9
+ 1524010p -0.3
+ 1526000p -0.3
+ 1526010p 0.9
+ 1528000p 0.9
+ 1528010p -0.3
+ 1530000p -0.3
+ 1530010p 0.9
+ 1532000p 0.9
+ 1532010p -0.3
+ 1534000p -0.3
+ 1534010p 0.9
+ 1536000p 0.9
+ 1536010p -0.3
+ 1538000p -0.3
+ 1538010p 0.9
+ 1540000p 0.9
+ 1540010p -0.3
+ 1542000p -0.3
+ 1542010p 0.9
+ 1544000p 0.9
+ 1544010p -0.3
+ 1546000p -0.3
+ 1546010p 0.9
+ 1548000p 0.9
+ 1548010p -0.3
+ 1550000p -0.3
+ 1550010p 0.9
+ 1552000p 0.9
+ 1552010p -0.3
+ 1554000p -0.3
+ 1554010p 0.9
+ 1556000p 0.9
+ 1556010p -0.3
+ 1558000p -0.3
+ 1558010p 0.9
+ 1560000p 0.9
+ 1560010p -0.3
+ 1562000p -0.3
+ 1562010p 0.9
+ 1564000p 0.9
+ 1564010p -0.3
+ 1566000p -0.3
+ 1566010p 0.9
+ 1568000p 0.9
+ 1568010p -0.3
+ 1570000p -0.3
+ 1570010p 0.9
+ 1572000p 0.9
+ 1572010p -0.3
+ 1574000p -0.3
+ 1574010p 0.9
+ 1576000p 0.9
+ 1576010p -0.3
+ 1578000p -0.3
+ 1578010p 0.9
+ 1580000p 0.9
+ 1580010p -0.3
+ 1582000p -0.3
+ 1582010p 0.9
+ 1584000p 0.9
+ 1584010p -0.3
+ 1586000p -0.3
+ 1586010p 0.9
+ 1588000p 0.9
+ 1588010p -0.3
+ 1590000p -0.3
+ 1590010p 0.9
+ 1592000p 0.9
+ 1592010p -0.3
+ 1594000p -0.3
+ 1594010p 0.9
+ 1596000p 0.9
+ 1596010p -0.3
+ 1598000p -0.3
+ 1598010p 0.9
+ 1600000p 0.9
+ 1600010p -0.3
+ 1602000p -0.3
+ 1602010p 0.9
+ 1604000p 0.9
+ 1604010p -0.3
+ 1606000p -0.3
+ 1606010p 0.9
+ 1608000p 0.9
+ 1608010p -0.3
+ 1610000p -0.3
+ 1610010p 0.9
+ 1612000p 0.9
+ 1612010p -0.3
+ 1614000p -0.3
+ 1614010p 0.9
+ 1616000p 0.9
+ 1616010p -0.3
+ 1618000p -0.3
+ 1618010p 0.9
+ 1620000p 0.9
+ 1620010p -0.3
+ 1622000p -0.3
+ 1622010p 0.9
+ 1624000p 0.9
+ 1624010p -0.3
+ 1626000p -0.3
+ 1626010p 0.9
+ 1628000p 0.9
+ 1628010p -0.3
+ 1630000p -0.3
+ 1630010p 0.9
+ 1632000p 0.9
+ 1632010p -0.3
+ 1634000p -0.3
+ 1634010p 0.9
+ 1636000p 0.9
+ 1636010p -0.3
+ 1638000p -0.3
+ 1638010p 0.9
+ 1640000p 0.9
+ 1640010p -0.3
+ 1642000p -0.3
+ 1642010p 0.9
+ 1644000p 0.9
+ 1644010p -0.3
+ 1646000p -0.3
+ 1646010p 0.9
+ 1648000p 0.9
+ 1648010p -0.3
+ 1650000p -0.3
+ 1650010p 0.9
+ 1652000p 0.9
+ 1652010p -0.3
+ 1654000p -0.3
+ 1654010p 0.9
+ 1656000p 0.9
+ 1656010p -0.3
+ 1658000p -0.3
+ 1658010p 0.9
+ 1660000p 0.9
+ 1660010p -0.3
+ 1662000p -0.3
+ 1662010p 0.9
+ 1664000p 0.9
+ 1664010p -0.3
+ 1666000p -0.3
+ 1666010p 0.9
+ 1668000p 0.9
+ 1668010p -0.3
+ 1670000p -0.3
+ 1670010p 0.9
+ 1672000p 0.9
+ 1672010p -0.3
+ 1674000p -0.3
+ 1674010p 0.9
+ 1676000p 0.9
+ 1676010p -0.3
+ 1678000p -0.3
+ 1678010p 0.9
+ 1680000p 0.9
+ 1680010p -0.3
+ 1682000p -0.3
+ 1682010p 0.9
+ 1684000p 0.9
+ 1684010p -0.3
+ 1686000p -0.3
+ 1686010p 0.9
+ 1688000p 0.9
+ 1688010p -0.3
+ 1690000p -0.3
+ 1690010p 0.9
+ 1692000p 0.9
+ 1692010p -0.3
+ 1694000p -0.3
+ 1694010p 0.9
+ 1696000p 0.9
+ 1696010p -0.3
+ 1698000p -0.3
+ 1698010p 0.9
+ 1700000p 0.9
+ 1700010p -0.3
+ 1702000p -0.3
+ 1702010p 0.9
+ 1704000p 0.9
+ 1704010p -0.3
+ 1706000p -0.3
+ 1706010p 0.9
+ 1708000p 0.9
+ 1708010p -0.3
+ 1710000p -0.3
+ 1710010p 0.9
+ 1712000p 0.9
+ 1712010p -0.3
+ 1714000p -0.3
+ 1714010p 0.9
+ 1716000p 0.9
+ 1716010p -0.3
+ 1718000p -0.3
+ 1718010p 0.9
+ 1720000p 0.9
+ 1720010p -0.3
+ 1722000p -0.3
+ 1722010p 0.9
+ 1724000p 0.9
+ 1724010p -0.3
+ 1726000p -0.3
+ 1726010p 0.9
+ 1728000p 0.9
+ 1728010p -0.3
+ 1730000p -0.3
+ 1730010p 0.9
+ 1732000p 0.9
+ 1732010p -0.3
+ 1734000p -0.3
+ 1734010p 0.9
+ 1736000p 0.9
+ 1736010p -0.3
+ 1738000p -0.3
+ 1738010p 0.9
+ 1740000p 0.9
+ 1740010p -0.3
+ 1742000p -0.3
+ 1742010p 0.9
+ 1744000p 0.9
+ 1744010p -0.3
+ 1746000p -0.3
+ 1746010p 0.9
+ 1748000p 0.9
+ 1748010p -0.3
+ 1750000p -0.3
+ 1750010p 0.9
+ 1752000p 0.9
+ 1752010p -0.3
+ 1754000p -0.3
+ 1754010p 0.9
+ 1756000p 0.9
+ 1756010p -0.3
+ 1758000p -0.3
+ 1758010p 0.9
+ 1760000p 0.9
+ 1760010p -0.3
+ 1762000p -0.3
+ 1762010p 0.9
+ 1764000p 0.9
+ 1764010p -0.3
+ 1766000p -0.3
+ 1766010p 0.9
+ 1768000p 0.9
+ 1768010p -0.3
+ 1770000p -0.3
+ 1770010p 0.9
+ 1772000p 0.9
+ 1772010p -0.3
+ 1774000p -0.3
+ 1774010p 0.9
+ 1776000p 0.9
+ 1776010p -0.3
+ 1778000p -0.3
+ 1778010p 0.9
+ 1780000p 0.9
+ 1780010p -0.3
+ 1782000p -0.3
+ 1782010p 0.9
+ 1784000p 0.9
+ 1784010p -0.3
+ 1786000p -0.3
+ 1786010p 0.9
+ 1788000p 0.9
+ 1788010p -0.3
+ 1790000p -0.3
+ 1790010p 0.9
+ 1792000p 0.9
+ 1792010p -0.3
+ 1794000p -0.3
+ 1794010p 0.9
+ 1796000p 0.9
+ 1796010p -0.3
+ 1798000p -0.3
+ 1798010p 0.9
+ 1800000p 0.9
+ 1800010p -0.3
+ 1802000p -0.3
+ 1802010p 0.9
+ 1804000p 0.9
+ 1804010p -0.3
+ 1806000p -0.3
+ 1806010p 0.9
+ 1808000p 0.9
+ 1808010p -0.3
+ 1810000p -0.3
+ 1810010p 0.9
+ 1812000p 0.9
+ 1812010p -0.3
+ 1814000p -0.3
+ 1814010p 0.9
+ 1816000p 0.9
+ 1816010p -0.3
+ 1818000p -0.3
+ 1818010p 0.9
+ 1820000p 0.9
+ 1820010p -0.3
+ 1822000p -0.3
+ 1822010p 0.9
+ 1824000p 0.9
+ 1824010p -0.3
+ 1826000p -0.3
+ 1826010p 0.9
+ 1828000p 0.9
+ 1828010p -0.3
+ 1830000p -0.3
+ 1830010p 0.9
+ 1832000p 0.9
+ 1832010p -0.3
+ 1834000p -0.3
+ 1834010p 0.9
+ 1836000p 0.9
+ 1836010p -0.3
+ 1838000p -0.3
+ 1838010p 0.9
+ 1840000p 0.9
+ 1840010p -0.3
+ 1842000p -0.3
+ 1842010p 0.9
+ 1844000p 0.9
+ 1844010p -0.3
+ 1846000p -0.3
+ 1846010p 0.9
+ 1848000p 0.9
+ 1848010p -0.3
+ 1850000p -0.3
+ 1850010p 0.9
+ 1852000p 0.9
+ 1852010p -0.3
+ 1854000p -0.3
+ 1854010p 0.9
+ 1856000p 0.9
+ 1856010p -0.3
+ 1858000p -0.3
+ 1858010p 0.9
+ 1860000p 0.9
+ 1860010p -0.3
+ 1862000p -0.3
+ 1862010p 0.9
+ 1864000p 0.9
+ 1864010p -0.3
+ 1866000p -0.3
+ 1866010p 0.9
+ 1868000p 0.9
+ 1868010p -0.3
+ 1870000p -0.3
+ 1870010p 0.9
+ 1872000p 0.9
+ 1872010p -0.3
+ 1874000p -0.3
+ 1874010p 0.9
+ 1876000p 0.9
+ 1876010p -0.3
+ 1878000p -0.3
+ 1878010p 0.9
+ 1880000p 0.9
+ 1880010p -0.3
+ 1882000p -0.3
+ 1882010p 0.9
+ 1884000p 0.9
+ 1884010p -0.3
+ 1886000p -0.3
+ 1886010p 0.9
+ 1888000p 0.9
+ 1888010p -0.3
+ 1890000p -0.3
+ 1890010p 0.9
+ 1892000p 0.9
+ 1892010p -0.3
+ 1894000p -0.3
+ 1894010p 0.9
+ 1896000p 0.9
+ 1896010p -0.3
+ 1898000p -0.3
+ 1898010p 0.9
+ 1900000p 0.9
+ 1900010p -0.3
+ 1902000p -0.3
+ 1902010p 0.9
+ 1904000p 0.9
+ 1904010p -0.3
+ 1906000p -0.3
+ 1906010p 0.9
+ 1908000p 0.9
+ 1908010p -0.3
+ 1910000p -0.3
+ 1910010p 0.9
+ 1912000p 0.9
+ 1912010p -0.3
+ 1914000p -0.3
+ 1914010p 0.9
+ 1916000p 0.9
+ 1916010p -0.3
+ 1918000p -0.3
+ 1918010p 0.9
+ 1920000p 0.9
+ 1920010p -0.3
+ 1922000p -0.3
+ 1922010p 0.9
+ 1924000p 0.9
+ 1924010p -0.3
+ 1926000p -0.3
+ 1926010p 0.9
+ 1928000p 0.9
+ 1928010p -0.3
+ 1930000p -0.3
+ 1930010p 0.9
+ 1932000p 0.9
+ 1932010p -0.3
+ 1934000p -0.3
+ 1934010p 0.9
+ 1936000p 0.9
+ 1936010p -0.3
+ 1938000p -0.3
+ 1938010p 0.9
+ 1940000p 0.9
+ 1940010p -0.3
+ 1942000p -0.3
+ 1942010p 0.9
+ 1944000p 0.9
+ 1944010p -0.3
+ 1946000p -0.3
+ 1946010p 0.9
+ 1948000p 0.9
+ 1948010p -0.3
+ 1950000p -0.3
+ 1950010p 0.9
+ 1952000p 0.9
+ 1952010p -0.3
+ 1954000p -0.3
+ 1954010p 0.9
+ 1956000p 0.9
+ 1956010p -0.3
+ 1958000p -0.3
+ 1958010p 0.9
+ 1960000p 0.9
+ 1960010p -0.3
+ 1962000p -0.3
+ 1962010p 0.9
+ 1964000p 0.9
+ 1964010p -0.3
+ 1966000p -0.3
+ 1966010p 0.9
+ 1968000p 0.9
+ 1968010p -0.3
+ 1970000p -0.3
+ 1970010p 0.9
+ 1972000p 0.9
+ 1972010p -0.3
+ 1974000p -0.3
+ 1974010p 0.9
+ 1976000p 0.9
+ 1976010p -0.3
+ 1978000p -0.3
+ 1978010p 0.9
+ 1980000p 0.9
+ 1980010p -0.3
+ 1982000p -0.3
+ 1982010p 0.9
+ 1984000p 0.9
+ 1984010p -0.3
+ 1986000p -0.3
+ 1986010p 0.9
+ 1988000p 0.9
+ 1988010p -0.3
+ 1990000p -0.3
+ 1990010p 0.9
+ 1992000p 0.9
+ 1992010p -0.3
+ 1994000p -0.3
+ 1994010p 0.9
+ 1996000p 0.9
+ 1996010p -0.3
+ 1998000p -0.3
+ 1998010p 0.9
+ 2000000p 0.9
+ 2000010p -0.3
+ 2002000p -0.3
+ 2002010p 0.9
+ 2004000p 0.9
+ 2004010p -0.3
+ 2006000p -0.3
+ 2006010p 0.9
+ 2008000p 0.9
+ 2008010p -0.3
+ 2010000p -0.3
+ 2010010p 0.9
+ 2012000p 0.9
+ 2012010p -0.3
+ 2014000p -0.3
+ 2014010p 0.9
+ 2016000p 0.9
+ 2016010p -0.3
+ 2018000p -0.3
+ 2018010p 0.9
+ 2020000p 0.9
+ 2020010p -0.3
+ 2022000p -0.3
+ 2022010p 0.9
+ 2024000p 0.9
+ 2024010p -0.3
+ 2026000p -0.3
+ 2026010p 0.9
+ 2028000p 0.9
+ 2028010p -0.3
+ 2030000p -0.3
+ 2030010p 0.9
+ 2032000p 0.9
+ 2032010p -0.3
+ 2034000p -0.3
+ 2034010p 0.9
+ 2036000p 0.9
+ 2036010p -0.3
+ 2038000p -0.3
+ 2038010p 0.9
+ 2040000p 0.9
+ 2040010p -0.3
+ 2042000p -0.3
+ 2042010p 0.9
+ 2044000p 0.9
+ 2044010p -0.3
+ 2046000p -0.3
+ 2046010p 0.9
+ 2048000p 0.9
+ 2048010p -0.3
+ \]
V_data_27 (Data\\<27\\> gnd!) vsource type=pwl wave=\[
+ 0    0.9
+ 2000p 0.9
+ 2010p -0.3
+ 4000p -0.3
+ 4010p 0.9
+ 6000p 0.9
+ 6010p -0.3
+ 8000p -0.3
+ 8010p 0.9
+ 10000p 0.9
+ 10010p -0.3
+ 12000p -0.3
+ 12010p 0.9
+ 14000p 0.9
+ 14010p -0.3
+ 16000p -0.3
+ 16010p 0.9
+ 18000p 0.9
+ 18010p -0.3
+ 20000p -0.3
+ 20010p 0.9
+ 22000p 0.9
+ 22010p -0.3
+ 24000p -0.3
+ 24010p 0.9
+ 26000p 0.9
+ 26010p -0.3
+ 28000p -0.3
+ 28010p 0.9
+ 30000p 0.9
+ 30010p -0.3
+ 32000p -0.3
+ 32010p 0.9
+ 34000p 0.9
+ 34010p -0.3
+ 36000p -0.3
+ 36010p 0.9
+ 38000p 0.9
+ 38010p -0.3
+ 40000p -0.3
+ 40010p 0.9
+ 42000p 0.9
+ 42010p -0.3
+ 44000p -0.3
+ 44010p 0.9
+ 46000p 0.9
+ 46010p -0.3
+ 48000p -0.3
+ 48010p 0.9
+ 50000p 0.9
+ 50010p -0.3
+ 52000p -0.3
+ 52010p 0.9
+ 54000p 0.9
+ 54010p -0.3
+ 56000p -0.3
+ 56010p 0.9
+ 58000p 0.9
+ 58010p -0.3
+ 60000p -0.3
+ 60010p 0.9
+ 62000p 0.9
+ 62010p -0.3
+ 64000p -0.3
+ 64010p 0.9
+ 66000p 0.9
+ 66010p -0.3
+ 68000p -0.3
+ 68010p 0.9
+ 70000p 0.9
+ 70010p -0.3
+ 72000p -0.3
+ 72010p 0.9
+ 74000p 0.9
+ 74010p -0.3
+ 76000p -0.3
+ 76010p 0.9
+ 78000p 0.9
+ 78010p -0.3
+ 80000p -0.3
+ 80010p 0.9
+ 82000p 0.9
+ 82010p -0.3
+ 84000p -0.3
+ 84010p 0.9
+ 86000p 0.9
+ 86010p -0.3
+ 88000p -0.3
+ 88010p 0.9
+ 90000p 0.9
+ 90010p -0.3
+ 92000p -0.3
+ 92010p 0.9
+ 94000p 0.9
+ 94010p -0.3
+ 96000p -0.3
+ 96010p 0.9
+ 98000p 0.9
+ 98010p -0.3
+ 100000p -0.3
+ 100010p 0.9
+ 102000p 0.9
+ 102010p -0.3
+ 104000p -0.3
+ 104010p 0.9
+ 106000p 0.9
+ 106010p -0.3
+ 108000p -0.3
+ 108010p 0.9
+ 110000p 0.9
+ 110010p -0.3
+ 112000p -0.3
+ 112010p 0.9
+ 114000p 0.9
+ 114010p -0.3
+ 116000p -0.3
+ 116010p 0.9
+ 118000p 0.9
+ 118010p -0.3
+ 120000p -0.3
+ 120010p 0.9
+ 122000p 0.9
+ 122010p -0.3
+ 124000p -0.3
+ 124010p 0.9
+ 126000p 0.9
+ 126010p -0.3
+ 128000p -0.3
+ 128010p 0.9
+ 130000p 0.9
+ 130010p -0.3
+ 132000p -0.3
+ 132010p 0.9
+ 134000p 0.9
+ 134010p -0.3
+ 136000p -0.3
+ 136010p 0.9
+ 138000p 0.9
+ 138010p -0.3
+ 140000p -0.3
+ 140010p 0.9
+ 142000p 0.9
+ 142010p -0.3
+ 144000p -0.3
+ 144010p 0.9
+ 146000p 0.9
+ 146010p -0.3
+ 148000p -0.3
+ 148010p 0.9
+ 150000p 0.9
+ 150010p -0.3
+ 152000p -0.3
+ 152010p 0.9
+ 154000p 0.9
+ 154010p -0.3
+ 156000p -0.3
+ 156010p 0.9
+ 158000p 0.9
+ 158010p -0.3
+ 160000p -0.3
+ 160010p 0.9
+ 162000p 0.9
+ 162010p -0.3
+ 164000p -0.3
+ 164010p 0.9
+ 166000p 0.9
+ 166010p -0.3
+ 168000p -0.3
+ 168010p 0.9
+ 170000p 0.9
+ 170010p -0.3
+ 172000p -0.3
+ 172010p 0.9
+ 174000p 0.9
+ 174010p -0.3
+ 176000p -0.3
+ 176010p 0.9
+ 178000p 0.9
+ 178010p -0.3
+ 180000p -0.3
+ 180010p 0.9
+ 182000p 0.9
+ 182010p -0.3
+ 184000p -0.3
+ 184010p 0.9
+ 186000p 0.9
+ 186010p -0.3
+ 188000p -0.3
+ 188010p 0.9
+ 190000p 0.9
+ 190010p -0.3
+ 192000p -0.3
+ 192010p 0.9
+ 194000p 0.9
+ 194010p -0.3
+ 196000p -0.3
+ 196010p 0.9
+ 198000p 0.9
+ 198010p -0.3
+ 200000p -0.3
+ 200010p 0.9
+ 202000p 0.9
+ 202010p -0.3
+ 204000p -0.3
+ 204010p 0.9
+ 206000p 0.9
+ 206010p -0.3
+ 208000p -0.3
+ 208010p 0.9
+ 210000p 0.9
+ 210010p -0.3
+ 212000p -0.3
+ 212010p 0.9
+ 214000p 0.9
+ 214010p -0.3
+ 216000p -0.3
+ 216010p 0.9
+ 218000p 0.9
+ 218010p -0.3
+ 220000p -0.3
+ 220010p 0.9
+ 222000p 0.9
+ 222010p -0.3
+ 224000p -0.3
+ 224010p 0.9
+ 226000p 0.9
+ 226010p -0.3
+ 228000p -0.3
+ 228010p 0.9
+ 230000p 0.9
+ 230010p -0.3
+ 232000p -0.3
+ 232010p 0.9
+ 234000p 0.9
+ 234010p -0.3
+ 236000p -0.3
+ 236010p 0.9
+ 238000p 0.9
+ 238010p -0.3
+ 240000p -0.3
+ 240010p 0.9
+ 242000p 0.9
+ 242010p -0.3
+ 244000p -0.3
+ 244010p 0.9
+ 246000p 0.9
+ 246010p -0.3
+ 248000p -0.3
+ 248010p 0.9
+ 250000p 0.9
+ 250010p -0.3
+ 252000p -0.3
+ 252010p 0.9
+ 254000p 0.9
+ 254010p -0.3
+ 256000p -0.3
+ 256010p 0.9
+ 258000p 0.9
+ 258010p -0.3
+ 260000p -0.3
+ 260010p 0.9
+ 262000p 0.9
+ 262010p -0.3
+ 264000p -0.3
+ 264010p 0.9
+ 266000p 0.9
+ 266010p -0.3
+ 268000p -0.3
+ 268010p 0.9
+ 270000p 0.9
+ 270010p -0.3
+ 272000p -0.3
+ 272010p 0.9
+ 274000p 0.9
+ 274010p -0.3
+ 276000p -0.3
+ 276010p 0.9
+ 278000p 0.9
+ 278010p -0.3
+ 280000p -0.3
+ 280010p 0.9
+ 282000p 0.9
+ 282010p -0.3
+ 284000p -0.3
+ 284010p 0.9
+ 286000p 0.9
+ 286010p -0.3
+ 288000p -0.3
+ 288010p 0.9
+ 290000p 0.9
+ 290010p -0.3
+ 292000p -0.3
+ 292010p 0.9
+ 294000p 0.9
+ 294010p -0.3
+ 296000p -0.3
+ 296010p 0.9
+ 298000p 0.9
+ 298010p -0.3
+ 300000p -0.3
+ 300010p 0.9
+ 302000p 0.9
+ 302010p -0.3
+ 304000p -0.3
+ 304010p 0.9
+ 306000p 0.9
+ 306010p -0.3
+ 308000p -0.3
+ 308010p 0.9
+ 310000p 0.9
+ 310010p -0.3
+ 312000p -0.3
+ 312010p 0.9
+ 314000p 0.9
+ 314010p -0.3
+ 316000p -0.3
+ 316010p 0.9
+ 318000p 0.9
+ 318010p -0.3
+ 320000p -0.3
+ 320010p 0.9
+ 322000p 0.9
+ 322010p -0.3
+ 324000p -0.3
+ 324010p 0.9
+ 326000p 0.9
+ 326010p -0.3
+ 328000p -0.3
+ 328010p 0.9
+ 330000p 0.9
+ 330010p -0.3
+ 332000p -0.3
+ 332010p 0.9
+ 334000p 0.9
+ 334010p -0.3
+ 336000p -0.3
+ 336010p 0.9
+ 338000p 0.9
+ 338010p -0.3
+ 340000p -0.3
+ 340010p 0.9
+ 342000p 0.9
+ 342010p -0.3
+ 344000p -0.3
+ 344010p 0.9
+ 346000p 0.9
+ 346010p -0.3
+ 348000p -0.3
+ 348010p 0.9
+ 350000p 0.9
+ 350010p -0.3
+ 352000p -0.3
+ 352010p 0.9
+ 354000p 0.9
+ 354010p -0.3
+ 356000p -0.3
+ 356010p 0.9
+ 358000p 0.9
+ 358010p -0.3
+ 360000p -0.3
+ 360010p 0.9
+ 362000p 0.9
+ 362010p -0.3
+ 364000p -0.3
+ 364010p 0.9
+ 366000p 0.9
+ 366010p -0.3
+ 368000p -0.3
+ 368010p 0.9
+ 370000p 0.9
+ 370010p -0.3
+ 372000p -0.3
+ 372010p 0.9
+ 374000p 0.9
+ 374010p -0.3
+ 376000p -0.3
+ 376010p 0.9
+ 378000p 0.9
+ 378010p -0.3
+ 380000p -0.3
+ 380010p 0.9
+ 382000p 0.9
+ 382010p -0.3
+ 384000p -0.3
+ 384010p 0.9
+ 386000p 0.9
+ 386010p -0.3
+ 388000p -0.3
+ 388010p 0.9
+ 390000p 0.9
+ 390010p -0.3
+ 392000p -0.3
+ 392010p 0.9
+ 394000p 0.9
+ 394010p -0.3
+ 396000p -0.3
+ 396010p 0.9
+ 398000p 0.9
+ 398010p -0.3
+ 400000p -0.3
+ 400010p 0.9
+ 402000p 0.9
+ 402010p -0.3
+ 404000p -0.3
+ 404010p 0.9
+ 406000p 0.9
+ 406010p -0.3
+ 408000p -0.3
+ 408010p 0.9
+ 410000p 0.9
+ 410010p -0.3
+ 412000p -0.3
+ 412010p 0.9
+ 414000p 0.9
+ 414010p -0.3
+ 416000p -0.3
+ 416010p 0.9
+ 418000p 0.9
+ 418010p -0.3
+ 420000p -0.3
+ 420010p 0.9
+ 422000p 0.9
+ 422010p -0.3
+ 424000p -0.3
+ 424010p 0.9
+ 426000p 0.9
+ 426010p -0.3
+ 428000p -0.3
+ 428010p 0.9
+ 430000p 0.9
+ 430010p -0.3
+ 432000p -0.3
+ 432010p 0.9
+ 434000p 0.9
+ 434010p -0.3
+ 436000p -0.3
+ 436010p 0.9
+ 438000p 0.9
+ 438010p -0.3
+ 440000p -0.3
+ 440010p 0.9
+ 442000p 0.9
+ 442010p -0.3
+ 444000p -0.3
+ 444010p 0.9
+ 446000p 0.9
+ 446010p -0.3
+ 448000p -0.3
+ 448010p 0.9
+ 450000p 0.9
+ 450010p -0.3
+ 452000p -0.3
+ 452010p 0.9
+ 454000p 0.9
+ 454010p -0.3
+ 456000p -0.3
+ 456010p 0.9
+ 458000p 0.9
+ 458010p -0.3
+ 460000p -0.3
+ 460010p 0.9
+ 462000p 0.9
+ 462010p -0.3
+ 464000p -0.3
+ 464010p 0.9
+ 466000p 0.9
+ 466010p -0.3
+ 468000p -0.3
+ 468010p 0.9
+ 470000p 0.9
+ 470010p -0.3
+ 472000p -0.3
+ 472010p 0.9
+ 474000p 0.9
+ 474010p -0.3
+ 476000p -0.3
+ 476010p 0.9
+ 478000p 0.9
+ 478010p -0.3
+ 480000p -0.3
+ 480010p 0.9
+ 482000p 0.9
+ 482010p -0.3
+ 484000p -0.3
+ 484010p 0.9
+ 486000p 0.9
+ 486010p -0.3
+ 488000p -0.3
+ 488010p 0.9
+ 490000p 0.9
+ 490010p -0.3
+ 492000p -0.3
+ 492010p 0.9
+ 494000p 0.9
+ 494010p -0.3
+ 496000p -0.3
+ 496010p 0.9
+ 498000p 0.9
+ 498010p -0.3
+ 500000p -0.3
+ 500010p 0.9
+ 502000p 0.9
+ 502010p -0.3
+ 504000p -0.3
+ 504010p 0.9
+ 506000p 0.9
+ 506010p -0.3
+ 508000p -0.3
+ 508010p 0.9
+ 510000p 0.9
+ 510010p -0.3
+ 512000p -0.3
+ 512010p 0.9
+ 514000p 0.9
+ 514010p -0.3
+ 516000p -0.3
+ 516010p 0.9
+ 518000p 0.9
+ 518010p -0.3
+ 520000p -0.3
+ 520010p 0.9
+ 522000p 0.9
+ 522010p -0.3
+ 524000p -0.3
+ 524010p 0.9
+ 526000p 0.9
+ 526010p -0.3
+ 528000p -0.3
+ 528010p 0.9
+ 530000p 0.9
+ 530010p -0.3
+ 532000p -0.3
+ 532010p 0.9
+ 534000p 0.9
+ 534010p -0.3
+ 536000p -0.3
+ 536010p 0.9
+ 538000p 0.9
+ 538010p -0.3
+ 540000p -0.3
+ 540010p 0.9
+ 542000p 0.9
+ 542010p -0.3
+ 544000p -0.3
+ 544010p 0.9
+ 546000p 0.9
+ 546010p -0.3
+ 548000p -0.3
+ 548010p 0.9
+ 550000p 0.9
+ 550010p -0.3
+ 552000p -0.3
+ 552010p 0.9
+ 554000p 0.9
+ 554010p -0.3
+ 556000p -0.3
+ 556010p 0.9
+ 558000p 0.9
+ 558010p -0.3
+ 560000p -0.3
+ 560010p 0.9
+ 562000p 0.9
+ 562010p -0.3
+ 564000p -0.3
+ 564010p 0.9
+ 566000p 0.9
+ 566010p -0.3
+ 568000p -0.3
+ 568010p 0.9
+ 570000p 0.9
+ 570010p -0.3
+ 572000p -0.3
+ 572010p 0.9
+ 574000p 0.9
+ 574010p -0.3
+ 576000p -0.3
+ 576010p 0.9
+ 578000p 0.9
+ 578010p -0.3
+ 580000p -0.3
+ 580010p 0.9
+ 582000p 0.9
+ 582010p -0.3
+ 584000p -0.3
+ 584010p 0.9
+ 586000p 0.9
+ 586010p -0.3
+ 588000p -0.3
+ 588010p 0.9
+ 590000p 0.9
+ 590010p -0.3
+ 592000p -0.3
+ 592010p 0.9
+ 594000p 0.9
+ 594010p -0.3
+ 596000p -0.3
+ 596010p 0.9
+ 598000p 0.9
+ 598010p -0.3
+ 600000p -0.3
+ 600010p 0.9
+ 602000p 0.9
+ 602010p -0.3
+ 604000p -0.3
+ 604010p 0.9
+ 606000p 0.9
+ 606010p -0.3
+ 608000p -0.3
+ 608010p 0.9
+ 610000p 0.9
+ 610010p -0.3
+ 612000p -0.3
+ 612010p 0.9
+ 614000p 0.9
+ 614010p -0.3
+ 616000p -0.3
+ 616010p 0.9
+ 618000p 0.9
+ 618010p -0.3
+ 620000p -0.3
+ 620010p 0.9
+ 622000p 0.9
+ 622010p -0.3
+ 624000p -0.3
+ 624010p 0.9
+ 626000p 0.9
+ 626010p -0.3
+ 628000p -0.3
+ 628010p 0.9
+ 630000p 0.9
+ 630010p -0.3
+ 632000p -0.3
+ 632010p 0.9
+ 634000p 0.9
+ 634010p -0.3
+ 636000p -0.3
+ 636010p 0.9
+ 638000p 0.9
+ 638010p -0.3
+ 640000p -0.3
+ 640010p 0.9
+ 642000p 0.9
+ 642010p -0.3
+ 644000p -0.3
+ 644010p 0.9
+ 646000p 0.9
+ 646010p -0.3
+ 648000p -0.3
+ 648010p 0.9
+ 650000p 0.9
+ 650010p -0.3
+ 652000p -0.3
+ 652010p 0.9
+ 654000p 0.9
+ 654010p -0.3
+ 656000p -0.3
+ 656010p 0.9
+ 658000p 0.9
+ 658010p -0.3
+ 660000p -0.3
+ 660010p 0.9
+ 662000p 0.9
+ 662010p -0.3
+ 664000p -0.3
+ 664010p 0.9
+ 666000p 0.9
+ 666010p -0.3
+ 668000p -0.3
+ 668010p 0.9
+ 670000p 0.9
+ 670010p -0.3
+ 672000p -0.3
+ 672010p 0.9
+ 674000p 0.9
+ 674010p -0.3
+ 676000p -0.3
+ 676010p 0.9
+ 678000p 0.9
+ 678010p -0.3
+ 680000p -0.3
+ 680010p 0.9
+ 682000p 0.9
+ 682010p -0.3
+ 684000p -0.3
+ 684010p 0.9
+ 686000p 0.9
+ 686010p -0.3
+ 688000p -0.3
+ 688010p 0.9
+ 690000p 0.9
+ 690010p -0.3
+ 692000p -0.3
+ 692010p 0.9
+ 694000p 0.9
+ 694010p -0.3
+ 696000p -0.3
+ 696010p 0.9
+ 698000p 0.9
+ 698010p -0.3
+ 700000p -0.3
+ 700010p 0.9
+ 702000p 0.9
+ 702010p -0.3
+ 704000p -0.3
+ 704010p 0.9
+ 706000p 0.9
+ 706010p -0.3
+ 708000p -0.3
+ 708010p 0.9
+ 710000p 0.9
+ 710010p -0.3
+ 712000p -0.3
+ 712010p 0.9
+ 714000p 0.9
+ 714010p -0.3
+ 716000p -0.3
+ 716010p 0.9
+ 718000p 0.9
+ 718010p -0.3
+ 720000p -0.3
+ 720010p 0.9
+ 722000p 0.9
+ 722010p -0.3
+ 724000p -0.3
+ 724010p 0.9
+ 726000p 0.9
+ 726010p -0.3
+ 728000p -0.3
+ 728010p 0.9
+ 730000p 0.9
+ 730010p -0.3
+ 732000p -0.3
+ 732010p 0.9
+ 734000p 0.9
+ 734010p -0.3
+ 736000p -0.3
+ 736010p 0.9
+ 738000p 0.9
+ 738010p -0.3
+ 740000p -0.3
+ 740010p 0.9
+ 742000p 0.9
+ 742010p -0.3
+ 744000p -0.3
+ 744010p 0.9
+ 746000p 0.9
+ 746010p -0.3
+ 748000p -0.3
+ 748010p 0.9
+ 750000p 0.9
+ 750010p -0.3
+ 752000p -0.3
+ 752010p 0.9
+ 754000p 0.9
+ 754010p -0.3
+ 756000p -0.3
+ 756010p 0.9
+ 758000p 0.9
+ 758010p -0.3
+ 760000p -0.3
+ 760010p 0.9
+ 762000p 0.9
+ 762010p -0.3
+ 764000p -0.3
+ 764010p 0.9
+ 766000p 0.9
+ 766010p -0.3
+ 768000p -0.3
+ 768010p 0.9
+ 770000p 0.9
+ 770010p -0.3
+ 772000p -0.3
+ 772010p 0.9
+ 774000p 0.9
+ 774010p -0.3
+ 776000p -0.3
+ 776010p 0.9
+ 778000p 0.9
+ 778010p -0.3
+ 780000p -0.3
+ 780010p 0.9
+ 782000p 0.9
+ 782010p -0.3
+ 784000p -0.3
+ 784010p 0.9
+ 786000p 0.9
+ 786010p -0.3
+ 788000p -0.3
+ 788010p 0.9
+ 790000p 0.9
+ 790010p -0.3
+ 792000p -0.3
+ 792010p 0.9
+ 794000p 0.9
+ 794010p -0.3
+ 796000p -0.3
+ 796010p 0.9
+ 798000p 0.9
+ 798010p -0.3
+ 800000p -0.3
+ 800010p 0.9
+ 802000p 0.9
+ 802010p -0.3
+ 804000p -0.3
+ 804010p 0.9
+ 806000p 0.9
+ 806010p -0.3
+ 808000p -0.3
+ 808010p 0.9
+ 810000p 0.9
+ 810010p -0.3
+ 812000p -0.3
+ 812010p 0.9
+ 814000p 0.9
+ 814010p -0.3
+ 816000p -0.3
+ 816010p 0.9
+ 818000p 0.9
+ 818010p -0.3
+ 820000p -0.3
+ 820010p 0.9
+ 822000p 0.9
+ 822010p -0.3
+ 824000p -0.3
+ 824010p 0.9
+ 826000p 0.9
+ 826010p -0.3
+ 828000p -0.3
+ 828010p 0.9
+ 830000p 0.9
+ 830010p -0.3
+ 832000p -0.3
+ 832010p 0.9
+ 834000p 0.9
+ 834010p -0.3
+ 836000p -0.3
+ 836010p 0.9
+ 838000p 0.9
+ 838010p -0.3
+ 840000p -0.3
+ 840010p 0.9
+ 842000p 0.9
+ 842010p -0.3
+ 844000p -0.3
+ 844010p 0.9
+ 846000p 0.9
+ 846010p -0.3
+ 848000p -0.3
+ 848010p 0.9
+ 850000p 0.9
+ 850010p -0.3
+ 852000p -0.3
+ 852010p 0.9
+ 854000p 0.9
+ 854010p -0.3
+ 856000p -0.3
+ 856010p 0.9
+ 858000p 0.9
+ 858010p -0.3
+ 860000p -0.3
+ 860010p 0.9
+ 862000p 0.9
+ 862010p -0.3
+ 864000p -0.3
+ 864010p 0.9
+ 866000p 0.9
+ 866010p -0.3
+ 868000p -0.3
+ 868010p 0.9
+ 870000p 0.9
+ 870010p -0.3
+ 872000p -0.3
+ 872010p 0.9
+ 874000p 0.9
+ 874010p -0.3
+ 876000p -0.3
+ 876010p 0.9
+ 878000p 0.9
+ 878010p -0.3
+ 880000p -0.3
+ 880010p 0.9
+ 882000p 0.9
+ 882010p -0.3
+ 884000p -0.3
+ 884010p 0.9
+ 886000p 0.9
+ 886010p -0.3
+ 888000p -0.3
+ 888010p 0.9
+ 890000p 0.9
+ 890010p -0.3
+ 892000p -0.3
+ 892010p 0.9
+ 894000p 0.9
+ 894010p -0.3
+ 896000p -0.3
+ 896010p 0.9
+ 898000p 0.9
+ 898010p -0.3
+ 900000p -0.3
+ 900010p 0.9
+ 902000p 0.9
+ 902010p -0.3
+ 904000p -0.3
+ 904010p 0.9
+ 906000p 0.9
+ 906010p -0.3
+ 908000p -0.3
+ 908010p 0.9
+ 910000p 0.9
+ 910010p -0.3
+ 912000p -0.3
+ 912010p 0.9
+ 914000p 0.9
+ 914010p -0.3
+ 916000p -0.3
+ 916010p 0.9
+ 918000p 0.9
+ 918010p -0.3
+ 920000p -0.3
+ 920010p 0.9
+ 922000p 0.9
+ 922010p -0.3
+ 924000p -0.3
+ 924010p 0.9
+ 926000p 0.9
+ 926010p -0.3
+ 928000p -0.3
+ 928010p 0.9
+ 930000p 0.9
+ 930010p -0.3
+ 932000p -0.3
+ 932010p 0.9
+ 934000p 0.9
+ 934010p -0.3
+ 936000p -0.3
+ 936010p 0.9
+ 938000p 0.9
+ 938010p -0.3
+ 940000p -0.3
+ 940010p 0.9
+ 942000p 0.9
+ 942010p -0.3
+ 944000p -0.3
+ 944010p 0.9
+ 946000p 0.9
+ 946010p -0.3
+ 948000p -0.3
+ 948010p 0.9
+ 950000p 0.9
+ 950010p -0.3
+ 952000p -0.3
+ 952010p 0.9
+ 954000p 0.9
+ 954010p -0.3
+ 956000p -0.3
+ 956010p 0.9
+ 958000p 0.9
+ 958010p -0.3
+ 960000p -0.3
+ 960010p 0.9
+ 962000p 0.9
+ 962010p -0.3
+ 964000p -0.3
+ 964010p 0.9
+ 966000p 0.9
+ 966010p -0.3
+ 968000p -0.3
+ 968010p 0.9
+ 970000p 0.9
+ 970010p -0.3
+ 972000p -0.3
+ 972010p 0.9
+ 974000p 0.9
+ 974010p -0.3
+ 976000p -0.3
+ 976010p 0.9
+ 978000p 0.9
+ 978010p -0.3
+ 980000p -0.3
+ 980010p 0.9
+ 982000p 0.9
+ 982010p -0.3
+ 984000p -0.3
+ 984010p 0.9
+ 986000p 0.9
+ 986010p -0.3
+ 988000p -0.3
+ 988010p 0.9
+ 990000p 0.9
+ 990010p -0.3
+ 992000p -0.3
+ 992010p 0.9
+ 994000p 0.9
+ 994010p -0.3
+ 996000p -0.3
+ 996010p 0.9
+ 998000p 0.9
+ 998010p -0.3
+ 1000000p -0.3
+ 1000010p 0.9
+ 1002000p 0.9
+ 1002010p -0.3
+ 1004000p -0.3
+ 1004010p 0.9
+ 1006000p 0.9
+ 1006010p -0.3
+ 1008000p -0.3
+ 1008010p 0.9
+ 1010000p 0.9
+ 1010010p -0.3
+ 1012000p -0.3
+ 1012010p 0.9
+ 1014000p 0.9
+ 1014010p -0.3
+ 1016000p -0.3
+ 1016010p 0.9
+ 1018000p 0.9
+ 1018010p -0.3
+ 1020000p -0.3
+ 1020010p 0.9
+ 1022000p 0.9
+ 1022010p -0.3
+ 1024000p -0.3
+ 1024010p 0.9
+ 1026000p 0.9
+ 1026010p -0.3
+ 1028000p -0.3
+ 1028010p 0.9
+ 1030000p 0.9
+ 1030010p -0.3
+ 1032000p -0.3
+ 1032010p 0.9
+ 1034000p 0.9
+ 1034010p -0.3
+ 1036000p -0.3
+ 1036010p 0.9
+ 1038000p 0.9
+ 1038010p -0.3
+ 1040000p -0.3
+ 1040010p 0.9
+ 1042000p 0.9
+ 1042010p -0.3
+ 1044000p -0.3
+ 1044010p 0.9
+ 1046000p 0.9
+ 1046010p -0.3
+ 1048000p -0.3
+ 1048010p 0.9
+ 1050000p 0.9
+ 1050010p -0.3
+ 1052000p -0.3
+ 1052010p 0.9
+ 1054000p 0.9
+ 1054010p -0.3
+ 1056000p -0.3
+ 1056010p 0.9
+ 1058000p 0.9
+ 1058010p -0.3
+ 1060000p -0.3
+ 1060010p 0.9
+ 1062000p 0.9
+ 1062010p -0.3
+ 1064000p -0.3
+ 1064010p 0.9
+ 1066000p 0.9
+ 1066010p -0.3
+ 1068000p -0.3
+ 1068010p 0.9
+ 1070000p 0.9
+ 1070010p -0.3
+ 1072000p -0.3
+ 1072010p 0.9
+ 1074000p 0.9
+ 1074010p -0.3
+ 1076000p -0.3
+ 1076010p 0.9
+ 1078000p 0.9
+ 1078010p -0.3
+ 1080000p -0.3
+ 1080010p 0.9
+ 1082000p 0.9
+ 1082010p -0.3
+ 1084000p -0.3
+ 1084010p 0.9
+ 1086000p 0.9
+ 1086010p -0.3
+ 1088000p -0.3
+ 1088010p 0.9
+ 1090000p 0.9
+ 1090010p -0.3
+ 1092000p -0.3
+ 1092010p 0.9
+ 1094000p 0.9
+ 1094010p -0.3
+ 1096000p -0.3
+ 1096010p 0.9
+ 1098000p 0.9
+ 1098010p -0.3
+ 1100000p -0.3
+ 1100010p 0.9
+ 1102000p 0.9
+ 1102010p -0.3
+ 1104000p -0.3
+ 1104010p 0.9
+ 1106000p 0.9
+ 1106010p -0.3
+ 1108000p -0.3
+ 1108010p 0.9
+ 1110000p 0.9
+ 1110010p -0.3
+ 1112000p -0.3
+ 1112010p 0.9
+ 1114000p 0.9
+ 1114010p -0.3
+ 1116000p -0.3
+ 1116010p 0.9
+ 1118000p 0.9
+ 1118010p -0.3
+ 1120000p -0.3
+ 1120010p 0.9
+ 1122000p 0.9
+ 1122010p -0.3
+ 1124000p -0.3
+ 1124010p 0.9
+ 1126000p 0.9
+ 1126010p -0.3
+ 1128000p -0.3
+ 1128010p 0.9
+ 1130000p 0.9
+ 1130010p -0.3
+ 1132000p -0.3
+ 1132010p 0.9
+ 1134000p 0.9
+ 1134010p -0.3
+ 1136000p -0.3
+ 1136010p 0.9
+ 1138000p 0.9
+ 1138010p -0.3
+ 1140000p -0.3
+ 1140010p 0.9
+ 1142000p 0.9
+ 1142010p -0.3
+ 1144000p -0.3
+ 1144010p 0.9
+ 1146000p 0.9
+ 1146010p -0.3
+ 1148000p -0.3
+ 1148010p 0.9
+ 1150000p 0.9
+ 1150010p -0.3
+ 1152000p -0.3
+ 1152010p 0.9
+ 1154000p 0.9
+ 1154010p -0.3
+ 1156000p -0.3
+ 1156010p 0.9
+ 1158000p 0.9
+ 1158010p -0.3
+ 1160000p -0.3
+ 1160010p 0.9
+ 1162000p 0.9
+ 1162010p -0.3
+ 1164000p -0.3
+ 1164010p 0.9
+ 1166000p 0.9
+ 1166010p -0.3
+ 1168000p -0.3
+ 1168010p 0.9
+ 1170000p 0.9
+ 1170010p -0.3
+ 1172000p -0.3
+ 1172010p 0.9
+ 1174000p 0.9
+ 1174010p -0.3
+ 1176000p -0.3
+ 1176010p 0.9
+ 1178000p 0.9
+ 1178010p -0.3
+ 1180000p -0.3
+ 1180010p 0.9
+ 1182000p 0.9
+ 1182010p -0.3
+ 1184000p -0.3
+ 1184010p 0.9
+ 1186000p 0.9
+ 1186010p -0.3
+ 1188000p -0.3
+ 1188010p 0.9
+ 1190000p 0.9
+ 1190010p -0.3
+ 1192000p -0.3
+ 1192010p 0.9
+ 1194000p 0.9
+ 1194010p -0.3
+ 1196000p -0.3
+ 1196010p 0.9
+ 1198000p 0.9
+ 1198010p -0.3
+ 1200000p -0.3
+ 1200010p 0.9
+ 1202000p 0.9
+ 1202010p -0.3
+ 1204000p -0.3
+ 1204010p 0.9
+ 1206000p 0.9
+ 1206010p -0.3
+ 1208000p -0.3
+ 1208010p 0.9
+ 1210000p 0.9
+ 1210010p -0.3
+ 1212000p -0.3
+ 1212010p 0.9
+ 1214000p 0.9
+ 1214010p -0.3
+ 1216000p -0.3
+ 1216010p 0.9
+ 1218000p 0.9
+ 1218010p -0.3
+ 1220000p -0.3
+ 1220010p 0.9
+ 1222000p 0.9
+ 1222010p -0.3
+ 1224000p -0.3
+ 1224010p 0.9
+ 1226000p 0.9
+ 1226010p -0.3
+ 1228000p -0.3
+ 1228010p 0.9
+ 1230000p 0.9
+ 1230010p -0.3
+ 1232000p -0.3
+ 1232010p 0.9
+ 1234000p 0.9
+ 1234010p -0.3
+ 1236000p -0.3
+ 1236010p 0.9
+ 1238000p 0.9
+ 1238010p -0.3
+ 1240000p -0.3
+ 1240010p 0.9
+ 1242000p 0.9
+ 1242010p -0.3
+ 1244000p -0.3
+ 1244010p 0.9
+ 1246000p 0.9
+ 1246010p -0.3
+ 1248000p -0.3
+ 1248010p 0.9
+ 1250000p 0.9
+ 1250010p -0.3
+ 1252000p -0.3
+ 1252010p 0.9
+ 1254000p 0.9
+ 1254010p -0.3
+ 1256000p -0.3
+ 1256010p 0.9
+ 1258000p 0.9
+ 1258010p -0.3
+ 1260000p -0.3
+ 1260010p 0.9
+ 1262000p 0.9
+ 1262010p -0.3
+ 1264000p -0.3
+ 1264010p 0.9
+ 1266000p 0.9
+ 1266010p -0.3
+ 1268000p -0.3
+ 1268010p 0.9
+ 1270000p 0.9
+ 1270010p -0.3
+ 1272000p -0.3
+ 1272010p 0.9
+ 1274000p 0.9
+ 1274010p -0.3
+ 1276000p -0.3
+ 1276010p 0.9
+ 1278000p 0.9
+ 1278010p -0.3
+ 1280000p -0.3
+ 1280010p 0.9
+ 1282000p 0.9
+ 1282010p -0.3
+ 1284000p -0.3
+ 1284010p 0.9
+ 1286000p 0.9
+ 1286010p -0.3
+ 1288000p -0.3
+ 1288010p 0.9
+ 1290000p 0.9
+ 1290010p -0.3
+ 1292000p -0.3
+ 1292010p 0.9
+ 1294000p 0.9
+ 1294010p -0.3
+ 1296000p -0.3
+ 1296010p 0.9
+ 1298000p 0.9
+ 1298010p -0.3
+ 1300000p -0.3
+ 1300010p 0.9
+ 1302000p 0.9
+ 1302010p -0.3
+ 1304000p -0.3
+ 1304010p 0.9
+ 1306000p 0.9
+ 1306010p -0.3
+ 1308000p -0.3
+ 1308010p 0.9
+ 1310000p 0.9
+ 1310010p -0.3
+ 1312000p -0.3
+ 1312010p 0.9
+ 1314000p 0.9
+ 1314010p -0.3
+ 1316000p -0.3
+ 1316010p 0.9
+ 1318000p 0.9
+ 1318010p -0.3
+ 1320000p -0.3
+ 1320010p 0.9
+ 1322000p 0.9
+ 1322010p -0.3
+ 1324000p -0.3
+ 1324010p 0.9
+ 1326000p 0.9
+ 1326010p -0.3
+ 1328000p -0.3
+ 1328010p 0.9
+ 1330000p 0.9
+ 1330010p -0.3
+ 1332000p -0.3
+ 1332010p 0.9
+ 1334000p 0.9
+ 1334010p -0.3
+ 1336000p -0.3
+ 1336010p 0.9
+ 1338000p 0.9
+ 1338010p -0.3
+ 1340000p -0.3
+ 1340010p 0.9
+ 1342000p 0.9
+ 1342010p -0.3
+ 1344000p -0.3
+ 1344010p 0.9
+ 1346000p 0.9
+ 1346010p -0.3
+ 1348000p -0.3
+ 1348010p 0.9
+ 1350000p 0.9
+ 1350010p -0.3
+ 1352000p -0.3
+ 1352010p 0.9
+ 1354000p 0.9
+ 1354010p -0.3
+ 1356000p -0.3
+ 1356010p 0.9
+ 1358000p 0.9
+ 1358010p -0.3
+ 1360000p -0.3
+ 1360010p 0.9
+ 1362000p 0.9
+ 1362010p -0.3
+ 1364000p -0.3
+ 1364010p 0.9
+ 1366000p 0.9
+ 1366010p -0.3
+ 1368000p -0.3
+ 1368010p 0.9
+ 1370000p 0.9
+ 1370010p -0.3
+ 1372000p -0.3
+ 1372010p 0.9
+ 1374000p 0.9
+ 1374010p -0.3
+ 1376000p -0.3
+ 1376010p 0.9
+ 1378000p 0.9
+ 1378010p -0.3
+ 1380000p -0.3
+ 1380010p 0.9
+ 1382000p 0.9
+ 1382010p -0.3
+ 1384000p -0.3
+ 1384010p 0.9
+ 1386000p 0.9
+ 1386010p -0.3
+ 1388000p -0.3
+ 1388010p 0.9
+ 1390000p 0.9
+ 1390010p -0.3
+ 1392000p -0.3
+ 1392010p 0.9
+ 1394000p 0.9
+ 1394010p -0.3
+ 1396000p -0.3
+ 1396010p 0.9
+ 1398000p 0.9
+ 1398010p -0.3
+ 1400000p -0.3
+ 1400010p 0.9
+ 1402000p 0.9
+ 1402010p -0.3
+ 1404000p -0.3
+ 1404010p 0.9
+ 1406000p 0.9
+ 1406010p -0.3
+ 1408000p -0.3
+ 1408010p 0.9
+ 1410000p 0.9
+ 1410010p -0.3
+ 1412000p -0.3
+ 1412010p 0.9
+ 1414000p 0.9
+ 1414010p -0.3
+ 1416000p -0.3
+ 1416010p 0.9
+ 1418000p 0.9
+ 1418010p -0.3
+ 1420000p -0.3
+ 1420010p 0.9
+ 1422000p 0.9
+ 1422010p -0.3
+ 1424000p -0.3
+ 1424010p 0.9
+ 1426000p 0.9
+ 1426010p -0.3
+ 1428000p -0.3
+ 1428010p 0.9
+ 1430000p 0.9
+ 1430010p -0.3
+ 1432000p -0.3
+ 1432010p 0.9
+ 1434000p 0.9
+ 1434010p -0.3
+ 1436000p -0.3
+ 1436010p 0.9
+ 1438000p 0.9
+ 1438010p -0.3
+ 1440000p -0.3
+ 1440010p 0.9
+ 1442000p 0.9
+ 1442010p -0.3
+ 1444000p -0.3
+ 1444010p 0.9
+ 1446000p 0.9
+ 1446010p -0.3
+ 1448000p -0.3
+ 1448010p 0.9
+ 1450000p 0.9
+ 1450010p -0.3
+ 1452000p -0.3
+ 1452010p 0.9
+ 1454000p 0.9
+ 1454010p -0.3
+ 1456000p -0.3
+ 1456010p 0.9
+ 1458000p 0.9
+ 1458010p -0.3
+ 1460000p -0.3
+ 1460010p 0.9
+ 1462000p 0.9
+ 1462010p -0.3
+ 1464000p -0.3
+ 1464010p 0.9
+ 1466000p 0.9
+ 1466010p -0.3
+ 1468000p -0.3
+ 1468010p 0.9
+ 1470000p 0.9
+ 1470010p -0.3
+ 1472000p -0.3
+ 1472010p 0.9
+ 1474000p 0.9
+ 1474010p -0.3
+ 1476000p -0.3
+ 1476010p 0.9
+ 1478000p 0.9
+ 1478010p -0.3
+ 1480000p -0.3
+ 1480010p 0.9
+ 1482000p 0.9
+ 1482010p -0.3
+ 1484000p -0.3
+ 1484010p 0.9
+ 1486000p 0.9
+ 1486010p -0.3
+ 1488000p -0.3
+ 1488010p 0.9
+ 1490000p 0.9
+ 1490010p -0.3
+ 1492000p -0.3
+ 1492010p 0.9
+ 1494000p 0.9
+ 1494010p -0.3
+ 1496000p -0.3
+ 1496010p 0.9
+ 1498000p 0.9
+ 1498010p -0.3
+ 1500000p -0.3
+ 1500010p 0.9
+ 1502000p 0.9
+ 1502010p -0.3
+ 1504000p -0.3
+ 1504010p 0.9
+ 1506000p 0.9
+ 1506010p -0.3
+ 1508000p -0.3
+ 1508010p 0.9
+ 1510000p 0.9
+ 1510010p -0.3
+ 1512000p -0.3
+ 1512010p 0.9
+ 1514000p 0.9
+ 1514010p -0.3
+ 1516000p -0.3
+ 1516010p 0.9
+ 1518000p 0.9
+ 1518010p -0.3
+ 1520000p -0.3
+ 1520010p 0.9
+ 1522000p 0.9
+ 1522010p -0.3
+ 1524000p -0.3
+ 1524010p 0.9
+ 1526000p 0.9
+ 1526010p -0.3
+ 1528000p -0.3
+ 1528010p 0.9
+ 1530000p 0.9
+ 1530010p -0.3
+ 1532000p -0.3
+ 1532010p 0.9
+ 1534000p 0.9
+ 1534010p -0.3
+ 1536000p -0.3
+ 1536010p 0.9
+ 1538000p 0.9
+ 1538010p -0.3
+ 1540000p -0.3
+ 1540010p 0.9
+ 1542000p 0.9
+ 1542010p -0.3
+ 1544000p -0.3
+ 1544010p 0.9
+ 1546000p 0.9
+ 1546010p -0.3
+ 1548000p -0.3
+ 1548010p 0.9
+ 1550000p 0.9
+ 1550010p -0.3
+ 1552000p -0.3
+ 1552010p 0.9
+ 1554000p 0.9
+ 1554010p -0.3
+ 1556000p -0.3
+ 1556010p 0.9
+ 1558000p 0.9
+ 1558010p -0.3
+ 1560000p -0.3
+ 1560010p 0.9
+ 1562000p 0.9
+ 1562010p -0.3
+ 1564000p -0.3
+ 1564010p 0.9
+ 1566000p 0.9
+ 1566010p -0.3
+ 1568000p -0.3
+ 1568010p 0.9
+ 1570000p 0.9
+ 1570010p -0.3
+ 1572000p -0.3
+ 1572010p 0.9
+ 1574000p 0.9
+ 1574010p -0.3
+ 1576000p -0.3
+ 1576010p 0.9
+ 1578000p 0.9
+ 1578010p -0.3
+ 1580000p -0.3
+ 1580010p 0.9
+ 1582000p 0.9
+ 1582010p -0.3
+ 1584000p -0.3
+ 1584010p 0.9
+ 1586000p 0.9
+ 1586010p -0.3
+ 1588000p -0.3
+ 1588010p 0.9
+ 1590000p 0.9
+ 1590010p -0.3
+ 1592000p -0.3
+ 1592010p 0.9
+ 1594000p 0.9
+ 1594010p -0.3
+ 1596000p -0.3
+ 1596010p 0.9
+ 1598000p 0.9
+ 1598010p -0.3
+ 1600000p -0.3
+ 1600010p 0.9
+ 1602000p 0.9
+ 1602010p -0.3
+ 1604000p -0.3
+ 1604010p 0.9
+ 1606000p 0.9
+ 1606010p -0.3
+ 1608000p -0.3
+ 1608010p 0.9
+ 1610000p 0.9
+ 1610010p -0.3
+ 1612000p -0.3
+ 1612010p 0.9
+ 1614000p 0.9
+ 1614010p -0.3
+ 1616000p -0.3
+ 1616010p 0.9
+ 1618000p 0.9
+ 1618010p -0.3
+ 1620000p -0.3
+ 1620010p 0.9
+ 1622000p 0.9
+ 1622010p -0.3
+ 1624000p -0.3
+ 1624010p 0.9
+ 1626000p 0.9
+ 1626010p -0.3
+ 1628000p -0.3
+ 1628010p 0.9
+ 1630000p 0.9
+ 1630010p -0.3
+ 1632000p -0.3
+ 1632010p 0.9
+ 1634000p 0.9
+ 1634010p -0.3
+ 1636000p -0.3
+ 1636010p 0.9
+ 1638000p 0.9
+ 1638010p -0.3
+ 1640000p -0.3
+ 1640010p 0.9
+ 1642000p 0.9
+ 1642010p -0.3
+ 1644000p -0.3
+ 1644010p 0.9
+ 1646000p 0.9
+ 1646010p -0.3
+ 1648000p -0.3
+ 1648010p 0.9
+ 1650000p 0.9
+ 1650010p -0.3
+ 1652000p -0.3
+ 1652010p 0.9
+ 1654000p 0.9
+ 1654010p -0.3
+ 1656000p -0.3
+ 1656010p 0.9
+ 1658000p 0.9
+ 1658010p -0.3
+ 1660000p -0.3
+ 1660010p 0.9
+ 1662000p 0.9
+ 1662010p -0.3
+ 1664000p -0.3
+ 1664010p 0.9
+ 1666000p 0.9
+ 1666010p -0.3
+ 1668000p -0.3
+ 1668010p 0.9
+ 1670000p 0.9
+ 1670010p -0.3
+ 1672000p -0.3
+ 1672010p 0.9
+ 1674000p 0.9
+ 1674010p -0.3
+ 1676000p -0.3
+ 1676010p 0.9
+ 1678000p 0.9
+ 1678010p -0.3
+ 1680000p -0.3
+ 1680010p 0.9
+ 1682000p 0.9
+ 1682010p -0.3
+ 1684000p -0.3
+ 1684010p 0.9
+ 1686000p 0.9
+ 1686010p -0.3
+ 1688000p -0.3
+ 1688010p 0.9
+ 1690000p 0.9
+ 1690010p -0.3
+ 1692000p -0.3
+ 1692010p 0.9
+ 1694000p 0.9
+ 1694010p -0.3
+ 1696000p -0.3
+ 1696010p 0.9
+ 1698000p 0.9
+ 1698010p -0.3
+ 1700000p -0.3
+ 1700010p 0.9
+ 1702000p 0.9
+ 1702010p -0.3
+ 1704000p -0.3
+ 1704010p 0.9
+ 1706000p 0.9
+ 1706010p -0.3
+ 1708000p -0.3
+ 1708010p 0.9
+ 1710000p 0.9
+ 1710010p -0.3
+ 1712000p -0.3
+ 1712010p 0.9
+ 1714000p 0.9
+ 1714010p -0.3
+ 1716000p -0.3
+ 1716010p 0.9
+ 1718000p 0.9
+ 1718010p -0.3
+ 1720000p -0.3
+ 1720010p 0.9
+ 1722000p 0.9
+ 1722010p -0.3
+ 1724000p -0.3
+ 1724010p 0.9
+ 1726000p 0.9
+ 1726010p -0.3
+ 1728000p -0.3
+ 1728010p 0.9
+ 1730000p 0.9
+ 1730010p -0.3
+ 1732000p -0.3
+ 1732010p 0.9
+ 1734000p 0.9
+ 1734010p -0.3
+ 1736000p -0.3
+ 1736010p 0.9
+ 1738000p 0.9
+ 1738010p -0.3
+ 1740000p -0.3
+ 1740010p 0.9
+ 1742000p 0.9
+ 1742010p -0.3
+ 1744000p -0.3
+ 1744010p 0.9
+ 1746000p 0.9
+ 1746010p -0.3
+ 1748000p -0.3
+ 1748010p 0.9
+ 1750000p 0.9
+ 1750010p -0.3
+ 1752000p -0.3
+ 1752010p 0.9
+ 1754000p 0.9
+ 1754010p -0.3
+ 1756000p -0.3
+ 1756010p 0.9
+ 1758000p 0.9
+ 1758010p -0.3
+ 1760000p -0.3
+ 1760010p 0.9
+ 1762000p 0.9
+ 1762010p -0.3
+ 1764000p -0.3
+ 1764010p 0.9
+ 1766000p 0.9
+ 1766010p -0.3
+ 1768000p -0.3
+ 1768010p 0.9
+ 1770000p 0.9
+ 1770010p -0.3
+ 1772000p -0.3
+ 1772010p 0.9
+ 1774000p 0.9
+ 1774010p -0.3
+ 1776000p -0.3
+ 1776010p 0.9
+ 1778000p 0.9
+ 1778010p -0.3
+ 1780000p -0.3
+ 1780010p 0.9
+ 1782000p 0.9
+ 1782010p -0.3
+ 1784000p -0.3
+ 1784010p 0.9
+ 1786000p 0.9
+ 1786010p -0.3
+ 1788000p -0.3
+ 1788010p 0.9
+ 1790000p 0.9
+ 1790010p -0.3
+ 1792000p -0.3
+ 1792010p 0.9
+ 1794000p 0.9
+ 1794010p -0.3
+ 1796000p -0.3
+ 1796010p 0.9
+ 1798000p 0.9
+ 1798010p -0.3
+ 1800000p -0.3
+ 1800010p 0.9
+ 1802000p 0.9
+ 1802010p -0.3
+ 1804000p -0.3
+ 1804010p 0.9
+ 1806000p 0.9
+ 1806010p -0.3
+ 1808000p -0.3
+ 1808010p 0.9
+ 1810000p 0.9
+ 1810010p -0.3
+ 1812000p -0.3
+ 1812010p 0.9
+ 1814000p 0.9
+ 1814010p -0.3
+ 1816000p -0.3
+ 1816010p 0.9
+ 1818000p 0.9
+ 1818010p -0.3
+ 1820000p -0.3
+ 1820010p 0.9
+ 1822000p 0.9
+ 1822010p -0.3
+ 1824000p -0.3
+ 1824010p 0.9
+ 1826000p 0.9
+ 1826010p -0.3
+ 1828000p -0.3
+ 1828010p 0.9
+ 1830000p 0.9
+ 1830010p -0.3
+ 1832000p -0.3
+ 1832010p 0.9
+ 1834000p 0.9
+ 1834010p -0.3
+ 1836000p -0.3
+ 1836010p 0.9
+ 1838000p 0.9
+ 1838010p -0.3
+ 1840000p -0.3
+ 1840010p 0.9
+ 1842000p 0.9
+ 1842010p -0.3
+ 1844000p -0.3
+ 1844010p 0.9
+ 1846000p 0.9
+ 1846010p -0.3
+ 1848000p -0.3
+ 1848010p 0.9
+ 1850000p 0.9
+ 1850010p -0.3
+ 1852000p -0.3
+ 1852010p 0.9
+ 1854000p 0.9
+ 1854010p -0.3
+ 1856000p -0.3
+ 1856010p 0.9
+ 1858000p 0.9
+ 1858010p -0.3
+ 1860000p -0.3
+ 1860010p 0.9
+ 1862000p 0.9
+ 1862010p -0.3
+ 1864000p -0.3
+ 1864010p 0.9
+ 1866000p 0.9
+ 1866010p -0.3
+ 1868000p -0.3
+ 1868010p 0.9
+ 1870000p 0.9
+ 1870010p -0.3
+ 1872000p -0.3
+ 1872010p 0.9
+ 1874000p 0.9
+ 1874010p -0.3
+ 1876000p -0.3
+ 1876010p 0.9
+ 1878000p 0.9
+ 1878010p -0.3
+ 1880000p -0.3
+ 1880010p 0.9
+ 1882000p 0.9
+ 1882010p -0.3
+ 1884000p -0.3
+ 1884010p 0.9
+ 1886000p 0.9
+ 1886010p -0.3
+ 1888000p -0.3
+ 1888010p 0.9
+ 1890000p 0.9
+ 1890010p -0.3
+ 1892000p -0.3
+ 1892010p 0.9
+ 1894000p 0.9
+ 1894010p -0.3
+ 1896000p -0.3
+ 1896010p 0.9
+ 1898000p 0.9
+ 1898010p -0.3
+ 1900000p -0.3
+ 1900010p 0.9
+ 1902000p 0.9
+ 1902010p -0.3
+ 1904000p -0.3
+ 1904010p 0.9
+ 1906000p 0.9
+ 1906010p -0.3
+ 1908000p -0.3
+ 1908010p 0.9
+ 1910000p 0.9
+ 1910010p -0.3
+ 1912000p -0.3
+ 1912010p 0.9
+ 1914000p 0.9
+ 1914010p -0.3
+ 1916000p -0.3
+ 1916010p 0.9
+ 1918000p 0.9
+ 1918010p -0.3
+ 1920000p -0.3
+ 1920010p 0.9
+ 1922000p 0.9
+ 1922010p -0.3
+ 1924000p -0.3
+ 1924010p 0.9
+ 1926000p 0.9
+ 1926010p -0.3
+ 1928000p -0.3
+ 1928010p 0.9
+ 1930000p 0.9
+ 1930010p -0.3
+ 1932000p -0.3
+ 1932010p 0.9
+ 1934000p 0.9
+ 1934010p -0.3
+ 1936000p -0.3
+ 1936010p 0.9
+ 1938000p 0.9
+ 1938010p -0.3
+ 1940000p -0.3
+ 1940010p 0.9
+ 1942000p 0.9
+ 1942010p -0.3
+ 1944000p -0.3
+ 1944010p 0.9
+ 1946000p 0.9
+ 1946010p -0.3
+ 1948000p -0.3
+ 1948010p 0.9
+ 1950000p 0.9
+ 1950010p -0.3
+ 1952000p -0.3
+ 1952010p 0.9
+ 1954000p 0.9
+ 1954010p -0.3
+ 1956000p -0.3
+ 1956010p 0.9
+ 1958000p 0.9
+ 1958010p -0.3
+ 1960000p -0.3
+ 1960010p 0.9
+ 1962000p 0.9
+ 1962010p -0.3
+ 1964000p -0.3
+ 1964010p 0.9
+ 1966000p 0.9
+ 1966010p -0.3
+ 1968000p -0.3
+ 1968010p 0.9
+ 1970000p 0.9
+ 1970010p -0.3
+ 1972000p -0.3
+ 1972010p 0.9
+ 1974000p 0.9
+ 1974010p -0.3
+ 1976000p -0.3
+ 1976010p 0.9
+ 1978000p 0.9
+ 1978010p -0.3
+ 1980000p -0.3
+ 1980010p 0.9
+ 1982000p 0.9
+ 1982010p -0.3
+ 1984000p -0.3
+ 1984010p 0.9
+ 1986000p 0.9
+ 1986010p -0.3
+ 1988000p -0.3
+ 1988010p 0.9
+ 1990000p 0.9
+ 1990010p -0.3
+ 1992000p -0.3
+ 1992010p 0.9
+ 1994000p 0.9
+ 1994010p -0.3
+ 1996000p -0.3
+ 1996010p 0.9
+ 1998000p 0.9
+ 1998010p -0.3
+ 2000000p -0.3
+ 2000010p 0.9
+ 2002000p 0.9
+ 2002010p -0.3
+ 2004000p -0.3
+ 2004010p 0.9
+ 2006000p 0.9
+ 2006010p -0.3
+ 2008000p -0.3
+ 2008010p 0.9
+ 2010000p 0.9
+ 2010010p -0.3
+ 2012000p -0.3
+ 2012010p 0.9
+ 2014000p 0.9
+ 2014010p -0.3
+ 2016000p -0.3
+ 2016010p 0.9
+ 2018000p 0.9
+ 2018010p -0.3
+ 2020000p -0.3
+ 2020010p 0.9
+ 2022000p 0.9
+ 2022010p -0.3
+ 2024000p -0.3
+ 2024010p 0.9
+ 2026000p 0.9
+ 2026010p -0.3
+ 2028000p -0.3
+ 2028010p 0.9
+ 2030000p 0.9
+ 2030010p -0.3
+ 2032000p -0.3
+ 2032010p 0.9
+ 2034000p 0.9
+ 2034010p -0.3
+ 2036000p -0.3
+ 2036010p 0.9
+ 2038000p 0.9
+ 2038010p -0.3
+ 2040000p -0.3
+ 2040010p 0.9
+ 2042000p 0.9
+ 2042010p -0.3
+ 2044000p -0.3
+ 2044010p 0.9
+ 2046000p 0.9
+ 2046010p -0.3
+ 2048000p -0.3
+ 2048010p 0.9
+ \]
V_data_bar_27 (Data_bar\\<27\\> gnd!) vsource type=pwl wave=\[
+ 0    -0.3
+ 2000p -0.3
+ 2010p 0.9
+ 4000p 0.9
+ 4010p -0.3
+ 6000p -0.3
+ 6010p 0.9
+ 8000p 0.9
+ 8010p -0.3
+ 10000p -0.3
+ 10010p 0.9
+ 12000p 0.9
+ 12010p -0.3
+ 14000p -0.3
+ 14010p 0.9
+ 16000p 0.9
+ 16010p -0.3
+ 18000p -0.3
+ 18010p 0.9
+ 20000p 0.9
+ 20010p -0.3
+ 22000p -0.3
+ 22010p 0.9
+ 24000p 0.9
+ 24010p -0.3
+ 26000p -0.3
+ 26010p 0.9
+ 28000p 0.9
+ 28010p -0.3
+ 30000p -0.3
+ 30010p 0.9
+ 32000p 0.9
+ 32010p -0.3
+ 34000p -0.3
+ 34010p 0.9
+ 36000p 0.9
+ 36010p -0.3
+ 38000p -0.3
+ 38010p 0.9
+ 40000p 0.9
+ 40010p -0.3
+ 42000p -0.3
+ 42010p 0.9
+ 44000p 0.9
+ 44010p -0.3
+ 46000p -0.3
+ 46010p 0.9
+ 48000p 0.9
+ 48010p -0.3
+ 50000p -0.3
+ 50010p 0.9
+ 52000p 0.9
+ 52010p -0.3
+ 54000p -0.3
+ 54010p 0.9
+ 56000p 0.9
+ 56010p -0.3
+ 58000p -0.3
+ 58010p 0.9
+ 60000p 0.9
+ 60010p -0.3
+ 62000p -0.3
+ 62010p 0.9
+ 64000p 0.9
+ 64010p -0.3
+ 66000p -0.3
+ 66010p 0.9
+ 68000p 0.9
+ 68010p -0.3
+ 70000p -0.3
+ 70010p 0.9
+ 72000p 0.9
+ 72010p -0.3
+ 74000p -0.3
+ 74010p 0.9
+ 76000p 0.9
+ 76010p -0.3
+ 78000p -0.3
+ 78010p 0.9
+ 80000p 0.9
+ 80010p -0.3
+ 82000p -0.3
+ 82010p 0.9
+ 84000p 0.9
+ 84010p -0.3
+ 86000p -0.3
+ 86010p 0.9
+ 88000p 0.9
+ 88010p -0.3
+ 90000p -0.3
+ 90010p 0.9
+ 92000p 0.9
+ 92010p -0.3
+ 94000p -0.3
+ 94010p 0.9
+ 96000p 0.9
+ 96010p -0.3
+ 98000p -0.3
+ 98010p 0.9
+ 100000p 0.9
+ 100010p -0.3
+ 102000p -0.3
+ 102010p 0.9
+ 104000p 0.9
+ 104010p -0.3
+ 106000p -0.3
+ 106010p 0.9
+ 108000p 0.9
+ 108010p -0.3
+ 110000p -0.3
+ 110010p 0.9
+ 112000p 0.9
+ 112010p -0.3
+ 114000p -0.3
+ 114010p 0.9
+ 116000p 0.9
+ 116010p -0.3
+ 118000p -0.3
+ 118010p 0.9
+ 120000p 0.9
+ 120010p -0.3
+ 122000p -0.3
+ 122010p 0.9
+ 124000p 0.9
+ 124010p -0.3
+ 126000p -0.3
+ 126010p 0.9
+ 128000p 0.9
+ 128010p -0.3
+ 130000p -0.3
+ 130010p 0.9
+ 132000p 0.9
+ 132010p -0.3
+ 134000p -0.3
+ 134010p 0.9
+ 136000p 0.9
+ 136010p -0.3
+ 138000p -0.3
+ 138010p 0.9
+ 140000p 0.9
+ 140010p -0.3
+ 142000p -0.3
+ 142010p 0.9
+ 144000p 0.9
+ 144010p -0.3
+ 146000p -0.3
+ 146010p 0.9
+ 148000p 0.9
+ 148010p -0.3
+ 150000p -0.3
+ 150010p 0.9
+ 152000p 0.9
+ 152010p -0.3
+ 154000p -0.3
+ 154010p 0.9
+ 156000p 0.9
+ 156010p -0.3
+ 158000p -0.3
+ 158010p 0.9
+ 160000p 0.9
+ 160010p -0.3
+ 162000p -0.3
+ 162010p 0.9
+ 164000p 0.9
+ 164010p -0.3
+ 166000p -0.3
+ 166010p 0.9
+ 168000p 0.9
+ 168010p -0.3
+ 170000p -0.3
+ 170010p 0.9
+ 172000p 0.9
+ 172010p -0.3
+ 174000p -0.3
+ 174010p 0.9
+ 176000p 0.9
+ 176010p -0.3
+ 178000p -0.3
+ 178010p 0.9
+ 180000p 0.9
+ 180010p -0.3
+ 182000p -0.3
+ 182010p 0.9
+ 184000p 0.9
+ 184010p -0.3
+ 186000p -0.3
+ 186010p 0.9
+ 188000p 0.9
+ 188010p -0.3
+ 190000p -0.3
+ 190010p 0.9
+ 192000p 0.9
+ 192010p -0.3
+ 194000p -0.3
+ 194010p 0.9
+ 196000p 0.9
+ 196010p -0.3
+ 198000p -0.3
+ 198010p 0.9
+ 200000p 0.9
+ 200010p -0.3
+ 202000p -0.3
+ 202010p 0.9
+ 204000p 0.9
+ 204010p -0.3
+ 206000p -0.3
+ 206010p 0.9
+ 208000p 0.9
+ 208010p -0.3
+ 210000p -0.3
+ 210010p 0.9
+ 212000p 0.9
+ 212010p -0.3
+ 214000p -0.3
+ 214010p 0.9
+ 216000p 0.9
+ 216010p -0.3
+ 218000p -0.3
+ 218010p 0.9
+ 220000p 0.9
+ 220010p -0.3
+ 222000p -0.3
+ 222010p 0.9
+ 224000p 0.9
+ 224010p -0.3
+ 226000p -0.3
+ 226010p 0.9
+ 228000p 0.9
+ 228010p -0.3
+ 230000p -0.3
+ 230010p 0.9
+ 232000p 0.9
+ 232010p -0.3
+ 234000p -0.3
+ 234010p 0.9
+ 236000p 0.9
+ 236010p -0.3
+ 238000p -0.3
+ 238010p 0.9
+ 240000p 0.9
+ 240010p -0.3
+ 242000p -0.3
+ 242010p 0.9
+ 244000p 0.9
+ 244010p -0.3
+ 246000p -0.3
+ 246010p 0.9
+ 248000p 0.9
+ 248010p -0.3
+ 250000p -0.3
+ 250010p 0.9
+ 252000p 0.9
+ 252010p -0.3
+ 254000p -0.3
+ 254010p 0.9
+ 256000p 0.9
+ 256010p -0.3
+ 258000p -0.3
+ 258010p 0.9
+ 260000p 0.9
+ 260010p -0.3
+ 262000p -0.3
+ 262010p 0.9
+ 264000p 0.9
+ 264010p -0.3
+ 266000p -0.3
+ 266010p 0.9
+ 268000p 0.9
+ 268010p -0.3
+ 270000p -0.3
+ 270010p 0.9
+ 272000p 0.9
+ 272010p -0.3
+ 274000p -0.3
+ 274010p 0.9
+ 276000p 0.9
+ 276010p -0.3
+ 278000p -0.3
+ 278010p 0.9
+ 280000p 0.9
+ 280010p -0.3
+ 282000p -0.3
+ 282010p 0.9
+ 284000p 0.9
+ 284010p -0.3
+ 286000p -0.3
+ 286010p 0.9
+ 288000p 0.9
+ 288010p -0.3
+ 290000p -0.3
+ 290010p 0.9
+ 292000p 0.9
+ 292010p -0.3
+ 294000p -0.3
+ 294010p 0.9
+ 296000p 0.9
+ 296010p -0.3
+ 298000p -0.3
+ 298010p 0.9
+ 300000p 0.9
+ 300010p -0.3
+ 302000p -0.3
+ 302010p 0.9
+ 304000p 0.9
+ 304010p -0.3
+ 306000p -0.3
+ 306010p 0.9
+ 308000p 0.9
+ 308010p -0.3
+ 310000p -0.3
+ 310010p 0.9
+ 312000p 0.9
+ 312010p -0.3
+ 314000p -0.3
+ 314010p 0.9
+ 316000p 0.9
+ 316010p -0.3
+ 318000p -0.3
+ 318010p 0.9
+ 320000p 0.9
+ 320010p -0.3
+ 322000p -0.3
+ 322010p 0.9
+ 324000p 0.9
+ 324010p -0.3
+ 326000p -0.3
+ 326010p 0.9
+ 328000p 0.9
+ 328010p -0.3
+ 330000p -0.3
+ 330010p 0.9
+ 332000p 0.9
+ 332010p -0.3
+ 334000p -0.3
+ 334010p 0.9
+ 336000p 0.9
+ 336010p -0.3
+ 338000p -0.3
+ 338010p 0.9
+ 340000p 0.9
+ 340010p -0.3
+ 342000p -0.3
+ 342010p 0.9
+ 344000p 0.9
+ 344010p -0.3
+ 346000p -0.3
+ 346010p 0.9
+ 348000p 0.9
+ 348010p -0.3
+ 350000p -0.3
+ 350010p 0.9
+ 352000p 0.9
+ 352010p -0.3
+ 354000p -0.3
+ 354010p 0.9
+ 356000p 0.9
+ 356010p -0.3
+ 358000p -0.3
+ 358010p 0.9
+ 360000p 0.9
+ 360010p -0.3
+ 362000p -0.3
+ 362010p 0.9
+ 364000p 0.9
+ 364010p -0.3
+ 366000p -0.3
+ 366010p 0.9
+ 368000p 0.9
+ 368010p -0.3
+ 370000p -0.3
+ 370010p 0.9
+ 372000p 0.9
+ 372010p -0.3
+ 374000p -0.3
+ 374010p 0.9
+ 376000p 0.9
+ 376010p -0.3
+ 378000p -0.3
+ 378010p 0.9
+ 380000p 0.9
+ 380010p -0.3
+ 382000p -0.3
+ 382010p 0.9
+ 384000p 0.9
+ 384010p -0.3
+ 386000p -0.3
+ 386010p 0.9
+ 388000p 0.9
+ 388010p -0.3
+ 390000p -0.3
+ 390010p 0.9
+ 392000p 0.9
+ 392010p -0.3
+ 394000p -0.3
+ 394010p 0.9
+ 396000p 0.9
+ 396010p -0.3
+ 398000p -0.3
+ 398010p 0.9
+ 400000p 0.9
+ 400010p -0.3
+ 402000p -0.3
+ 402010p 0.9
+ 404000p 0.9
+ 404010p -0.3
+ 406000p -0.3
+ 406010p 0.9
+ 408000p 0.9
+ 408010p -0.3
+ 410000p -0.3
+ 410010p 0.9
+ 412000p 0.9
+ 412010p -0.3
+ 414000p -0.3
+ 414010p 0.9
+ 416000p 0.9
+ 416010p -0.3
+ 418000p -0.3
+ 418010p 0.9
+ 420000p 0.9
+ 420010p -0.3
+ 422000p -0.3
+ 422010p 0.9
+ 424000p 0.9
+ 424010p -0.3
+ 426000p -0.3
+ 426010p 0.9
+ 428000p 0.9
+ 428010p -0.3
+ 430000p -0.3
+ 430010p 0.9
+ 432000p 0.9
+ 432010p -0.3
+ 434000p -0.3
+ 434010p 0.9
+ 436000p 0.9
+ 436010p -0.3
+ 438000p -0.3
+ 438010p 0.9
+ 440000p 0.9
+ 440010p -0.3
+ 442000p -0.3
+ 442010p 0.9
+ 444000p 0.9
+ 444010p -0.3
+ 446000p -0.3
+ 446010p 0.9
+ 448000p 0.9
+ 448010p -0.3
+ 450000p -0.3
+ 450010p 0.9
+ 452000p 0.9
+ 452010p -0.3
+ 454000p -0.3
+ 454010p 0.9
+ 456000p 0.9
+ 456010p -0.3
+ 458000p -0.3
+ 458010p 0.9
+ 460000p 0.9
+ 460010p -0.3
+ 462000p -0.3
+ 462010p 0.9
+ 464000p 0.9
+ 464010p -0.3
+ 466000p -0.3
+ 466010p 0.9
+ 468000p 0.9
+ 468010p -0.3
+ 470000p -0.3
+ 470010p 0.9
+ 472000p 0.9
+ 472010p -0.3
+ 474000p -0.3
+ 474010p 0.9
+ 476000p 0.9
+ 476010p -0.3
+ 478000p -0.3
+ 478010p 0.9
+ 480000p 0.9
+ 480010p -0.3
+ 482000p -0.3
+ 482010p 0.9
+ 484000p 0.9
+ 484010p -0.3
+ 486000p -0.3
+ 486010p 0.9
+ 488000p 0.9
+ 488010p -0.3
+ 490000p -0.3
+ 490010p 0.9
+ 492000p 0.9
+ 492010p -0.3
+ 494000p -0.3
+ 494010p 0.9
+ 496000p 0.9
+ 496010p -0.3
+ 498000p -0.3
+ 498010p 0.9
+ 500000p 0.9
+ 500010p -0.3
+ 502000p -0.3
+ 502010p 0.9
+ 504000p 0.9
+ 504010p -0.3
+ 506000p -0.3
+ 506010p 0.9
+ 508000p 0.9
+ 508010p -0.3
+ 510000p -0.3
+ 510010p 0.9
+ 512000p 0.9
+ 512010p -0.3
+ 514000p -0.3
+ 514010p 0.9
+ 516000p 0.9
+ 516010p -0.3
+ 518000p -0.3
+ 518010p 0.9
+ 520000p 0.9
+ 520010p -0.3
+ 522000p -0.3
+ 522010p 0.9
+ 524000p 0.9
+ 524010p -0.3
+ 526000p -0.3
+ 526010p 0.9
+ 528000p 0.9
+ 528010p -0.3
+ 530000p -0.3
+ 530010p 0.9
+ 532000p 0.9
+ 532010p -0.3
+ 534000p -0.3
+ 534010p 0.9
+ 536000p 0.9
+ 536010p -0.3
+ 538000p -0.3
+ 538010p 0.9
+ 540000p 0.9
+ 540010p -0.3
+ 542000p -0.3
+ 542010p 0.9
+ 544000p 0.9
+ 544010p -0.3
+ 546000p -0.3
+ 546010p 0.9
+ 548000p 0.9
+ 548010p -0.3
+ 550000p -0.3
+ 550010p 0.9
+ 552000p 0.9
+ 552010p -0.3
+ 554000p -0.3
+ 554010p 0.9
+ 556000p 0.9
+ 556010p -0.3
+ 558000p -0.3
+ 558010p 0.9
+ 560000p 0.9
+ 560010p -0.3
+ 562000p -0.3
+ 562010p 0.9
+ 564000p 0.9
+ 564010p -0.3
+ 566000p -0.3
+ 566010p 0.9
+ 568000p 0.9
+ 568010p -0.3
+ 570000p -0.3
+ 570010p 0.9
+ 572000p 0.9
+ 572010p -0.3
+ 574000p -0.3
+ 574010p 0.9
+ 576000p 0.9
+ 576010p -0.3
+ 578000p -0.3
+ 578010p 0.9
+ 580000p 0.9
+ 580010p -0.3
+ 582000p -0.3
+ 582010p 0.9
+ 584000p 0.9
+ 584010p -0.3
+ 586000p -0.3
+ 586010p 0.9
+ 588000p 0.9
+ 588010p -0.3
+ 590000p -0.3
+ 590010p 0.9
+ 592000p 0.9
+ 592010p -0.3
+ 594000p -0.3
+ 594010p 0.9
+ 596000p 0.9
+ 596010p -0.3
+ 598000p -0.3
+ 598010p 0.9
+ 600000p 0.9
+ 600010p -0.3
+ 602000p -0.3
+ 602010p 0.9
+ 604000p 0.9
+ 604010p -0.3
+ 606000p -0.3
+ 606010p 0.9
+ 608000p 0.9
+ 608010p -0.3
+ 610000p -0.3
+ 610010p 0.9
+ 612000p 0.9
+ 612010p -0.3
+ 614000p -0.3
+ 614010p 0.9
+ 616000p 0.9
+ 616010p -0.3
+ 618000p -0.3
+ 618010p 0.9
+ 620000p 0.9
+ 620010p -0.3
+ 622000p -0.3
+ 622010p 0.9
+ 624000p 0.9
+ 624010p -0.3
+ 626000p -0.3
+ 626010p 0.9
+ 628000p 0.9
+ 628010p -0.3
+ 630000p -0.3
+ 630010p 0.9
+ 632000p 0.9
+ 632010p -0.3
+ 634000p -0.3
+ 634010p 0.9
+ 636000p 0.9
+ 636010p -0.3
+ 638000p -0.3
+ 638010p 0.9
+ 640000p 0.9
+ 640010p -0.3
+ 642000p -0.3
+ 642010p 0.9
+ 644000p 0.9
+ 644010p -0.3
+ 646000p -0.3
+ 646010p 0.9
+ 648000p 0.9
+ 648010p -0.3
+ 650000p -0.3
+ 650010p 0.9
+ 652000p 0.9
+ 652010p -0.3
+ 654000p -0.3
+ 654010p 0.9
+ 656000p 0.9
+ 656010p -0.3
+ 658000p -0.3
+ 658010p 0.9
+ 660000p 0.9
+ 660010p -0.3
+ 662000p -0.3
+ 662010p 0.9
+ 664000p 0.9
+ 664010p -0.3
+ 666000p -0.3
+ 666010p 0.9
+ 668000p 0.9
+ 668010p -0.3
+ 670000p -0.3
+ 670010p 0.9
+ 672000p 0.9
+ 672010p -0.3
+ 674000p -0.3
+ 674010p 0.9
+ 676000p 0.9
+ 676010p -0.3
+ 678000p -0.3
+ 678010p 0.9
+ 680000p 0.9
+ 680010p -0.3
+ 682000p -0.3
+ 682010p 0.9
+ 684000p 0.9
+ 684010p -0.3
+ 686000p -0.3
+ 686010p 0.9
+ 688000p 0.9
+ 688010p -0.3
+ 690000p -0.3
+ 690010p 0.9
+ 692000p 0.9
+ 692010p -0.3
+ 694000p -0.3
+ 694010p 0.9
+ 696000p 0.9
+ 696010p -0.3
+ 698000p -0.3
+ 698010p 0.9
+ 700000p 0.9
+ 700010p -0.3
+ 702000p -0.3
+ 702010p 0.9
+ 704000p 0.9
+ 704010p -0.3
+ 706000p -0.3
+ 706010p 0.9
+ 708000p 0.9
+ 708010p -0.3
+ 710000p -0.3
+ 710010p 0.9
+ 712000p 0.9
+ 712010p -0.3
+ 714000p -0.3
+ 714010p 0.9
+ 716000p 0.9
+ 716010p -0.3
+ 718000p -0.3
+ 718010p 0.9
+ 720000p 0.9
+ 720010p -0.3
+ 722000p -0.3
+ 722010p 0.9
+ 724000p 0.9
+ 724010p -0.3
+ 726000p -0.3
+ 726010p 0.9
+ 728000p 0.9
+ 728010p -0.3
+ 730000p -0.3
+ 730010p 0.9
+ 732000p 0.9
+ 732010p -0.3
+ 734000p -0.3
+ 734010p 0.9
+ 736000p 0.9
+ 736010p -0.3
+ 738000p -0.3
+ 738010p 0.9
+ 740000p 0.9
+ 740010p -0.3
+ 742000p -0.3
+ 742010p 0.9
+ 744000p 0.9
+ 744010p -0.3
+ 746000p -0.3
+ 746010p 0.9
+ 748000p 0.9
+ 748010p -0.3
+ 750000p -0.3
+ 750010p 0.9
+ 752000p 0.9
+ 752010p -0.3
+ 754000p -0.3
+ 754010p 0.9
+ 756000p 0.9
+ 756010p -0.3
+ 758000p -0.3
+ 758010p 0.9
+ 760000p 0.9
+ 760010p -0.3
+ 762000p -0.3
+ 762010p 0.9
+ 764000p 0.9
+ 764010p -0.3
+ 766000p -0.3
+ 766010p 0.9
+ 768000p 0.9
+ 768010p -0.3
+ 770000p -0.3
+ 770010p 0.9
+ 772000p 0.9
+ 772010p -0.3
+ 774000p -0.3
+ 774010p 0.9
+ 776000p 0.9
+ 776010p -0.3
+ 778000p -0.3
+ 778010p 0.9
+ 780000p 0.9
+ 780010p -0.3
+ 782000p -0.3
+ 782010p 0.9
+ 784000p 0.9
+ 784010p -0.3
+ 786000p -0.3
+ 786010p 0.9
+ 788000p 0.9
+ 788010p -0.3
+ 790000p -0.3
+ 790010p 0.9
+ 792000p 0.9
+ 792010p -0.3
+ 794000p -0.3
+ 794010p 0.9
+ 796000p 0.9
+ 796010p -0.3
+ 798000p -0.3
+ 798010p 0.9
+ 800000p 0.9
+ 800010p -0.3
+ 802000p -0.3
+ 802010p 0.9
+ 804000p 0.9
+ 804010p -0.3
+ 806000p -0.3
+ 806010p 0.9
+ 808000p 0.9
+ 808010p -0.3
+ 810000p -0.3
+ 810010p 0.9
+ 812000p 0.9
+ 812010p -0.3
+ 814000p -0.3
+ 814010p 0.9
+ 816000p 0.9
+ 816010p -0.3
+ 818000p -0.3
+ 818010p 0.9
+ 820000p 0.9
+ 820010p -0.3
+ 822000p -0.3
+ 822010p 0.9
+ 824000p 0.9
+ 824010p -0.3
+ 826000p -0.3
+ 826010p 0.9
+ 828000p 0.9
+ 828010p -0.3
+ 830000p -0.3
+ 830010p 0.9
+ 832000p 0.9
+ 832010p -0.3
+ 834000p -0.3
+ 834010p 0.9
+ 836000p 0.9
+ 836010p -0.3
+ 838000p -0.3
+ 838010p 0.9
+ 840000p 0.9
+ 840010p -0.3
+ 842000p -0.3
+ 842010p 0.9
+ 844000p 0.9
+ 844010p -0.3
+ 846000p -0.3
+ 846010p 0.9
+ 848000p 0.9
+ 848010p -0.3
+ 850000p -0.3
+ 850010p 0.9
+ 852000p 0.9
+ 852010p -0.3
+ 854000p -0.3
+ 854010p 0.9
+ 856000p 0.9
+ 856010p -0.3
+ 858000p -0.3
+ 858010p 0.9
+ 860000p 0.9
+ 860010p -0.3
+ 862000p -0.3
+ 862010p 0.9
+ 864000p 0.9
+ 864010p -0.3
+ 866000p -0.3
+ 866010p 0.9
+ 868000p 0.9
+ 868010p -0.3
+ 870000p -0.3
+ 870010p 0.9
+ 872000p 0.9
+ 872010p -0.3
+ 874000p -0.3
+ 874010p 0.9
+ 876000p 0.9
+ 876010p -0.3
+ 878000p -0.3
+ 878010p 0.9
+ 880000p 0.9
+ 880010p -0.3
+ 882000p -0.3
+ 882010p 0.9
+ 884000p 0.9
+ 884010p -0.3
+ 886000p -0.3
+ 886010p 0.9
+ 888000p 0.9
+ 888010p -0.3
+ 890000p -0.3
+ 890010p 0.9
+ 892000p 0.9
+ 892010p -0.3
+ 894000p -0.3
+ 894010p 0.9
+ 896000p 0.9
+ 896010p -0.3
+ 898000p -0.3
+ 898010p 0.9
+ 900000p 0.9
+ 900010p -0.3
+ 902000p -0.3
+ 902010p 0.9
+ 904000p 0.9
+ 904010p -0.3
+ 906000p -0.3
+ 906010p 0.9
+ 908000p 0.9
+ 908010p -0.3
+ 910000p -0.3
+ 910010p 0.9
+ 912000p 0.9
+ 912010p -0.3
+ 914000p -0.3
+ 914010p 0.9
+ 916000p 0.9
+ 916010p -0.3
+ 918000p -0.3
+ 918010p 0.9
+ 920000p 0.9
+ 920010p -0.3
+ 922000p -0.3
+ 922010p 0.9
+ 924000p 0.9
+ 924010p -0.3
+ 926000p -0.3
+ 926010p 0.9
+ 928000p 0.9
+ 928010p -0.3
+ 930000p -0.3
+ 930010p 0.9
+ 932000p 0.9
+ 932010p -0.3
+ 934000p -0.3
+ 934010p 0.9
+ 936000p 0.9
+ 936010p -0.3
+ 938000p -0.3
+ 938010p 0.9
+ 940000p 0.9
+ 940010p -0.3
+ 942000p -0.3
+ 942010p 0.9
+ 944000p 0.9
+ 944010p -0.3
+ 946000p -0.3
+ 946010p 0.9
+ 948000p 0.9
+ 948010p -0.3
+ 950000p -0.3
+ 950010p 0.9
+ 952000p 0.9
+ 952010p -0.3
+ 954000p -0.3
+ 954010p 0.9
+ 956000p 0.9
+ 956010p -0.3
+ 958000p -0.3
+ 958010p 0.9
+ 960000p 0.9
+ 960010p -0.3
+ 962000p -0.3
+ 962010p 0.9
+ 964000p 0.9
+ 964010p -0.3
+ 966000p -0.3
+ 966010p 0.9
+ 968000p 0.9
+ 968010p -0.3
+ 970000p -0.3
+ 970010p 0.9
+ 972000p 0.9
+ 972010p -0.3
+ 974000p -0.3
+ 974010p 0.9
+ 976000p 0.9
+ 976010p -0.3
+ 978000p -0.3
+ 978010p 0.9
+ 980000p 0.9
+ 980010p -0.3
+ 982000p -0.3
+ 982010p 0.9
+ 984000p 0.9
+ 984010p -0.3
+ 986000p -0.3
+ 986010p 0.9
+ 988000p 0.9
+ 988010p -0.3
+ 990000p -0.3
+ 990010p 0.9
+ 992000p 0.9
+ 992010p -0.3
+ 994000p -0.3
+ 994010p 0.9
+ 996000p 0.9
+ 996010p -0.3
+ 998000p -0.3
+ 998010p 0.9
+ 1000000p 0.9
+ 1000010p -0.3
+ 1002000p -0.3
+ 1002010p 0.9
+ 1004000p 0.9
+ 1004010p -0.3
+ 1006000p -0.3
+ 1006010p 0.9
+ 1008000p 0.9
+ 1008010p -0.3
+ 1010000p -0.3
+ 1010010p 0.9
+ 1012000p 0.9
+ 1012010p -0.3
+ 1014000p -0.3
+ 1014010p 0.9
+ 1016000p 0.9
+ 1016010p -0.3
+ 1018000p -0.3
+ 1018010p 0.9
+ 1020000p 0.9
+ 1020010p -0.3
+ 1022000p -0.3
+ 1022010p 0.9
+ 1024000p 0.9
+ 1024010p -0.3
+ 1026000p -0.3
+ 1026010p 0.9
+ 1028000p 0.9
+ 1028010p -0.3
+ 1030000p -0.3
+ 1030010p 0.9
+ 1032000p 0.9
+ 1032010p -0.3
+ 1034000p -0.3
+ 1034010p 0.9
+ 1036000p 0.9
+ 1036010p -0.3
+ 1038000p -0.3
+ 1038010p 0.9
+ 1040000p 0.9
+ 1040010p -0.3
+ 1042000p -0.3
+ 1042010p 0.9
+ 1044000p 0.9
+ 1044010p -0.3
+ 1046000p -0.3
+ 1046010p 0.9
+ 1048000p 0.9
+ 1048010p -0.3
+ 1050000p -0.3
+ 1050010p 0.9
+ 1052000p 0.9
+ 1052010p -0.3
+ 1054000p -0.3
+ 1054010p 0.9
+ 1056000p 0.9
+ 1056010p -0.3
+ 1058000p -0.3
+ 1058010p 0.9
+ 1060000p 0.9
+ 1060010p -0.3
+ 1062000p -0.3
+ 1062010p 0.9
+ 1064000p 0.9
+ 1064010p -0.3
+ 1066000p -0.3
+ 1066010p 0.9
+ 1068000p 0.9
+ 1068010p -0.3
+ 1070000p -0.3
+ 1070010p 0.9
+ 1072000p 0.9
+ 1072010p -0.3
+ 1074000p -0.3
+ 1074010p 0.9
+ 1076000p 0.9
+ 1076010p -0.3
+ 1078000p -0.3
+ 1078010p 0.9
+ 1080000p 0.9
+ 1080010p -0.3
+ 1082000p -0.3
+ 1082010p 0.9
+ 1084000p 0.9
+ 1084010p -0.3
+ 1086000p -0.3
+ 1086010p 0.9
+ 1088000p 0.9
+ 1088010p -0.3
+ 1090000p -0.3
+ 1090010p 0.9
+ 1092000p 0.9
+ 1092010p -0.3
+ 1094000p -0.3
+ 1094010p 0.9
+ 1096000p 0.9
+ 1096010p -0.3
+ 1098000p -0.3
+ 1098010p 0.9
+ 1100000p 0.9
+ 1100010p -0.3
+ 1102000p -0.3
+ 1102010p 0.9
+ 1104000p 0.9
+ 1104010p -0.3
+ 1106000p -0.3
+ 1106010p 0.9
+ 1108000p 0.9
+ 1108010p -0.3
+ 1110000p -0.3
+ 1110010p 0.9
+ 1112000p 0.9
+ 1112010p -0.3
+ 1114000p -0.3
+ 1114010p 0.9
+ 1116000p 0.9
+ 1116010p -0.3
+ 1118000p -0.3
+ 1118010p 0.9
+ 1120000p 0.9
+ 1120010p -0.3
+ 1122000p -0.3
+ 1122010p 0.9
+ 1124000p 0.9
+ 1124010p -0.3
+ 1126000p -0.3
+ 1126010p 0.9
+ 1128000p 0.9
+ 1128010p -0.3
+ 1130000p -0.3
+ 1130010p 0.9
+ 1132000p 0.9
+ 1132010p -0.3
+ 1134000p -0.3
+ 1134010p 0.9
+ 1136000p 0.9
+ 1136010p -0.3
+ 1138000p -0.3
+ 1138010p 0.9
+ 1140000p 0.9
+ 1140010p -0.3
+ 1142000p -0.3
+ 1142010p 0.9
+ 1144000p 0.9
+ 1144010p -0.3
+ 1146000p -0.3
+ 1146010p 0.9
+ 1148000p 0.9
+ 1148010p -0.3
+ 1150000p -0.3
+ 1150010p 0.9
+ 1152000p 0.9
+ 1152010p -0.3
+ 1154000p -0.3
+ 1154010p 0.9
+ 1156000p 0.9
+ 1156010p -0.3
+ 1158000p -0.3
+ 1158010p 0.9
+ 1160000p 0.9
+ 1160010p -0.3
+ 1162000p -0.3
+ 1162010p 0.9
+ 1164000p 0.9
+ 1164010p -0.3
+ 1166000p -0.3
+ 1166010p 0.9
+ 1168000p 0.9
+ 1168010p -0.3
+ 1170000p -0.3
+ 1170010p 0.9
+ 1172000p 0.9
+ 1172010p -0.3
+ 1174000p -0.3
+ 1174010p 0.9
+ 1176000p 0.9
+ 1176010p -0.3
+ 1178000p -0.3
+ 1178010p 0.9
+ 1180000p 0.9
+ 1180010p -0.3
+ 1182000p -0.3
+ 1182010p 0.9
+ 1184000p 0.9
+ 1184010p -0.3
+ 1186000p -0.3
+ 1186010p 0.9
+ 1188000p 0.9
+ 1188010p -0.3
+ 1190000p -0.3
+ 1190010p 0.9
+ 1192000p 0.9
+ 1192010p -0.3
+ 1194000p -0.3
+ 1194010p 0.9
+ 1196000p 0.9
+ 1196010p -0.3
+ 1198000p -0.3
+ 1198010p 0.9
+ 1200000p 0.9
+ 1200010p -0.3
+ 1202000p -0.3
+ 1202010p 0.9
+ 1204000p 0.9
+ 1204010p -0.3
+ 1206000p -0.3
+ 1206010p 0.9
+ 1208000p 0.9
+ 1208010p -0.3
+ 1210000p -0.3
+ 1210010p 0.9
+ 1212000p 0.9
+ 1212010p -0.3
+ 1214000p -0.3
+ 1214010p 0.9
+ 1216000p 0.9
+ 1216010p -0.3
+ 1218000p -0.3
+ 1218010p 0.9
+ 1220000p 0.9
+ 1220010p -0.3
+ 1222000p -0.3
+ 1222010p 0.9
+ 1224000p 0.9
+ 1224010p -0.3
+ 1226000p -0.3
+ 1226010p 0.9
+ 1228000p 0.9
+ 1228010p -0.3
+ 1230000p -0.3
+ 1230010p 0.9
+ 1232000p 0.9
+ 1232010p -0.3
+ 1234000p -0.3
+ 1234010p 0.9
+ 1236000p 0.9
+ 1236010p -0.3
+ 1238000p -0.3
+ 1238010p 0.9
+ 1240000p 0.9
+ 1240010p -0.3
+ 1242000p -0.3
+ 1242010p 0.9
+ 1244000p 0.9
+ 1244010p -0.3
+ 1246000p -0.3
+ 1246010p 0.9
+ 1248000p 0.9
+ 1248010p -0.3
+ 1250000p -0.3
+ 1250010p 0.9
+ 1252000p 0.9
+ 1252010p -0.3
+ 1254000p -0.3
+ 1254010p 0.9
+ 1256000p 0.9
+ 1256010p -0.3
+ 1258000p -0.3
+ 1258010p 0.9
+ 1260000p 0.9
+ 1260010p -0.3
+ 1262000p -0.3
+ 1262010p 0.9
+ 1264000p 0.9
+ 1264010p -0.3
+ 1266000p -0.3
+ 1266010p 0.9
+ 1268000p 0.9
+ 1268010p -0.3
+ 1270000p -0.3
+ 1270010p 0.9
+ 1272000p 0.9
+ 1272010p -0.3
+ 1274000p -0.3
+ 1274010p 0.9
+ 1276000p 0.9
+ 1276010p -0.3
+ 1278000p -0.3
+ 1278010p 0.9
+ 1280000p 0.9
+ 1280010p -0.3
+ 1282000p -0.3
+ 1282010p 0.9
+ 1284000p 0.9
+ 1284010p -0.3
+ 1286000p -0.3
+ 1286010p 0.9
+ 1288000p 0.9
+ 1288010p -0.3
+ 1290000p -0.3
+ 1290010p 0.9
+ 1292000p 0.9
+ 1292010p -0.3
+ 1294000p -0.3
+ 1294010p 0.9
+ 1296000p 0.9
+ 1296010p -0.3
+ 1298000p -0.3
+ 1298010p 0.9
+ 1300000p 0.9
+ 1300010p -0.3
+ 1302000p -0.3
+ 1302010p 0.9
+ 1304000p 0.9
+ 1304010p -0.3
+ 1306000p -0.3
+ 1306010p 0.9
+ 1308000p 0.9
+ 1308010p -0.3
+ 1310000p -0.3
+ 1310010p 0.9
+ 1312000p 0.9
+ 1312010p -0.3
+ 1314000p -0.3
+ 1314010p 0.9
+ 1316000p 0.9
+ 1316010p -0.3
+ 1318000p -0.3
+ 1318010p 0.9
+ 1320000p 0.9
+ 1320010p -0.3
+ 1322000p -0.3
+ 1322010p 0.9
+ 1324000p 0.9
+ 1324010p -0.3
+ 1326000p -0.3
+ 1326010p 0.9
+ 1328000p 0.9
+ 1328010p -0.3
+ 1330000p -0.3
+ 1330010p 0.9
+ 1332000p 0.9
+ 1332010p -0.3
+ 1334000p -0.3
+ 1334010p 0.9
+ 1336000p 0.9
+ 1336010p -0.3
+ 1338000p -0.3
+ 1338010p 0.9
+ 1340000p 0.9
+ 1340010p -0.3
+ 1342000p -0.3
+ 1342010p 0.9
+ 1344000p 0.9
+ 1344010p -0.3
+ 1346000p -0.3
+ 1346010p 0.9
+ 1348000p 0.9
+ 1348010p -0.3
+ 1350000p -0.3
+ 1350010p 0.9
+ 1352000p 0.9
+ 1352010p -0.3
+ 1354000p -0.3
+ 1354010p 0.9
+ 1356000p 0.9
+ 1356010p -0.3
+ 1358000p -0.3
+ 1358010p 0.9
+ 1360000p 0.9
+ 1360010p -0.3
+ 1362000p -0.3
+ 1362010p 0.9
+ 1364000p 0.9
+ 1364010p -0.3
+ 1366000p -0.3
+ 1366010p 0.9
+ 1368000p 0.9
+ 1368010p -0.3
+ 1370000p -0.3
+ 1370010p 0.9
+ 1372000p 0.9
+ 1372010p -0.3
+ 1374000p -0.3
+ 1374010p 0.9
+ 1376000p 0.9
+ 1376010p -0.3
+ 1378000p -0.3
+ 1378010p 0.9
+ 1380000p 0.9
+ 1380010p -0.3
+ 1382000p -0.3
+ 1382010p 0.9
+ 1384000p 0.9
+ 1384010p -0.3
+ 1386000p -0.3
+ 1386010p 0.9
+ 1388000p 0.9
+ 1388010p -0.3
+ 1390000p -0.3
+ 1390010p 0.9
+ 1392000p 0.9
+ 1392010p -0.3
+ 1394000p -0.3
+ 1394010p 0.9
+ 1396000p 0.9
+ 1396010p -0.3
+ 1398000p -0.3
+ 1398010p 0.9
+ 1400000p 0.9
+ 1400010p -0.3
+ 1402000p -0.3
+ 1402010p 0.9
+ 1404000p 0.9
+ 1404010p -0.3
+ 1406000p -0.3
+ 1406010p 0.9
+ 1408000p 0.9
+ 1408010p -0.3
+ 1410000p -0.3
+ 1410010p 0.9
+ 1412000p 0.9
+ 1412010p -0.3
+ 1414000p -0.3
+ 1414010p 0.9
+ 1416000p 0.9
+ 1416010p -0.3
+ 1418000p -0.3
+ 1418010p 0.9
+ 1420000p 0.9
+ 1420010p -0.3
+ 1422000p -0.3
+ 1422010p 0.9
+ 1424000p 0.9
+ 1424010p -0.3
+ 1426000p -0.3
+ 1426010p 0.9
+ 1428000p 0.9
+ 1428010p -0.3
+ 1430000p -0.3
+ 1430010p 0.9
+ 1432000p 0.9
+ 1432010p -0.3
+ 1434000p -0.3
+ 1434010p 0.9
+ 1436000p 0.9
+ 1436010p -0.3
+ 1438000p -0.3
+ 1438010p 0.9
+ 1440000p 0.9
+ 1440010p -0.3
+ 1442000p -0.3
+ 1442010p 0.9
+ 1444000p 0.9
+ 1444010p -0.3
+ 1446000p -0.3
+ 1446010p 0.9
+ 1448000p 0.9
+ 1448010p -0.3
+ 1450000p -0.3
+ 1450010p 0.9
+ 1452000p 0.9
+ 1452010p -0.3
+ 1454000p -0.3
+ 1454010p 0.9
+ 1456000p 0.9
+ 1456010p -0.3
+ 1458000p -0.3
+ 1458010p 0.9
+ 1460000p 0.9
+ 1460010p -0.3
+ 1462000p -0.3
+ 1462010p 0.9
+ 1464000p 0.9
+ 1464010p -0.3
+ 1466000p -0.3
+ 1466010p 0.9
+ 1468000p 0.9
+ 1468010p -0.3
+ 1470000p -0.3
+ 1470010p 0.9
+ 1472000p 0.9
+ 1472010p -0.3
+ 1474000p -0.3
+ 1474010p 0.9
+ 1476000p 0.9
+ 1476010p -0.3
+ 1478000p -0.3
+ 1478010p 0.9
+ 1480000p 0.9
+ 1480010p -0.3
+ 1482000p -0.3
+ 1482010p 0.9
+ 1484000p 0.9
+ 1484010p -0.3
+ 1486000p -0.3
+ 1486010p 0.9
+ 1488000p 0.9
+ 1488010p -0.3
+ 1490000p -0.3
+ 1490010p 0.9
+ 1492000p 0.9
+ 1492010p -0.3
+ 1494000p -0.3
+ 1494010p 0.9
+ 1496000p 0.9
+ 1496010p -0.3
+ 1498000p -0.3
+ 1498010p 0.9
+ 1500000p 0.9
+ 1500010p -0.3
+ 1502000p -0.3
+ 1502010p 0.9
+ 1504000p 0.9
+ 1504010p -0.3
+ 1506000p -0.3
+ 1506010p 0.9
+ 1508000p 0.9
+ 1508010p -0.3
+ 1510000p -0.3
+ 1510010p 0.9
+ 1512000p 0.9
+ 1512010p -0.3
+ 1514000p -0.3
+ 1514010p 0.9
+ 1516000p 0.9
+ 1516010p -0.3
+ 1518000p -0.3
+ 1518010p 0.9
+ 1520000p 0.9
+ 1520010p -0.3
+ 1522000p -0.3
+ 1522010p 0.9
+ 1524000p 0.9
+ 1524010p -0.3
+ 1526000p -0.3
+ 1526010p 0.9
+ 1528000p 0.9
+ 1528010p -0.3
+ 1530000p -0.3
+ 1530010p 0.9
+ 1532000p 0.9
+ 1532010p -0.3
+ 1534000p -0.3
+ 1534010p 0.9
+ 1536000p 0.9
+ 1536010p -0.3
+ 1538000p -0.3
+ 1538010p 0.9
+ 1540000p 0.9
+ 1540010p -0.3
+ 1542000p -0.3
+ 1542010p 0.9
+ 1544000p 0.9
+ 1544010p -0.3
+ 1546000p -0.3
+ 1546010p 0.9
+ 1548000p 0.9
+ 1548010p -0.3
+ 1550000p -0.3
+ 1550010p 0.9
+ 1552000p 0.9
+ 1552010p -0.3
+ 1554000p -0.3
+ 1554010p 0.9
+ 1556000p 0.9
+ 1556010p -0.3
+ 1558000p -0.3
+ 1558010p 0.9
+ 1560000p 0.9
+ 1560010p -0.3
+ 1562000p -0.3
+ 1562010p 0.9
+ 1564000p 0.9
+ 1564010p -0.3
+ 1566000p -0.3
+ 1566010p 0.9
+ 1568000p 0.9
+ 1568010p -0.3
+ 1570000p -0.3
+ 1570010p 0.9
+ 1572000p 0.9
+ 1572010p -0.3
+ 1574000p -0.3
+ 1574010p 0.9
+ 1576000p 0.9
+ 1576010p -0.3
+ 1578000p -0.3
+ 1578010p 0.9
+ 1580000p 0.9
+ 1580010p -0.3
+ 1582000p -0.3
+ 1582010p 0.9
+ 1584000p 0.9
+ 1584010p -0.3
+ 1586000p -0.3
+ 1586010p 0.9
+ 1588000p 0.9
+ 1588010p -0.3
+ 1590000p -0.3
+ 1590010p 0.9
+ 1592000p 0.9
+ 1592010p -0.3
+ 1594000p -0.3
+ 1594010p 0.9
+ 1596000p 0.9
+ 1596010p -0.3
+ 1598000p -0.3
+ 1598010p 0.9
+ 1600000p 0.9
+ 1600010p -0.3
+ 1602000p -0.3
+ 1602010p 0.9
+ 1604000p 0.9
+ 1604010p -0.3
+ 1606000p -0.3
+ 1606010p 0.9
+ 1608000p 0.9
+ 1608010p -0.3
+ 1610000p -0.3
+ 1610010p 0.9
+ 1612000p 0.9
+ 1612010p -0.3
+ 1614000p -0.3
+ 1614010p 0.9
+ 1616000p 0.9
+ 1616010p -0.3
+ 1618000p -0.3
+ 1618010p 0.9
+ 1620000p 0.9
+ 1620010p -0.3
+ 1622000p -0.3
+ 1622010p 0.9
+ 1624000p 0.9
+ 1624010p -0.3
+ 1626000p -0.3
+ 1626010p 0.9
+ 1628000p 0.9
+ 1628010p -0.3
+ 1630000p -0.3
+ 1630010p 0.9
+ 1632000p 0.9
+ 1632010p -0.3
+ 1634000p -0.3
+ 1634010p 0.9
+ 1636000p 0.9
+ 1636010p -0.3
+ 1638000p -0.3
+ 1638010p 0.9
+ 1640000p 0.9
+ 1640010p -0.3
+ 1642000p -0.3
+ 1642010p 0.9
+ 1644000p 0.9
+ 1644010p -0.3
+ 1646000p -0.3
+ 1646010p 0.9
+ 1648000p 0.9
+ 1648010p -0.3
+ 1650000p -0.3
+ 1650010p 0.9
+ 1652000p 0.9
+ 1652010p -0.3
+ 1654000p -0.3
+ 1654010p 0.9
+ 1656000p 0.9
+ 1656010p -0.3
+ 1658000p -0.3
+ 1658010p 0.9
+ 1660000p 0.9
+ 1660010p -0.3
+ 1662000p -0.3
+ 1662010p 0.9
+ 1664000p 0.9
+ 1664010p -0.3
+ 1666000p -0.3
+ 1666010p 0.9
+ 1668000p 0.9
+ 1668010p -0.3
+ 1670000p -0.3
+ 1670010p 0.9
+ 1672000p 0.9
+ 1672010p -0.3
+ 1674000p -0.3
+ 1674010p 0.9
+ 1676000p 0.9
+ 1676010p -0.3
+ 1678000p -0.3
+ 1678010p 0.9
+ 1680000p 0.9
+ 1680010p -0.3
+ 1682000p -0.3
+ 1682010p 0.9
+ 1684000p 0.9
+ 1684010p -0.3
+ 1686000p -0.3
+ 1686010p 0.9
+ 1688000p 0.9
+ 1688010p -0.3
+ 1690000p -0.3
+ 1690010p 0.9
+ 1692000p 0.9
+ 1692010p -0.3
+ 1694000p -0.3
+ 1694010p 0.9
+ 1696000p 0.9
+ 1696010p -0.3
+ 1698000p -0.3
+ 1698010p 0.9
+ 1700000p 0.9
+ 1700010p -0.3
+ 1702000p -0.3
+ 1702010p 0.9
+ 1704000p 0.9
+ 1704010p -0.3
+ 1706000p -0.3
+ 1706010p 0.9
+ 1708000p 0.9
+ 1708010p -0.3
+ 1710000p -0.3
+ 1710010p 0.9
+ 1712000p 0.9
+ 1712010p -0.3
+ 1714000p -0.3
+ 1714010p 0.9
+ 1716000p 0.9
+ 1716010p -0.3
+ 1718000p -0.3
+ 1718010p 0.9
+ 1720000p 0.9
+ 1720010p -0.3
+ 1722000p -0.3
+ 1722010p 0.9
+ 1724000p 0.9
+ 1724010p -0.3
+ 1726000p -0.3
+ 1726010p 0.9
+ 1728000p 0.9
+ 1728010p -0.3
+ 1730000p -0.3
+ 1730010p 0.9
+ 1732000p 0.9
+ 1732010p -0.3
+ 1734000p -0.3
+ 1734010p 0.9
+ 1736000p 0.9
+ 1736010p -0.3
+ 1738000p -0.3
+ 1738010p 0.9
+ 1740000p 0.9
+ 1740010p -0.3
+ 1742000p -0.3
+ 1742010p 0.9
+ 1744000p 0.9
+ 1744010p -0.3
+ 1746000p -0.3
+ 1746010p 0.9
+ 1748000p 0.9
+ 1748010p -0.3
+ 1750000p -0.3
+ 1750010p 0.9
+ 1752000p 0.9
+ 1752010p -0.3
+ 1754000p -0.3
+ 1754010p 0.9
+ 1756000p 0.9
+ 1756010p -0.3
+ 1758000p -0.3
+ 1758010p 0.9
+ 1760000p 0.9
+ 1760010p -0.3
+ 1762000p -0.3
+ 1762010p 0.9
+ 1764000p 0.9
+ 1764010p -0.3
+ 1766000p -0.3
+ 1766010p 0.9
+ 1768000p 0.9
+ 1768010p -0.3
+ 1770000p -0.3
+ 1770010p 0.9
+ 1772000p 0.9
+ 1772010p -0.3
+ 1774000p -0.3
+ 1774010p 0.9
+ 1776000p 0.9
+ 1776010p -0.3
+ 1778000p -0.3
+ 1778010p 0.9
+ 1780000p 0.9
+ 1780010p -0.3
+ 1782000p -0.3
+ 1782010p 0.9
+ 1784000p 0.9
+ 1784010p -0.3
+ 1786000p -0.3
+ 1786010p 0.9
+ 1788000p 0.9
+ 1788010p -0.3
+ 1790000p -0.3
+ 1790010p 0.9
+ 1792000p 0.9
+ 1792010p -0.3
+ 1794000p -0.3
+ 1794010p 0.9
+ 1796000p 0.9
+ 1796010p -0.3
+ 1798000p -0.3
+ 1798010p 0.9
+ 1800000p 0.9
+ 1800010p -0.3
+ 1802000p -0.3
+ 1802010p 0.9
+ 1804000p 0.9
+ 1804010p -0.3
+ 1806000p -0.3
+ 1806010p 0.9
+ 1808000p 0.9
+ 1808010p -0.3
+ 1810000p -0.3
+ 1810010p 0.9
+ 1812000p 0.9
+ 1812010p -0.3
+ 1814000p -0.3
+ 1814010p 0.9
+ 1816000p 0.9
+ 1816010p -0.3
+ 1818000p -0.3
+ 1818010p 0.9
+ 1820000p 0.9
+ 1820010p -0.3
+ 1822000p -0.3
+ 1822010p 0.9
+ 1824000p 0.9
+ 1824010p -0.3
+ 1826000p -0.3
+ 1826010p 0.9
+ 1828000p 0.9
+ 1828010p -0.3
+ 1830000p -0.3
+ 1830010p 0.9
+ 1832000p 0.9
+ 1832010p -0.3
+ 1834000p -0.3
+ 1834010p 0.9
+ 1836000p 0.9
+ 1836010p -0.3
+ 1838000p -0.3
+ 1838010p 0.9
+ 1840000p 0.9
+ 1840010p -0.3
+ 1842000p -0.3
+ 1842010p 0.9
+ 1844000p 0.9
+ 1844010p -0.3
+ 1846000p -0.3
+ 1846010p 0.9
+ 1848000p 0.9
+ 1848010p -0.3
+ 1850000p -0.3
+ 1850010p 0.9
+ 1852000p 0.9
+ 1852010p -0.3
+ 1854000p -0.3
+ 1854010p 0.9
+ 1856000p 0.9
+ 1856010p -0.3
+ 1858000p -0.3
+ 1858010p 0.9
+ 1860000p 0.9
+ 1860010p -0.3
+ 1862000p -0.3
+ 1862010p 0.9
+ 1864000p 0.9
+ 1864010p -0.3
+ 1866000p -0.3
+ 1866010p 0.9
+ 1868000p 0.9
+ 1868010p -0.3
+ 1870000p -0.3
+ 1870010p 0.9
+ 1872000p 0.9
+ 1872010p -0.3
+ 1874000p -0.3
+ 1874010p 0.9
+ 1876000p 0.9
+ 1876010p -0.3
+ 1878000p -0.3
+ 1878010p 0.9
+ 1880000p 0.9
+ 1880010p -0.3
+ 1882000p -0.3
+ 1882010p 0.9
+ 1884000p 0.9
+ 1884010p -0.3
+ 1886000p -0.3
+ 1886010p 0.9
+ 1888000p 0.9
+ 1888010p -0.3
+ 1890000p -0.3
+ 1890010p 0.9
+ 1892000p 0.9
+ 1892010p -0.3
+ 1894000p -0.3
+ 1894010p 0.9
+ 1896000p 0.9
+ 1896010p -0.3
+ 1898000p -0.3
+ 1898010p 0.9
+ 1900000p 0.9
+ 1900010p -0.3
+ 1902000p -0.3
+ 1902010p 0.9
+ 1904000p 0.9
+ 1904010p -0.3
+ 1906000p -0.3
+ 1906010p 0.9
+ 1908000p 0.9
+ 1908010p -0.3
+ 1910000p -0.3
+ 1910010p 0.9
+ 1912000p 0.9
+ 1912010p -0.3
+ 1914000p -0.3
+ 1914010p 0.9
+ 1916000p 0.9
+ 1916010p -0.3
+ 1918000p -0.3
+ 1918010p 0.9
+ 1920000p 0.9
+ 1920010p -0.3
+ 1922000p -0.3
+ 1922010p 0.9
+ 1924000p 0.9
+ 1924010p -0.3
+ 1926000p -0.3
+ 1926010p 0.9
+ 1928000p 0.9
+ 1928010p -0.3
+ 1930000p -0.3
+ 1930010p 0.9
+ 1932000p 0.9
+ 1932010p -0.3
+ 1934000p -0.3
+ 1934010p 0.9
+ 1936000p 0.9
+ 1936010p -0.3
+ 1938000p -0.3
+ 1938010p 0.9
+ 1940000p 0.9
+ 1940010p -0.3
+ 1942000p -0.3
+ 1942010p 0.9
+ 1944000p 0.9
+ 1944010p -0.3
+ 1946000p -0.3
+ 1946010p 0.9
+ 1948000p 0.9
+ 1948010p -0.3
+ 1950000p -0.3
+ 1950010p 0.9
+ 1952000p 0.9
+ 1952010p -0.3
+ 1954000p -0.3
+ 1954010p 0.9
+ 1956000p 0.9
+ 1956010p -0.3
+ 1958000p -0.3
+ 1958010p 0.9
+ 1960000p 0.9
+ 1960010p -0.3
+ 1962000p -0.3
+ 1962010p 0.9
+ 1964000p 0.9
+ 1964010p -0.3
+ 1966000p -0.3
+ 1966010p 0.9
+ 1968000p 0.9
+ 1968010p -0.3
+ 1970000p -0.3
+ 1970010p 0.9
+ 1972000p 0.9
+ 1972010p -0.3
+ 1974000p -0.3
+ 1974010p 0.9
+ 1976000p 0.9
+ 1976010p -0.3
+ 1978000p -0.3
+ 1978010p 0.9
+ 1980000p 0.9
+ 1980010p -0.3
+ 1982000p -0.3
+ 1982010p 0.9
+ 1984000p 0.9
+ 1984010p -0.3
+ 1986000p -0.3
+ 1986010p 0.9
+ 1988000p 0.9
+ 1988010p -0.3
+ 1990000p -0.3
+ 1990010p 0.9
+ 1992000p 0.9
+ 1992010p -0.3
+ 1994000p -0.3
+ 1994010p 0.9
+ 1996000p 0.9
+ 1996010p -0.3
+ 1998000p -0.3
+ 1998010p 0.9
+ 2000000p 0.9
+ 2000010p -0.3
+ 2002000p -0.3
+ 2002010p 0.9
+ 2004000p 0.9
+ 2004010p -0.3
+ 2006000p -0.3
+ 2006010p 0.9
+ 2008000p 0.9
+ 2008010p -0.3
+ 2010000p -0.3
+ 2010010p 0.9
+ 2012000p 0.9
+ 2012010p -0.3
+ 2014000p -0.3
+ 2014010p 0.9
+ 2016000p 0.9
+ 2016010p -0.3
+ 2018000p -0.3
+ 2018010p 0.9
+ 2020000p 0.9
+ 2020010p -0.3
+ 2022000p -0.3
+ 2022010p 0.9
+ 2024000p 0.9
+ 2024010p -0.3
+ 2026000p -0.3
+ 2026010p 0.9
+ 2028000p 0.9
+ 2028010p -0.3
+ 2030000p -0.3
+ 2030010p 0.9
+ 2032000p 0.9
+ 2032010p -0.3
+ 2034000p -0.3
+ 2034010p 0.9
+ 2036000p 0.9
+ 2036010p -0.3
+ 2038000p -0.3
+ 2038010p 0.9
+ 2040000p 0.9
+ 2040010p -0.3
+ 2042000p -0.3
+ 2042010p 0.9
+ 2044000p 0.9
+ 2044010p -0.3
+ 2046000p -0.3
+ 2046010p 0.9
+ 2048000p 0.9
+ 2048010p -0.3
+ \]
V_data_28 (Data\\<28\\> gnd!) vsource type=pwl wave=\[
+ 0    0.9
+ 2000p 0.9
+ 2010p -0.3
+ 4000p -0.3
+ 4010p 0.9
+ 6000p 0.9
+ 6010p -0.3
+ 8000p -0.3
+ 8010p 0.9
+ 10000p 0.9
+ 10010p -0.3
+ 12000p -0.3
+ 12010p 0.9
+ 14000p 0.9
+ 14010p -0.3
+ 16000p -0.3
+ 16010p 0.9
+ 18000p 0.9
+ 18010p -0.3
+ 20000p -0.3
+ 20010p 0.9
+ 22000p 0.9
+ 22010p -0.3
+ 24000p -0.3
+ 24010p 0.9
+ 26000p 0.9
+ 26010p -0.3
+ 28000p -0.3
+ 28010p 0.9
+ 30000p 0.9
+ 30010p -0.3
+ 32000p -0.3
+ 32010p 0.9
+ 34000p 0.9
+ 34010p -0.3
+ 36000p -0.3
+ 36010p 0.9
+ 38000p 0.9
+ 38010p -0.3
+ 40000p -0.3
+ 40010p 0.9
+ 42000p 0.9
+ 42010p -0.3
+ 44000p -0.3
+ 44010p 0.9
+ 46000p 0.9
+ 46010p -0.3
+ 48000p -0.3
+ 48010p 0.9
+ 50000p 0.9
+ 50010p -0.3
+ 52000p -0.3
+ 52010p 0.9
+ 54000p 0.9
+ 54010p -0.3
+ 56000p -0.3
+ 56010p 0.9
+ 58000p 0.9
+ 58010p -0.3
+ 60000p -0.3
+ 60010p 0.9
+ 62000p 0.9
+ 62010p -0.3
+ 64000p -0.3
+ 64010p 0.9
+ 66000p 0.9
+ 66010p -0.3
+ 68000p -0.3
+ 68010p 0.9
+ 70000p 0.9
+ 70010p -0.3
+ 72000p -0.3
+ 72010p 0.9
+ 74000p 0.9
+ 74010p -0.3
+ 76000p -0.3
+ 76010p 0.9
+ 78000p 0.9
+ 78010p -0.3
+ 80000p -0.3
+ 80010p 0.9
+ 82000p 0.9
+ 82010p -0.3
+ 84000p -0.3
+ 84010p 0.9
+ 86000p 0.9
+ 86010p -0.3
+ 88000p -0.3
+ 88010p 0.9
+ 90000p 0.9
+ 90010p -0.3
+ 92000p -0.3
+ 92010p 0.9
+ 94000p 0.9
+ 94010p -0.3
+ 96000p -0.3
+ 96010p 0.9
+ 98000p 0.9
+ 98010p -0.3
+ 100000p -0.3
+ 100010p 0.9
+ 102000p 0.9
+ 102010p -0.3
+ 104000p -0.3
+ 104010p 0.9
+ 106000p 0.9
+ 106010p -0.3
+ 108000p -0.3
+ 108010p 0.9
+ 110000p 0.9
+ 110010p -0.3
+ 112000p -0.3
+ 112010p 0.9
+ 114000p 0.9
+ 114010p -0.3
+ 116000p -0.3
+ 116010p 0.9
+ 118000p 0.9
+ 118010p -0.3
+ 120000p -0.3
+ 120010p 0.9
+ 122000p 0.9
+ 122010p -0.3
+ 124000p -0.3
+ 124010p 0.9
+ 126000p 0.9
+ 126010p -0.3
+ 128000p -0.3
+ 128010p 0.9
+ 130000p 0.9
+ 130010p -0.3
+ 132000p -0.3
+ 132010p 0.9
+ 134000p 0.9
+ 134010p -0.3
+ 136000p -0.3
+ 136010p 0.9
+ 138000p 0.9
+ 138010p -0.3
+ 140000p -0.3
+ 140010p 0.9
+ 142000p 0.9
+ 142010p -0.3
+ 144000p -0.3
+ 144010p 0.9
+ 146000p 0.9
+ 146010p -0.3
+ 148000p -0.3
+ 148010p 0.9
+ 150000p 0.9
+ 150010p -0.3
+ 152000p -0.3
+ 152010p 0.9
+ 154000p 0.9
+ 154010p -0.3
+ 156000p -0.3
+ 156010p 0.9
+ 158000p 0.9
+ 158010p -0.3
+ 160000p -0.3
+ 160010p 0.9
+ 162000p 0.9
+ 162010p -0.3
+ 164000p -0.3
+ 164010p 0.9
+ 166000p 0.9
+ 166010p -0.3
+ 168000p -0.3
+ 168010p 0.9
+ 170000p 0.9
+ 170010p -0.3
+ 172000p -0.3
+ 172010p 0.9
+ 174000p 0.9
+ 174010p -0.3
+ 176000p -0.3
+ 176010p 0.9
+ 178000p 0.9
+ 178010p -0.3
+ 180000p -0.3
+ 180010p 0.9
+ 182000p 0.9
+ 182010p -0.3
+ 184000p -0.3
+ 184010p 0.9
+ 186000p 0.9
+ 186010p -0.3
+ 188000p -0.3
+ 188010p 0.9
+ 190000p 0.9
+ 190010p -0.3
+ 192000p -0.3
+ 192010p 0.9
+ 194000p 0.9
+ 194010p -0.3
+ 196000p -0.3
+ 196010p 0.9
+ 198000p 0.9
+ 198010p -0.3
+ 200000p -0.3
+ 200010p 0.9
+ 202000p 0.9
+ 202010p -0.3
+ 204000p -0.3
+ 204010p 0.9
+ 206000p 0.9
+ 206010p -0.3
+ 208000p -0.3
+ 208010p 0.9
+ 210000p 0.9
+ 210010p -0.3
+ 212000p -0.3
+ 212010p 0.9
+ 214000p 0.9
+ 214010p -0.3
+ 216000p -0.3
+ 216010p 0.9
+ 218000p 0.9
+ 218010p -0.3
+ 220000p -0.3
+ 220010p 0.9
+ 222000p 0.9
+ 222010p -0.3
+ 224000p -0.3
+ 224010p 0.9
+ 226000p 0.9
+ 226010p -0.3
+ 228000p -0.3
+ 228010p 0.9
+ 230000p 0.9
+ 230010p -0.3
+ 232000p -0.3
+ 232010p 0.9
+ 234000p 0.9
+ 234010p -0.3
+ 236000p -0.3
+ 236010p 0.9
+ 238000p 0.9
+ 238010p -0.3
+ 240000p -0.3
+ 240010p 0.9
+ 242000p 0.9
+ 242010p -0.3
+ 244000p -0.3
+ 244010p 0.9
+ 246000p 0.9
+ 246010p -0.3
+ 248000p -0.3
+ 248010p 0.9
+ 250000p 0.9
+ 250010p -0.3
+ 252000p -0.3
+ 252010p 0.9
+ 254000p 0.9
+ 254010p -0.3
+ 256000p -0.3
+ 256010p 0.9
+ 258000p 0.9
+ 258010p -0.3
+ 260000p -0.3
+ 260010p 0.9
+ 262000p 0.9
+ 262010p -0.3
+ 264000p -0.3
+ 264010p 0.9
+ 266000p 0.9
+ 266010p -0.3
+ 268000p -0.3
+ 268010p 0.9
+ 270000p 0.9
+ 270010p -0.3
+ 272000p -0.3
+ 272010p 0.9
+ 274000p 0.9
+ 274010p -0.3
+ 276000p -0.3
+ 276010p 0.9
+ 278000p 0.9
+ 278010p -0.3
+ 280000p -0.3
+ 280010p 0.9
+ 282000p 0.9
+ 282010p -0.3
+ 284000p -0.3
+ 284010p 0.9
+ 286000p 0.9
+ 286010p -0.3
+ 288000p -0.3
+ 288010p 0.9
+ 290000p 0.9
+ 290010p -0.3
+ 292000p -0.3
+ 292010p 0.9
+ 294000p 0.9
+ 294010p -0.3
+ 296000p -0.3
+ 296010p 0.9
+ 298000p 0.9
+ 298010p -0.3
+ 300000p -0.3
+ 300010p 0.9
+ 302000p 0.9
+ 302010p -0.3
+ 304000p -0.3
+ 304010p 0.9
+ 306000p 0.9
+ 306010p -0.3
+ 308000p -0.3
+ 308010p 0.9
+ 310000p 0.9
+ 310010p -0.3
+ 312000p -0.3
+ 312010p 0.9
+ 314000p 0.9
+ 314010p -0.3
+ 316000p -0.3
+ 316010p 0.9
+ 318000p 0.9
+ 318010p -0.3
+ 320000p -0.3
+ 320010p 0.9
+ 322000p 0.9
+ 322010p -0.3
+ 324000p -0.3
+ 324010p 0.9
+ 326000p 0.9
+ 326010p -0.3
+ 328000p -0.3
+ 328010p 0.9
+ 330000p 0.9
+ 330010p -0.3
+ 332000p -0.3
+ 332010p 0.9
+ 334000p 0.9
+ 334010p -0.3
+ 336000p -0.3
+ 336010p 0.9
+ 338000p 0.9
+ 338010p -0.3
+ 340000p -0.3
+ 340010p 0.9
+ 342000p 0.9
+ 342010p -0.3
+ 344000p -0.3
+ 344010p 0.9
+ 346000p 0.9
+ 346010p -0.3
+ 348000p -0.3
+ 348010p 0.9
+ 350000p 0.9
+ 350010p -0.3
+ 352000p -0.3
+ 352010p 0.9
+ 354000p 0.9
+ 354010p -0.3
+ 356000p -0.3
+ 356010p 0.9
+ 358000p 0.9
+ 358010p -0.3
+ 360000p -0.3
+ 360010p 0.9
+ 362000p 0.9
+ 362010p -0.3
+ 364000p -0.3
+ 364010p 0.9
+ 366000p 0.9
+ 366010p -0.3
+ 368000p -0.3
+ 368010p 0.9
+ 370000p 0.9
+ 370010p -0.3
+ 372000p -0.3
+ 372010p 0.9
+ 374000p 0.9
+ 374010p -0.3
+ 376000p -0.3
+ 376010p 0.9
+ 378000p 0.9
+ 378010p -0.3
+ 380000p -0.3
+ 380010p 0.9
+ 382000p 0.9
+ 382010p -0.3
+ 384000p -0.3
+ 384010p 0.9
+ 386000p 0.9
+ 386010p -0.3
+ 388000p -0.3
+ 388010p 0.9
+ 390000p 0.9
+ 390010p -0.3
+ 392000p -0.3
+ 392010p 0.9
+ 394000p 0.9
+ 394010p -0.3
+ 396000p -0.3
+ 396010p 0.9
+ 398000p 0.9
+ 398010p -0.3
+ 400000p -0.3
+ 400010p 0.9
+ 402000p 0.9
+ 402010p -0.3
+ 404000p -0.3
+ 404010p 0.9
+ 406000p 0.9
+ 406010p -0.3
+ 408000p -0.3
+ 408010p 0.9
+ 410000p 0.9
+ 410010p -0.3
+ 412000p -0.3
+ 412010p 0.9
+ 414000p 0.9
+ 414010p -0.3
+ 416000p -0.3
+ 416010p 0.9
+ 418000p 0.9
+ 418010p -0.3
+ 420000p -0.3
+ 420010p 0.9
+ 422000p 0.9
+ 422010p -0.3
+ 424000p -0.3
+ 424010p 0.9
+ 426000p 0.9
+ 426010p -0.3
+ 428000p -0.3
+ 428010p 0.9
+ 430000p 0.9
+ 430010p -0.3
+ 432000p -0.3
+ 432010p 0.9
+ 434000p 0.9
+ 434010p -0.3
+ 436000p -0.3
+ 436010p 0.9
+ 438000p 0.9
+ 438010p -0.3
+ 440000p -0.3
+ 440010p 0.9
+ 442000p 0.9
+ 442010p -0.3
+ 444000p -0.3
+ 444010p 0.9
+ 446000p 0.9
+ 446010p -0.3
+ 448000p -0.3
+ 448010p 0.9
+ 450000p 0.9
+ 450010p -0.3
+ 452000p -0.3
+ 452010p 0.9
+ 454000p 0.9
+ 454010p -0.3
+ 456000p -0.3
+ 456010p 0.9
+ 458000p 0.9
+ 458010p -0.3
+ 460000p -0.3
+ 460010p 0.9
+ 462000p 0.9
+ 462010p -0.3
+ 464000p -0.3
+ 464010p 0.9
+ 466000p 0.9
+ 466010p -0.3
+ 468000p -0.3
+ 468010p 0.9
+ 470000p 0.9
+ 470010p -0.3
+ 472000p -0.3
+ 472010p 0.9
+ 474000p 0.9
+ 474010p -0.3
+ 476000p -0.3
+ 476010p 0.9
+ 478000p 0.9
+ 478010p -0.3
+ 480000p -0.3
+ 480010p 0.9
+ 482000p 0.9
+ 482010p -0.3
+ 484000p -0.3
+ 484010p 0.9
+ 486000p 0.9
+ 486010p -0.3
+ 488000p -0.3
+ 488010p 0.9
+ 490000p 0.9
+ 490010p -0.3
+ 492000p -0.3
+ 492010p 0.9
+ 494000p 0.9
+ 494010p -0.3
+ 496000p -0.3
+ 496010p 0.9
+ 498000p 0.9
+ 498010p -0.3
+ 500000p -0.3
+ 500010p 0.9
+ 502000p 0.9
+ 502010p -0.3
+ 504000p -0.3
+ 504010p 0.9
+ 506000p 0.9
+ 506010p -0.3
+ 508000p -0.3
+ 508010p 0.9
+ 510000p 0.9
+ 510010p -0.3
+ 512000p -0.3
+ 512010p 0.9
+ 514000p 0.9
+ 514010p -0.3
+ 516000p -0.3
+ 516010p 0.9
+ 518000p 0.9
+ 518010p -0.3
+ 520000p -0.3
+ 520010p 0.9
+ 522000p 0.9
+ 522010p -0.3
+ 524000p -0.3
+ 524010p 0.9
+ 526000p 0.9
+ 526010p -0.3
+ 528000p -0.3
+ 528010p 0.9
+ 530000p 0.9
+ 530010p -0.3
+ 532000p -0.3
+ 532010p 0.9
+ 534000p 0.9
+ 534010p -0.3
+ 536000p -0.3
+ 536010p 0.9
+ 538000p 0.9
+ 538010p -0.3
+ 540000p -0.3
+ 540010p 0.9
+ 542000p 0.9
+ 542010p -0.3
+ 544000p -0.3
+ 544010p 0.9
+ 546000p 0.9
+ 546010p -0.3
+ 548000p -0.3
+ 548010p 0.9
+ 550000p 0.9
+ 550010p -0.3
+ 552000p -0.3
+ 552010p 0.9
+ 554000p 0.9
+ 554010p -0.3
+ 556000p -0.3
+ 556010p 0.9
+ 558000p 0.9
+ 558010p -0.3
+ 560000p -0.3
+ 560010p 0.9
+ 562000p 0.9
+ 562010p -0.3
+ 564000p -0.3
+ 564010p 0.9
+ 566000p 0.9
+ 566010p -0.3
+ 568000p -0.3
+ 568010p 0.9
+ 570000p 0.9
+ 570010p -0.3
+ 572000p -0.3
+ 572010p 0.9
+ 574000p 0.9
+ 574010p -0.3
+ 576000p -0.3
+ 576010p 0.9
+ 578000p 0.9
+ 578010p -0.3
+ 580000p -0.3
+ 580010p 0.9
+ 582000p 0.9
+ 582010p -0.3
+ 584000p -0.3
+ 584010p 0.9
+ 586000p 0.9
+ 586010p -0.3
+ 588000p -0.3
+ 588010p 0.9
+ 590000p 0.9
+ 590010p -0.3
+ 592000p -0.3
+ 592010p 0.9
+ 594000p 0.9
+ 594010p -0.3
+ 596000p -0.3
+ 596010p 0.9
+ 598000p 0.9
+ 598010p -0.3
+ 600000p -0.3
+ 600010p 0.9
+ 602000p 0.9
+ 602010p -0.3
+ 604000p -0.3
+ 604010p 0.9
+ 606000p 0.9
+ 606010p -0.3
+ 608000p -0.3
+ 608010p 0.9
+ 610000p 0.9
+ 610010p -0.3
+ 612000p -0.3
+ 612010p 0.9
+ 614000p 0.9
+ 614010p -0.3
+ 616000p -0.3
+ 616010p 0.9
+ 618000p 0.9
+ 618010p -0.3
+ 620000p -0.3
+ 620010p 0.9
+ 622000p 0.9
+ 622010p -0.3
+ 624000p -0.3
+ 624010p 0.9
+ 626000p 0.9
+ 626010p -0.3
+ 628000p -0.3
+ 628010p 0.9
+ 630000p 0.9
+ 630010p -0.3
+ 632000p -0.3
+ 632010p 0.9
+ 634000p 0.9
+ 634010p -0.3
+ 636000p -0.3
+ 636010p 0.9
+ 638000p 0.9
+ 638010p -0.3
+ 640000p -0.3
+ 640010p 0.9
+ 642000p 0.9
+ 642010p -0.3
+ 644000p -0.3
+ 644010p 0.9
+ 646000p 0.9
+ 646010p -0.3
+ 648000p -0.3
+ 648010p 0.9
+ 650000p 0.9
+ 650010p -0.3
+ 652000p -0.3
+ 652010p 0.9
+ 654000p 0.9
+ 654010p -0.3
+ 656000p -0.3
+ 656010p 0.9
+ 658000p 0.9
+ 658010p -0.3
+ 660000p -0.3
+ 660010p 0.9
+ 662000p 0.9
+ 662010p -0.3
+ 664000p -0.3
+ 664010p 0.9
+ 666000p 0.9
+ 666010p -0.3
+ 668000p -0.3
+ 668010p 0.9
+ 670000p 0.9
+ 670010p -0.3
+ 672000p -0.3
+ 672010p 0.9
+ 674000p 0.9
+ 674010p -0.3
+ 676000p -0.3
+ 676010p 0.9
+ 678000p 0.9
+ 678010p -0.3
+ 680000p -0.3
+ 680010p 0.9
+ 682000p 0.9
+ 682010p -0.3
+ 684000p -0.3
+ 684010p 0.9
+ 686000p 0.9
+ 686010p -0.3
+ 688000p -0.3
+ 688010p 0.9
+ 690000p 0.9
+ 690010p -0.3
+ 692000p -0.3
+ 692010p 0.9
+ 694000p 0.9
+ 694010p -0.3
+ 696000p -0.3
+ 696010p 0.9
+ 698000p 0.9
+ 698010p -0.3
+ 700000p -0.3
+ 700010p 0.9
+ 702000p 0.9
+ 702010p -0.3
+ 704000p -0.3
+ 704010p 0.9
+ 706000p 0.9
+ 706010p -0.3
+ 708000p -0.3
+ 708010p 0.9
+ 710000p 0.9
+ 710010p -0.3
+ 712000p -0.3
+ 712010p 0.9
+ 714000p 0.9
+ 714010p -0.3
+ 716000p -0.3
+ 716010p 0.9
+ 718000p 0.9
+ 718010p -0.3
+ 720000p -0.3
+ 720010p 0.9
+ 722000p 0.9
+ 722010p -0.3
+ 724000p -0.3
+ 724010p 0.9
+ 726000p 0.9
+ 726010p -0.3
+ 728000p -0.3
+ 728010p 0.9
+ 730000p 0.9
+ 730010p -0.3
+ 732000p -0.3
+ 732010p 0.9
+ 734000p 0.9
+ 734010p -0.3
+ 736000p -0.3
+ 736010p 0.9
+ 738000p 0.9
+ 738010p -0.3
+ 740000p -0.3
+ 740010p 0.9
+ 742000p 0.9
+ 742010p -0.3
+ 744000p -0.3
+ 744010p 0.9
+ 746000p 0.9
+ 746010p -0.3
+ 748000p -0.3
+ 748010p 0.9
+ 750000p 0.9
+ 750010p -0.3
+ 752000p -0.3
+ 752010p 0.9
+ 754000p 0.9
+ 754010p -0.3
+ 756000p -0.3
+ 756010p 0.9
+ 758000p 0.9
+ 758010p -0.3
+ 760000p -0.3
+ 760010p 0.9
+ 762000p 0.9
+ 762010p -0.3
+ 764000p -0.3
+ 764010p 0.9
+ 766000p 0.9
+ 766010p -0.3
+ 768000p -0.3
+ 768010p 0.9
+ 770000p 0.9
+ 770010p -0.3
+ 772000p -0.3
+ 772010p 0.9
+ 774000p 0.9
+ 774010p -0.3
+ 776000p -0.3
+ 776010p 0.9
+ 778000p 0.9
+ 778010p -0.3
+ 780000p -0.3
+ 780010p 0.9
+ 782000p 0.9
+ 782010p -0.3
+ 784000p -0.3
+ 784010p 0.9
+ 786000p 0.9
+ 786010p -0.3
+ 788000p -0.3
+ 788010p 0.9
+ 790000p 0.9
+ 790010p -0.3
+ 792000p -0.3
+ 792010p 0.9
+ 794000p 0.9
+ 794010p -0.3
+ 796000p -0.3
+ 796010p 0.9
+ 798000p 0.9
+ 798010p -0.3
+ 800000p -0.3
+ 800010p 0.9
+ 802000p 0.9
+ 802010p -0.3
+ 804000p -0.3
+ 804010p 0.9
+ 806000p 0.9
+ 806010p -0.3
+ 808000p -0.3
+ 808010p 0.9
+ 810000p 0.9
+ 810010p -0.3
+ 812000p -0.3
+ 812010p 0.9
+ 814000p 0.9
+ 814010p -0.3
+ 816000p -0.3
+ 816010p 0.9
+ 818000p 0.9
+ 818010p -0.3
+ 820000p -0.3
+ 820010p 0.9
+ 822000p 0.9
+ 822010p -0.3
+ 824000p -0.3
+ 824010p 0.9
+ 826000p 0.9
+ 826010p -0.3
+ 828000p -0.3
+ 828010p 0.9
+ 830000p 0.9
+ 830010p -0.3
+ 832000p -0.3
+ 832010p 0.9
+ 834000p 0.9
+ 834010p -0.3
+ 836000p -0.3
+ 836010p 0.9
+ 838000p 0.9
+ 838010p -0.3
+ 840000p -0.3
+ 840010p 0.9
+ 842000p 0.9
+ 842010p -0.3
+ 844000p -0.3
+ 844010p 0.9
+ 846000p 0.9
+ 846010p -0.3
+ 848000p -0.3
+ 848010p 0.9
+ 850000p 0.9
+ 850010p -0.3
+ 852000p -0.3
+ 852010p 0.9
+ 854000p 0.9
+ 854010p -0.3
+ 856000p -0.3
+ 856010p 0.9
+ 858000p 0.9
+ 858010p -0.3
+ 860000p -0.3
+ 860010p 0.9
+ 862000p 0.9
+ 862010p -0.3
+ 864000p -0.3
+ 864010p 0.9
+ 866000p 0.9
+ 866010p -0.3
+ 868000p -0.3
+ 868010p 0.9
+ 870000p 0.9
+ 870010p -0.3
+ 872000p -0.3
+ 872010p 0.9
+ 874000p 0.9
+ 874010p -0.3
+ 876000p -0.3
+ 876010p 0.9
+ 878000p 0.9
+ 878010p -0.3
+ 880000p -0.3
+ 880010p 0.9
+ 882000p 0.9
+ 882010p -0.3
+ 884000p -0.3
+ 884010p 0.9
+ 886000p 0.9
+ 886010p -0.3
+ 888000p -0.3
+ 888010p 0.9
+ 890000p 0.9
+ 890010p -0.3
+ 892000p -0.3
+ 892010p 0.9
+ 894000p 0.9
+ 894010p -0.3
+ 896000p -0.3
+ 896010p 0.9
+ 898000p 0.9
+ 898010p -0.3
+ 900000p -0.3
+ 900010p 0.9
+ 902000p 0.9
+ 902010p -0.3
+ 904000p -0.3
+ 904010p 0.9
+ 906000p 0.9
+ 906010p -0.3
+ 908000p -0.3
+ 908010p 0.9
+ 910000p 0.9
+ 910010p -0.3
+ 912000p -0.3
+ 912010p 0.9
+ 914000p 0.9
+ 914010p -0.3
+ 916000p -0.3
+ 916010p 0.9
+ 918000p 0.9
+ 918010p -0.3
+ 920000p -0.3
+ 920010p 0.9
+ 922000p 0.9
+ 922010p -0.3
+ 924000p -0.3
+ 924010p 0.9
+ 926000p 0.9
+ 926010p -0.3
+ 928000p -0.3
+ 928010p 0.9
+ 930000p 0.9
+ 930010p -0.3
+ 932000p -0.3
+ 932010p 0.9
+ 934000p 0.9
+ 934010p -0.3
+ 936000p -0.3
+ 936010p 0.9
+ 938000p 0.9
+ 938010p -0.3
+ 940000p -0.3
+ 940010p 0.9
+ 942000p 0.9
+ 942010p -0.3
+ 944000p -0.3
+ 944010p 0.9
+ 946000p 0.9
+ 946010p -0.3
+ 948000p -0.3
+ 948010p 0.9
+ 950000p 0.9
+ 950010p -0.3
+ 952000p -0.3
+ 952010p 0.9
+ 954000p 0.9
+ 954010p -0.3
+ 956000p -0.3
+ 956010p 0.9
+ 958000p 0.9
+ 958010p -0.3
+ 960000p -0.3
+ 960010p 0.9
+ 962000p 0.9
+ 962010p -0.3
+ 964000p -0.3
+ 964010p 0.9
+ 966000p 0.9
+ 966010p -0.3
+ 968000p -0.3
+ 968010p 0.9
+ 970000p 0.9
+ 970010p -0.3
+ 972000p -0.3
+ 972010p 0.9
+ 974000p 0.9
+ 974010p -0.3
+ 976000p -0.3
+ 976010p 0.9
+ 978000p 0.9
+ 978010p -0.3
+ 980000p -0.3
+ 980010p 0.9
+ 982000p 0.9
+ 982010p -0.3
+ 984000p -0.3
+ 984010p 0.9
+ 986000p 0.9
+ 986010p -0.3
+ 988000p -0.3
+ 988010p 0.9
+ 990000p 0.9
+ 990010p -0.3
+ 992000p -0.3
+ 992010p 0.9
+ 994000p 0.9
+ 994010p -0.3
+ 996000p -0.3
+ 996010p 0.9
+ 998000p 0.9
+ 998010p -0.3
+ 1000000p -0.3
+ 1000010p 0.9
+ 1002000p 0.9
+ 1002010p -0.3
+ 1004000p -0.3
+ 1004010p 0.9
+ 1006000p 0.9
+ 1006010p -0.3
+ 1008000p -0.3
+ 1008010p 0.9
+ 1010000p 0.9
+ 1010010p -0.3
+ 1012000p -0.3
+ 1012010p 0.9
+ 1014000p 0.9
+ 1014010p -0.3
+ 1016000p -0.3
+ 1016010p 0.9
+ 1018000p 0.9
+ 1018010p -0.3
+ 1020000p -0.3
+ 1020010p 0.9
+ 1022000p 0.9
+ 1022010p -0.3
+ 1024000p -0.3
+ 1024010p 0.9
+ 1026000p 0.9
+ 1026010p -0.3
+ 1028000p -0.3
+ 1028010p 0.9
+ 1030000p 0.9
+ 1030010p -0.3
+ 1032000p -0.3
+ 1032010p 0.9
+ 1034000p 0.9
+ 1034010p -0.3
+ 1036000p -0.3
+ 1036010p 0.9
+ 1038000p 0.9
+ 1038010p -0.3
+ 1040000p -0.3
+ 1040010p 0.9
+ 1042000p 0.9
+ 1042010p -0.3
+ 1044000p -0.3
+ 1044010p 0.9
+ 1046000p 0.9
+ 1046010p -0.3
+ 1048000p -0.3
+ 1048010p 0.9
+ 1050000p 0.9
+ 1050010p -0.3
+ 1052000p -0.3
+ 1052010p 0.9
+ 1054000p 0.9
+ 1054010p -0.3
+ 1056000p -0.3
+ 1056010p 0.9
+ 1058000p 0.9
+ 1058010p -0.3
+ 1060000p -0.3
+ 1060010p 0.9
+ 1062000p 0.9
+ 1062010p -0.3
+ 1064000p -0.3
+ 1064010p 0.9
+ 1066000p 0.9
+ 1066010p -0.3
+ 1068000p -0.3
+ 1068010p 0.9
+ 1070000p 0.9
+ 1070010p -0.3
+ 1072000p -0.3
+ 1072010p 0.9
+ 1074000p 0.9
+ 1074010p -0.3
+ 1076000p -0.3
+ 1076010p 0.9
+ 1078000p 0.9
+ 1078010p -0.3
+ 1080000p -0.3
+ 1080010p 0.9
+ 1082000p 0.9
+ 1082010p -0.3
+ 1084000p -0.3
+ 1084010p 0.9
+ 1086000p 0.9
+ 1086010p -0.3
+ 1088000p -0.3
+ 1088010p 0.9
+ 1090000p 0.9
+ 1090010p -0.3
+ 1092000p -0.3
+ 1092010p 0.9
+ 1094000p 0.9
+ 1094010p -0.3
+ 1096000p -0.3
+ 1096010p 0.9
+ 1098000p 0.9
+ 1098010p -0.3
+ 1100000p -0.3
+ 1100010p 0.9
+ 1102000p 0.9
+ 1102010p -0.3
+ 1104000p -0.3
+ 1104010p 0.9
+ 1106000p 0.9
+ 1106010p -0.3
+ 1108000p -0.3
+ 1108010p 0.9
+ 1110000p 0.9
+ 1110010p -0.3
+ 1112000p -0.3
+ 1112010p 0.9
+ 1114000p 0.9
+ 1114010p -0.3
+ 1116000p -0.3
+ 1116010p 0.9
+ 1118000p 0.9
+ 1118010p -0.3
+ 1120000p -0.3
+ 1120010p 0.9
+ 1122000p 0.9
+ 1122010p -0.3
+ 1124000p -0.3
+ 1124010p 0.9
+ 1126000p 0.9
+ 1126010p -0.3
+ 1128000p -0.3
+ 1128010p 0.9
+ 1130000p 0.9
+ 1130010p -0.3
+ 1132000p -0.3
+ 1132010p 0.9
+ 1134000p 0.9
+ 1134010p -0.3
+ 1136000p -0.3
+ 1136010p 0.9
+ 1138000p 0.9
+ 1138010p -0.3
+ 1140000p -0.3
+ 1140010p 0.9
+ 1142000p 0.9
+ 1142010p -0.3
+ 1144000p -0.3
+ 1144010p 0.9
+ 1146000p 0.9
+ 1146010p -0.3
+ 1148000p -0.3
+ 1148010p 0.9
+ 1150000p 0.9
+ 1150010p -0.3
+ 1152000p -0.3
+ 1152010p 0.9
+ 1154000p 0.9
+ 1154010p -0.3
+ 1156000p -0.3
+ 1156010p 0.9
+ 1158000p 0.9
+ 1158010p -0.3
+ 1160000p -0.3
+ 1160010p 0.9
+ 1162000p 0.9
+ 1162010p -0.3
+ 1164000p -0.3
+ 1164010p 0.9
+ 1166000p 0.9
+ 1166010p -0.3
+ 1168000p -0.3
+ 1168010p 0.9
+ 1170000p 0.9
+ 1170010p -0.3
+ 1172000p -0.3
+ 1172010p 0.9
+ 1174000p 0.9
+ 1174010p -0.3
+ 1176000p -0.3
+ 1176010p 0.9
+ 1178000p 0.9
+ 1178010p -0.3
+ 1180000p -0.3
+ 1180010p 0.9
+ 1182000p 0.9
+ 1182010p -0.3
+ 1184000p -0.3
+ 1184010p 0.9
+ 1186000p 0.9
+ 1186010p -0.3
+ 1188000p -0.3
+ 1188010p 0.9
+ 1190000p 0.9
+ 1190010p -0.3
+ 1192000p -0.3
+ 1192010p 0.9
+ 1194000p 0.9
+ 1194010p -0.3
+ 1196000p -0.3
+ 1196010p 0.9
+ 1198000p 0.9
+ 1198010p -0.3
+ 1200000p -0.3
+ 1200010p 0.9
+ 1202000p 0.9
+ 1202010p -0.3
+ 1204000p -0.3
+ 1204010p 0.9
+ 1206000p 0.9
+ 1206010p -0.3
+ 1208000p -0.3
+ 1208010p 0.9
+ 1210000p 0.9
+ 1210010p -0.3
+ 1212000p -0.3
+ 1212010p 0.9
+ 1214000p 0.9
+ 1214010p -0.3
+ 1216000p -0.3
+ 1216010p 0.9
+ 1218000p 0.9
+ 1218010p -0.3
+ 1220000p -0.3
+ 1220010p 0.9
+ 1222000p 0.9
+ 1222010p -0.3
+ 1224000p -0.3
+ 1224010p 0.9
+ 1226000p 0.9
+ 1226010p -0.3
+ 1228000p -0.3
+ 1228010p 0.9
+ 1230000p 0.9
+ 1230010p -0.3
+ 1232000p -0.3
+ 1232010p 0.9
+ 1234000p 0.9
+ 1234010p -0.3
+ 1236000p -0.3
+ 1236010p 0.9
+ 1238000p 0.9
+ 1238010p -0.3
+ 1240000p -0.3
+ 1240010p 0.9
+ 1242000p 0.9
+ 1242010p -0.3
+ 1244000p -0.3
+ 1244010p 0.9
+ 1246000p 0.9
+ 1246010p -0.3
+ 1248000p -0.3
+ 1248010p 0.9
+ 1250000p 0.9
+ 1250010p -0.3
+ 1252000p -0.3
+ 1252010p 0.9
+ 1254000p 0.9
+ 1254010p -0.3
+ 1256000p -0.3
+ 1256010p 0.9
+ 1258000p 0.9
+ 1258010p -0.3
+ 1260000p -0.3
+ 1260010p 0.9
+ 1262000p 0.9
+ 1262010p -0.3
+ 1264000p -0.3
+ 1264010p 0.9
+ 1266000p 0.9
+ 1266010p -0.3
+ 1268000p -0.3
+ 1268010p 0.9
+ 1270000p 0.9
+ 1270010p -0.3
+ 1272000p -0.3
+ 1272010p 0.9
+ 1274000p 0.9
+ 1274010p -0.3
+ 1276000p -0.3
+ 1276010p 0.9
+ 1278000p 0.9
+ 1278010p -0.3
+ 1280000p -0.3
+ 1280010p 0.9
+ 1282000p 0.9
+ 1282010p -0.3
+ 1284000p -0.3
+ 1284010p 0.9
+ 1286000p 0.9
+ 1286010p -0.3
+ 1288000p -0.3
+ 1288010p 0.9
+ 1290000p 0.9
+ 1290010p -0.3
+ 1292000p -0.3
+ 1292010p 0.9
+ 1294000p 0.9
+ 1294010p -0.3
+ 1296000p -0.3
+ 1296010p 0.9
+ 1298000p 0.9
+ 1298010p -0.3
+ 1300000p -0.3
+ 1300010p 0.9
+ 1302000p 0.9
+ 1302010p -0.3
+ 1304000p -0.3
+ 1304010p 0.9
+ 1306000p 0.9
+ 1306010p -0.3
+ 1308000p -0.3
+ 1308010p 0.9
+ 1310000p 0.9
+ 1310010p -0.3
+ 1312000p -0.3
+ 1312010p 0.9
+ 1314000p 0.9
+ 1314010p -0.3
+ 1316000p -0.3
+ 1316010p 0.9
+ 1318000p 0.9
+ 1318010p -0.3
+ 1320000p -0.3
+ 1320010p 0.9
+ 1322000p 0.9
+ 1322010p -0.3
+ 1324000p -0.3
+ 1324010p 0.9
+ 1326000p 0.9
+ 1326010p -0.3
+ 1328000p -0.3
+ 1328010p 0.9
+ 1330000p 0.9
+ 1330010p -0.3
+ 1332000p -0.3
+ 1332010p 0.9
+ 1334000p 0.9
+ 1334010p -0.3
+ 1336000p -0.3
+ 1336010p 0.9
+ 1338000p 0.9
+ 1338010p -0.3
+ 1340000p -0.3
+ 1340010p 0.9
+ 1342000p 0.9
+ 1342010p -0.3
+ 1344000p -0.3
+ 1344010p 0.9
+ 1346000p 0.9
+ 1346010p -0.3
+ 1348000p -0.3
+ 1348010p 0.9
+ 1350000p 0.9
+ 1350010p -0.3
+ 1352000p -0.3
+ 1352010p 0.9
+ 1354000p 0.9
+ 1354010p -0.3
+ 1356000p -0.3
+ 1356010p 0.9
+ 1358000p 0.9
+ 1358010p -0.3
+ 1360000p -0.3
+ 1360010p 0.9
+ 1362000p 0.9
+ 1362010p -0.3
+ 1364000p -0.3
+ 1364010p 0.9
+ 1366000p 0.9
+ 1366010p -0.3
+ 1368000p -0.3
+ 1368010p 0.9
+ 1370000p 0.9
+ 1370010p -0.3
+ 1372000p -0.3
+ 1372010p 0.9
+ 1374000p 0.9
+ 1374010p -0.3
+ 1376000p -0.3
+ 1376010p 0.9
+ 1378000p 0.9
+ 1378010p -0.3
+ 1380000p -0.3
+ 1380010p 0.9
+ 1382000p 0.9
+ 1382010p -0.3
+ 1384000p -0.3
+ 1384010p 0.9
+ 1386000p 0.9
+ 1386010p -0.3
+ 1388000p -0.3
+ 1388010p 0.9
+ 1390000p 0.9
+ 1390010p -0.3
+ 1392000p -0.3
+ 1392010p 0.9
+ 1394000p 0.9
+ 1394010p -0.3
+ 1396000p -0.3
+ 1396010p 0.9
+ 1398000p 0.9
+ 1398010p -0.3
+ 1400000p -0.3
+ 1400010p 0.9
+ 1402000p 0.9
+ 1402010p -0.3
+ 1404000p -0.3
+ 1404010p 0.9
+ 1406000p 0.9
+ 1406010p -0.3
+ 1408000p -0.3
+ 1408010p 0.9
+ 1410000p 0.9
+ 1410010p -0.3
+ 1412000p -0.3
+ 1412010p 0.9
+ 1414000p 0.9
+ 1414010p -0.3
+ 1416000p -0.3
+ 1416010p 0.9
+ 1418000p 0.9
+ 1418010p -0.3
+ 1420000p -0.3
+ 1420010p 0.9
+ 1422000p 0.9
+ 1422010p -0.3
+ 1424000p -0.3
+ 1424010p 0.9
+ 1426000p 0.9
+ 1426010p -0.3
+ 1428000p -0.3
+ 1428010p 0.9
+ 1430000p 0.9
+ 1430010p -0.3
+ 1432000p -0.3
+ 1432010p 0.9
+ 1434000p 0.9
+ 1434010p -0.3
+ 1436000p -0.3
+ 1436010p 0.9
+ 1438000p 0.9
+ 1438010p -0.3
+ 1440000p -0.3
+ 1440010p 0.9
+ 1442000p 0.9
+ 1442010p -0.3
+ 1444000p -0.3
+ 1444010p 0.9
+ 1446000p 0.9
+ 1446010p -0.3
+ 1448000p -0.3
+ 1448010p 0.9
+ 1450000p 0.9
+ 1450010p -0.3
+ 1452000p -0.3
+ 1452010p 0.9
+ 1454000p 0.9
+ 1454010p -0.3
+ 1456000p -0.3
+ 1456010p 0.9
+ 1458000p 0.9
+ 1458010p -0.3
+ 1460000p -0.3
+ 1460010p 0.9
+ 1462000p 0.9
+ 1462010p -0.3
+ 1464000p -0.3
+ 1464010p 0.9
+ 1466000p 0.9
+ 1466010p -0.3
+ 1468000p -0.3
+ 1468010p 0.9
+ 1470000p 0.9
+ 1470010p -0.3
+ 1472000p -0.3
+ 1472010p 0.9
+ 1474000p 0.9
+ 1474010p -0.3
+ 1476000p -0.3
+ 1476010p 0.9
+ 1478000p 0.9
+ 1478010p -0.3
+ 1480000p -0.3
+ 1480010p 0.9
+ 1482000p 0.9
+ 1482010p -0.3
+ 1484000p -0.3
+ 1484010p 0.9
+ 1486000p 0.9
+ 1486010p -0.3
+ 1488000p -0.3
+ 1488010p 0.9
+ 1490000p 0.9
+ 1490010p -0.3
+ 1492000p -0.3
+ 1492010p 0.9
+ 1494000p 0.9
+ 1494010p -0.3
+ 1496000p -0.3
+ 1496010p 0.9
+ 1498000p 0.9
+ 1498010p -0.3
+ 1500000p -0.3
+ 1500010p 0.9
+ 1502000p 0.9
+ 1502010p -0.3
+ 1504000p -0.3
+ 1504010p 0.9
+ 1506000p 0.9
+ 1506010p -0.3
+ 1508000p -0.3
+ 1508010p 0.9
+ 1510000p 0.9
+ 1510010p -0.3
+ 1512000p -0.3
+ 1512010p 0.9
+ 1514000p 0.9
+ 1514010p -0.3
+ 1516000p -0.3
+ 1516010p 0.9
+ 1518000p 0.9
+ 1518010p -0.3
+ 1520000p -0.3
+ 1520010p 0.9
+ 1522000p 0.9
+ 1522010p -0.3
+ 1524000p -0.3
+ 1524010p 0.9
+ 1526000p 0.9
+ 1526010p -0.3
+ 1528000p -0.3
+ 1528010p 0.9
+ 1530000p 0.9
+ 1530010p -0.3
+ 1532000p -0.3
+ 1532010p 0.9
+ 1534000p 0.9
+ 1534010p -0.3
+ 1536000p -0.3
+ 1536010p 0.9
+ 1538000p 0.9
+ 1538010p -0.3
+ 1540000p -0.3
+ 1540010p 0.9
+ 1542000p 0.9
+ 1542010p -0.3
+ 1544000p -0.3
+ 1544010p 0.9
+ 1546000p 0.9
+ 1546010p -0.3
+ 1548000p -0.3
+ 1548010p 0.9
+ 1550000p 0.9
+ 1550010p -0.3
+ 1552000p -0.3
+ 1552010p 0.9
+ 1554000p 0.9
+ 1554010p -0.3
+ 1556000p -0.3
+ 1556010p 0.9
+ 1558000p 0.9
+ 1558010p -0.3
+ 1560000p -0.3
+ 1560010p 0.9
+ 1562000p 0.9
+ 1562010p -0.3
+ 1564000p -0.3
+ 1564010p 0.9
+ 1566000p 0.9
+ 1566010p -0.3
+ 1568000p -0.3
+ 1568010p 0.9
+ 1570000p 0.9
+ 1570010p -0.3
+ 1572000p -0.3
+ 1572010p 0.9
+ 1574000p 0.9
+ 1574010p -0.3
+ 1576000p -0.3
+ 1576010p 0.9
+ 1578000p 0.9
+ 1578010p -0.3
+ 1580000p -0.3
+ 1580010p 0.9
+ 1582000p 0.9
+ 1582010p -0.3
+ 1584000p -0.3
+ 1584010p 0.9
+ 1586000p 0.9
+ 1586010p -0.3
+ 1588000p -0.3
+ 1588010p 0.9
+ 1590000p 0.9
+ 1590010p -0.3
+ 1592000p -0.3
+ 1592010p 0.9
+ 1594000p 0.9
+ 1594010p -0.3
+ 1596000p -0.3
+ 1596010p 0.9
+ 1598000p 0.9
+ 1598010p -0.3
+ 1600000p -0.3
+ 1600010p 0.9
+ 1602000p 0.9
+ 1602010p -0.3
+ 1604000p -0.3
+ 1604010p 0.9
+ 1606000p 0.9
+ 1606010p -0.3
+ 1608000p -0.3
+ 1608010p 0.9
+ 1610000p 0.9
+ 1610010p -0.3
+ 1612000p -0.3
+ 1612010p 0.9
+ 1614000p 0.9
+ 1614010p -0.3
+ 1616000p -0.3
+ 1616010p 0.9
+ 1618000p 0.9
+ 1618010p -0.3
+ 1620000p -0.3
+ 1620010p 0.9
+ 1622000p 0.9
+ 1622010p -0.3
+ 1624000p -0.3
+ 1624010p 0.9
+ 1626000p 0.9
+ 1626010p -0.3
+ 1628000p -0.3
+ 1628010p 0.9
+ 1630000p 0.9
+ 1630010p -0.3
+ 1632000p -0.3
+ 1632010p 0.9
+ 1634000p 0.9
+ 1634010p -0.3
+ 1636000p -0.3
+ 1636010p 0.9
+ 1638000p 0.9
+ 1638010p -0.3
+ 1640000p -0.3
+ 1640010p 0.9
+ 1642000p 0.9
+ 1642010p -0.3
+ 1644000p -0.3
+ 1644010p 0.9
+ 1646000p 0.9
+ 1646010p -0.3
+ 1648000p -0.3
+ 1648010p 0.9
+ 1650000p 0.9
+ 1650010p -0.3
+ 1652000p -0.3
+ 1652010p 0.9
+ 1654000p 0.9
+ 1654010p -0.3
+ 1656000p -0.3
+ 1656010p 0.9
+ 1658000p 0.9
+ 1658010p -0.3
+ 1660000p -0.3
+ 1660010p 0.9
+ 1662000p 0.9
+ 1662010p -0.3
+ 1664000p -0.3
+ 1664010p 0.9
+ 1666000p 0.9
+ 1666010p -0.3
+ 1668000p -0.3
+ 1668010p 0.9
+ 1670000p 0.9
+ 1670010p -0.3
+ 1672000p -0.3
+ 1672010p 0.9
+ 1674000p 0.9
+ 1674010p -0.3
+ 1676000p -0.3
+ 1676010p 0.9
+ 1678000p 0.9
+ 1678010p -0.3
+ 1680000p -0.3
+ 1680010p 0.9
+ 1682000p 0.9
+ 1682010p -0.3
+ 1684000p -0.3
+ 1684010p 0.9
+ 1686000p 0.9
+ 1686010p -0.3
+ 1688000p -0.3
+ 1688010p 0.9
+ 1690000p 0.9
+ 1690010p -0.3
+ 1692000p -0.3
+ 1692010p 0.9
+ 1694000p 0.9
+ 1694010p -0.3
+ 1696000p -0.3
+ 1696010p 0.9
+ 1698000p 0.9
+ 1698010p -0.3
+ 1700000p -0.3
+ 1700010p 0.9
+ 1702000p 0.9
+ 1702010p -0.3
+ 1704000p -0.3
+ 1704010p 0.9
+ 1706000p 0.9
+ 1706010p -0.3
+ 1708000p -0.3
+ 1708010p 0.9
+ 1710000p 0.9
+ 1710010p -0.3
+ 1712000p -0.3
+ 1712010p 0.9
+ 1714000p 0.9
+ 1714010p -0.3
+ 1716000p -0.3
+ 1716010p 0.9
+ 1718000p 0.9
+ 1718010p -0.3
+ 1720000p -0.3
+ 1720010p 0.9
+ 1722000p 0.9
+ 1722010p -0.3
+ 1724000p -0.3
+ 1724010p 0.9
+ 1726000p 0.9
+ 1726010p -0.3
+ 1728000p -0.3
+ 1728010p 0.9
+ 1730000p 0.9
+ 1730010p -0.3
+ 1732000p -0.3
+ 1732010p 0.9
+ 1734000p 0.9
+ 1734010p -0.3
+ 1736000p -0.3
+ 1736010p 0.9
+ 1738000p 0.9
+ 1738010p -0.3
+ 1740000p -0.3
+ 1740010p 0.9
+ 1742000p 0.9
+ 1742010p -0.3
+ 1744000p -0.3
+ 1744010p 0.9
+ 1746000p 0.9
+ 1746010p -0.3
+ 1748000p -0.3
+ 1748010p 0.9
+ 1750000p 0.9
+ 1750010p -0.3
+ 1752000p -0.3
+ 1752010p 0.9
+ 1754000p 0.9
+ 1754010p -0.3
+ 1756000p -0.3
+ 1756010p 0.9
+ 1758000p 0.9
+ 1758010p -0.3
+ 1760000p -0.3
+ 1760010p 0.9
+ 1762000p 0.9
+ 1762010p -0.3
+ 1764000p -0.3
+ 1764010p 0.9
+ 1766000p 0.9
+ 1766010p -0.3
+ 1768000p -0.3
+ 1768010p 0.9
+ 1770000p 0.9
+ 1770010p -0.3
+ 1772000p -0.3
+ 1772010p 0.9
+ 1774000p 0.9
+ 1774010p -0.3
+ 1776000p -0.3
+ 1776010p 0.9
+ 1778000p 0.9
+ 1778010p -0.3
+ 1780000p -0.3
+ 1780010p 0.9
+ 1782000p 0.9
+ 1782010p -0.3
+ 1784000p -0.3
+ 1784010p 0.9
+ 1786000p 0.9
+ 1786010p -0.3
+ 1788000p -0.3
+ 1788010p 0.9
+ 1790000p 0.9
+ 1790010p -0.3
+ 1792000p -0.3
+ 1792010p 0.9
+ 1794000p 0.9
+ 1794010p -0.3
+ 1796000p -0.3
+ 1796010p 0.9
+ 1798000p 0.9
+ 1798010p -0.3
+ 1800000p -0.3
+ 1800010p 0.9
+ 1802000p 0.9
+ 1802010p -0.3
+ 1804000p -0.3
+ 1804010p 0.9
+ 1806000p 0.9
+ 1806010p -0.3
+ 1808000p -0.3
+ 1808010p 0.9
+ 1810000p 0.9
+ 1810010p -0.3
+ 1812000p -0.3
+ 1812010p 0.9
+ 1814000p 0.9
+ 1814010p -0.3
+ 1816000p -0.3
+ 1816010p 0.9
+ 1818000p 0.9
+ 1818010p -0.3
+ 1820000p -0.3
+ 1820010p 0.9
+ 1822000p 0.9
+ 1822010p -0.3
+ 1824000p -0.3
+ 1824010p 0.9
+ 1826000p 0.9
+ 1826010p -0.3
+ 1828000p -0.3
+ 1828010p 0.9
+ 1830000p 0.9
+ 1830010p -0.3
+ 1832000p -0.3
+ 1832010p 0.9
+ 1834000p 0.9
+ 1834010p -0.3
+ 1836000p -0.3
+ 1836010p 0.9
+ 1838000p 0.9
+ 1838010p -0.3
+ 1840000p -0.3
+ 1840010p 0.9
+ 1842000p 0.9
+ 1842010p -0.3
+ 1844000p -0.3
+ 1844010p 0.9
+ 1846000p 0.9
+ 1846010p -0.3
+ 1848000p -0.3
+ 1848010p 0.9
+ 1850000p 0.9
+ 1850010p -0.3
+ 1852000p -0.3
+ 1852010p 0.9
+ 1854000p 0.9
+ 1854010p -0.3
+ 1856000p -0.3
+ 1856010p 0.9
+ 1858000p 0.9
+ 1858010p -0.3
+ 1860000p -0.3
+ 1860010p 0.9
+ 1862000p 0.9
+ 1862010p -0.3
+ 1864000p -0.3
+ 1864010p 0.9
+ 1866000p 0.9
+ 1866010p -0.3
+ 1868000p -0.3
+ 1868010p 0.9
+ 1870000p 0.9
+ 1870010p -0.3
+ 1872000p -0.3
+ 1872010p 0.9
+ 1874000p 0.9
+ 1874010p -0.3
+ 1876000p -0.3
+ 1876010p 0.9
+ 1878000p 0.9
+ 1878010p -0.3
+ 1880000p -0.3
+ 1880010p 0.9
+ 1882000p 0.9
+ 1882010p -0.3
+ 1884000p -0.3
+ 1884010p 0.9
+ 1886000p 0.9
+ 1886010p -0.3
+ 1888000p -0.3
+ 1888010p 0.9
+ 1890000p 0.9
+ 1890010p -0.3
+ 1892000p -0.3
+ 1892010p 0.9
+ 1894000p 0.9
+ 1894010p -0.3
+ 1896000p -0.3
+ 1896010p 0.9
+ 1898000p 0.9
+ 1898010p -0.3
+ 1900000p -0.3
+ 1900010p 0.9
+ 1902000p 0.9
+ 1902010p -0.3
+ 1904000p -0.3
+ 1904010p 0.9
+ 1906000p 0.9
+ 1906010p -0.3
+ 1908000p -0.3
+ 1908010p 0.9
+ 1910000p 0.9
+ 1910010p -0.3
+ 1912000p -0.3
+ 1912010p 0.9
+ 1914000p 0.9
+ 1914010p -0.3
+ 1916000p -0.3
+ 1916010p 0.9
+ 1918000p 0.9
+ 1918010p -0.3
+ 1920000p -0.3
+ 1920010p 0.9
+ 1922000p 0.9
+ 1922010p -0.3
+ 1924000p -0.3
+ 1924010p 0.9
+ 1926000p 0.9
+ 1926010p -0.3
+ 1928000p -0.3
+ 1928010p 0.9
+ 1930000p 0.9
+ 1930010p -0.3
+ 1932000p -0.3
+ 1932010p 0.9
+ 1934000p 0.9
+ 1934010p -0.3
+ 1936000p -0.3
+ 1936010p 0.9
+ 1938000p 0.9
+ 1938010p -0.3
+ 1940000p -0.3
+ 1940010p 0.9
+ 1942000p 0.9
+ 1942010p -0.3
+ 1944000p -0.3
+ 1944010p 0.9
+ 1946000p 0.9
+ 1946010p -0.3
+ 1948000p -0.3
+ 1948010p 0.9
+ 1950000p 0.9
+ 1950010p -0.3
+ 1952000p -0.3
+ 1952010p 0.9
+ 1954000p 0.9
+ 1954010p -0.3
+ 1956000p -0.3
+ 1956010p 0.9
+ 1958000p 0.9
+ 1958010p -0.3
+ 1960000p -0.3
+ 1960010p 0.9
+ 1962000p 0.9
+ 1962010p -0.3
+ 1964000p -0.3
+ 1964010p 0.9
+ 1966000p 0.9
+ 1966010p -0.3
+ 1968000p -0.3
+ 1968010p 0.9
+ 1970000p 0.9
+ 1970010p -0.3
+ 1972000p -0.3
+ 1972010p 0.9
+ 1974000p 0.9
+ 1974010p -0.3
+ 1976000p -0.3
+ 1976010p 0.9
+ 1978000p 0.9
+ 1978010p -0.3
+ 1980000p -0.3
+ 1980010p 0.9
+ 1982000p 0.9
+ 1982010p -0.3
+ 1984000p -0.3
+ 1984010p 0.9
+ 1986000p 0.9
+ 1986010p -0.3
+ 1988000p -0.3
+ 1988010p 0.9
+ 1990000p 0.9
+ 1990010p -0.3
+ 1992000p -0.3
+ 1992010p 0.9
+ 1994000p 0.9
+ 1994010p -0.3
+ 1996000p -0.3
+ 1996010p 0.9
+ 1998000p 0.9
+ 1998010p -0.3
+ 2000000p -0.3
+ 2000010p 0.9
+ 2002000p 0.9
+ 2002010p -0.3
+ 2004000p -0.3
+ 2004010p 0.9
+ 2006000p 0.9
+ 2006010p -0.3
+ 2008000p -0.3
+ 2008010p 0.9
+ 2010000p 0.9
+ 2010010p -0.3
+ 2012000p -0.3
+ 2012010p 0.9
+ 2014000p 0.9
+ 2014010p -0.3
+ 2016000p -0.3
+ 2016010p 0.9
+ 2018000p 0.9
+ 2018010p -0.3
+ 2020000p -0.3
+ 2020010p 0.9
+ 2022000p 0.9
+ 2022010p -0.3
+ 2024000p -0.3
+ 2024010p 0.9
+ 2026000p 0.9
+ 2026010p -0.3
+ 2028000p -0.3
+ 2028010p 0.9
+ 2030000p 0.9
+ 2030010p -0.3
+ 2032000p -0.3
+ 2032010p 0.9
+ 2034000p 0.9
+ 2034010p -0.3
+ 2036000p -0.3
+ 2036010p 0.9
+ 2038000p 0.9
+ 2038010p -0.3
+ 2040000p -0.3
+ 2040010p 0.9
+ 2042000p 0.9
+ 2042010p -0.3
+ 2044000p -0.3
+ 2044010p 0.9
+ 2046000p 0.9
+ 2046010p -0.3
+ 2048000p -0.3
+ 2048010p 0.9
+ \]
V_data_bar_28 (Data_bar\\<28\\> gnd!) vsource type=pwl wave=\[
+ 0    -0.3
+ 2000p -0.3
+ 2010p 0.9
+ 4000p 0.9
+ 4010p -0.3
+ 6000p -0.3
+ 6010p 0.9
+ 8000p 0.9
+ 8010p -0.3
+ 10000p -0.3
+ 10010p 0.9
+ 12000p 0.9
+ 12010p -0.3
+ 14000p -0.3
+ 14010p 0.9
+ 16000p 0.9
+ 16010p -0.3
+ 18000p -0.3
+ 18010p 0.9
+ 20000p 0.9
+ 20010p -0.3
+ 22000p -0.3
+ 22010p 0.9
+ 24000p 0.9
+ 24010p -0.3
+ 26000p -0.3
+ 26010p 0.9
+ 28000p 0.9
+ 28010p -0.3
+ 30000p -0.3
+ 30010p 0.9
+ 32000p 0.9
+ 32010p -0.3
+ 34000p -0.3
+ 34010p 0.9
+ 36000p 0.9
+ 36010p -0.3
+ 38000p -0.3
+ 38010p 0.9
+ 40000p 0.9
+ 40010p -0.3
+ 42000p -0.3
+ 42010p 0.9
+ 44000p 0.9
+ 44010p -0.3
+ 46000p -0.3
+ 46010p 0.9
+ 48000p 0.9
+ 48010p -0.3
+ 50000p -0.3
+ 50010p 0.9
+ 52000p 0.9
+ 52010p -0.3
+ 54000p -0.3
+ 54010p 0.9
+ 56000p 0.9
+ 56010p -0.3
+ 58000p -0.3
+ 58010p 0.9
+ 60000p 0.9
+ 60010p -0.3
+ 62000p -0.3
+ 62010p 0.9
+ 64000p 0.9
+ 64010p -0.3
+ 66000p -0.3
+ 66010p 0.9
+ 68000p 0.9
+ 68010p -0.3
+ 70000p -0.3
+ 70010p 0.9
+ 72000p 0.9
+ 72010p -0.3
+ 74000p -0.3
+ 74010p 0.9
+ 76000p 0.9
+ 76010p -0.3
+ 78000p -0.3
+ 78010p 0.9
+ 80000p 0.9
+ 80010p -0.3
+ 82000p -0.3
+ 82010p 0.9
+ 84000p 0.9
+ 84010p -0.3
+ 86000p -0.3
+ 86010p 0.9
+ 88000p 0.9
+ 88010p -0.3
+ 90000p -0.3
+ 90010p 0.9
+ 92000p 0.9
+ 92010p -0.3
+ 94000p -0.3
+ 94010p 0.9
+ 96000p 0.9
+ 96010p -0.3
+ 98000p -0.3
+ 98010p 0.9
+ 100000p 0.9
+ 100010p -0.3
+ 102000p -0.3
+ 102010p 0.9
+ 104000p 0.9
+ 104010p -0.3
+ 106000p -0.3
+ 106010p 0.9
+ 108000p 0.9
+ 108010p -0.3
+ 110000p -0.3
+ 110010p 0.9
+ 112000p 0.9
+ 112010p -0.3
+ 114000p -0.3
+ 114010p 0.9
+ 116000p 0.9
+ 116010p -0.3
+ 118000p -0.3
+ 118010p 0.9
+ 120000p 0.9
+ 120010p -0.3
+ 122000p -0.3
+ 122010p 0.9
+ 124000p 0.9
+ 124010p -0.3
+ 126000p -0.3
+ 126010p 0.9
+ 128000p 0.9
+ 128010p -0.3
+ 130000p -0.3
+ 130010p 0.9
+ 132000p 0.9
+ 132010p -0.3
+ 134000p -0.3
+ 134010p 0.9
+ 136000p 0.9
+ 136010p -0.3
+ 138000p -0.3
+ 138010p 0.9
+ 140000p 0.9
+ 140010p -0.3
+ 142000p -0.3
+ 142010p 0.9
+ 144000p 0.9
+ 144010p -0.3
+ 146000p -0.3
+ 146010p 0.9
+ 148000p 0.9
+ 148010p -0.3
+ 150000p -0.3
+ 150010p 0.9
+ 152000p 0.9
+ 152010p -0.3
+ 154000p -0.3
+ 154010p 0.9
+ 156000p 0.9
+ 156010p -0.3
+ 158000p -0.3
+ 158010p 0.9
+ 160000p 0.9
+ 160010p -0.3
+ 162000p -0.3
+ 162010p 0.9
+ 164000p 0.9
+ 164010p -0.3
+ 166000p -0.3
+ 166010p 0.9
+ 168000p 0.9
+ 168010p -0.3
+ 170000p -0.3
+ 170010p 0.9
+ 172000p 0.9
+ 172010p -0.3
+ 174000p -0.3
+ 174010p 0.9
+ 176000p 0.9
+ 176010p -0.3
+ 178000p -0.3
+ 178010p 0.9
+ 180000p 0.9
+ 180010p -0.3
+ 182000p -0.3
+ 182010p 0.9
+ 184000p 0.9
+ 184010p -0.3
+ 186000p -0.3
+ 186010p 0.9
+ 188000p 0.9
+ 188010p -0.3
+ 190000p -0.3
+ 190010p 0.9
+ 192000p 0.9
+ 192010p -0.3
+ 194000p -0.3
+ 194010p 0.9
+ 196000p 0.9
+ 196010p -0.3
+ 198000p -0.3
+ 198010p 0.9
+ 200000p 0.9
+ 200010p -0.3
+ 202000p -0.3
+ 202010p 0.9
+ 204000p 0.9
+ 204010p -0.3
+ 206000p -0.3
+ 206010p 0.9
+ 208000p 0.9
+ 208010p -0.3
+ 210000p -0.3
+ 210010p 0.9
+ 212000p 0.9
+ 212010p -0.3
+ 214000p -0.3
+ 214010p 0.9
+ 216000p 0.9
+ 216010p -0.3
+ 218000p -0.3
+ 218010p 0.9
+ 220000p 0.9
+ 220010p -0.3
+ 222000p -0.3
+ 222010p 0.9
+ 224000p 0.9
+ 224010p -0.3
+ 226000p -0.3
+ 226010p 0.9
+ 228000p 0.9
+ 228010p -0.3
+ 230000p -0.3
+ 230010p 0.9
+ 232000p 0.9
+ 232010p -0.3
+ 234000p -0.3
+ 234010p 0.9
+ 236000p 0.9
+ 236010p -0.3
+ 238000p -0.3
+ 238010p 0.9
+ 240000p 0.9
+ 240010p -0.3
+ 242000p -0.3
+ 242010p 0.9
+ 244000p 0.9
+ 244010p -0.3
+ 246000p -0.3
+ 246010p 0.9
+ 248000p 0.9
+ 248010p -0.3
+ 250000p -0.3
+ 250010p 0.9
+ 252000p 0.9
+ 252010p -0.3
+ 254000p -0.3
+ 254010p 0.9
+ 256000p 0.9
+ 256010p -0.3
+ 258000p -0.3
+ 258010p 0.9
+ 260000p 0.9
+ 260010p -0.3
+ 262000p -0.3
+ 262010p 0.9
+ 264000p 0.9
+ 264010p -0.3
+ 266000p -0.3
+ 266010p 0.9
+ 268000p 0.9
+ 268010p -0.3
+ 270000p -0.3
+ 270010p 0.9
+ 272000p 0.9
+ 272010p -0.3
+ 274000p -0.3
+ 274010p 0.9
+ 276000p 0.9
+ 276010p -0.3
+ 278000p -0.3
+ 278010p 0.9
+ 280000p 0.9
+ 280010p -0.3
+ 282000p -0.3
+ 282010p 0.9
+ 284000p 0.9
+ 284010p -0.3
+ 286000p -0.3
+ 286010p 0.9
+ 288000p 0.9
+ 288010p -0.3
+ 290000p -0.3
+ 290010p 0.9
+ 292000p 0.9
+ 292010p -0.3
+ 294000p -0.3
+ 294010p 0.9
+ 296000p 0.9
+ 296010p -0.3
+ 298000p -0.3
+ 298010p 0.9
+ 300000p 0.9
+ 300010p -0.3
+ 302000p -0.3
+ 302010p 0.9
+ 304000p 0.9
+ 304010p -0.3
+ 306000p -0.3
+ 306010p 0.9
+ 308000p 0.9
+ 308010p -0.3
+ 310000p -0.3
+ 310010p 0.9
+ 312000p 0.9
+ 312010p -0.3
+ 314000p -0.3
+ 314010p 0.9
+ 316000p 0.9
+ 316010p -0.3
+ 318000p -0.3
+ 318010p 0.9
+ 320000p 0.9
+ 320010p -0.3
+ 322000p -0.3
+ 322010p 0.9
+ 324000p 0.9
+ 324010p -0.3
+ 326000p -0.3
+ 326010p 0.9
+ 328000p 0.9
+ 328010p -0.3
+ 330000p -0.3
+ 330010p 0.9
+ 332000p 0.9
+ 332010p -0.3
+ 334000p -0.3
+ 334010p 0.9
+ 336000p 0.9
+ 336010p -0.3
+ 338000p -0.3
+ 338010p 0.9
+ 340000p 0.9
+ 340010p -0.3
+ 342000p -0.3
+ 342010p 0.9
+ 344000p 0.9
+ 344010p -0.3
+ 346000p -0.3
+ 346010p 0.9
+ 348000p 0.9
+ 348010p -0.3
+ 350000p -0.3
+ 350010p 0.9
+ 352000p 0.9
+ 352010p -0.3
+ 354000p -0.3
+ 354010p 0.9
+ 356000p 0.9
+ 356010p -0.3
+ 358000p -0.3
+ 358010p 0.9
+ 360000p 0.9
+ 360010p -0.3
+ 362000p -0.3
+ 362010p 0.9
+ 364000p 0.9
+ 364010p -0.3
+ 366000p -0.3
+ 366010p 0.9
+ 368000p 0.9
+ 368010p -0.3
+ 370000p -0.3
+ 370010p 0.9
+ 372000p 0.9
+ 372010p -0.3
+ 374000p -0.3
+ 374010p 0.9
+ 376000p 0.9
+ 376010p -0.3
+ 378000p -0.3
+ 378010p 0.9
+ 380000p 0.9
+ 380010p -0.3
+ 382000p -0.3
+ 382010p 0.9
+ 384000p 0.9
+ 384010p -0.3
+ 386000p -0.3
+ 386010p 0.9
+ 388000p 0.9
+ 388010p -0.3
+ 390000p -0.3
+ 390010p 0.9
+ 392000p 0.9
+ 392010p -0.3
+ 394000p -0.3
+ 394010p 0.9
+ 396000p 0.9
+ 396010p -0.3
+ 398000p -0.3
+ 398010p 0.9
+ 400000p 0.9
+ 400010p -0.3
+ 402000p -0.3
+ 402010p 0.9
+ 404000p 0.9
+ 404010p -0.3
+ 406000p -0.3
+ 406010p 0.9
+ 408000p 0.9
+ 408010p -0.3
+ 410000p -0.3
+ 410010p 0.9
+ 412000p 0.9
+ 412010p -0.3
+ 414000p -0.3
+ 414010p 0.9
+ 416000p 0.9
+ 416010p -0.3
+ 418000p -0.3
+ 418010p 0.9
+ 420000p 0.9
+ 420010p -0.3
+ 422000p -0.3
+ 422010p 0.9
+ 424000p 0.9
+ 424010p -0.3
+ 426000p -0.3
+ 426010p 0.9
+ 428000p 0.9
+ 428010p -0.3
+ 430000p -0.3
+ 430010p 0.9
+ 432000p 0.9
+ 432010p -0.3
+ 434000p -0.3
+ 434010p 0.9
+ 436000p 0.9
+ 436010p -0.3
+ 438000p -0.3
+ 438010p 0.9
+ 440000p 0.9
+ 440010p -0.3
+ 442000p -0.3
+ 442010p 0.9
+ 444000p 0.9
+ 444010p -0.3
+ 446000p -0.3
+ 446010p 0.9
+ 448000p 0.9
+ 448010p -0.3
+ 450000p -0.3
+ 450010p 0.9
+ 452000p 0.9
+ 452010p -0.3
+ 454000p -0.3
+ 454010p 0.9
+ 456000p 0.9
+ 456010p -0.3
+ 458000p -0.3
+ 458010p 0.9
+ 460000p 0.9
+ 460010p -0.3
+ 462000p -0.3
+ 462010p 0.9
+ 464000p 0.9
+ 464010p -0.3
+ 466000p -0.3
+ 466010p 0.9
+ 468000p 0.9
+ 468010p -0.3
+ 470000p -0.3
+ 470010p 0.9
+ 472000p 0.9
+ 472010p -0.3
+ 474000p -0.3
+ 474010p 0.9
+ 476000p 0.9
+ 476010p -0.3
+ 478000p -0.3
+ 478010p 0.9
+ 480000p 0.9
+ 480010p -0.3
+ 482000p -0.3
+ 482010p 0.9
+ 484000p 0.9
+ 484010p -0.3
+ 486000p -0.3
+ 486010p 0.9
+ 488000p 0.9
+ 488010p -0.3
+ 490000p -0.3
+ 490010p 0.9
+ 492000p 0.9
+ 492010p -0.3
+ 494000p -0.3
+ 494010p 0.9
+ 496000p 0.9
+ 496010p -0.3
+ 498000p -0.3
+ 498010p 0.9
+ 500000p 0.9
+ 500010p -0.3
+ 502000p -0.3
+ 502010p 0.9
+ 504000p 0.9
+ 504010p -0.3
+ 506000p -0.3
+ 506010p 0.9
+ 508000p 0.9
+ 508010p -0.3
+ 510000p -0.3
+ 510010p 0.9
+ 512000p 0.9
+ 512010p -0.3
+ 514000p -0.3
+ 514010p 0.9
+ 516000p 0.9
+ 516010p -0.3
+ 518000p -0.3
+ 518010p 0.9
+ 520000p 0.9
+ 520010p -0.3
+ 522000p -0.3
+ 522010p 0.9
+ 524000p 0.9
+ 524010p -0.3
+ 526000p -0.3
+ 526010p 0.9
+ 528000p 0.9
+ 528010p -0.3
+ 530000p -0.3
+ 530010p 0.9
+ 532000p 0.9
+ 532010p -0.3
+ 534000p -0.3
+ 534010p 0.9
+ 536000p 0.9
+ 536010p -0.3
+ 538000p -0.3
+ 538010p 0.9
+ 540000p 0.9
+ 540010p -0.3
+ 542000p -0.3
+ 542010p 0.9
+ 544000p 0.9
+ 544010p -0.3
+ 546000p -0.3
+ 546010p 0.9
+ 548000p 0.9
+ 548010p -0.3
+ 550000p -0.3
+ 550010p 0.9
+ 552000p 0.9
+ 552010p -0.3
+ 554000p -0.3
+ 554010p 0.9
+ 556000p 0.9
+ 556010p -0.3
+ 558000p -0.3
+ 558010p 0.9
+ 560000p 0.9
+ 560010p -0.3
+ 562000p -0.3
+ 562010p 0.9
+ 564000p 0.9
+ 564010p -0.3
+ 566000p -0.3
+ 566010p 0.9
+ 568000p 0.9
+ 568010p -0.3
+ 570000p -0.3
+ 570010p 0.9
+ 572000p 0.9
+ 572010p -0.3
+ 574000p -0.3
+ 574010p 0.9
+ 576000p 0.9
+ 576010p -0.3
+ 578000p -0.3
+ 578010p 0.9
+ 580000p 0.9
+ 580010p -0.3
+ 582000p -0.3
+ 582010p 0.9
+ 584000p 0.9
+ 584010p -0.3
+ 586000p -0.3
+ 586010p 0.9
+ 588000p 0.9
+ 588010p -0.3
+ 590000p -0.3
+ 590010p 0.9
+ 592000p 0.9
+ 592010p -0.3
+ 594000p -0.3
+ 594010p 0.9
+ 596000p 0.9
+ 596010p -0.3
+ 598000p -0.3
+ 598010p 0.9
+ 600000p 0.9
+ 600010p -0.3
+ 602000p -0.3
+ 602010p 0.9
+ 604000p 0.9
+ 604010p -0.3
+ 606000p -0.3
+ 606010p 0.9
+ 608000p 0.9
+ 608010p -0.3
+ 610000p -0.3
+ 610010p 0.9
+ 612000p 0.9
+ 612010p -0.3
+ 614000p -0.3
+ 614010p 0.9
+ 616000p 0.9
+ 616010p -0.3
+ 618000p -0.3
+ 618010p 0.9
+ 620000p 0.9
+ 620010p -0.3
+ 622000p -0.3
+ 622010p 0.9
+ 624000p 0.9
+ 624010p -0.3
+ 626000p -0.3
+ 626010p 0.9
+ 628000p 0.9
+ 628010p -0.3
+ 630000p -0.3
+ 630010p 0.9
+ 632000p 0.9
+ 632010p -0.3
+ 634000p -0.3
+ 634010p 0.9
+ 636000p 0.9
+ 636010p -0.3
+ 638000p -0.3
+ 638010p 0.9
+ 640000p 0.9
+ 640010p -0.3
+ 642000p -0.3
+ 642010p 0.9
+ 644000p 0.9
+ 644010p -0.3
+ 646000p -0.3
+ 646010p 0.9
+ 648000p 0.9
+ 648010p -0.3
+ 650000p -0.3
+ 650010p 0.9
+ 652000p 0.9
+ 652010p -0.3
+ 654000p -0.3
+ 654010p 0.9
+ 656000p 0.9
+ 656010p -0.3
+ 658000p -0.3
+ 658010p 0.9
+ 660000p 0.9
+ 660010p -0.3
+ 662000p -0.3
+ 662010p 0.9
+ 664000p 0.9
+ 664010p -0.3
+ 666000p -0.3
+ 666010p 0.9
+ 668000p 0.9
+ 668010p -0.3
+ 670000p -0.3
+ 670010p 0.9
+ 672000p 0.9
+ 672010p -0.3
+ 674000p -0.3
+ 674010p 0.9
+ 676000p 0.9
+ 676010p -0.3
+ 678000p -0.3
+ 678010p 0.9
+ 680000p 0.9
+ 680010p -0.3
+ 682000p -0.3
+ 682010p 0.9
+ 684000p 0.9
+ 684010p -0.3
+ 686000p -0.3
+ 686010p 0.9
+ 688000p 0.9
+ 688010p -0.3
+ 690000p -0.3
+ 690010p 0.9
+ 692000p 0.9
+ 692010p -0.3
+ 694000p -0.3
+ 694010p 0.9
+ 696000p 0.9
+ 696010p -0.3
+ 698000p -0.3
+ 698010p 0.9
+ 700000p 0.9
+ 700010p -0.3
+ 702000p -0.3
+ 702010p 0.9
+ 704000p 0.9
+ 704010p -0.3
+ 706000p -0.3
+ 706010p 0.9
+ 708000p 0.9
+ 708010p -0.3
+ 710000p -0.3
+ 710010p 0.9
+ 712000p 0.9
+ 712010p -0.3
+ 714000p -0.3
+ 714010p 0.9
+ 716000p 0.9
+ 716010p -0.3
+ 718000p -0.3
+ 718010p 0.9
+ 720000p 0.9
+ 720010p -0.3
+ 722000p -0.3
+ 722010p 0.9
+ 724000p 0.9
+ 724010p -0.3
+ 726000p -0.3
+ 726010p 0.9
+ 728000p 0.9
+ 728010p -0.3
+ 730000p -0.3
+ 730010p 0.9
+ 732000p 0.9
+ 732010p -0.3
+ 734000p -0.3
+ 734010p 0.9
+ 736000p 0.9
+ 736010p -0.3
+ 738000p -0.3
+ 738010p 0.9
+ 740000p 0.9
+ 740010p -0.3
+ 742000p -0.3
+ 742010p 0.9
+ 744000p 0.9
+ 744010p -0.3
+ 746000p -0.3
+ 746010p 0.9
+ 748000p 0.9
+ 748010p -0.3
+ 750000p -0.3
+ 750010p 0.9
+ 752000p 0.9
+ 752010p -0.3
+ 754000p -0.3
+ 754010p 0.9
+ 756000p 0.9
+ 756010p -0.3
+ 758000p -0.3
+ 758010p 0.9
+ 760000p 0.9
+ 760010p -0.3
+ 762000p -0.3
+ 762010p 0.9
+ 764000p 0.9
+ 764010p -0.3
+ 766000p -0.3
+ 766010p 0.9
+ 768000p 0.9
+ 768010p -0.3
+ 770000p -0.3
+ 770010p 0.9
+ 772000p 0.9
+ 772010p -0.3
+ 774000p -0.3
+ 774010p 0.9
+ 776000p 0.9
+ 776010p -0.3
+ 778000p -0.3
+ 778010p 0.9
+ 780000p 0.9
+ 780010p -0.3
+ 782000p -0.3
+ 782010p 0.9
+ 784000p 0.9
+ 784010p -0.3
+ 786000p -0.3
+ 786010p 0.9
+ 788000p 0.9
+ 788010p -0.3
+ 790000p -0.3
+ 790010p 0.9
+ 792000p 0.9
+ 792010p -0.3
+ 794000p -0.3
+ 794010p 0.9
+ 796000p 0.9
+ 796010p -0.3
+ 798000p -0.3
+ 798010p 0.9
+ 800000p 0.9
+ 800010p -0.3
+ 802000p -0.3
+ 802010p 0.9
+ 804000p 0.9
+ 804010p -0.3
+ 806000p -0.3
+ 806010p 0.9
+ 808000p 0.9
+ 808010p -0.3
+ 810000p -0.3
+ 810010p 0.9
+ 812000p 0.9
+ 812010p -0.3
+ 814000p -0.3
+ 814010p 0.9
+ 816000p 0.9
+ 816010p -0.3
+ 818000p -0.3
+ 818010p 0.9
+ 820000p 0.9
+ 820010p -0.3
+ 822000p -0.3
+ 822010p 0.9
+ 824000p 0.9
+ 824010p -0.3
+ 826000p -0.3
+ 826010p 0.9
+ 828000p 0.9
+ 828010p -0.3
+ 830000p -0.3
+ 830010p 0.9
+ 832000p 0.9
+ 832010p -0.3
+ 834000p -0.3
+ 834010p 0.9
+ 836000p 0.9
+ 836010p -0.3
+ 838000p -0.3
+ 838010p 0.9
+ 840000p 0.9
+ 840010p -0.3
+ 842000p -0.3
+ 842010p 0.9
+ 844000p 0.9
+ 844010p -0.3
+ 846000p -0.3
+ 846010p 0.9
+ 848000p 0.9
+ 848010p -0.3
+ 850000p -0.3
+ 850010p 0.9
+ 852000p 0.9
+ 852010p -0.3
+ 854000p -0.3
+ 854010p 0.9
+ 856000p 0.9
+ 856010p -0.3
+ 858000p -0.3
+ 858010p 0.9
+ 860000p 0.9
+ 860010p -0.3
+ 862000p -0.3
+ 862010p 0.9
+ 864000p 0.9
+ 864010p -0.3
+ 866000p -0.3
+ 866010p 0.9
+ 868000p 0.9
+ 868010p -0.3
+ 870000p -0.3
+ 870010p 0.9
+ 872000p 0.9
+ 872010p -0.3
+ 874000p -0.3
+ 874010p 0.9
+ 876000p 0.9
+ 876010p -0.3
+ 878000p -0.3
+ 878010p 0.9
+ 880000p 0.9
+ 880010p -0.3
+ 882000p -0.3
+ 882010p 0.9
+ 884000p 0.9
+ 884010p -0.3
+ 886000p -0.3
+ 886010p 0.9
+ 888000p 0.9
+ 888010p -0.3
+ 890000p -0.3
+ 890010p 0.9
+ 892000p 0.9
+ 892010p -0.3
+ 894000p -0.3
+ 894010p 0.9
+ 896000p 0.9
+ 896010p -0.3
+ 898000p -0.3
+ 898010p 0.9
+ 900000p 0.9
+ 900010p -0.3
+ 902000p -0.3
+ 902010p 0.9
+ 904000p 0.9
+ 904010p -0.3
+ 906000p -0.3
+ 906010p 0.9
+ 908000p 0.9
+ 908010p -0.3
+ 910000p -0.3
+ 910010p 0.9
+ 912000p 0.9
+ 912010p -0.3
+ 914000p -0.3
+ 914010p 0.9
+ 916000p 0.9
+ 916010p -0.3
+ 918000p -0.3
+ 918010p 0.9
+ 920000p 0.9
+ 920010p -0.3
+ 922000p -0.3
+ 922010p 0.9
+ 924000p 0.9
+ 924010p -0.3
+ 926000p -0.3
+ 926010p 0.9
+ 928000p 0.9
+ 928010p -0.3
+ 930000p -0.3
+ 930010p 0.9
+ 932000p 0.9
+ 932010p -0.3
+ 934000p -0.3
+ 934010p 0.9
+ 936000p 0.9
+ 936010p -0.3
+ 938000p -0.3
+ 938010p 0.9
+ 940000p 0.9
+ 940010p -0.3
+ 942000p -0.3
+ 942010p 0.9
+ 944000p 0.9
+ 944010p -0.3
+ 946000p -0.3
+ 946010p 0.9
+ 948000p 0.9
+ 948010p -0.3
+ 950000p -0.3
+ 950010p 0.9
+ 952000p 0.9
+ 952010p -0.3
+ 954000p -0.3
+ 954010p 0.9
+ 956000p 0.9
+ 956010p -0.3
+ 958000p -0.3
+ 958010p 0.9
+ 960000p 0.9
+ 960010p -0.3
+ 962000p -0.3
+ 962010p 0.9
+ 964000p 0.9
+ 964010p -0.3
+ 966000p -0.3
+ 966010p 0.9
+ 968000p 0.9
+ 968010p -0.3
+ 970000p -0.3
+ 970010p 0.9
+ 972000p 0.9
+ 972010p -0.3
+ 974000p -0.3
+ 974010p 0.9
+ 976000p 0.9
+ 976010p -0.3
+ 978000p -0.3
+ 978010p 0.9
+ 980000p 0.9
+ 980010p -0.3
+ 982000p -0.3
+ 982010p 0.9
+ 984000p 0.9
+ 984010p -0.3
+ 986000p -0.3
+ 986010p 0.9
+ 988000p 0.9
+ 988010p -0.3
+ 990000p -0.3
+ 990010p 0.9
+ 992000p 0.9
+ 992010p -0.3
+ 994000p -0.3
+ 994010p 0.9
+ 996000p 0.9
+ 996010p -0.3
+ 998000p -0.3
+ 998010p 0.9
+ 1000000p 0.9
+ 1000010p -0.3
+ 1002000p -0.3
+ 1002010p 0.9
+ 1004000p 0.9
+ 1004010p -0.3
+ 1006000p -0.3
+ 1006010p 0.9
+ 1008000p 0.9
+ 1008010p -0.3
+ 1010000p -0.3
+ 1010010p 0.9
+ 1012000p 0.9
+ 1012010p -0.3
+ 1014000p -0.3
+ 1014010p 0.9
+ 1016000p 0.9
+ 1016010p -0.3
+ 1018000p -0.3
+ 1018010p 0.9
+ 1020000p 0.9
+ 1020010p -0.3
+ 1022000p -0.3
+ 1022010p 0.9
+ 1024000p 0.9
+ 1024010p -0.3
+ 1026000p -0.3
+ 1026010p 0.9
+ 1028000p 0.9
+ 1028010p -0.3
+ 1030000p -0.3
+ 1030010p 0.9
+ 1032000p 0.9
+ 1032010p -0.3
+ 1034000p -0.3
+ 1034010p 0.9
+ 1036000p 0.9
+ 1036010p -0.3
+ 1038000p -0.3
+ 1038010p 0.9
+ 1040000p 0.9
+ 1040010p -0.3
+ 1042000p -0.3
+ 1042010p 0.9
+ 1044000p 0.9
+ 1044010p -0.3
+ 1046000p -0.3
+ 1046010p 0.9
+ 1048000p 0.9
+ 1048010p -0.3
+ 1050000p -0.3
+ 1050010p 0.9
+ 1052000p 0.9
+ 1052010p -0.3
+ 1054000p -0.3
+ 1054010p 0.9
+ 1056000p 0.9
+ 1056010p -0.3
+ 1058000p -0.3
+ 1058010p 0.9
+ 1060000p 0.9
+ 1060010p -0.3
+ 1062000p -0.3
+ 1062010p 0.9
+ 1064000p 0.9
+ 1064010p -0.3
+ 1066000p -0.3
+ 1066010p 0.9
+ 1068000p 0.9
+ 1068010p -0.3
+ 1070000p -0.3
+ 1070010p 0.9
+ 1072000p 0.9
+ 1072010p -0.3
+ 1074000p -0.3
+ 1074010p 0.9
+ 1076000p 0.9
+ 1076010p -0.3
+ 1078000p -0.3
+ 1078010p 0.9
+ 1080000p 0.9
+ 1080010p -0.3
+ 1082000p -0.3
+ 1082010p 0.9
+ 1084000p 0.9
+ 1084010p -0.3
+ 1086000p -0.3
+ 1086010p 0.9
+ 1088000p 0.9
+ 1088010p -0.3
+ 1090000p -0.3
+ 1090010p 0.9
+ 1092000p 0.9
+ 1092010p -0.3
+ 1094000p -0.3
+ 1094010p 0.9
+ 1096000p 0.9
+ 1096010p -0.3
+ 1098000p -0.3
+ 1098010p 0.9
+ 1100000p 0.9
+ 1100010p -0.3
+ 1102000p -0.3
+ 1102010p 0.9
+ 1104000p 0.9
+ 1104010p -0.3
+ 1106000p -0.3
+ 1106010p 0.9
+ 1108000p 0.9
+ 1108010p -0.3
+ 1110000p -0.3
+ 1110010p 0.9
+ 1112000p 0.9
+ 1112010p -0.3
+ 1114000p -0.3
+ 1114010p 0.9
+ 1116000p 0.9
+ 1116010p -0.3
+ 1118000p -0.3
+ 1118010p 0.9
+ 1120000p 0.9
+ 1120010p -0.3
+ 1122000p -0.3
+ 1122010p 0.9
+ 1124000p 0.9
+ 1124010p -0.3
+ 1126000p -0.3
+ 1126010p 0.9
+ 1128000p 0.9
+ 1128010p -0.3
+ 1130000p -0.3
+ 1130010p 0.9
+ 1132000p 0.9
+ 1132010p -0.3
+ 1134000p -0.3
+ 1134010p 0.9
+ 1136000p 0.9
+ 1136010p -0.3
+ 1138000p -0.3
+ 1138010p 0.9
+ 1140000p 0.9
+ 1140010p -0.3
+ 1142000p -0.3
+ 1142010p 0.9
+ 1144000p 0.9
+ 1144010p -0.3
+ 1146000p -0.3
+ 1146010p 0.9
+ 1148000p 0.9
+ 1148010p -0.3
+ 1150000p -0.3
+ 1150010p 0.9
+ 1152000p 0.9
+ 1152010p -0.3
+ 1154000p -0.3
+ 1154010p 0.9
+ 1156000p 0.9
+ 1156010p -0.3
+ 1158000p -0.3
+ 1158010p 0.9
+ 1160000p 0.9
+ 1160010p -0.3
+ 1162000p -0.3
+ 1162010p 0.9
+ 1164000p 0.9
+ 1164010p -0.3
+ 1166000p -0.3
+ 1166010p 0.9
+ 1168000p 0.9
+ 1168010p -0.3
+ 1170000p -0.3
+ 1170010p 0.9
+ 1172000p 0.9
+ 1172010p -0.3
+ 1174000p -0.3
+ 1174010p 0.9
+ 1176000p 0.9
+ 1176010p -0.3
+ 1178000p -0.3
+ 1178010p 0.9
+ 1180000p 0.9
+ 1180010p -0.3
+ 1182000p -0.3
+ 1182010p 0.9
+ 1184000p 0.9
+ 1184010p -0.3
+ 1186000p -0.3
+ 1186010p 0.9
+ 1188000p 0.9
+ 1188010p -0.3
+ 1190000p -0.3
+ 1190010p 0.9
+ 1192000p 0.9
+ 1192010p -0.3
+ 1194000p -0.3
+ 1194010p 0.9
+ 1196000p 0.9
+ 1196010p -0.3
+ 1198000p -0.3
+ 1198010p 0.9
+ 1200000p 0.9
+ 1200010p -0.3
+ 1202000p -0.3
+ 1202010p 0.9
+ 1204000p 0.9
+ 1204010p -0.3
+ 1206000p -0.3
+ 1206010p 0.9
+ 1208000p 0.9
+ 1208010p -0.3
+ 1210000p -0.3
+ 1210010p 0.9
+ 1212000p 0.9
+ 1212010p -0.3
+ 1214000p -0.3
+ 1214010p 0.9
+ 1216000p 0.9
+ 1216010p -0.3
+ 1218000p -0.3
+ 1218010p 0.9
+ 1220000p 0.9
+ 1220010p -0.3
+ 1222000p -0.3
+ 1222010p 0.9
+ 1224000p 0.9
+ 1224010p -0.3
+ 1226000p -0.3
+ 1226010p 0.9
+ 1228000p 0.9
+ 1228010p -0.3
+ 1230000p -0.3
+ 1230010p 0.9
+ 1232000p 0.9
+ 1232010p -0.3
+ 1234000p -0.3
+ 1234010p 0.9
+ 1236000p 0.9
+ 1236010p -0.3
+ 1238000p -0.3
+ 1238010p 0.9
+ 1240000p 0.9
+ 1240010p -0.3
+ 1242000p -0.3
+ 1242010p 0.9
+ 1244000p 0.9
+ 1244010p -0.3
+ 1246000p -0.3
+ 1246010p 0.9
+ 1248000p 0.9
+ 1248010p -0.3
+ 1250000p -0.3
+ 1250010p 0.9
+ 1252000p 0.9
+ 1252010p -0.3
+ 1254000p -0.3
+ 1254010p 0.9
+ 1256000p 0.9
+ 1256010p -0.3
+ 1258000p -0.3
+ 1258010p 0.9
+ 1260000p 0.9
+ 1260010p -0.3
+ 1262000p -0.3
+ 1262010p 0.9
+ 1264000p 0.9
+ 1264010p -0.3
+ 1266000p -0.3
+ 1266010p 0.9
+ 1268000p 0.9
+ 1268010p -0.3
+ 1270000p -0.3
+ 1270010p 0.9
+ 1272000p 0.9
+ 1272010p -0.3
+ 1274000p -0.3
+ 1274010p 0.9
+ 1276000p 0.9
+ 1276010p -0.3
+ 1278000p -0.3
+ 1278010p 0.9
+ 1280000p 0.9
+ 1280010p -0.3
+ 1282000p -0.3
+ 1282010p 0.9
+ 1284000p 0.9
+ 1284010p -0.3
+ 1286000p -0.3
+ 1286010p 0.9
+ 1288000p 0.9
+ 1288010p -0.3
+ 1290000p -0.3
+ 1290010p 0.9
+ 1292000p 0.9
+ 1292010p -0.3
+ 1294000p -0.3
+ 1294010p 0.9
+ 1296000p 0.9
+ 1296010p -0.3
+ 1298000p -0.3
+ 1298010p 0.9
+ 1300000p 0.9
+ 1300010p -0.3
+ 1302000p -0.3
+ 1302010p 0.9
+ 1304000p 0.9
+ 1304010p -0.3
+ 1306000p -0.3
+ 1306010p 0.9
+ 1308000p 0.9
+ 1308010p -0.3
+ 1310000p -0.3
+ 1310010p 0.9
+ 1312000p 0.9
+ 1312010p -0.3
+ 1314000p -0.3
+ 1314010p 0.9
+ 1316000p 0.9
+ 1316010p -0.3
+ 1318000p -0.3
+ 1318010p 0.9
+ 1320000p 0.9
+ 1320010p -0.3
+ 1322000p -0.3
+ 1322010p 0.9
+ 1324000p 0.9
+ 1324010p -0.3
+ 1326000p -0.3
+ 1326010p 0.9
+ 1328000p 0.9
+ 1328010p -0.3
+ 1330000p -0.3
+ 1330010p 0.9
+ 1332000p 0.9
+ 1332010p -0.3
+ 1334000p -0.3
+ 1334010p 0.9
+ 1336000p 0.9
+ 1336010p -0.3
+ 1338000p -0.3
+ 1338010p 0.9
+ 1340000p 0.9
+ 1340010p -0.3
+ 1342000p -0.3
+ 1342010p 0.9
+ 1344000p 0.9
+ 1344010p -0.3
+ 1346000p -0.3
+ 1346010p 0.9
+ 1348000p 0.9
+ 1348010p -0.3
+ 1350000p -0.3
+ 1350010p 0.9
+ 1352000p 0.9
+ 1352010p -0.3
+ 1354000p -0.3
+ 1354010p 0.9
+ 1356000p 0.9
+ 1356010p -0.3
+ 1358000p -0.3
+ 1358010p 0.9
+ 1360000p 0.9
+ 1360010p -0.3
+ 1362000p -0.3
+ 1362010p 0.9
+ 1364000p 0.9
+ 1364010p -0.3
+ 1366000p -0.3
+ 1366010p 0.9
+ 1368000p 0.9
+ 1368010p -0.3
+ 1370000p -0.3
+ 1370010p 0.9
+ 1372000p 0.9
+ 1372010p -0.3
+ 1374000p -0.3
+ 1374010p 0.9
+ 1376000p 0.9
+ 1376010p -0.3
+ 1378000p -0.3
+ 1378010p 0.9
+ 1380000p 0.9
+ 1380010p -0.3
+ 1382000p -0.3
+ 1382010p 0.9
+ 1384000p 0.9
+ 1384010p -0.3
+ 1386000p -0.3
+ 1386010p 0.9
+ 1388000p 0.9
+ 1388010p -0.3
+ 1390000p -0.3
+ 1390010p 0.9
+ 1392000p 0.9
+ 1392010p -0.3
+ 1394000p -0.3
+ 1394010p 0.9
+ 1396000p 0.9
+ 1396010p -0.3
+ 1398000p -0.3
+ 1398010p 0.9
+ 1400000p 0.9
+ 1400010p -0.3
+ 1402000p -0.3
+ 1402010p 0.9
+ 1404000p 0.9
+ 1404010p -0.3
+ 1406000p -0.3
+ 1406010p 0.9
+ 1408000p 0.9
+ 1408010p -0.3
+ 1410000p -0.3
+ 1410010p 0.9
+ 1412000p 0.9
+ 1412010p -0.3
+ 1414000p -0.3
+ 1414010p 0.9
+ 1416000p 0.9
+ 1416010p -0.3
+ 1418000p -0.3
+ 1418010p 0.9
+ 1420000p 0.9
+ 1420010p -0.3
+ 1422000p -0.3
+ 1422010p 0.9
+ 1424000p 0.9
+ 1424010p -0.3
+ 1426000p -0.3
+ 1426010p 0.9
+ 1428000p 0.9
+ 1428010p -0.3
+ 1430000p -0.3
+ 1430010p 0.9
+ 1432000p 0.9
+ 1432010p -0.3
+ 1434000p -0.3
+ 1434010p 0.9
+ 1436000p 0.9
+ 1436010p -0.3
+ 1438000p -0.3
+ 1438010p 0.9
+ 1440000p 0.9
+ 1440010p -0.3
+ 1442000p -0.3
+ 1442010p 0.9
+ 1444000p 0.9
+ 1444010p -0.3
+ 1446000p -0.3
+ 1446010p 0.9
+ 1448000p 0.9
+ 1448010p -0.3
+ 1450000p -0.3
+ 1450010p 0.9
+ 1452000p 0.9
+ 1452010p -0.3
+ 1454000p -0.3
+ 1454010p 0.9
+ 1456000p 0.9
+ 1456010p -0.3
+ 1458000p -0.3
+ 1458010p 0.9
+ 1460000p 0.9
+ 1460010p -0.3
+ 1462000p -0.3
+ 1462010p 0.9
+ 1464000p 0.9
+ 1464010p -0.3
+ 1466000p -0.3
+ 1466010p 0.9
+ 1468000p 0.9
+ 1468010p -0.3
+ 1470000p -0.3
+ 1470010p 0.9
+ 1472000p 0.9
+ 1472010p -0.3
+ 1474000p -0.3
+ 1474010p 0.9
+ 1476000p 0.9
+ 1476010p -0.3
+ 1478000p -0.3
+ 1478010p 0.9
+ 1480000p 0.9
+ 1480010p -0.3
+ 1482000p -0.3
+ 1482010p 0.9
+ 1484000p 0.9
+ 1484010p -0.3
+ 1486000p -0.3
+ 1486010p 0.9
+ 1488000p 0.9
+ 1488010p -0.3
+ 1490000p -0.3
+ 1490010p 0.9
+ 1492000p 0.9
+ 1492010p -0.3
+ 1494000p -0.3
+ 1494010p 0.9
+ 1496000p 0.9
+ 1496010p -0.3
+ 1498000p -0.3
+ 1498010p 0.9
+ 1500000p 0.9
+ 1500010p -0.3
+ 1502000p -0.3
+ 1502010p 0.9
+ 1504000p 0.9
+ 1504010p -0.3
+ 1506000p -0.3
+ 1506010p 0.9
+ 1508000p 0.9
+ 1508010p -0.3
+ 1510000p -0.3
+ 1510010p 0.9
+ 1512000p 0.9
+ 1512010p -0.3
+ 1514000p -0.3
+ 1514010p 0.9
+ 1516000p 0.9
+ 1516010p -0.3
+ 1518000p -0.3
+ 1518010p 0.9
+ 1520000p 0.9
+ 1520010p -0.3
+ 1522000p -0.3
+ 1522010p 0.9
+ 1524000p 0.9
+ 1524010p -0.3
+ 1526000p -0.3
+ 1526010p 0.9
+ 1528000p 0.9
+ 1528010p -0.3
+ 1530000p -0.3
+ 1530010p 0.9
+ 1532000p 0.9
+ 1532010p -0.3
+ 1534000p -0.3
+ 1534010p 0.9
+ 1536000p 0.9
+ 1536010p -0.3
+ 1538000p -0.3
+ 1538010p 0.9
+ 1540000p 0.9
+ 1540010p -0.3
+ 1542000p -0.3
+ 1542010p 0.9
+ 1544000p 0.9
+ 1544010p -0.3
+ 1546000p -0.3
+ 1546010p 0.9
+ 1548000p 0.9
+ 1548010p -0.3
+ 1550000p -0.3
+ 1550010p 0.9
+ 1552000p 0.9
+ 1552010p -0.3
+ 1554000p -0.3
+ 1554010p 0.9
+ 1556000p 0.9
+ 1556010p -0.3
+ 1558000p -0.3
+ 1558010p 0.9
+ 1560000p 0.9
+ 1560010p -0.3
+ 1562000p -0.3
+ 1562010p 0.9
+ 1564000p 0.9
+ 1564010p -0.3
+ 1566000p -0.3
+ 1566010p 0.9
+ 1568000p 0.9
+ 1568010p -0.3
+ 1570000p -0.3
+ 1570010p 0.9
+ 1572000p 0.9
+ 1572010p -0.3
+ 1574000p -0.3
+ 1574010p 0.9
+ 1576000p 0.9
+ 1576010p -0.3
+ 1578000p -0.3
+ 1578010p 0.9
+ 1580000p 0.9
+ 1580010p -0.3
+ 1582000p -0.3
+ 1582010p 0.9
+ 1584000p 0.9
+ 1584010p -0.3
+ 1586000p -0.3
+ 1586010p 0.9
+ 1588000p 0.9
+ 1588010p -0.3
+ 1590000p -0.3
+ 1590010p 0.9
+ 1592000p 0.9
+ 1592010p -0.3
+ 1594000p -0.3
+ 1594010p 0.9
+ 1596000p 0.9
+ 1596010p -0.3
+ 1598000p -0.3
+ 1598010p 0.9
+ 1600000p 0.9
+ 1600010p -0.3
+ 1602000p -0.3
+ 1602010p 0.9
+ 1604000p 0.9
+ 1604010p -0.3
+ 1606000p -0.3
+ 1606010p 0.9
+ 1608000p 0.9
+ 1608010p -0.3
+ 1610000p -0.3
+ 1610010p 0.9
+ 1612000p 0.9
+ 1612010p -0.3
+ 1614000p -0.3
+ 1614010p 0.9
+ 1616000p 0.9
+ 1616010p -0.3
+ 1618000p -0.3
+ 1618010p 0.9
+ 1620000p 0.9
+ 1620010p -0.3
+ 1622000p -0.3
+ 1622010p 0.9
+ 1624000p 0.9
+ 1624010p -0.3
+ 1626000p -0.3
+ 1626010p 0.9
+ 1628000p 0.9
+ 1628010p -0.3
+ 1630000p -0.3
+ 1630010p 0.9
+ 1632000p 0.9
+ 1632010p -0.3
+ 1634000p -0.3
+ 1634010p 0.9
+ 1636000p 0.9
+ 1636010p -0.3
+ 1638000p -0.3
+ 1638010p 0.9
+ 1640000p 0.9
+ 1640010p -0.3
+ 1642000p -0.3
+ 1642010p 0.9
+ 1644000p 0.9
+ 1644010p -0.3
+ 1646000p -0.3
+ 1646010p 0.9
+ 1648000p 0.9
+ 1648010p -0.3
+ 1650000p -0.3
+ 1650010p 0.9
+ 1652000p 0.9
+ 1652010p -0.3
+ 1654000p -0.3
+ 1654010p 0.9
+ 1656000p 0.9
+ 1656010p -0.3
+ 1658000p -0.3
+ 1658010p 0.9
+ 1660000p 0.9
+ 1660010p -0.3
+ 1662000p -0.3
+ 1662010p 0.9
+ 1664000p 0.9
+ 1664010p -0.3
+ 1666000p -0.3
+ 1666010p 0.9
+ 1668000p 0.9
+ 1668010p -0.3
+ 1670000p -0.3
+ 1670010p 0.9
+ 1672000p 0.9
+ 1672010p -0.3
+ 1674000p -0.3
+ 1674010p 0.9
+ 1676000p 0.9
+ 1676010p -0.3
+ 1678000p -0.3
+ 1678010p 0.9
+ 1680000p 0.9
+ 1680010p -0.3
+ 1682000p -0.3
+ 1682010p 0.9
+ 1684000p 0.9
+ 1684010p -0.3
+ 1686000p -0.3
+ 1686010p 0.9
+ 1688000p 0.9
+ 1688010p -0.3
+ 1690000p -0.3
+ 1690010p 0.9
+ 1692000p 0.9
+ 1692010p -0.3
+ 1694000p -0.3
+ 1694010p 0.9
+ 1696000p 0.9
+ 1696010p -0.3
+ 1698000p -0.3
+ 1698010p 0.9
+ 1700000p 0.9
+ 1700010p -0.3
+ 1702000p -0.3
+ 1702010p 0.9
+ 1704000p 0.9
+ 1704010p -0.3
+ 1706000p -0.3
+ 1706010p 0.9
+ 1708000p 0.9
+ 1708010p -0.3
+ 1710000p -0.3
+ 1710010p 0.9
+ 1712000p 0.9
+ 1712010p -0.3
+ 1714000p -0.3
+ 1714010p 0.9
+ 1716000p 0.9
+ 1716010p -0.3
+ 1718000p -0.3
+ 1718010p 0.9
+ 1720000p 0.9
+ 1720010p -0.3
+ 1722000p -0.3
+ 1722010p 0.9
+ 1724000p 0.9
+ 1724010p -0.3
+ 1726000p -0.3
+ 1726010p 0.9
+ 1728000p 0.9
+ 1728010p -0.3
+ 1730000p -0.3
+ 1730010p 0.9
+ 1732000p 0.9
+ 1732010p -0.3
+ 1734000p -0.3
+ 1734010p 0.9
+ 1736000p 0.9
+ 1736010p -0.3
+ 1738000p -0.3
+ 1738010p 0.9
+ 1740000p 0.9
+ 1740010p -0.3
+ 1742000p -0.3
+ 1742010p 0.9
+ 1744000p 0.9
+ 1744010p -0.3
+ 1746000p -0.3
+ 1746010p 0.9
+ 1748000p 0.9
+ 1748010p -0.3
+ 1750000p -0.3
+ 1750010p 0.9
+ 1752000p 0.9
+ 1752010p -0.3
+ 1754000p -0.3
+ 1754010p 0.9
+ 1756000p 0.9
+ 1756010p -0.3
+ 1758000p -0.3
+ 1758010p 0.9
+ 1760000p 0.9
+ 1760010p -0.3
+ 1762000p -0.3
+ 1762010p 0.9
+ 1764000p 0.9
+ 1764010p -0.3
+ 1766000p -0.3
+ 1766010p 0.9
+ 1768000p 0.9
+ 1768010p -0.3
+ 1770000p -0.3
+ 1770010p 0.9
+ 1772000p 0.9
+ 1772010p -0.3
+ 1774000p -0.3
+ 1774010p 0.9
+ 1776000p 0.9
+ 1776010p -0.3
+ 1778000p -0.3
+ 1778010p 0.9
+ 1780000p 0.9
+ 1780010p -0.3
+ 1782000p -0.3
+ 1782010p 0.9
+ 1784000p 0.9
+ 1784010p -0.3
+ 1786000p -0.3
+ 1786010p 0.9
+ 1788000p 0.9
+ 1788010p -0.3
+ 1790000p -0.3
+ 1790010p 0.9
+ 1792000p 0.9
+ 1792010p -0.3
+ 1794000p -0.3
+ 1794010p 0.9
+ 1796000p 0.9
+ 1796010p -0.3
+ 1798000p -0.3
+ 1798010p 0.9
+ 1800000p 0.9
+ 1800010p -0.3
+ 1802000p -0.3
+ 1802010p 0.9
+ 1804000p 0.9
+ 1804010p -0.3
+ 1806000p -0.3
+ 1806010p 0.9
+ 1808000p 0.9
+ 1808010p -0.3
+ 1810000p -0.3
+ 1810010p 0.9
+ 1812000p 0.9
+ 1812010p -0.3
+ 1814000p -0.3
+ 1814010p 0.9
+ 1816000p 0.9
+ 1816010p -0.3
+ 1818000p -0.3
+ 1818010p 0.9
+ 1820000p 0.9
+ 1820010p -0.3
+ 1822000p -0.3
+ 1822010p 0.9
+ 1824000p 0.9
+ 1824010p -0.3
+ 1826000p -0.3
+ 1826010p 0.9
+ 1828000p 0.9
+ 1828010p -0.3
+ 1830000p -0.3
+ 1830010p 0.9
+ 1832000p 0.9
+ 1832010p -0.3
+ 1834000p -0.3
+ 1834010p 0.9
+ 1836000p 0.9
+ 1836010p -0.3
+ 1838000p -0.3
+ 1838010p 0.9
+ 1840000p 0.9
+ 1840010p -0.3
+ 1842000p -0.3
+ 1842010p 0.9
+ 1844000p 0.9
+ 1844010p -0.3
+ 1846000p -0.3
+ 1846010p 0.9
+ 1848000p 0.9
+ 1848010p -0.3
+ 1850000p -0.3
+ 1850010p 0.9
+ 1852000p 0.9
+ 1852010p -0.3
+ 1854000p -0.3
+ 1854010p 0.9
+ 1856000p 0.9
+ 1856010p -0.3
+ 1858000p -0.3
+ 1858010p 0.9
+ 1860000p 0.9
+ 1860010p -0.3
+ 1862000p -0.3
+ 1862010p 0.9
+ 1864000p 0.9
+ 1864010p -0.3
+ 1866000p -0.3
+ 1866010p 0.9
+ 1868000p 0.9
+ 1868010p -0.3
+ 1870000p -0.3
+ 1870010p 0.9
+ 1872000p 0.9
+ 1872010p -0.3
+ 1874000p -0.3
+ 1874010p 0.9
+ 1876000p 0.9
+ 1876010p -0.3
+ 1878000p -0.3
+ 1878010p 0.9
+ 1880000p 0.9
+ 1880010p -0.3
+ 1882000p -0.3
+ 1882010p 0.9
+ 1884000p 0.9
+ 1884010p -0.3
+ 1886000p -0.3
+ 1886010p 0.9
+ 1888000p 0.9
+ 1888010p -0.3
+ 1890000p -0.3
+ 1890010p 0.9
+ 1892000p 0.9
+ 1892010p -0.3
+ 1894000p -0.3
+ 1894010p 0.9
+ 1896000p 0.9
+ 1896010p -0.3
+ 1898000p -0.3
+ 1898010p 0.9
+ 1900000p 0.9
+ 1900010p -0.3
+ 1902000p -0.3
+ 1902010p 0.9
+ 1904000p 0.9
+ 1904010p -0.3
+ 1906000p -0.3
+ 1906010p 0.9
+ 1908000p 0.9
+ 1908010p -0.3
+ 1910000p -0.3
+ 1910010p 0.9
+ 1912000p 0.9
+ 1912010p -0.3
+ 1914000p -0.3
+ 1914010p 0.9
+ 1916000p 0.9
+ 1916010p -0.3
+ 1918000p -0.3
+ 1918010p 0.9
+ 1920000p 0.9
+ 1920010p -0.3
+ 1922000p -0.3
+ 1922010p 0.9
+ 1924000p 0.9
+ 1924010p -0.3
+ 1926000p -0.3
+ 1926010p 0.9
+ 1928000p 0.9
+ 1928010p -0.3
+ 1930000p -0.3
+ 1930010p 0.9
+ 1932000p 0.9
+ 1932010p -0.3
+ 1934000p -0.3
+ 1934010p 0.9
+ 1936000p 0.9
+ 1936010p -0.3
+ 1938000p -0.3
+ 1938010p 0.9
+ 1940000p 0.9
+ 1940010p -0.3
+ 1942000p -0.3
+ 1942010p 0.9
+ 1944000p 0.9
+ 1944010p -0.3
+ 1946000p -0.3
+ 1946010p 0.9
+ 1948000p 0.9
+ 1948010p -0.3
+ 1950000p -0.3
+ 1950010p 0.9
+ 1952000p 0.9
+ 1952010p -0.3
+ 1954000p -0.3
+ 1954010p 0.9
+ 1956000p 0.9
+ 1956010p -0.3
+ 1958000p -0.3
+ 1958010p 0.9
+ 1960000p 0.9
+ 1960010p -0.3
+ 1962000p -0.3
+ 1962010p 0.9
+ 1964000p 0.9
+ 1964010p -0.3
+ 1966000p -0.3
+ 1966010p 0.9
+ 1968000p 0.9
+ 1968010p -0.3
+ 1970000p -0.3
+ 1970010p 0.9
+ 1972000p 0.9
+ 1972010p -0.3
+ 1974000p -0.3
+ 1974010p 0.9
+ 1976000p 0.9
+ 1976010p -0.3
+ 1978000p -0.3
+ 1978010p 0.9
+ 1980000p 0.9
+ 1980010p -0.3
+ 1982000p -0.3
+ 1982010p 0.9
+ 1984000p 0.9
+ 1984010p -0.3
+ 1986000p -0.3
+ 1986010p 0.9
+ 1988000p 0.9
+ 1988010p -0.3
+ 1990000p -0.3
+ 1990010p 0.9
+ 1992000p 0.9
+ 1992010p -0.3
+ 1994000p -0.3
+ 1994010p 0.9
+ 1996000p 0.9
+ 1996010p -0.3
+ 1998000p -0.3
+ 1998010p 0.9
+ 2000000p 0.9
+ 2000010p -0.3
+ 2002000p -0.3
+ 2002010p 0.9
+ 2004000p 0.9
+ 2004010p -0.3
+ 2006000p -0.3
+ 2006010p 0.9
+ 2008000p 0.9
+ 2008010p -0.3
+ 2010000p -0.3
+ 2010010p 0.9
+ 2012000p 0.9
+ 2012010p -0.3
+ 2014000p -0.3
+ 2014010p 0.9
+ 2016000p 0.9
+ 2016010p -0.3
+ 2018000p -0.3
+ 2018010p 0.9
+ 2020000p 0.9
+ 2020010p -0.3
+ 2022000p -0.3
+ 2022010p 0.9
+ 2024000p 0.9
+ 2024010p -0.3
+ 2026000p -0.3
+ 2026010p 0.9
+ 2028000p 0.9
+ 2028010p -0.3
+ 2030000p -0.3
+ 2030010p 0.9
+ 2032000p 0.9
+ 2032010p -0.3
+ 2034000p -0.3
+ 2034010p 0.9
+ 2036000p 0.9
+ 2036010p -0.3
+ 2038000p -0.3
+ 2038010p 0.9
+ 2040000p 0.9
+ 2040010p -0.3
+ 2042000p -0.3
+ 2042010p 0.9
+ 2044000p 0.9
+ 2044010p -0.3
+ 2046000p -0.3
+ 2046010p 0.9
+ 2048000p 0.9
+ 2048010p -0.3
+ \]
V_data_29 (Data\\<29\\> gnd!) vsource type=pwl wave=\[
+ 0    0.9
+ 2000p 0.9
+ 2010p -0.3
+ 4000p -0.3
+ 4010p 0.9
+ 6000p 0.9
+ 6010p -0.3
+ 8000p -0.3
+ 8010p 0.9
+ 10000p 0.9
+ 10010p -0.3
+ 12000p -0.3
+ 12010p 0.9
+ 14000p 0.9
+ 14010p -0.3
+ 16000p -0.3
+ 16010p 0.9
+ 18000p 0.9
+ 18010p -0.3
+ 20000p -0.3
+ 20010p 0.9
+ 22000p 0.9
+ 22010p -0.3
+ 24000p -0.3
+ 24010p 0.9
+ 26000p 0.9
+ 26010p -0.3
+ 28000p -0.3
+ 28010p 0.9
+ 30000p 0.9
+ 30010p -0.3
+ 32000p -0.3
+ 32010p 0.9
+ 34000p 0.9
+ 34010p -0.3
+ 36000p -0.3
+ 36010p 0.9
+ 38000p 0.9
+ 38010p -0.3
+ 40000p -0.3
+ 40010p 0.9
+ 42000p 0.9
+ 42010p -0.3
+ 44000p -0.3
+ 44010p 0.9
+ 46000p 0.9
+ 46010p -0.3
+ 48000p -0.3
+ 48010p 0.9
+ 50000p 0.9
+ 50010p -0.3
+ 52000p -0.3
+ 52010p 0.9
+ 54000p 0.9
+ 54010p -0.3
+ 56000p -0.3
+ 56010p 0.9
+ 58000p 0.9
+ 58010p -0.3
+ 60000p -0.3
+ 60010p 0.9
+ 62000p 0.9
+ 62010p -0.3
+ 64000p -0.3
+ 64010p 0.9
+ 66000p 0.9
+ 66010p -0.3
+ 68000p -0.3
+ 68010p 0.9
+ 70000p 0.9
+ 70010p -0.3
+ 72000p -0.3
+ 72010p 0.9
+ 74000p 0.9
+ 74010p -0.3
+ 76000p -0.3
+ 76010p 0.9
+ 78000p 0.9
+ 78010p -0.3
+ 80000p -0.3
+ 80010p 0.9
+ 82000p 0.9
+ 82010p -0.3
+ 84000p -0.3
+ 84010p 0.9
+ 86000p 0.9
+ 86010p -0.3
+ 88000p -0.3
+ 88010p 0.9
+ 90000p 0.9
+ 90010p -0.3
+ 92000p -0.3
+ 92010p 0.9
+ 94000p 0.9
+ 94010p -0.3
+ 96000p -0.3
+ 96010p 0.9
+ 98000p 0.9
+ 98010p -0.3
+ 100000p -0.3
+ 100010p 0.9
+ 102000p 0.9
+ 102010p -0.3
+ 104000p -0.3
+ 104010p 0.9
+ 106000p 0.9
+ 106010p -0.3
+ 108000p -0.3
+ 108010p 0.9
+ 110000p 0.9
+ 110010p -0.3
+ 112000p -0.3
+ 112010p 0.9
+ 114000p 0.9
+ 114010p -0.3
+ 116000p -0.3
+ 116010p 0.9
+ 118000p 0.9
+ 118010p -0.3
+ 120000p -0.3
+ 120010p 0.9
+ 122000p 0.9
+ 122010p -0.3
+ 124000p -0.3
+ 124010p 0.9
+ 126000p 0.9
+ 126010p -0.3
+ 128000p -0.3
+ 128010p 0.9
+ 130000p 0.9
+ 130010p -0.3
+ 132000p -0.3
+ 132010p 0.9
+ 134000p 0.9
+ 134010p -0.3
+ 136000p -0.3
+ 136010p 0.9
+ 138000p 0.9
+ 138010p -0.3
+ 140000p -0.3
+ 140010p 0.9
+ 142000p 0.9
+ 142010p -0.3
+ 144000p -0.3
+ 144010p 0.9
+ 146000p 0.9
+ 146010p -0.3
+ 148000p -0.3
+ 148010p 0.9
+ 150000p 0.9
+ 150010p -0.3
+ 152000p -0.3
+ 152010p 0.9
+ 154000p 0.9
+ 154010p -0.3
+ 156000p -0.3
+ 156010p 0.9
+ 158000p 0.9
+ 158010p -0.3
+ 160000p -0.3
+ 160010p 0.9
+ 162000p 0.9
+ 162010p -0.3
+ 164000p -0.3
+ 164010p 0.9
+ 166000p 0.9
+ 166010p -0.3
+ 168000p -0.3
+ 168010p 0.9
+ 170000p 0.9
+ 170010p -0.3
+ 172000p -0.3
+ 172010p 0.9
+ 174000p 0.9
+ 174010p -0.3
+ 176000p -0.3
+ 176010p 0.9
+ 178000p 0.9
+ 178010p -0.3
+ 180000p -0.3
+ 180010p 0.9
+ 182000p 0.9
+ 182010p -0.3
+ 184000p -0.3
+ 184010p 0.9
+ 186000p 0.9
+ 186010p -0.3
+ 188000p -0.3
+ 188010p 0.9
+ 190000p 0.9
+ 190010p -0.3
+ 192000p -0.3
+ 192010p 0.9
+ 194000p 0.9
+ 194010p -0.3
+ 196000p -0.3
+ 196010p 0.9
+ 198000p 0.9
+ 198010p -0.3
+ 200000p -0.3
+ 200010p 0.9
+ 202000p 0.9
+ 202010p -0.3
+ 204000p -0.3
+ 204010p 0.9
+ 206000p 0.9
+ 206010p -0.3
+ 208000p -0.3
+ 208010p 0.9
+ 210000p 0.9
+ 210010p -0.3
+ 212000p -0.3
+ 212010p 0.9
+ 214000p 0.9
+ 214010p -0.3
+ 216000p -0.3
+ 216010p 0.9
+ 218000p 0.9
+ 218010p -0.3
+ 220000p -0.3
+ 220010p 0.9
+ 222000p 0.9
+ 222010p -0.3
+ 224000p -0.3
+ 224010p 0.9
+ 226000p 0.9
+ 226010p -0.3
+ 228000p -0.3
+ 228010p 0.9
+ 230000p 0.9
+ 230010p -0.3
+ 232000p -0.3
+ 232010p 0.9
+ 234000p 0.9
+ 234010p -0.3
+ 236000p -0.3
+ 236010p 0.9
+ 238000p 0.9
+ 238010p -0.3
+ 240000p -0.3
+ 240010p 0.9
+ 242000p 0.9
+ 242010p -0.3
+ 244000p -0.3
+ 244010p 0.9
+ 246000p 0.9
+ 246010p -0.3
+ 248000p -0.3
+ 248010p 0.9
+ 250000p 0.9
+ 250010p -0.3
+ 252000p -0.3
+ 252010p 0.9
+ 254000p 0.9
+ 254010p -0.3
+ 256000p -0.3
+ 256010p 0.9
+ 258000p 0.9
+ 258010p -0.3
+ 260000p -0.3
+ 260010p 0.9
+ 262000p 0.9
+ 262010p -0.3
+ 264000p -0.3
+ 264010p 0.9
+ 266000p 0.9
+ 266010p -0.3
+ 268000p -0.3
+ 268010p 0.9
+ 270000p 0.9
+ 270010p -0.3
+ 272000p -0.3
+ 272010p 0.9
+ 274000p 0.9
+ 274010p -0.3
+ 276000p -0.3
+ 276010p 0.9
+ 278000p 0.9
+ 278010p -0.3
+ 280000p -0.3
+ 280010p 0.9
+ 282000p 0.9
+ 282010p -0.3
+ 284000p -0.3
+ 284010p 0.9
+ 286000p 0.9
+ 286010p -0.3
+ 288000p -0.3
+ 288010p 0.9
+ 290000p 0.9
+ 290010p -0.3
+ 292000p -0.3
+ 292010p 0.9
+ 294000p 0.9
+ 294010p -0.3
+ 296000p -0.3
+ 296010p 0.9
+ 298000p 0.9
+ 298010p -0.3
+ 300000p -0.3
+ 300010p 0.9
+ 302000p 0.9
+ 302010p -0.3
+ 304000p -0.3
+ 304010p 0.9
+ 306000p 0.9
+ 306010p -0.3
+ 308000p -0.3
+ 308010p 0.9
+ 310000p 0.9
+ 310010p -0.3
+ 312000p -0.3
+ 312010p 0.9
+ 314000p 0.9
+ 314010p -0.3
+ 316000p -0.3
+ 316010p 0.9
+ 318000p 0.9
+ 318010p -0.3
+ 320000p -0.3
+ 320010p 0.9
+ 322000p 0.9
+ 322010p -0.3
+ 324000p -0.3
+ 324010p 0.9
+ 326000p 0.9
+ 326010p -0.3
+ 328000p -0.3
+ 328010p 0.9
+ 330000p 0.9
+ 330010p -0.3
+ 332000p -0.3
+ 332010p 0.9
+ 334000p 0.9
+ 334010p -0.3
+ 336000p -0.3
+ 336010p 0.9
+ 338000p 0.9
+ 338010p -0.3
+ 340000p -0.3
+ 340010p 0.9
+ 342000p 0.9
+ 342010p -0.3
+ 344000p -0.3
+ 344010p 0.9
+ 346000p 0.9
+ 346010p -0.3
+ 348000p -0.3
+ 348010p 0.9
+ 350000p 0.9
+ 350010p -0.3
+ 352000p -0.3
+ 352010p 0.9
+ 354000p 0.9
+ 354010p -0.3
+ 356000p -0.3
+ 356010p 0.9
+ 358000p 0.9
+ 358010p -0.3
+ 360000p -0.3
+ 360010p 0.9
+ 362000p 0.9
+ 362010p -0.3
+ 364000p -0.3
+ 364010p 0.9
+ 366000p 0.9
+ 366010p -0.3
+ 368000p -0.3
+ 368010p 0.9
+ 370000p 0.9
+ 370010p -0.3
+ 372000p -0.3
+ 372010p 0.9
+ 374000p 0.9
+ 374010p -0.3
+ 376000p -0.3
+ 376010p 0.9
+ 378000p 0.9
+ 378010p -0.3
+ 380000p -0.3
+ 380010p 0.9
+ 382000p 0.9
+ 382010p -0.3
+ 384000p -0.3
+ 384010p 0.9
+ 386000p 0.9
+ 386010p -0.3
+ 388000p -0.3
+ 388010p 0.9
+ 390000p 0.9
+ 390010p -0.3
+ 392000p -0.3
+ 392010p 0.9
+ 394000p 0.9
+ 394010p -0.3
+ 396000p -0.3
+ 396010p 0.9
+ 398000p 0.9
+ 398010p -0.3
+ 400000p -0.3
+ 400010p 0.9
+ 402000p 0.9
+ 402010p -0.3
+ 404000p -0.3
+ 404010p 0.9
+ 406000p 0.9
+ 406010p -0.3
+ 408000p -0.3
+ 408010p 0.9
+ 410000p 0.9
+ 410010p -0.3
+ 412000p -0.3
+ 412010p 0.9
+ 414000p 0.9
+ 414010p -0.3
+ 416000p -0.3
+ 416010p 0.9
+ 418000p 0.9
+ 418010p -0.3
+ 420000p -0.3
+ 420010p 0.9
+ 422000p 0.9
+ 422010p -0.3
+ 424000p -0.3
+ 424010p 0.9
+ 426000p 0.9
+ 426010p -0.3
+ 428000p -0.3
+ 428010p 0.9
+ 430000p 0.9
+ 430010p -0.3
+ 432000p -0.3
+ 432010p 0.9
+ 434000p 0.9
+ 434010p -0.3
+ 436000p -0.3
+ 436010p 0.9
+ 438000p 0.9
+ 438010p -0.3
+ 440000p -0.3
+ 440010p 0.9
+ 442000p 0.9
+ 442010p -0.3
+ 444000p -0.3
+ 444010p 0.9
+ 446000p 0.9
+ 446010p -0.3
+ 448000p -0.3
+ 448010p 0.9
+ 450000p 0.9
+ 450010p -0.3
+ 452000p -0.3
+ 452010p 0.9
+ 454000p 0.9
+ 454010p -0.3
+ 456000p -0.3
+ 456010p 0.9
+ 458000p 0.9
+ 458010p -0.3
+ 460000p -0.3
+ 460010p 0.9
+ 462000p 0.9
+ 462010p -0.3
+ 464000p -0.3
+ 464010p 0.9
+ 466000p 0.9
+ 466010p -0.3
+ 468000p -0.3
+ 468010p 0.9
+ 470000p 0.9
+ 470010p -0.3
+ 472000p -0.3
+ 472010p 0.9
+ 474000p 0.9
+ 474010p -0.3
+ 476000p -0.3
+ 476010p 0.9
+ 478000p 0.9
+ 478010p -0.3
+ 480000p -0.3
+ 480010p 0.9
+ 482000p 0.9
+ 482010p -0.3
+ 484000p -0.3
+ 484010p 0.9
+ 486000p 0.9
+ 486010p -0.3
+ 488000p -0.3
+ 488010p 0.9
+ 490000p 0.9
+ 490010p -0.3
+ 492000p -0.3
+ 492010p 0.9
+ 494000p 0.9
+ 494010p -0.3
+ 496000p -0.3
+ 496010p 0.9
+ 498000p 0.9
+ 498010p -0.3
+ 500000p -0.3
+ 500010p 0.9
+ 502000p 0.9
+ 502010p -0.3
+ 504000p -0.3
+ 504010p 0.9
+ 506000p 0.9
+ 506010p -0.3
+ 508000p -0.3
+ 508010p 0.9
+ 510000p 0.9
+ 510010p -0.3
+ 512000p -0.3
+ 512010p 0.9
+ 514000p 0.9
+ 514010p -0.3
+ 516000p -0.3
+ 516010p 0.9
+ 518000p 0.9
+ 518010p -0.3
+ 520000p -0.3
+ 520010p 0.9
+ 522000p 0.9
+ 522010p -0.3
+ 524000p -0.3
+ 524010p 0.9
+ 526000p 0.9
+ 526010p -0.3
+ 528000p -0.3
+ 528010p 0.9
+ 530000p 0.9
+ 530010p -0.3
+ 532000p -0.3
+ 532010p 0.9
+ 534000p 0.9
+ 534010p -0.3
+ 536000p -0.3
+ 536010p 0.9
+ 538000p 0.9
+ 538010p -0.3
+ 540000p -0.3
+ 540010p 0.9
+ 542000p 0.9
+ 542010p -0.3
+ 544000p -0.3
+ 544010p 0.9
+ 546000p 0.9
+ 546010p -0.3
+ 548000p -0.3
+ 548010p 0.9
+ 550000p 0.9
+ 550010p -0.3
+ 552000p -0.3
+ 552010p 0.9
+ 554000p 0.9
+ 554010p -0.3
+ 556000p -0.3
+ 556010p 0.9
+ 558000p 0.9
+ 558010p -0.3
+ 560000p -0.3
+ 560010p 0.9
+ 562000p 0.9
+ 562010p -0.3
+ 564000p -0.3
+ 564010p 0.9
+ 566000p 0.9
+ 566010p -0.3
+ 568000p -0.3
+ 568010p 0.9
+ 570000p 0.9
+ 570010p -0.3
+ 572000p -0.3
+ 572010p 0.9
+ 574000p 0.9
+ 574010p -0.3
+ 576000p -0.3
+ 576010p 0.9
+ 578000p 0.9
+ 578010p -0.3
+ 580000p -0.3
+ 580010p 0.9
+ 582000p 0.9
+ 582010p -0.3
+ 584000p -0.3
+ 584010p 0.9
+ 586000p 0.9
+ 586010p -0.3
+ 588000p -0.3
+ 588010p 0.9
+ 590000p 0.9
+ 590010p -0.3
+ 592000p -0.3
+ 592010p 0.9
+ 594000p 0.9
+ 594010p -0.3
+ 596000p -0.3
+ 596010p 0.9
+ 598000p 0.9
+ 598010p -0.3
+ 600000p -0.3
+ 600010p 0.9
+ 602000p 0.9
+ 602010p -0.3
+ 604000p -0.3
+ 604010p 0.9
+ 606000p 0.9
+ 606010p -0.3
+ 608000p -0.3
+ 608010p 0.9
+ 610000p 0.9
+ 610010p -0.3
+ 612000p -0.3
+ 612010p 0.9
+ 614000p 0.9
+ 614010p -0.3
+ 616000p -0.3
+ 616010p 0.9
+ 618000p 0.9
+ 618010p -0.3
+ 620000p -0.3
+ 620010p 0.9
+ 622000p 0.9
+ 622010p -0.3
+ 624000p -0.3
+ 624010p 0.9
+ 626000p 0.9
+ 626010p -0.3
+ 628000p -0.3
+ 628010p 0.9
+ 630000p 0.9
+ 630010p -0.3
+ 632000p -0.3
+ 632010p 0.9
+ 634000p 0.9
+ 634010p -0.3
+ 636000p -0.3
+ 636010p 0.9
+ 638000p 0.9
+ 638010p -0.3
+ 640000p -0.3
+ 640010p 0.9
+ 642000p 0.9
+ 642010p -0.3
+ 644000p -0.3
+ 644010p 0.9
+ 646000p 0.9
+ 646010p -0.3
+ 648000p -0.3
+ 648010p 0.9
+ 650000p 0.9
+ 650010p -0.3
+ 652000p -0.3
+ 652010p 0.9
+ 654000p 0.9
+ 654010p -0.3
+ 656000p -0.3
+ 656010p 0.9
+ 658000p 0.9
+ 658010p -0.3
+ 660000p -0.3
+ 660010p 0.9
+ 662000p 0.9
+ 662010p -0.3
+ 664000p -0.3
+ 664010p 0.9
+ 666000p 0.9
+ 666010p -0.3
+ 668000p -0.3
+ 668010p 0.9
+ 670000p 0.9
+ 670010p -0.3
+ 672000p -0.3
+ 672010p 0.9
+ 674000p 0.9
+ 674010p -0.3
+ 676000p -0.3
+ 676010p 0.9
+ 678000p 0.9
+ 678010p -0.3
+ 680000p -0.3
+ 680010p 0.9
+ 682000p 0.9
+ 682010p -0.3
+ 684000p -0.3
+ 684010p 0.9
+ 686000p 0.9
+ 686010p -0.3
+ 688000p -0.3
+ 688010p 0.9
+ 690000p 0.9
+ 690010p -0.3
+ 692000p -0.3
+ 692010p 0.9
+ 694000p 0.9
+ 694010p -0.3
+ 696000p -0.3
+ 696010p 0.9
+ 698000p 0.9
+ 698010p -0.3
+ 700000p -0.3
+ 700010p 0.9
+ 702000p 0.9
+ 702010p -0.3
+ 704000p -0.3
+ 704010p 0.9
+ 706000p 0.9
+ 706010p -0.3
+ 708000p -0.3
+ 708010p 0.9
+ 710000p 0.9
+ 710010p -0.3
+ 712000p -0.3
+ 712010p 0.9
+ 714000p 0.9
+ 714010p -0.3
+ 716000p -0.3
+ 716010p 0.9
+ 718000p 0.9
+ 718010p -0.3
+ 720000p -0.3
+ 720010p 0.9
+ 722000p 0.9
+ 722010p -0.3
+ 724000p -0.3
+ 724010p 0.9
+ 726000p 0.9
+ 726010p -0.3
+ 728000p -0.3
+ 728010p 0.9
+ 730000p 0.9
+ 730010p -0.3
+ 732000p -0.3
+ 732010p 0.9
+ 734000p 0.9
+ 734010p -0.3
+ 736000p -0.3
+ 736010p 0.9
+ 738000p 0.9
+ 738010p -0.3
+ 740000p -0.3
+ 740010p 0.9
+ 742000p 0.9
+ 742010p -0.3
+ 744000p -0.3
+ 744010p 0.9
+ 746000p 0.9
+ 746010p -0.3
+ 748000p -0.3
+ 748010p 0.9
+ 750000p 0.9
+ 750010p -0.3
+ 752000p -0.3
+ 752010p 0.9
+ 754000p 0.9
+ 754010p -0.3
+ 756000p -0.3
+ 756010p 0.9
+ 758000p 0.9
+ 758010p -0.3
+ 760000p -0.3
+ 760010p 0.9
+ 762000p 0.9
+ 762010p -0.3
+ 764000p -0.3
+ 764010p 0.9
+ 766000p 0.9
+ 766010p -0.3
+ 768000p -0.3
+ 768010p 0.9
+ 770000p 0.9
+ 770010p -0.3
+ 772000p -0.3
+ 772010p 0.9
+ 774000p 0.9
+ 774010p -0.3
+ 776000p -0.3
+ 776010p 0.9
+ 778000p 0.9
+ 778010p -0.3
+ 780000p -0.3
+ 780010p 0.9
+ 782000p 0.9
+ 782010p -0.3
+ 784000p -0.3
+ 784010p 0.9
+ 786000p 0.9
+ 786010p -0.3
+ 788000p -0.3
+ 788010p 0.9
+ 790000p 0.9
+ 790010p -0.3
+ 792000p -0.3
+ 792010p 0.9
+ 794000p 0.9
+ 794010p -0.3
+ 796000p -0.3
+ 796010p 0.9
+ 798000p 0.9
+ 798010p -0.3
+ 800000p -0.3
+ 800010p 0.9
+ 802000p 0.9
+ 802010p -0.3
+ 804000p -0.3
+ 804010p 0.9
+ 806000p 0.9
+ 806010p -0.3
+ 808000p -0.3
+ 808010p 0.9
+ 810000p 0.9
+ 810010p -0.3
+ 812000p -0.3
+ 812010p 0.9
+ 814000p 0.9
+ 814010p -0.3
+ 816000p -0.3
+ 816010p 0.9
+ 818000p 0.9
+ 818010p -0.3
+ 820000p -0.3
+ 820010p 0.9
+ 822000p 0.9
+ 822010p -0.3
+ 824000p -0.3
+ 824010p 0.9
+ 826000p 0.9
+ 826010p -0.3
+ 828000p -0.3
+ 828010p 0.9
+ 830000p 0.9
+ 830010p -0.3
+ 832000p -0.3
+ 832010p 0.9
+ 834000p 0.9
+ 834010p -0.3
+ 836000p -0.3
+ 836010p 0.9
+ 838000p 0.9
+ 838010p -0.3
+ 840000p -0.3
+ 840010p 0.9
+ 842000p 0.9
+ 842010p -0.3
+ 844000p -0.3
+ 844010p 0.9
+ 846000p 0.9
+ 846010p -0.3
+ 848000p -0.3
+ 848010p 0.9
+ 850000p 0.9
+ 850010p -0.3
+ 852000p -0.3
+ 852010p 0.9
+ 854000p 0.9
+ 854010p -0.3
+ 856000p -0.3
+ 856010p 0.9
+ 858000p 0.9
+ 858010p -0.3
+ 860000p -0.3
+ 860010p 0.9
+ 862000p 0.9
+ 862010p -0.3
+ 864000p -0.3
+ 864010p 0.9
+ 866000p 0.9
+ 866010p -0.3
+ 868000p -0.3
+ 868010p 0.9
+ 870000p 0.9
+ 870010p -0.3
+ 872000p -0.3
+ 872010p 0.9
+ 874000p 0.9
+ 874010p -0.3
+ 876000p -0.3
+ 876010p 0.9
+ 878000p 0.9
+ 878010p -0.3
+ 880000p -0.3
+ 880010p 0.9
+ 882000p 0.9
+ 882010p -0.3
+ 884000p -0.3
+ 884010p 0.9
+ 886000p 0.9
+ 886010p -0.3
+ 888000p -0.3
+ 888010p 0.9
+ 890000p 0.9
+ 890010p -0.3
+ 892000p -0.3
+ 892010p 0.9
+ 894000p 0.9
+ 894010p -0.3
+ 896000p -0.3
+ 896010p 0.9
+ 898000p 0.9
+ 898010p -0.3
+ 900000p -0.3
+ 900010p 0.9
+ 902000p 0.9
+ 902010p -0.3
+ 904000p -0.3
+ 904010p 0.9
+ 906000p 0.9
+ 906010p -0.3
+ 908000p -0.3
+ 908010p 0.9
+ 910000p 0.9
+ 910010p -0.3
+ 912000p -0.3
+ 912010p 0.9
+ 914000p 0.9
+ 914010p -0.3
+ 916000p -0.3
+ 916010p 0.9
+ 918000p 0.9
+ 918010p -0.3
+ 920000p -0.3
+ 920010p 0.9
+ 922000p 0.9
+ 922010p -0.3
+ 924000p -0.3
+ 924010p 0.9
+ 926000p 0.9
+ 926010p -0.3
+ 928000p -0.3
+ 928010p 0.9
+ 930000p 0.9
+ 930010p -0.3
+ 932000p -0.3
+ 932010p 0.9
+ 934000p 0.9
+ 934010p -0.3
+ 936000p -0.3
+ 936010p 0.9
+ 938000p 0.9
+ 938010p -0.3
+ 940000p -0.3
+ 940010p 0.9
+ 942000p 0.9
+ 942010p -0.3
+ 944000p -0.3
+ 944010p 0.9
+ 946000p 0.9
+ 946010p -0.3
+ 948000p -0.3
+ 948010p 0.9
+ 950000p 0.9
+ 950010p -0.3
+ 952000p -0.3
+ 952010p 0.9
+ 954000p 0.9
+ 954010p -0.3
+ 956000p -0.3
+ 956010p 0.9
+ 958000p 0.9
+ 958010p -0.3
+ 960000p -0.3
+ 960010p 0.9
+ 962000p 0.9
+ 962010p -0.3
+ 964000p -0.3
+ 964010p 0.9
+ 966000p 0.9
+ 966010p -0.3
+ 968000p -0.3
+ 968010p 0.9
+ 970000p 0.9
+ 970010p -0.3
+ 972000p -0.3
+ 972010p 0.9
+ 974000p 0.9
+ 974010p -0.3
+ 976000p -0.3
+ 976010p 0.9
+ 978000p 0.9
+ 978010p -0.3
+ 980000p -0.3
+ 980010p 0.9
+ 982000p 0.9
+ 982010p -0.3
+ 984000p -0.3
+ 984010p 0.9
+ 986000p 0.9
+ 986010p -0.3
+ 988000p -0.3
+ 988010p 0.9
+ 990000p 0.9
+ 990010p -0.3
+ 992000p -0.3
+ 992010p 0.9
+ 994000p 0.9
+ 994010p -0.3
+ 996000p -0.3
+ 996010p 0.9
+ 998000p 0.9
+ 998010p -0.3
+ 1000000p -0.3
+ 1000010p 0.9
+ 1002000p 0.9
+ 1002010p -0.3
+ 1004000p -0.3
+ 1004010p 0.9
+ 1006000p 0.9
+ 1006010p -0.3
+ 1008000p -0.3
+ 1008010p 0.9
+ 1010000p 0.9
+ 1010010p -0.3
+ 1012000p -0.3
+ 1012010p 0.9
+ 1014000p 0.9
+ 1014010p -0.3
+ 1016000p -0.3
+ 1016010p 0.9
+ 1018000p 0.9
+ 1018010p -0.3
+ 1020000p -0.3
+ 1020010p 0.9
+ 1022000p 0.9
+ 1022010p -0.3
+ 1024000p -0.3
+ 1024010p 0.9
+ 1026000p 0.9
+ 1026010p -0.3
+ 1028000p -0.3
+ 1028010p 0.9
+ 1030000p 0.9
+ 1030010p -0.3
+ 1032000p -0.3
+ 1032010p 0.9
+ 1034000p 0.9
+ 1034010p -0.3
+ 1036000p -0.3
+ 1036010p 0.9
+ 1038000p 0.9
+ 1038010p -0.3
+ 1040000p -0.3
+ 1040010p 0.9
+ 1042000p 0.9
+ 1042010p -0.3
+ 1044000p -0.3
+ 1044010p 0.9
+ 1046000p 0.9
+ 1046010p -0.3
+ 1048000p -0.3
+ 1048010p 0.9
+ 1050000p 0.9
+ 1050010p -0.3
+ 1052000p -0.3
+ 1052010p 0.9
+ 1054000p 0.9
+ 1054010p -0.3
+ 1056000p -0.3
+ 1056010p 0.9
+ 1058000p 0.9
+ 1058010p -0.3
+ 1060000p -0.3
+ 1060010p 0.9
+ 1062000p 0.9
+ 1062010p -0.3
+ 1064000p -0.3
+ 1064010p 0.9
+ 1066000p 0.9
+ 1066010p -0.3
+ 1068000p -0.3
+ 1068010p 0.9
+ 1070000p 0.9
+ 1070010p -0.3
+ 1072000p -0.3
+ 1072010p 0.9
+ 1074000p 0.9
+ 1074010p -0.3
+ 1076000p -0.3
+ 1076010p 0.9
+ 1078000p 0.9
+ 1078010p -0.3
+ 1080000p -0.3
+ 1080010p 0.9
+ 1082000p 0.9
+ 1082010p -0.3
+ 1084000p -0.3
+ 1084010p 0.9
+ 1086000p 0.9
+ 1086010p -0.3
+ 1088000p -0.3
+ 1088010p 0.9
+ 1090000p 0.9
+ 1090010p -0.3
+ 1092000p -0.3
+ 1092010p 0.9
+ 1094000p 0.9
+ 1094010p -0.3
+ 1096000p -0.3
+ 1096010p 0.9
+ 1098000p 0.9
+ 1098010p -0.3
+ 1100000p -0.3
+ 1100010p 0.9
+ 1102000p 0.9
+ 1102010p -0.3
+ 1104000p -0.3
+ 1104010p 0.9
+ 1106000p 0.9
+ 1106010p -0.3
+ 1108000p -0.3
+ 1108010p 0.9
+ 1110000p 0.9
+ 1110010p -0.3
+ 1112000p -0.3
+ 1112010p 0.9
+ 1114000p 0.9
+ 1114010p -0.3
+ 1116000p -0.3
+ 1116010p 0.9
+ 1118000p 0.9
+ 1118010p -0.3
+ 1120000p -0.3
+ 1120010p 0.9
+ 1122000p 0.9
+ 1122010p -0.3
+ 1124000p -0.3
+ 1124010p 0.9
+ 1126000p 0.9
+ 1126010p -0.3
+ 1128000p -0.3
+ 1128010p 0.9
+ 1130000p 0.9
+ 1130010p -0.3
+ 1132000p -0.3
+ 1132010p 0.9
+ 1134000p 0.9
+ 1134010p -0.3
+ 1136000p -0.3
+ 1136010p 0.9
+ 1138000p 0.9
+ 1138010p -0.3
+ 1140000p -0.3
+ 1140010p 0.9
+ 1142000p 0.9
+ 1142010p -0.3
+ 1144000p -0.3
+ 1144010p 0.9
+ 1146000p 0.9
+ 1146010p -0.3
+ 1148000p -0.3
+ 1148010p 0.9
+ 1150000p 0.9
+ 1150010p -0.3
+ 1152000p -0.3
+ 1152010p 0.9
+ 1154000p 0.9
+ 1154010p -0.3
+ 1156000p -0.3
+ 1156010p 0.9
+ 1158000p 0.9
+ 1158010p -0.3
+ 1160000p -0.3
+ 1160010p 0.9
+ 1162000p 0.9
+ 1162010p -0.3
+ 1164000p -0.3
+ 1164010p 0.9
+ 1166000p 0.9
+ 1166010p -0.3
+ 1168000p -0.3
+ 1168010p 0.9
+ 1170000p 0.9
+ 1170010p -0.3
+ 1172000p -0.3
+ 1172010p 0.9
+ 1174000p 0.9
+ 1174010p -0.3
+ 1176000p -0.3
+ 1176010p 0.9
+ 1178000p 0.9
+ 1178010p -0.3
+ 1180000p -0.3
+ 1180010p 0.9
+ 1182000p 0.9
+ 1182010p -0.3
+ 1184000p -0.3
+ 1184010p 0.9
+ 1186000p 0.9
+ 1186010p -0.3
+ 1188000p -0.3
+ 1188010p 0.9
+ 1190000p 0.9
+ 1190010p -0.3
+ 1192000p -0.3
+ 1192010p 0.9
+ 1194000p 0.9
+ 1194010p -0.3
+ 1196000p -0.3
+ 1196010p 0.9
+ 1198000p 0.9
+ 1198010p -0.3
+ 1200000p -0.3
+ 1200010p 0.9
+ 1202000p 0.9
+ 1202010p -0.3
+ 1204000p -0.3
+ 1204010p 0.9
+ 1206000p 0.9
+ 1206010p -0.3
+ 1208000p -0.3
+ 1208010p 0.9
+ 1210000p 0.9
+ 1210010p -0.3
+ 1212000p -0.3
+ 1212010p 0.9
+ 1214000p 0.9
+ 1214010p -0.3
+ 1216000p -0.3
+ 1216010p 0.9
+ 1218000p 0.9
+ 1218010p -0.3
+ 1220000p -0.3
+ 1220010p 0.9
+ 1222000p 0.9
+ 1222010p -0.3
+ 1224000p -0.3
+ 1224010p 0.9
+ 1226000p 0.9
+ 1226010p -0.3
+ 1228000p -0.3
+ 1228010p 0.9
+ 1230000p 0.9
+ 1230010p -0.3
+ 1232000p -0.3
+ 1232010p 0.9
+ 1234000p 0.9
+ 1234010p -0.3
+ 1236000p -0.3
+ 1236010p 0.9
+ 1238000p 0.9
+ 1238010p -0.3
+ 1240000p -0.3
+ 1240010p 0.9
+ 1242000p 0.9
+ 1242010p -0.3
+ 1244000p -0.3
+ 1244010p 0.9
+ 1246000p 0.9
+ 1246010p -0.3
+ 1248000p -0.3
+ 1248010p 0.9
+ 1250000p 0.9
+ 1250010p -0.3
+ 1252000p -0.3
+ 1252010p 0.9
+ 1254000p 0.9
+ 1254010p -0.3
+ 1256000p -0.3
+ 1256010p 0.9
+ 1258000p 0.9
+ 1258010p -0.3
+ 1260000p -0.3
+ 1260010p 0.9
+ 1262000p 0.9
+ 1262010p -0.3
+ 1264000p -0.3
+ 1264010p 0.9
+ 1266000p 0.9
+ 1266010p -0.3
+ 1268000p -0.3
+ 1268010p 0.9
+ 1270000p 0.9
+ 1270010p -0.3
+ 1272000p -0.3
+ 1272010p 0.9
+ 1274000p 0.9
+ 1274010p -0.3
+ 1276000p -0.3
+ 1276010p 0.9
+ 1278000p 0.9
+ 1278010p -0.3
+ 1280000p -0.3
+ 1280010p 0.9
+ 1282000p 0.9
+ 1282010p -0.3
+ 1284000p -0.3
+ 1284010p 0.9
+ 1286000p 0.9
+ 1286010p -0.3
+ 1288000p -0.3
+ 1288010p 0.9
+ 1290000p 0.9
+ 1290010p -0.3
+ 1292000p -0.3
+ 1292010p 0.9
+ 1294000p 0.9
+ 1294010p -0.3
+ 1296000p -0.3
+ 1296010p 0.9
+ 1298000p 0.9
+ 1298010p -0.3
+ 1300000p -0.3
+ 1300010p 0.9
+ 1302000p 0.9
+ 1302010p -0.3
+ 1304000p -0.3
+ 1304010p 0.9
+ 1306000p 0.9
+ 1306010p -0.3
+ 1308000p -0.3
+ 1308010p 0.9
+ 1310000p 0.9
+ 1310010p -0.3
+ 1312000p -0.3
+ 1312010p 0.9
+ 1314000p 0.9
+ 1314010p -0.3
+ 1316000p -0.3
+ 1316010p 0.9
+ 1318000p 0.9
+ 1318010p -0.3
+ 1320000p -0.3
+ 1320010p 0.9
+ 1322000p 0.9
+ 1322010p -0.3
+ 1324000p -0.3
+ 1324010p 0.9
+ 1326000p 0.9
+ 1326010p -0.3
+ 1328000p -0.3
+ 1328010p 0.9
+ 1330000p 0.9
+ 1330010p -0.3
+ 1332000p -0.3
+ 1332010p 0.9
+ 1334000p 0.9
+ 1334010p -0.3
+ 1336000p -0.3
+ 1336010p 0.9
+ 1338000p 0.9
+ 1338010p -0.3
+ 1340000p -0.3
+ 1340010p 0.9
+ 1342000p 0.9
+ 1342010p -0.3
+ 1344000p -0.3
+ 1344010p 0.9
+ 1346000p 0.9
+ 1346010p -0.3
+ 1348000p -0.3
+ 1348010p 0.9
+ 1350000p 0.9
+ 1350010p -0.3
+ 1352000p -0.3
+ 1352010p 0.9
+ 1354000p 0.9
+ 1354010p -0.3
+ 1356000p -0.3
+ 1356010p 0.9
+ 1358000p 0.9
+ 1358010p -0.3
+ 1360000p -0.3
+ 1360010p 0.9
+ 1362000p 0.9
+ 1362010p -0.3
+ 1364000p -0.3
+ 1364010p 0.9
+ 1366000p 0.9
+ 1366010p -0.3
+ 1368000p -0.3
+ 1368010p 0.9
+ 1370000p 0.9
+ 1370010p -0.3
+ 1372000p -0.3
+ 1372010p 0.9
+ 1374000p 0.9
+ 1374010p -0.3
+ 1376000p -0.3
+ 1376010p 0.9
+ 1378000p 0.9
+ 1378010p -0.3
+ 1380000p -0.3
+ 1380010p 0.9
+ 1382000p 0.9
+ 1382010p -0.3
+ 1384000p -0.3
+ 1384010p 0.9
+ 1386000p 0.9
+ 1386010p -0.3
+ 1388000p -0.3
+ 1388010p 0.9
+ 1390000p 0.9
+ 1390010p -0.3
+ 1392000p -0.3
+ 1392010p 0.9
+ 1394000p 0.9
+ 1394010p -0.3
+ 1396000p -0.3
+ 1396010p 0.9
+ 1398000p 0.9
+ 1398010p -0.3
+ 1400000p -0.3
+ 1400010p 0.9
+ 1402000p 0.9
+ 1402010p -0.3
+ 1404000p -0.3
+ 1404010p 0.9
+ 1406000p 0.9
+ 1406010p -0.3
+ 1408000p -0.3
+ 1408010p 0.9
+ 1410000p 0.9
+ 1410010p -0.3
+ 1412000p -0.3
+ 1412010p 0.9
+ 1414000p 0.9
+ 1414010p -0.3
+ 1416000p -0.3
+ 1416010p 0.9
+ 1418000p 0.9
+ 1418010p -0.3
+ 1420000p -0.3
+ 1420010p 0.9
+ 1422000p 0.9
+ 1422010p -0.3
+ 1424000p -0.3
+ 1424010p 0.9
+ 1426000p 0.9
+ 1426010p -0.3
+ 1428000p -0.3
+ 1428010p 0.9
+ 1430000p 0.9
+ 1430010p -0.3
+ 1432000p -0.3
+ 1432010p 0.9
+ 1434000p 0.9
+ 1434010p -0.3
+ 1436000p -0.3
+ 1436010p 0.9
+ 1438000p 0.9
+ 1438010p -0.3
+ 1440000p -0.3
+ 1440010p 0.9
+ 1442000p 0.9
+ 1442010p -0.3
+ 1444000p -0.3
+ 1444010p 0.9
+ 1446000p 0.9
+ 1446010p -0.3
+ 1448000p -0.3
+ 1448010p 0.9
+ 1450000p 0.9
+ 1450010p -0.3
+ 1452000p -0.3
+ 1452010p 0.9
+ 1454000p 0.9
+ 1454010p -0.3
+ 1456000p -0.3
+ 1456010p 0.9
+ 1458000p 0.9
+ 1458010p -0.3
+ 1460000p -0.3
+ 1460010p 0.9
+ 1462000p 0.9
+ 1462010p -0.3
+ 1464000p -0.3
+ 1464010p 0.9
+ 1466000p 0.9
+ 1466010p -0.3
+ 1468000p -0.3
+ 1468010p 0.9
+ 1470000p 0.9
+ 1470010p -0.3
+ 1472000p -0.3
+ 1472010p 0.9
+ 1474000p 0.9
+ 1474010p -0.3
+ 1476000p -0.3
+ 1476010p 0.9
+ 1478000p 0.9
+ 1478010p -0.3
+ 1480000p -0.3
+ 1480010p 0.9
+ 1482000p 0.9
+ 1482010p -0.3
+ 1484000p -0.3
+ 1484010p 0.9
+ 1486000p 0.9
+ 1486010p -0.3
+ 1488000p -0.3
+ 1488010p 0.9
+ 1490000p 0.9
+ 1490010p -0.3
+ 1492000p -0.3
+ 1492010p 0.9
+ 1494000p 0.9
+ 1494010p -0.3
+ 1496000p -0.3
+ 1496010p 0.9
+ 1498000p 0.9
+ 1498010p -0.3
+ 1500000p -0.3
+ 1500010p 0.9
+ 1502000p 0.9
+ 1502010p -0.3
+ 1504000p -0.3
+ 1504010p 0.9
+ 1506000p 0.9
+ 1506010p -0.3
+ 1508000p -0.3
+ 1508010p 0.9
+ 1510000p 0.9
+ 1510010p -0.3
+ 1512000p -0.3
+ 1512010p 0.9
+ 1514000p 0.9
+ 1514010p -0.3
+ 1516000p -0.3
+ 1516010p 0.9
+ 1518000p 0.9
+ 1518010p -0.3
+ 1520000p -0.3
+ 1520010p 0.9
+ 1522000p 0.9
+ 1522010p -0.3
+ 1524000p -0.3
+ 1524010p 0.9
+ 1526000p 0.9
+ 1526010p -0.3
+ 1528000p -0.3
+ 1528010p 0.9
+ 1530000p 0.9
+ 1530010p -0.3
+ 1532000p -0.3
+ 1532010p 0.9
+ 1534000p 0.9
+ 1534010p -0.3
+ 1536000p -0.3
+ 1536010p 0.9
+ 1538000p 0.9
+ 1538010p -0.3
+ 1540000p -0.3
+ 1540010p 0.9
+ 1542000p 0.9
+ 1542010p -0.3
+ 1544000p -0.3
+ 1544010p 0.9
+ 1546000p 0.9
+ 1546010p -0.3
+ 1548000p -0.3
+ 1548010p 0.9
+ 1550000p 0.9
+ 1550010p -0.3
+ 1552000p -0.3
+ 1552010p 0.9
+ 1554000p 0.9
+ 1554010p -0.3
+ 1556000p -0.3
+ 1556010p 0.9
+ 1558000p 0.9
+ 1558010p -0.3
+ 1560000p -0.3
+ 1560010p 0.9
+ 1562000p 0.9
+ 1562010p -0.3
+ 1564000p -0.3
+ 1564010p 0.9
+ 1566000p 0.9
+ 1566010p -0.3
+ 1568000p -0.3
+ 1568010p 0.9
+ 1570000p 0.9
+ 1570010p -0.3
+ 1572000p -0.3
+ 1572010p 0.9
+ 1574000p 0.9
+ 1574010p -0.3
+ 1576000p -0.3
+ 1576010p 0.9
+ 1578000p 0.9
+ 1578010p -0.3
+ 1580000p -0.3
+ 1580010p 0.9
+ 1582000p 0.9
+ 1582010p -0.3
+ 1584000p -0.3
+ 1584010p 0.9
+ 1586000p 0.9
+ 1586010p -0.3
+ 1588000p -0.3
+ 1588010p 0.9
+ 1590000p 0.9
+ 1590010p -0.3
+ 1592000p -0.3
+ 1592010p 0.9
+ 1594000p 0.9
+ 1594010p -0.3
+ 1596000p -0.3
+ 1596010p 0.9
+ 1598000p 0.9
+ 1598010p -0.3
+ 1600000p -0.3
+ 1600010p 0.9
+ 1602000p 0.9
+ 1602010p -0.3
+ 1604000p -0.3
+ 1604010p 0.9
+ 1606000p 0.9
+ 1606010p -0.3
+ 1608000p -0.3
+ 1608010p 0.9
+ 1610000p 0.9
+ 1610010p -0.3
+ 1612000p -0.3
+ 1612010p 0.9
+ 1614000p 0.9
+ 1614010p -0.3
+ 1616000p -0.3
+ 1616010p 0.9
+ 1618000p 0.9
+ 1618010p -0.3
+ 1620000p -0.3
+ 1620010p 0.9
+ 1622000p 0.9
+ 1622010p -0.3
+ 1624000p -0.3
+ 1624010p 0.9
+ 1626000p 0.9
+ 1626010p -0.3
+ 1628000p -0.3
+ 1628010p 0.9
+ 1630000p 0.9
+ 1630010p -0.3
+ 1632000p -0.3
+ 1632010p 0.9
+ 1634000p 0.9
+ 1634010p -0.3
+ 1636000p -0.3
+ 1636010p 0.9
+ 1638000p 0.9
+ 1638010p -0.3
+ 1640000p -0.3
+ 1640010p 0.9
+ 1642000p 0.9
+ 1642010p -0.3
+ 1644000p -0.3
+ 1644010p 0.9
+ 1646000p 0.9
+ 1646010p -0.3
+ 1648000p -0.3
+ 1648010p 0.9
+ 1650000p 0.9
+ 1650010p -0.3
+ 1652000p -0.3
+ 1652010p 0.9
+ 1654000p 0.9
+ 1654010p -0.3
+ 1656000p -0.3
+ 1656010p 0.9
+ 1658000p 0.9
+ 1658010p -0.3
+ 1660000p -0.3
+ 1660010p 0.9
+ 1662000p 0.9
+ 1662010p -0.3
+ 1664000p -0.3
+ 1664010p 0.9
+ 1666000p 0.9
+ 1666010p -0.3
+ 1668000p -0.3
+ 1668010p 0.9
+ 1670000p 0.9
+ 1670010p -0.3
+ 1672000p -0.3
+ 1672010p 0.9
+ 1674000p 0.9
+ 1674010p -0.3
+ 1676000p -0.3
+ 1676010p 0.9
+ 1678000p 0.9
+ 1678010p -0.3
+ 1680000p -0.3
+ 1680010p 0.9
+ 1682000p 0.9
+ 1682010p -0.3
+ 1684000p -0.3
+ 1684010p 0.9
+ 1686000p 0.9
+ 1686010p -0.3
+ 1688000p -0.3
+ 1688010p 0.9
+ 1690000p 0.9
+ 1690010p -0.3
+ 1692000p -0.3
+ 1692010p 0.9
+ 1694000p 0.9
+ 1694010p -0.3
+ 1696000p -0.3
+ 1696010p 0.9
+ 1698000p 0.9
+ 1698010p -0.3
+ 1700000p -0.3
+ 1700010p 0.9
+ 1702000p 0.9
+ 1702010p -0.3
+ 1704000p -0.3
+ 1704010p 0.9
+ 1706000p 0.9
+ 1706010p -0.3
+ 1708000p -0.3
+ 1708010p 0.9
+ 1710000p 0.9
+ 1710010p -0.3
+ 1712000p -0.3
+ 1712010p 0.9
+ 1714000p 0.9
+ 1714010p -0.3
+ 1716000p -0.3
+ 1716010p 0.9
+ 1718000p 0.9
+ 1718010p -0.3
+ 1720000p -0.3
+ 1720010p 0.9
+ 1722000p 0.9
+ 1722010p -0.3
+ 1724000p -0.3
+ 1724010p 0.9
+ 1726000p 0.9
+ 1726010p -0.3
+ 1728000p -0.3
+ 1728010p 0.9
+ 1730000p 0.9
+ 1730010p -0.3
+ 1732000p -0.3
+ 1732010p 0.9
+ 1734000p 0.9
+ 1734010p -0.3
+ 1736000p -0.3
+ 1736010p 0.9
+ 1738000p 0.9
+ 1738010p -0.3
+ 1740000p -0.3
+ 1740010p 0.9
+ 1742000p 0.9
+ 1742010p -0.3
+ 1744000p -0.3
+ 1744010p 0.9
+ 1746000p 0.9
+ 1746010p -0.3
+ 1748000p -0.3
+ 1748010p 0.9
+ 1750000p 0.9
+ 1750010p -0.3
+ 1752000p -0.3
+ 1752010p 0.9
+ 1754000p 0.9
+ 1754010p -0.3
+ 1756000p -0.3
+ 1756010p 0.9
+ 1758000p 0.9
+ 1758010p -0.3
+ 1760000p -0.3
+ 1760010p 0.9
+ 1762000p 0.9
+ 1762010p -0.3
+ 1764000p -0.3
+ 1764010p 0.9
+ 1766000p 0.9
+ 1766010p -0.3
+ 1768000p -0.3
+ 1768010p 0.9
+ 1770000p 0.9
+ 1770010p -0.3
+ 1772000p -0.3
+ 1772010p 0.9
+ 1774000p 0.9
+ 1774010p -0.3
+ 1776000p -0.3
+ 1776010p 0.9
+ 1778000p 0.9
+ 1778010p -0.3
+ 1780000p -0.3
+ 1780010p 0.9
+ 1782000p 0.9
+ 1782010p -0.3
+ 1784000p -0.3
+ 1784010p 0.9
+ 1786000p 0.9
+ 1786010p -0.3
+ 1788000p -0.3
+ 1788010p 0.9
+ 1790000p 0.9
+ 1790010p -0.3
+ 1792000p -0.3
+ 1792010p 0.9
+ 1794000p 0.9
+ 1794010p -0.3
+ 1796000p -0.3
+ 1796010p 0.9
+ 1798000p 0.9
+ 1798010p -0.3
+ 1800000p -0.3
+ 1800010p 0.9
+ 1802000p 0.9
+ 1802010p -0.3
+ 1804000p -0.3
+ 1804010p 0.9
+ 1806000p 0.9
+ 1806010p -0.3
+ 1808000p -0.3
+ 1808010p 0.9
+ 1810000p 0.9
+ 1810010p -0.3
+ 1812000p -0.3
+ 1812010p 0.9
+ 1814000p 0.9
+ 1814010p -0.3
+ 1816000p -0.3
+ 1816010p 0.9
+ 1818000p 0.9
+ 1818010p -0.3
+ 1820000p -0.3
+ 1820010p 0.9
+ 1822000p 0.9
+ 1822010p -0.3
+ 1824000p -0.3
+ 1824010p 0.9
+ 1826000p 0.9
+ 1826010p -0.3
+ 1828000p -0.3
+ 1828010p 0.9
+ 1830000p 0.9
+ 1830010p -0.3
+ 1832000p -0.3
+ 1832010p 0.9
+ 1834000p 0.9
+ 1834010p -0.3
+ 1836000p -0.3
+ 1836010p 0.9
+ 1838000p 0.9
+ 1838010p -0.3
+ 1840000p -0.3
+ 1840010p 0.9
+ 1842000p 0.9
+ 1842010p -0.3
+ 1844000p -0.3
+ 1844010p 0.9
+ 1846000p 0.9
+ 1846010p -0.3
+ 1848000p -0.3
+ 1848010p 0.9
+ 1850000p 0.9
+ 1850010p -0.3
+ 1852000p -0.3
+ 1852010p 0.9
+ 1854000p 0.9
+ 1854010p -0.3
+ 1856000p -0.3
+ 1856010p 0.9
+ 1858000p 0.9
+ 1858010p -0.3
+ 1860000p -0.3
+ 1860010p 0.9
+ 1862000p 0.9
+ 1862010p -0.3
+ 1864000p -0.3
+ 1864010p 0.9
+ 1866000p 0.9
+ 1866010p -0.3
+ 1868000p -0.3
+ 1868010p 0.9
+ 1870000p 0.9
+ 1870010p -0.3
+ 1872000p -0.3
+ 1872010p 0.9
+ 1874000p 0.9
+ 1874010p -0.3
+ 1876000p -0.3
+ 1876010p 0.9
+ 1878000p 0.9
+ 1878010p -0.3
+ 1880000p -0.3
+ 1880010p 0.9
+ 1882000p 0.9
+ 1882010p -0.3
+ 1884000p -0.3
+ 1884010p 0.9
+ 1886000p 0.9
+ 1886010p -0.3
+ 1888000p -0.3
+ 1888010p 0.9
+ 1890000p 0.9
+ 1890010p -0.3
+ 1892000p -0.3
+ 1892010p 0.9
+ 1894000p 0.9
+ 1894010p -0.3
+ 1896000p -0.3
+ 1896010p 0.9
+ 1898000p 0.9
+ 1898010p -0.3
+ 1900000p -0.3
+ 1900010p 0.9
+ 1902000p 0.9
+ 1902010p -0.3
+ 1904000p -0.3
+ 1904010p 0.9
+ 1906000p 0.9
+ 1906010p -0.3
+ 1908000p -0.3
+ 1908010p 0.9
+ 1910000p 0.9
+ 1910010p -0.3
+ 1912000p -0.3
+ 1912010p 0.9
+ 1914000p 0.9
+ 1914010p -0.3
+ 1916000p -0.3
+ 1916010p 0.9
+ 1918000p 0.9
+ 1918010p -0.3
+ 1920000p -0.3
+ 1920010p 0.9
+ 1922000p 0.9
+ 1922010p -0.3
+ 1924000p -0.3
+ 1924010p 0.9
+ 1926000p 0.9
+ 1926010p -0.3
+ 1928000p -0.3
+ 1928010p 0.9
+ 1930000p 0.9
+ 1930010p -0.3
+ 1932000p -0.3
+ 1932010p 0.9
+ 1934000p 0.9
+ 1934010p -0.3
+ 1936000p -0.3
+ 1936010p 0.9
+ 1938000p 0.9
+ 1938010p -0.3
+ 1940000p -0.3
+ 1940010p 0.9
+ 1942000p 0.9
+ 1942010p -0.3
+ 1944000p -0.3
+ 1944010p 0.9
+ 1946000p 0.9
+ 1946010p -0.3
+ 1948000p -0.3
+ 1948010p 0.9
+ 1950000p 0.9
+ 1950010p -0.3
+ 1952000p -0.3
+ 1952010p 0.9
+ 1954000p 0.9
+ 1954010p -0.3
+ 1956000p -0.3
+ 1956010p 0.9
+ 1958000p 0.9
+ 1958010p -0.3
+ 1960000p -0.3
+ 1960010p 0.9
+ 1962000p 0.9
+ 1962010p -0.3
+ 1964000p -0.3
+ 1964010p 0.9
+ 1966000p 0.9
+ 1966010p -0.3
+ 1968000p -0.3
+ 1968010p 0.9
+ 1970000p 0.9
+ 1970010p -0.3
+ 1972000p -0.3
+ 1972010p 0.9
+ 1974000p 0.9
+ 1974010p -0.3
+ 1976000p -0.3
+ 1976010p 0.9
+ 1978000p 0.9
+ 1978010p -0.3
+ 1980000p -0.3
+ 1980010p 0.9
+ 1982000p 0.9
+ 1982010p -0.3
+ 1984000p -0.3
+ 1984010p 0.9
+ 1986000p 0.9
+ 1986010p -0.3
+ 1988000p -0.3
+ 1988010p 0.9
+ 1990000p 0.9
+ 1990010p -0.3
+ 1992000p -0.3
+ 1992010p 0.9
+ 1994000p 0.9
+ 1994010p -0.3
+ 1996000p -0.3
+ 1996010p 0.9
+ 1998000p 0.9
+ 1998010p -0.3
+ 2000000p -0.3
+ 2000010p 0.9
+ 2002000p 0.9
+ 2002010p -0.3
+ 2004000p -0.3
+ 2004010p 0.9
+ 2006000p 0.9
+ 2006010p -0.3
+ 2008000p -0.3
+ 2008010p 0.9
+ 2010000p 0.9
+ 2010010p -0.3
+ 2012000p -0.3
+ 2012010p 0.9
+ 2014000p 0.9
+ 2014010p -0.3
+ 2016000p -0.3
+ 2016010p 0.9
+ 2018000p 0.9
+ 2018010p -0.3
+ 2020000p -0.3
+ 2020010p 0.9
+ 2022000p 0.9
+ 2022010p -0.3
+ 2024000p -0.3
+ 2024010p 0.9
+ 2026000p 0.9
+ 2026010p -0.3
+ 2028000p -0.3
+ 2028010p 0.9
+ 2030000p 0.9
+ 2030010p -0.3
+ 2032000p -0.3
+ 2032010p 0.9
+ 2034000p 0.9
+ 2034010p -0.3
+ 2036000p -0.3
+ 2036010p 0.9
+ 2038000p 0.9
+ 2038010p -0.3
+ 2040000p -0.3
+ 2040010p 0.9
+ 2042000p 0.9
+ 2042010p -0.3
+ 2044000p -0.3
+ 2044010p 0.9
+ 2046000p 0.9
+ 2046010p -0.3
+ 2048000p -0.3
+ 2048010p 0.9
+ \]
V_data_bar_29 (Data_bar\\<29\\> gnd!) vsource type=pwl wave=\[
+ 0    -0.3
+ 2000p -0.3
+ 2010p 0.9
+ 4000p 0.9
+ 4010p -0.3
+ 6000p -0.3
+ 6010p 0.9
+ 8000p 0.9
+ 8010p -0.3
+ 10000p -0.3
+ 10010p 0.9
+ 12000p 0.9
+ 12010p -0.3
+ 14000p -0.3
+ 14010p 0.9
+ 16000p 0.9
+ 16010p -0.3
+ 18000p -0.3
+ 18010p 0.9
+ 20000p 0.9
+ 20010p -0.3
+ 22000p -0.3
+ 22010p 0.9
+ 24000p 0.9
+ 24010p -0.3
+ 26000p -0.3
+ 26010p 0.9
+ 28000p 0.9
+ 28010p -0.3
+ 30000p -0.3
+ 30010p 0.9
+ 32000p 0.9
+ 32010p -0.3
+ 34000p -0.3
+ 34010p 0.9
+ 36000p 0.9
+ 36010p -0.3
+ 38000p -0.3
+ 38010p 0.9
+ 40000p 0.9
+ 40010p -0.3
+ 42000p -0.3
+ 42010p 0.9
+ 44000p 0.9
+ 44010p -0.3
+ 46000p -0.3
+ 46010p 0.9
+ 48000p 0.9
+ 48010p -0.3
+ 50000p -0.3
+ 50010p 0.9
+ 52000p 0.9
+ 52010p -0.3
+ 54000p -0.3
+ 54010p 0.9
+ 56000p 0.9
+ 56010p -0.3
+ 58000p -0.3
+ 58010p 0.9
+ 60000p 0.9
+ 60010p -0.3
+ 62000p -0.3
+ 62010p 0.9
+ 64000p 0.9
+ 64010p -0.3
+ 66000p -0.3
+ 66010p 0.9
+ 68000p 0.9
+ 68010p -0.3
+ 70000p -0.3
+ 70010p 0.9
+ 72000p 0.9
+ 72010p -0.3
+ 74000p -0.3
+ 74010p 0.9
+ 76000p 0.9
+ 76010p -0.3
+ 78000p -0.3
+ 78010p 0.9
+ 80000p 0.9
+ 80010p -0.3
+ 82000p -0.3
+ 82010p 0.9
+ 84000p 0.9
+ 84010p -0.3
+ 86000p -0.3
+ 86010p 0.9
+ 88000p 0.9
+ 88010p -0.3
+ 90000p -0.3
+ 90010p 0.9
+ 92000p 0.9
+ 92010p -0.3
+ 94000p -0.3
+ 94010p 0.9
+ 96000p 0.9
+ 96010p -0.3
+ 98000p -0.3
+ 98010p 0.9
+ 100000p 0.9
+ 100010p -0.3
+ 102000p -0.3
+ 102010p 0.9
+ 104000p 0.9
+ 104010p -0.3
+ 106000p -0.3
+ 106010p 0.9
+ 108000p 0.9
+ 108010p -0.3
+ 110000p -0.3
+ 110010p 0.9
+ 112000p 0.9
+ 112010p -0.3
+ 114000p -0.3
+ 114010p 0.9
+ 116000p 0.9
+ 116010p -0.3
+ 118000p -0.3
+ 118010p 0.9
+ 120000p 0.9
+ 120010p -0.3
+ 122000p -0.3
+ 122010p 0.9
+ 124000p 0.9
+ 124010p -0.3
+ 126000p -0.3
+ 126010p 0.9
+ 128000p 0.9
+ 128010p -0.3
+ 130000p -0.3
+ 130010p 0.9
+ 132000p 0.9
+ 132010p -0.3
+ 134000p -0.3
+ 134010p 0.9
+ 136000p 0.9
+ 136010p -0.3
+ 138000p -0.3
+ 138010p 0.9
+ 140000p 0.9
+ 140010p -0.3
+ 142000p -0.3
+ 142010p 0.9
+ 144000p 0.9
+ 144010p -0.3
+ 146000p -0.3
+ 146010p 0.9
+ 148000p 0.9
+ 148010p -0.3
+ 150000p -0.3
+ 150010p 0.9
+ 152000p 0.9
+ 152010p -0.3
+ 154000p -0.3
+ 154010p 0.9
+ 156000p 0.9
+ 156010p -0.3
+ 158000p -0.3
+ 158010p 0.9
+ 160000p 0.9
+ 160010p -0.3
+ 162000p -0.3
+ 162010p 0.9
+ 164000p 0.9
+ 164010p -0.3
+ 166000p -0.3
+ 166010p 0.9
+ 168000p 0.9
+ 168010p -0.3
+ 170000p -0.3
+ 170010p 0.9
+ 172000p 0.9
+ 172010p -0.3
+ 174000p -0.3
+ 174010p 0.9
+ 176000p 0.9
+ 176010p -0.3
+ 178000p -0.3
+ 178010p 0.9
+ 180000p 0.9
+ 180010p -0.3
+ 182000p -0.3
+ 182010p 0.9
+ 184000p 0.9
+ 184010p -0.3
+ 186000p -0.3
+ 186010p 0.9
+ 188000p 0.9
+ 188010p -0.3
+ 190000p -0.3
+ 190010p 0.9
+ 192000p 0.9
+ 192010p -0.3
+ 194000p -0.3
+ 194010p 0.9
+ 196000p 0.9
+ 196010p -0.3
+ 198000p -0.3
+ 198010p 0.9
+ 200000p 0.9
+ 200010p -0.3
+ 202000p -0.3
+ 202010p 0.9
+ 204000p 0.9
+ 204010p -0.3
+ 206000p -0.3
+ 206010p 0.9
+ 208000p 0.9
+ 208010p -0.3
+ 210000p -0.3
+ 210010p 0.9
+ 212000p 0.9
+ 212010p -0.3
+ 214000p -0.3
+ 214010p 0.9
+ 216000p 0.9
+ 216010p -0.3
+ 218000p -0.3
+ 218010p 0.9
+ 220000p 0.9
+ 220010p -0.3
+ 222000p -0.3
+ 222010p 0.9
+ 224000p 0.9
+ 224010p -0.3
+ 226000p -0.3
+ 226010p 0.9
+ 228000p 0.9
+ 228010p -0.3
+ 230000p -0.3
+ 230010p 0.9
+ 232000p 0.9
+ 232010p -0.3
+ 234000p -0.3
+ 234010p 0.9
+ 236000p 0.9
+ 236010p -0.3
+ 238000p -0.3
+ 238010p 0.9
+ 240000p 0.9
+ 240010p -0.3
+ 242000p -0.3
+ 242010p 0.9
+ 244000p 0.9
+ 244010p -0.3
+ 246000p -0.3
+ 246010p 0.9
+ 248000p 0.9
+ 248010p -0.3
+ 250000p -0.3
+ 250010p 0.9
+ 252000p 0.9
+ 252010p -0.3
+ 254000p -0.3
+ 254010p 0.9
+ 256000p 0.9
+ 256010p -0.3
+ 258000p -0.3
+ 258010p 0.9
+ 260000p 0.9
+ 260010p -0.3
+ 262000p -0.3
+ 262010p 0.9
+ 264000p 0.9
+ 264010p -0.3
+ 266000p -0.3
+ 266010p 0.9
+ 268000p 0.9
+ 268010p -0.3
+ 270000p -0.3
+ 270010p 0.9
+ 272000p 0.9
+ 272010p -0.3
+ 274000p -0.3
+ 274010p 0.9
+ 276000p 0.9
+ 276010p -0.3
+ 278000p -0.3
+ 278010p 0.9
+ 280000p 0.9
+ 280010p -0.3
+ 282000p -0.3
+ 282010p 0.9
+ 284000p 0.9
+ 284010p -0.3
+ 286000p -0.3
+ 286010p 0.9
+ 288000p 0.9
+ 288010p -0.3
+ 290000p -0.3
+ 290010p 0.9
+ 292000p 0.9
+ 292010p -0.3
+ 294000p -0.3
+ 294010p 0.9
+ 296000p 0.9
+ 296010p -0.3
+ 298000p -0.3
+ 298010p 0.9
+ 300000p 0.9
+ 300010p -0.3
+ 302000p -0.3
+ 302010p 0.9
+ 304000p 0.9
+ 304010p -0.3
+ 306000p -0.3
+ 306010p 0.9
+ 308000p 0.9
+ 308010p -0.3
+ 310000p -0.3
+ 310010p 0.9
+ 312000p 0.9
+ 312010p -0.3
+ 314000p -0.3
+ 314010p 0.9
+ 316000p 0.9
+ 316010p -0.3
+ 318000p -0.3
+ 318010p 0.9
+ 320000p 0.9
+ 320010p -0.3
+ 322000p -0.3
+ 322010p 0.9
+ 324000p 0.9
+ 324010p -0.3
+ 326000p -0.3
+ 326010p 0.9
+ 328000p 0.9
+ 328010p -0.3
+ 330000p -0.3
+ 330010p 0.9
+ 332000p 0.9
+ 332010p -0.3
+ 334000p -0.3
+ 334010p 0.9
+ 336000p 0.9
+ 336010p -0.3
+ 338000p -0.3
+ 338010p 0.9
+ 340000p 0.9
+ 340010p -0.3
+ 342000p -0.3
+ 342010p 0.9
+ 344000p 0.9
+ 344010p -0.3
+ 346000p -0.3
+ 346010p 0.9
+ 348000p 0.9
+ 348010p -0.3
+ 350000p -0.3
+ 350010p 0.9
+ 352000p 0.9
+ 352010p -0.3
+ 354000p -0.3
+ 354010p 0.9
+ 356000p 0.9
+ 356010p -0.3
+ 358000p -0.3
+ 358010p 0.9
+ 360000p 0.9
+ 360010p -0.3
+ 362000p -0.3
+ 362010p 0.9
+ 364000p 0.9
+ 364010p -0.3
+ 366000p -0.3
+ 366010p 0.9
+ 368000p 0.9
+ 368010p -0.3
+ 370000p -0.3
+ 370010p 0.9
+ 372000p 0.9
+ 372010p -0.3
+ 374000p -0.3
+ 374010p 0.9
+ 376000p 0.9
+ 376010p -0.3
+ 378000p -0.3
+ 378010p 0.9
+ 380000p 0.9
+ 380010p -0.3
+ 382000p -0.3
+ 382010p 0.9
+ 384000p 0.9
+ 384010p -0.3
+ 386000p -0.3
+ 386010p 0.9
+ 388000p 0.9
+ 388010p -0.3
+ 390000p -0.3
+ 390010p 0.9
+ 392000p 0.9
+ 392010p -0.3
+ 394000p -0.3
+ 394010p 0.9
+ 396000p 0.9
+ 396010p -0.3
+ 398000p -0.3
+ 398010p 0.9
+ 400000p 0.9
+ 400010p -0.3
+ 402000p -0.3
+ 402010p 0.9
+ 404000p 0.9
+ 404010p -0.3
+ 406000p -0.3
+ 406010p 0.9
+ 408000p 0.9
+ 408010p -0.3
+ 410000p -0.3
+ 410010p 0.9
+ 412000p 0.9
+ 412010p -0.3
+ 414000p -0.3
+ 414010p 0.9
+ 416000p 0.9
+ 416010p -0.3
+ 418000p -0.3
+ 418010p 0.9
+ 420000p 0.9
+ 420010p -0.3
+ 422000p -0.3
+ 422010p 0.9
+ 424000p 0.9
+ 424010p -0.3
+ 426000p -0.3
+ 426010p 0.9
+ 428000p 0.9
+ 428010p -0.3
+ 430000p -0.3
+ 430010p 0.9
+ 432000p 0.9
+ 432010p -0.3
+ 434000p -0.3
+ 434010p 0.9
+ 436000p 0.9
+ 436010p -0.3
+ 438000p -0.3
+ 438010p 0.9
+ 440000p 0.9
+ 440010p -0.3
+ 442000p -0.3
+ 442010p 0.9
+ 444000p 0.9
+ 444010p -0.3
+ 446000p -0.3
+ 446010p 0.9
+ 448000p 0.9
+ 448010p -0.3
+ 450000p -0.3
+ 450010p 0.9
+ 452000p 0.9
+ 452010p -0.3
+ 454000p -0.3
+ 454010p 0.9
+ 456000p 0.9
+ 456010p -0.3
+ 458000p -0.3
+ 458010p 0.9
+ 460000p 0.9
+ 460010p -0.3
+ 462000p -0.3
+ 462010p 0.9
+ 464000p 0.9
+ 464010p -0.3
+ 466000p -0.3
+ 466010p 0.9
+ 468000p 0.9
+ 468010p -0.3
+ 470000p -0.3
+ 470010p 0.9
+ 472000p 0.9
+ 472010p -0.3
+ 474000p -0.3
+ 474010p 0.9
+ 476000p 0.9
+ 476010p -0.3
+ 478000p -0.3
+ 478010p 0.9
+ 480000p 0.9
+ 480010p -0.3
+ 482000p -0.3
+ 482010p 0.9
+ 484000p 0.9
+ 484010p -0.3
+ 486000p -0.3
+ 486010p 0.9
+ 488000p 0.9
+ 488010p -0.3
+ 490000p -0.3
+ 490010p 0.9
+ 492000p 0.9
+ 492010p -0.3
+ 494000p -0.3
+ 494010p 0.9
+ 496000p 0.9
+ 496010p -0.3
+ 498000p -0.3
+ 498010p 0.9
+ 500000p 0.9
+ 500010p -0.3
+ 502000p -0.3
+ 502010p 0.9
+ 504000p 0.9
+ 504010p -0.3
+ 506000p -0.3
+ 506010p 0.9
+ 508000p 0.9
+ 508010p -0.3
+ 510000p -0.3
+ 510010p 0.9
+ 512000p 0.9
+ 512010p -0.3
+ 514000p -0.3
+ 514010p 0.9
+ 516000p 0.9
+ 516010p -0.3
+ 518000p -0.3
+ 518010p 0.9
+ 520000p 0.9
+ 520010p -0.3
+ 522000p -0.3
+ 522010p 0.9
+ 524000p 0.9
+ 524010p -0.3
+ 526000p -0.3
+ 526010p 0.9
+ 528000p 0.9
+ 528010p -0.3
+ 530000p -0.3
+ 530010p 0.9
+ 532000p 0.9
+ 532010p -0.3
+ 534000p -0.3
+ 534010p 0.9
+ 536000p 0.9
+ 536010p -0.3
+ 538000p -0.3
+ 538010p 0.9
+ 540000p 0.9
+ 540010p -0.3
+ 542000p -0.3
+ 542010p 0.9
+ 544000p 0.9
+ 544010p -0.3
+ 546000p -0.3
+ 546010p 0.9
+ 548000p 0.9
+ 548010p -0.3
+ 550000p -0.3
+ 550010p 0.9
+ 552000p 0.9
+ 552010p -0.3
+ 554000p -0.3
+ 554010p 0.9
+ 556000p 0.9
+ 556010p -0.3
+ 558000p -0.3
+ 558010p 0.9
+ 560000p 0.9
+ 560010p -0.3
+ 562000p -0.3
+ 562010p 0.9
+ 564000p 0.9
+ 564010p -0.3
+ 566000p -0.3
+ 566010p 0.9
+ 568000p 0.9
+ 568010p -0.3
+ 570000p -0.3
+ 570010p 0.9
+ 572000p 0.9
+ 572010p -0.3
+ 574000p -0.3
+ 574010p 0.9
+ 576000p 0.9
+ 576010p -0.3
+ 578000p -0.3
+ 578010p 0.9
+ 580000p 0.9
+ 580010p -0.3
+ 582000p -0.3
+ 582010p 0.9
+ 584000p 0.9
+ 584010p -0.3
+ 586000p -0.3
+ 586010p 0.9
+ 588000p 0.9
+ 588010p -0.3
+ 590000p -0.3
+ 590010p 0.9
+ 592000p 0.9
+ 592010p -0.3
+ 594000p -0.3
+ 594010p 0.9
+ 596000p 0.9
+ 596010p -0.3
+ 598000p -0.3
+ 598010p 0.9
+ 600000p 0.9
+ 600010p -0.3
+ 602000p -0.3
+ 602010p 0.9
+ 604000p 0.9
+ 604010p -0.3
+ 606000p -0.3
+ 606010p 0.9
+ 608000p 0.9
+ 608010p -0.3
+ 610000p -0.3
+ 610010p 0.9
+ 612000p 0.9
+ 612010p -0.3
+ 614000p -0.3
+ 614010p 0.9
+ 616000p 0.9
+ 616010p -0.3
+ 618000p -0.3
+ 618010p 0.9
+ 620000p 0.9
+ 620010p -0.3
+ 622000p -0.3
+ 622010p 0.9
+ 624000p 0.9
+ 624010p -0.3
+ 626000p -0.3
+ 626010p 0.9
+ 628000p 0.9
+ 628010p -0.3
+ 630000p -0.3
+ 630010p 0.9
+ 632000p 0.9
+ 632010p -0.3
+ 634000p -0.3
+ 634010p 0.9
+ 636000p 0.9
+ 636010p -0.3
+ 638000p -0.3
+ 638010p 0.9
+ 640000p 0.9
+ 640010p -0.3
+ 642000p -0.3
+ 642010p 0.9
+ 644000p 0.9
+ 644010p -0.3
+ 646000p -0.3
+ 646010p 0.9
+ 648000p 0.9
+ 648010p -0.3
+ 650000p -0.3
+ 650010p 0.9
+ 652000p 0.9
+ 652010p -0.3
+ 654000p -0.3
+ 654010p 0.9
+ 656000p 0.9
+ 656010p -0.3
+ 658000p -0.3
+ 658010p 0.9
+ 660000p 0.9
+ 660010p -0.3
+ 662000p -0.3
+ 662010p 0.9
+ 664000p 0.9
+ 664010p -0.3
+ 666000p -0.3
+ 666010p 0.9
+ 668000p 0.9
+ 668010p -0.3
+ 670000p -0.3
+ 670010p 0.9
+ 672000p 0.9
+ 672010p -0.3
+ 674000p -0.3
+ 674010p 0.9
+ 676000p 0.9
+ 676010p -0.3
+ 678000p -0.3
+ 678010p 0.9
+ 680000p 0.9
+ 680010p -0.3
+ 682000p -0.3
+ 682010p 0.9
+ 684000p 0.9
+ 684010p -0.3
+ 686000p -0.3
+ 686010p 0.9
+ 688000p 0.9
+ 688010p -0.3
+ 690000p -0.3
+ 690010p 0.9
+ 692000p 0.9
+ 692010p -0.3
+ 694000p -0.3
+ 694010p 0.9
+ 696000p 0.9
+ 696010p -0.3
+ 698000p -0.3
+ 698010p 0.9
+ 700000p 0.9
+ 700010p -0.3
+ 702000p -0.3
+ 702010p 0.9
+ 704000p 0.9
+ 704010p -0.3
+ 706000p -0.3
+ 706010p 0.9
+ 708000p 0.9
+ 708010p -0.3
+ 710000p -0.3
+ 710010p 0.9
+ 712000p 0.9
+ 712010p -0.3
+ 714000p -0.3
+ 714010p 0.9
+ 716000p 0.9
+ 716010p -0.3
+ 718000p -0.3
+ 718010p 0.9
+ 720000p 0.9
+ 720010p -0.3
+ 722000p -0.3
+ 722010p 0.9
+ 724000p 0.9
+ 724010p -0.3
+ 726000p -0.3
+ 726010p 0.9
+ 728000p 0.9
+ 728010p -0.3
+ 730000p -0.3
+ 730010p 0.9
+ 732000p 0.9
+ 732010p -0.3
+ 734000p -0.3
+ 734010p 0.9
+ 736000p 0.9
+ 736010p -0.3
+ 738000p -0.3
+ 738010p 0.9
+ 740000p 0.9
+ 740010p -0.3
+ 742000p -0.3
+ 742010p 0.9
+ 744000p 0.9
+ 744010p -0.3
+ 746000p -0.3
+ 746010p 0.9
+ 748000p 0.9
+ 748010p -0.3
+ 750000p -0.3
+ 750010p 0.9
+ 752000p 0.9
+ 752010p -0.3
+ 754000p -0.3
+ 754010p 0.9
+ 756000p 0.9
+ 756010p -0.3
+ 758000p -0.3
+ 758010p 0.9
+ 760000p 0.9
+ 760010p -0.3
+ 762000p -0.3
+ 762010p 0.9
+ 764000p 0.9
+ 764010p -0.3
+ 766000p -0.3
+ 766010p 0.9
+ 768000p 0.9
+ 768010p -0.3
+ 770000p -0.3
+ 770010p 0.9
+ 772000p 0.9
+ 772010p -0.3
+ 774000p -0.3
+ 774010p 0.9
+ 776000p 0.9
+ 776010p -0.3
+ 778000p -0.3
+ 778010p 0.9
+ 780000p 0.9
+ 780010p -0.3
+ 782000p -0.3
+ 782010p 0.9
+ 784000p 0.9
+ 784010p -0.3
+ 786000p -0.3
+ 786010p 0.9
+ 788000p 0.9
+ 788010p -0.3
+ 790000p -0.3
+ 790010p 0.9
+ 792000p 0.9
+ 792010p -0.3
+ 794000p -0.3
+ 794010p 0.9
+ 796000p 0.9
+ 796010p -0.3
+ 798000p -0.3
+ 798010p 0.9
+ 800000p 0.9
+ 800010p -0.3
+ 802000p -0.3
+ 802010p 0.9
+ 804000p 0.9
+ 804010p -0.3
+ 806000p -0.3
+ 806010p 0.9
+ 808000p 0.9
+ 808010p -0.3
+ 810000p -0.3
+ 810010p 0.9
+ 812000p 0.9
+ 812010p -0.3
+ 814000p -0.3
+ 814010p 0.9
+ 816000p 0.9
+ 816010p -0.3
+ 818000p -0.3
+ 818010p 0.9
+ 820000p 0.9
+ 820010p -0.3
+ 822000p -0.3
+ 822010p 0.9
+ 824000p 0.9
+ 824010p -0.3
+ 826000p -0.3
+ 826010p 0.9
+ 828000p 0.9
+ 828010p -0.3
+ 830000p -0.3
+ 830010p 0.9
+ 832000p 0.9
+ 832010p -0.3
+ 834000p -0.3
+ 834010p 0.9
+ 836000p 0.9
+ 836010p -0.3
+ 838000p -0.3
+ 838010p 0.9
+ 840000p 0.9
+ 840010p -0.3
+ 842000p -0.3
+ 842010p 0.9
+ 844000p 0.9
+ 844010p -0.3
+ 846000p -0.3
+ 846010p 0.9
+ 848000p 0.9
+ 848010p -0.3
+ 850000p -0.3
+ 850010p 0.9
+ 852000p 0.9
+ 852010p -0.3
+ 854000p -0.3
+ 854010p 0.9
+ 856000p 0.9
+ 856010p -0.3
+ 858000p -0.3
+ 858010p 0.9
+ 860000p 0.9
+ 860010p -0.3
+ 862000p -0.3
+ 862010p 0.9
+ 864000p 0.9
+ 864010p -0.3
+ 866000p -0.3
+ 866010p 0.9
+ 868000p 0.9
+ 868010p -0.3
+ 870000p -0.3
+ 870010p 0.9
+ 872000p 0.9
+ 872010p -0.3
+ 874000p -0.3
+ 874010p 0.9
+ 876000p 0.9
+ 876010p -0.3
+ 878000p -0.3
+ 878010p 0.9
+ 880000p 0.9
+ 880010p -0.3
+ 882000p -0.3
+ 882010p 0.9
+ 884000p 0.9
+ 884010p -0.3
+ 886000p -0.3
+ 886010p 0.9
+ 888000p 0.9
+ 888010p -0.3
+ 890000p -0.3
+ 890010p 0.9
+ 892000p 0.9
+ 892010p -0.3
+ 894000p -0.3
+ 894010p 0.9
+ 896000p 0.9
+ 896010p -0.3
+ 898000p -0.3
+ 898010p 0.9
+ 900000p 0.9
+ 900010p -0.3
+ 902000p -0.3
+ 902010p 0.9
+ 904000p 0.9
+ 904010p -0.3
+ 906000p -0.3
+ 906010p 0.9
+ 908000p 0.9
+ 908010p -0.3
+ 910000p -0.3
+ 910010p 0.9
+ 912000p 0.9
+ 912010p -0.3
+ 914000p -0.3
+ 914010p 0.9
+ 916000p 0.9
+ 916010p -0.3
+ 918000p -0.3
+ 918010p 0.9
+ 920000p 0.9
+ 920010p -0.3
+ 922000p -0.3
+ 922010p 0.9
+ 924000p 0.9
+ 924010p -0.3
+ 926000p -0.3
+ 926010p 0.9
+ 928000p 0.9
+ 928010p -0.3
+ 930000p -0.3
+ 930010p 0.9
+ 932000p 0.9
+ 932010p -0.3
+ 934000p -0.3
+ 934010p 0.9
+ 936000p 0.9
+ 936010p -0.3
+ 938000p -0.3
+ 938010p 0.9
+ 940000p 0.9
+ 940010p -0.3
+ 942000p -0.3
+ 942010p 0.9
+ 944000p 0.9
+ 944010p -0.3
+ 946000p -0.3
+ 946010p 0.9
+ 948000p 0.9
+ 948010p -0.3
+ 950000p -0.3
+ 950010p 0.9
+ 952000p 0.9
+ 952010p -0.3
+ 954000p -0.3
+ 954010p 0.9
+ 956000p 0.9
+ 956010p -0.3
+ 958000p -0.3
+ 958010p 0.9
+ 960000p 0.9
+ 960010p -0.3
+ 962000p -0.3
+ 962010p 0.9
+ 964000p 0.9
+ 964010p -0.3
+ 966000p -0.3
+ 966010p 0.9
+ 968000p 0.9
+ 968010p -0.3
+ 970000p -0.3
+ 970010p 0.9
+ 972000p 0.9
+ 972010p -0.3
+ 974000p -0.3
+ 974010p 0.9
+ 976000p 0.9
+ 976010p -0.3
+ 978000p -0.3
+ 978010p 0.9
+ 980000p 0.9
+ 980010p -0.3
+ 982000p -0.3
+ 982010p 0.9
+ 984000p 0.9
+ 984010p -0.3
+ 986000p -0.3
+ 986010p 0.9
+ 988000p 0.9
+ 988010p -0.3
+ 990000p -0.3
+ 990010p 0.9
+ 992000p 0.9
+ 992010p -0.3
+ 994000p -0.3
+ 994010p 0.9
+ 996000p 0.9
+ 996010p -0.3
+ 998000p -0.3
+ 998010p 0.9
+ 1000000p 0.9
+ 1000010p -0.3
+ 1002000p -0.3
+ 1002010p 0.9
+ 1004000p 0.9
+ 1004010p -0.3
+ 1006000p -0.3
+ 1006010p 0.9
+ 1008000p 0.9
+ 1008010p -0.3
+ 1010000p -0.3
+ 1010010p 0.9
+ 1012000p 0.9
+ 1012010p -0.3
+ 1014000p -0.3
+ 1014010p 0.9
+ 1016000p 0.9
+ 1016010p -0.3
+ 1018000p -0.3
+ 1018010p 0.9
+ 1020000p 0.9
+ 1020010p -0.3
+ 1022000p -0.3
+ 1022010p 0.9
+ 1024000p 0.9
+ 1024010p -0.3
+ 1026000p -0.3
+ 1026010p 0.9
+ 1028000p 0.9
+ 1028010p -0.3
+ 1030000p -0.3
+ 1030010p 0.9
+ 1032000p 0.9
+ 1032010p -0.3
+ 1034000p -0.3
+ 1034010p 0.9
+ 1036000p 0.9
+ 1036010p -0.3
+ 1038000p -0.3
+ 1038010p 0.9
+ 1040000p 0.9
+ 1040010p -0.3
+ 1042000p -0.3
+ 1042010p 0.9
+ 1044000p 0.9
+ 1044010p -0.3
+ 1046000p -0.3
+ 1046010p 0.9
+ 1048000p 0.9
+ 1048010p -0.3
+ 1050000p -0.3
+ 1050010p 0.9
+ 1052000p 0.9
+ 1052010p -0.3
+ 1054000p -0.3
+ 1054010p 0.9
+ 1056000p 0.9
+ 1056010p -0.3
+ 1058000p -0.3
+ 1058010p 0.9
+ 1060000p 0.9
+ 1060010p -0.3
+ 1062000p -0.3
+ 1062010p 0.9
+ 1064000p 0.9
+ 1064010p -0.3
+ 1066000p -0.3
+ 1066010p 0.9
+ 1068000p 0.9
+ 1068010p -0.3
+ 1070000p -0.3
+ 1070010p 0.9
+ 1072000p 0.9
+ 1072010p -0.3
+ 1074000p -0.3
+ 1074010p 0.9
+ 1076000p 0.9
+ 1076010p -0.3
+ 1078000p -0.3
+ 1078010p 0.9
+ 1080000p 0.9
+ 1080010p -0.3
+ 1082000p -0.3
+ 1082010p 0.9
+ 1084000p 0.9
+ 1084010p -0.3
+ 1086000p -0.3
+ 1086010p 0.9
+ 1088000p 0.9
+ 1088010p -0.3
+ 1090000p -0.3
+ 1090010p 0.9
+ 1092000p 0.9
+ 1092010p -0.3
+ 1094000p -0.3
+ 1094010p 0.9
+ 1096000p 0.9
+ 1096010p -0.3
+ 1098000p -0.3
+ 1098010p 0.9
+ 1100000p 0.9
+ 1100010p -0.3
+ 1102000p -0.3
+ 1102010p 0.9
+ 1104000p 0.9
+ 1104010p -0.3
+ 1106000p -0.3
+ 1106010p 0.9
+ 1108000p 0.9
+ 1108010p -0.3
+ 1110000p -0.3
+ 1110010p 0.9
+ 1112000p 0.9
+ 1112010p -0.3
+ 1114000p -0.3
+ 1114010p 0.9
+ 1116000p 0.9
+ 1116010p -0.3
+ 1118000p -0.3
+ 1118010p 0.9
+ 1120000p 0.9
+ 1120010p -0.3
+ 1122000p -0.3
+ 1122010p 0.9
+ 1124000p 0.9
+ 1124010p -0.3
+ 1126000p -0.3
+ 1126010p 0.9
+ 1128000p 0.9
+ 1128010p -0.3
+ 1130000p -0.3
+ 1130010p 0.9
+ 1132000p 0.9
+ 1132010p -0.3
+ 1134000p -0.3
+ 1134010p 0.9
+ 1136000p 0.9
+ 1136010p -0.3
+ 1138000p -0.3
+ 1138010p 0.9
+ 1140000p 0.9
+ 1140010p -0.3
+ 1142000p -0.3
+ 1142010p 0.9
+ 1144000p 0.9
+ 1144010p -0.3
+ 1146000p -0.3
+ 1146010p 0.9
+ 1148000p 0.9
+ 1148010p -0.3
+ 1150000p -0.3
+ 1150010p 0.9
+ 1152000p 0.9
+ 1152010p -0.3
+ 1154000p -0.3
+ 1154010p 0.9
+ 1156000p 0.9
+ 1156010p -0.3
+ 1158000p -0.3
+ 1158010p 0.9
+ 1160000p 0.9
+ 1160010p -0.3
+ 1162000p -0.3
+ 1162010p 0.9
+ 1164000p 0.9
+ 1164010p -0.3
+ 1166000p -0.3
+ 1166010p 0.9
+ 1168000p 0.9
+ 1168010p -0.3
+ 1170000p -0.3
+ 1170010p 0.9
+ 1172000p 0.9
+ 1172010p -0.3
+ 1174000p -0.3
+ 1174010p 0.9
+ 1176000p 0.9
+ 1176010p -0.3
+ 1178000p -0.3
+ 1178010p 0.9
+ 1180000p 0.9
+ 1180010p -0.3
+ 1182000p -0.3
+ 1182010p 0.9
+ 1184000p 0.9
+ 1184010p -0.3
+ 1186000p -0.3
+ 1186010p 0.9
+ 1188000p 0.9
+ 1188010p -0.3
+ 1190000p -0.3
+ 1190010p 0.9
+ 1192000p 0.9
+ 1192010p -0.3
+ 1194000p -0.3
+ 1194010p 0.9
+ 1196000p 0.9
+ 1196010p -0.3
+ 1198000p -0.3
+ 1198010p 0.9
+ 1200000p 0.9
+ 1200010p -0.3
+ 1202000p -0.3
+ 1202010p 0.9
+ 1204000p 0.9
+ 1204010p -0.3
+ 1206000p -0.3
+ 1206010p 0.9
+ 1208000p 0.9
+ 1208010p -0.3
+ 1210000p -0.3
+ 1210010p 0.9
+ 1212000p 0.9
+ 1212010p -0.3
+ 1214000p -0.3
+ 1214010p 0.9
+ 1216000p 0.9
+ 1216010p -0.3
+ 1218000p -0.3
+ 1218010p 0.9
+ 1220000p 0.9
+ 1220010p -0.3
+ 1222000p -0.3
+ 1222010p 0.9
+ 1224000p 0.9
+ 1224010p -0.3
+ 1226000p -0.3
+ 1226010p 0.9
+ 1228000p 0.9
+ 1228010p -0.3
+ 1230000p -0.3
+ 1230010p 0.9
+ 1232000p 0.9
+ 1232010p -0.3
+ 1234000p -0.3
+ 1234010p 0.9
+ 1236000p 0.9
+ 1236010p -0.3
+ 1238000p -0.3
+ 1238010p 0.9
+ 1240000p 0.9
+ 1240010p -0.3
+ 1242000p -0.3
+ 1242010p 0.9
+ 1244000p 0.9
+ 1244010p -0.3
+ 1246000p -0.3
+ 1246010p 0.9
+ 1248000p 0.9
+ 1248010p -0.3
+ 1250000p -0.3
+ 1250010p 0.9
+ 1252000p 0.9
+ 1252010p -0.3
+ 1254000p -0.3
+ 1254010p 0.9
+ 1256000p 0.9
+ 1256010p -0.3
+ 1258000p -0.3
+ 1258010p 0.9
+ 1260000p 0.9
+ 1260010p -0.3
+ 1262000p -0.3
+ 1262010p 0.9
+ 1264000p 0.9
+ 1264010p -0.3
+ 1266000p -0.3
+ 1266010p 0.9
+ 1268000p 0.9
+ 1268010p -0.3
+ 1270000p -0.3
+ 1270010p 0.9
+ 1272000p 0.9
+ 1272010p -0.3
+ 1274000p -0.3
+ 1274010p 0.9
+ 1276000p 0.9
+ 1276010p -0.3
+ 1278000p -0.3
+ 1278010p 0.9
+ 1280000p 0.9
+ 1280010p -0.3
+ 1282000p -0.3
+ 1282010p 0.9
+ 1284000p 0.9
+ 1284010p -0.3
+ 1286000p -0.3
+ 1286010p 0.9
+ 1288000p 0.9
+ 1288010p -0.3
+ 1290000p -0.3
+ 1290010p 0.9
+ 1292000p 0.9
+ 1292010p -0.3
+ 1294000p -0.3
+ 1294010p 0.9
+ 1296000p 0.9
+ 1296010p -0.3
+ 1298000p -0.3
+ 1298010p 0.9
+ 1300000p 0.9
+ 1300010p -0.3
+ 1302000p -0.3
+ 1302010p 0.9
+ 1304000p 0.9
+ 1304010p -0.3
+ 1306000p -0.3
+ 1306010p 0.9
+ 1308000p 0.9
+ 1308010p -0.3
+ 1310000p -0.3
+ 1310010p 0.9
+ 1312000p 0.9
+ 1312010p -0.3
+ 1314000p -0.3
+ 1314010p 0.9
+ 1316000p 0.9
+ 1316010p -0.3
+ 1318000p -0.3
+ 1318010p 0.9
+ 1320000p 0.9
+ 1320010p -0.3
+ 1322000p -0.3
+ 1322010p 0.9
+ 1324000p 0.9
+ 1324010p -0.3
+ 1326000p -0.3
+ 1326010p 0.9
+ 1328000p 0.9
+ 1328010p -0.3
+ 1330000p -0.3
+ 1330010p 0.9
+ 1332000p 0.9
+ 1332010p -0.3
+ 1334000p -0.3
+ 1334010p 0.9
+ 1336000p 0.9
+ 1336010p -0.3
+ 1338000p -0.3
+ 1338010p 0.9
+ 1340000p 0.9
+ 1340010p -0.3
+ 1342000p -0.3
+ 1342010p 0.9
+ 1344000p 0.9
+ 1344010p -0.3
+ 1346000p -0.3
+ 1346010p 0.9
+ 1348000p 0.9
+ 1348010p -0.3
+ 1350000p -0.3
+ 1350010p 0.9
+ 1352000p 0.9
+ 1352010p -0.3
+ 1354000p -0.3
+ 1354010p 0.9
+ 1356000p 0.9
+ 1356010p -0.3
+ 1358000p -0.3
+ 1358010p 0.9
+ 1360000p 0.9
+ 1360010p -0.3
+ 1362000p -0.3
+ 1362010p 0.9
+ 1364000p 0.9
+ 1364010p -0.3
+ 1366000p -0.3
+ 1366010p 0.9
+ 1368000p 0.9
+ 1368010p -0.3
+ 1370000p -0.3
+ 1370010p 0.9
+ 1372000p 0.9
+ 1372010p -0.3
+ 1374000p -0.3
+ 1374010p 0.9
+ 1376000p 0.9
+ 1376010p -0.3
+ 1378000p -0.3
+ 1378010p 0.9
+ 1380000p 0.9
+ 1380010p -0.3
+ 1382000p -0.3
+ 1382010p 0.9
+ 1384000p 0.9
+ 1384010p -0.3
+ 1386000p -0.3
+ 1386010p 0.9
+ 1388000p 0.9
+ 1388010p -0.3
+ 1390000p -0.3
+ 1390010p 0.9
+ 1392000p 0.9
+ 1392010p -0.3
+ 1394000p -0.3
+ 1394010p 0.9
+ 1396000p 0.9
+ 1396010p -0.3
+ 1398000p -0.3
+ 1398010p 0.9
+ 1400000p 0.9
+ 1400010p -0.3
+ 1402000p -0.3
+ 1402010p 0.9
+ 1404000p 0.9
+ 1404010p -0.3
+ 1406000p -0.3
+ 1406010p 0.9
+ 1408000p 0.9
+ 1408010p -0.3
+ 1410000p -0.3
+ 1410010p 0.9
+ 1412000p 0.9
+ 1412010p -0.3
+ 1414000p -0.3
+ 1414010p 0.9
+ 1416000p 0.9
+ 1416010p -0.3
+ 1418000p -0.3
+ 1418010p 0.9
+ 1420000p 0.9
+ 1420010p -0.3
+ 1422000p -0.3
+ 1422010p 0.9
+ 1424000p 0.9
+ 1424010p -0.3
+ 1426000p -0.3
+ 1426010p 0.9
+ 1428000p 0.9
+ 1428010p -0.3
+ 1430000p -0.3
+ 1430010p 0.9
+ 1432000p 0.9
+ 1432010p -0.3
+ 1434000p -0.3
+ 1434010p 0.9
+ 1436000p 0.9
+ 1436010p -0.3
+ 1438000p -0.3
+ 1438010p 0.9
+ 1440000p 0.9
+ 1440010p -0.3
+ 1442000p -0.3
+ 1442010p 0.9
+ 1444000p 0.9
+ 1444010p -0.3
+ 1446000p -0.3
+ 1446010p 0.9
+ 1448000p 0.9
+ 1448010p -0.3
+ 1450000p -0.3
+ 1450010p 0.9
+ 1452000p 0.9
+ 1452010p -0.3
+ 1454000p -0.3
+ 1454010p 0.9
+ 1456000p 0.9
+ 1456010p -0.3
+ 1458000p -0.3
+ 1458010p 0.9
+ 1460000p 0.9
+ 1460010p -0.3
+ 1462000p -0.3
+ 1462010p 0.9
+ 1464000p 0.9
+ 1464010p -0.3
+ 1466000p -0.3
+ 1466010p 0.9
+ 1468000p 0.9
+ 1468010p -0.3
+ 1470000p -0.3
+ 1470010p 0.9
+ 1472000p 0.9
+ 1472010p -0.3
+ 1474000p -0.3
+ 1474010p 0.9
+ 1476000p 0.9
+ 1476010p -0.3
+ 1478000p -0.3
+ 1478010p 0.9
+ 1480000p 0.9
+ 1480010p -0.3
+ 1482000p -0.3
+ 1482010p 0.9
+ 1484000p 0.9
+ 1484010p -0.3
+ 1486000p -0.3
+ 1486010p 0.9
+ 1488000p 0.9
+ 1488010p -0.3
+ 1490000p -0.3
+ 1490010p 0.9
+ 1492000p 0.9
+ 1492010p -0.3
+ 1494000p -0.3
+ 1494010p 0.9
+ 1496000p 0.9
+ 1496010p -0.3
+ 1498000p -0.3
+ 1498010p 0.9
+ 1500000p 0.9
+ 1500010p -0.3
+ 1502000p -0.3
+ 1502010p 0.9
+ 1504000p 0.9
+ 1504010p -0.3
+ 1506000p -0.3
+ 1506010p 0.9
+ 1508000p 0.9
+ 1508010p -0.3
+ 1510000p -0.3
+ 1510010p 0.9
+ 1512000p 0.9
+ 1512010p -0.3
+ 1514000p -0.3
+ 1514010p 0.9
+ 1516000p 0.9
+ 1516010p -0.3
+ 1518000p -0.3
+ 1518010p 0.9
+ 1520000p 0.9
+ 1520010p -0.3
+ 1522000p -0.3
+ 1522010p 0.9
+ 1524000p 0.9
+ 1524010p -0.3
+ 1526000p -0.3
+ 1526010p 0.9
+ 1528000p 0.9
+ 1528010p -0.3
+ 1530000p -0.3
+ 1530010p 0.9
+ 1532000p 0.9
+ 1532010p -0.3
+ 1534000p -0.3
+ 1534010p 0.9
+ 1536000p 0.9
+ 1536010p -0.3
+ 1538000p -0.3
+ 1538010p 0.9
+ 1540000p 0.9
+ 1540010p -0.3
+ 1542000p -0.3
+ 1542010p 0.9
+ 1544000p 0.9
+ 1544010p -0.3
+ 1546000p -0.3
+ 1546010p 0.9
+ 1548000p 0.9
+ 1548010p -0.3
+ 1550000p -0.3
+ 1550010p 0.9
+ 1552000p 0.9
+ 1552010p -0.3
+ 1554000p -0.3
+ 1554010p 0.9
+ 1556000p 0.9
+ 1556010p -0.3
+ 1558000p -0.3
+ 1558010p 0.9
+ 1560000p 0.9
+ 1560010p -0.3
+ 1562000p -0.3
+ 1562010p 0.9
+ 1564000p 0.9
+ 1564010p -0.3
+ 1566000p -0.3
+ 1566010p 0.9
+ 1568000p 0.9
+ 1568010p -0.3
+ 1570000p -0.3
+ 1570010p 0.9
+ 1572000p 0.9
+ 1572010p -0.3
+ 1574000p -0.3
+ 1574010p 0.9
+ 1576000p 0.9
+ 1576010p -0.3
+ 1578000p -0.3
+ 1578010p 0.9
+ 1580000p 0.9
+ 1580010p -0.3
+ 1582000p -0.3
+ 1582010p 0.9
+ 1584000p 0.9
+ 1584010p -0.3
+ 1586000p -0.3
+ 1586010p 0.9
+ 1588000p 0.9
+ 1588010p -0.3
+ 1590000p -0.3
+ 1590010p 0.9
+ 1592000p 0.9
+ 1592010p -0.3
+ 1594000p -0.3
+ 1594010p 0.9
+ 1596000p 0.9
+ 1596010p -0.3
+ 1598000p -0.3
+ 1598010p 0.9
+ 1600000p 0.9
+ 1600010p -0.3
+ 1602000p -0.3
+ 1602010p 0.9
+ 1604000p 0.9
+ 1604010p -0.3
+ 1606000p -0.3
+ 1606010p 0.9
+ 1608000p 0.9
+ 1608010p -0.3
+ 1610000p -0.3
+ 1610010p 0.9
+ 1612000p 0.9
+ 1612010p -0.3
+ 1614000p -0.3
+ 1614010p 0.9
+ 1616000p 0.9
+ 1616010p -0.3
+ 1618000p -0.3
+ 1618010p 0.9
+ 1620000p 0.9
+ 1620010p -0.3
+ 1622000p -0.3
+ 1622010p 0.9
+ 1624000p 0.9
+ 1624010p -0.3
+ 1626000p -0.3
+ 1626010p 0.9
+ 1628000p 0.9
+ 1628010p -0.3
+ 1630000p -0.3
+ 1630010p 0.9
+ 1632000p 0.9
+ 1632010p -0.3
+ 1634000p -0.3
+ 1634010p 0.9
+ 1636000p 0.9
+ 1636010p -0.3
+ 1638000p -0.3
+ 1638010p 0.9
+ 1640000p 0.9
+ 1640010p -0.3
+ 1642000p -0.3
+ 1642010p 0.9
+ 1644000p 0.9
+ 1644010p -0.3
+ 1646000p -0.3
+ 1646010p 0.9
+ 1648000p 0.9
+ 1648010p -0.3
+ 1650000p -0.3
+ 1650010p 0.9
+ 1652000p 0.9
+ 1652010p -0.3
+ 1654000p -0.3
+ 1654010p 0.9
+ 1656000p 0.9
+ 1656010p -0.3
+ 1658000p -0.3
+ 1658010p 0.9
+ 1660000p 0.9
+ 1660010p -0.3
+ 1662000p -0.3
+ 1662010p 0.9
+ 1664000p 0.9
+ 1664010p -0.3
+ 1666000p -0.3
+ 1666010p 0.9
+ 1668000p 0.9
+ 1668010p -0.3
+ 1670000p -0.3
+ 1670010p 0.9
+ 1672000p 0.9
+ 1672010p -0.3
+ 1674000p -0.3
+ 1674010p 0.9
+ 1676000p 0.9
+ 1676010p -0.3
+ 1678000p -0.3
+ 1678010p 0.9
+ 1680000p 0.9
+ 1680010p -0.3
+ 1682000p -0.3
+ 1682010p 0.9
+ 1684000p 0.9
+ 1684010p -0.3
+ 1686000p -0.3
+ 1686010p 0.9
+ 1688000p 0.9
+ 1688010p -0.3
+ 1690000p -0.3
+ 1690010p 0.9
+ 1692000p 0.9
+ 1692010p -0.3
+ 1694000p -0.3
+ 1694010p 0.9
+ 1696000p 0.9
+ 1696010p -0.3
+ 1698000p -0.3
+ 1698010p 0.9
+ 1700000p 0.9
+ 1700010p -0.3
+ 1702000p -0.3
+ 1702010p 0.9
+ 1704000p 0.9
+ 1704010p -0.3
+ 1706000p -0.3
+ 1706010p 0.9
+ 1708000p 0.9
+ 1708010p -0.3
+ 1710000p -0.3
+ 1710010p 0.9
+ 1712000p 0.9
+ 1712010p -0.3
+ 1714000p -0.3
+ 1714010p 0.9
+ 1716000p 0.9
+ 1716010p -0.3
+ 1718000p -0.3
+ 1718010p 0.9
+ 1720000p 0.9
+ 1720010p -0.3
+ 1722000p -0.3
+ 1722010p 0.9
+ 1724000p 0.9
+ 1724010p -0.3
+ 1726000p -0.3
+ 1726010p 0.9
+ 1728000p 0.9
+ 1728010p -0.3
+ 1730000p -0.3
+ 1730010p 0.9
+ 1732000p 0.9
+ 1732010p -0.3
+ 1734000p -0.3
+ 1734010p 0.9
+ 1736000p 0.9
+ 1736010p -0.3
+ 1738000p -0.3
+ 1738010p 0.9
+ 1740000p 0.9
+ 1740010p -0.3
+ 1742000p -0.3
+ 1742010p 0.9
+ 1744000p 0.9
+ 1744010p -0.3
+ 1746000p -0.3
+ 1746010p 0.9
+ 1748000p 0.9
+ 1748010p -0.3
+ 1750000p -0.3
+ 1750010p 0.9
+ 1752000p 0.9
+ 1752010p -0.3
+ 1754000p -0.3
+ 1754010p 0.9
+ 1756000p 0.9
+ 1756010p -0.3
+ 1758000p -0.3
+ 1758010p 0.9
+ 1760000p 0.9
+ 1760010p -0.3
+ 1762000p -0.3
+ 1762010p 0.9
+ 1764000p 0.9
+ 1764010p -0.3
+ 1766000p -0.3
+ 1766010p 0.9
+ 1768000p 0.9
+ 1768010p -0.3
+ 1770000p -0.3
+ 1770010p 0.9
+ 1772000p 0.9
+ 1772010p -0.3
+ 1774000p -0.3
+ 1774010p 0.9
+ 1776000p 0.9
+ 1776010p -0.3
+ 1778000p -0.3
+ 1778010p 0.9
+ 1780000p 0.9
+ 1780010p -0.3
+ 1782000p -0.3
+ 1782010p 0.9
+ 1784000p 0.9
+ 1784010p -0.3
+ 1786000p -0.3
+ 1786010p 0.9
+ 1788000p 0.9
+ 1788010p -0.3
+ 1790000p -0.3
+ 1790010p 0.9
+ 1792000p 0.9
+ 1792010p -0.3
+ 1794000p -0.3
+ 1794010p 0.9
+ 1796000p 0.9
+ 1796010p -0.3
+ 1798000p -0.3
+ 1798010p 0.9
+ 1800000p 0.9
+ 1800010p -0.3
+ 1802000p -0.3
+ 1802010p 0.9
+ 1804000p 0.9
+ 1804010p -0.3
+ 1806000p -0.3
+ 1806010p 0.9
+ 1808000p 0.9
+ 1808010p -0.3
+ 1810000p -0.3
+ 1810010p 0.9
+ 1812000p 0.9
+ 1812010p -0.3
+ 1814000p -0.3
+ 1814010p 0.9
+ 1816000p 0.9
+ 1816010p -0.3
+ 1818000p -0.3
+ 1818010p 0.9
+ 1820000p 0.9
+ 1820010p -0.3
+ 1822000p -0.3
+ 1822010p 0.9
+ 1824000p 0.9
+ 1824010p -0.3
+ 1826000p -0.3
+ 1826010p 0.9
+ 1828000p 0.9
+ 1828010p -0.3
+ 1830000p -0.3
+ 1830010p 0.9
+ 1832000p 0.9
+ 1832010p -0.3
+ 1834000p -0.3
+ 1834010p 0.9
+ 1836000p 0.9
+ 1836010p -0.3
+ 1838000p -0.3
+ 1838010p 0.9
+ 1840000p 0.9
+ 1840010p -0.3
+ 1842000p -0.3
+ 1842010p 0.9
+ 1844000p 0.9
+ 1844010p -0.3
+ 1846000p -0.3
+ 1846010p 0.9
+ 1848000p 0.9
+ 1848010p -0.3
+ 1850000p -0.3
+ 1850010p 0.9
+ 1852000p 0.9
+ 1852010p -0.3
+ 1854000p -0.3
+ 1854010p 0.9
+ 1856000p 0.9
+ 1856010p -0.3
+ 1858000p -0.3
+ 1858010p 0.9
+ 1860000p 0.9
+ 1860010p -0.3
+ 1862000p -0.3
+ 1862010p 0.9
+ 1864000p 0.9
+ 1864010p -0.3
+ 1866000p -0.3
+ 1866010p 0.9
+ 1868000p 0.9
+ 1868010p -0.3
+ 1870000p -0.3
+ 1870010p 0.9
+ 1872000p 0.9
+ 1872010p -0.3
+ 1874000p -0.3
+ 1874010p 0.9
+ 1876000p 0.9
+ 1876010p -0.3
+ 1878000p -0.3
+ 1878010p 0.9
+ 1880000p 0.9
+ 1880010p -0.3
+ 1882000p -0.3
+ 1882010p 0.9
+ 1884000p 0.9
+ 1884010p -0.3
+ 1886000p -0.3
+ 1886010p 0.9
+ 1888000p 0.9
+ 1888010p -0.3
+ 1890000p -0.3
+ 1890010p 0.9
+ 1892000p 0.9
+ 1892010p -0.3
+ 1894000p -0.3
+ 1894010p 0.9
+ 1896000p 0.9
+ 1896010p -0.3
+ 1898000p -0.3
+ 1898010p 0.9
+ 1900000p 0.9
+ 1900010p -0.3
+ 1902000p -0.3
+ 1902010p 0.9
+ 1904000p 0.9
+ 1904010p -0.3
+ 1906000p -0.3
+ 1906010p 0.9
+ 1908000p 0.9
+ 1908010p -0.3
+ 1910000p -0.3
+ 1910010p 0.9
+ 1912000p 0.9
+ 1912010p -0.3
+ 1914000p -0.3
+ 1914010p 0.9
+ 1916000p 0.9
+ 1916010p -0.3
+ 1918000p -0.3
+ 1918010p 0.9
+ 1920000p 0.9
+ 1920010p -0.3
+ 1922000p -0.3
+ 1922010p 0.9
+ 1924000p 0.9
+ 1924010p -0.3
+ 1926000p -0.3
+ 1926010p 0.9
+ 1928000p 0.9
+ 1928010p -0.3
+ 1930000p -0.3
+ 1930010p 0.9
+ 1932000p 0.9
+ 1932010p -0.3
+ 1934000p -0.3
+ 1934010p 0.9
+ 1936000p 0.9
+ 1936010p -0.3
+ 1938000p -0.3
+ 1938010p 0.9
+ 1940000p 0.9
+ 1940010p -0.3
+ 1942000p -0.3
+ 1942010p 0.9
+ 1944000p 0.9
+ 1944010p -0.3
+ 1946000p -0.3
+ 1946010p 0.9
+ 1948000p 0.9
+ 1948010p -0.3
+ 1950000p -0.3
+ 1950010p 0.9
+ 1952000p 0.9
+ 1952010p -0.3
+ 1954000p -0.3
+ 1954010p 0.9
+ 1956000p 0.9
+ 1956010p -0.3
+ 1958000p -0.3
+ 1958010p 0.9
+ 1960000p 0.9
+ 1960010p -0.3
+ 1962000p -0.3
+ 1962010p 0.9
+ 1964000p 0.9
+ 1964010p -0.3
+ 1966000p -0.3
+ 1966010p 0.9
+ 1968000p 0.9
+ 1968010p -0.3
+ 1970000p -0.3
+ 1970010p 0.9
+ 1972000p 0.9
+ 1972010p -0.3
+ 1974000p -0.3
+ 1974010p 0.9
+ 1976000p 0.9
+ 1976010p -0.3
+ 1978000p -0.3
+ 1978010p 0.9
+ 1980000p 0.9
+ 1980010p -0.3
+ 1982000p -0.3
+ 1982010p 0.9
+ 1984000p 0.9
+ 1984010p -0.3
+ 1986000p -0.3
+ 1986010p 0.9
+ 1988000p 0.9
+ 1988010p -0.3
+ 1990000p -0.3
+ 1990010p 0.9
+ 1992000p 0.9
+ 1992010p -0.3
+ 1994000p -0.3
+ 1994010p 0.9
+ 1996000p 0.9
+ 1996010p -0.3
+ 1998000p -0.3
+ 1998010p 0.9
+ 2000000p 0.9
+ 2000010p -0.3
+ 2002000p -0.3
+ 2002010p 0.9
+ 2004000p 0.9
+ 2004010p -0.3
+ 2006000p -0.3
+ 2006010p 0.9
+ 2008000p 0.9
+ 2008010p -0.3
+ 2010000p -0.3
+ 2010010p 0.9
+ 2012000p 0.9
+ 2012010p -0.3
+ 2014000p -0.3
+ 2014010p 0.9
+ 2016000p 0.9
+ 2016010p -0.3
+ 2018000p -0.3
+ 2018010p 0.9
+ 2020000p 0.9
+ 2020010p -0.3
+ 2022000p -0.3
+ 2022010p 0.9
+ 2024000p 0.9
+ 2024010p -0.3
+ 2026000p -0.3
+ 2026010p 0.9
+ 2028000p 0.9
+ 2028010p -0.3
+ 2030000p -0.3
+ 2030010p 0.9
+ 2032000p 0.9
+ 2032010p -0.3
+ 2034000p -0.3
+ 2034010p 0.9
+ 2036000p 0.9
+ 2036010p -0.3
+ 2038000p -0.3
+ 2038010p 0.9
+ 2040000p 0.9
+ 2040010p -0.3
+ 2042000p -0.3
+ 2042010p 0.9
+ 2044000p 0.9
+ 2044010p -0.3
+ 2046000p -0.3
+ 2046010p 0.9
+ 2048000p 0.9
+ 2048010p -0.3
+ \]
V_data_30 (Data\\<30\\> gnd!) vsource type=pwl wave=\[
+ 0    0.9
+ 2000p 0.9
+ 2010p -0.3
+ 4000p -0.3
+ 4010p 0.9
+ 6000p 0.9
+ 6010p -0.3
+ 8000p -0.3
+ 8010p 0.9
+ 10000p 0.9
+ 10010p -0.3
+ 12000p -0.3
+ 12010p 0.9
+ 14000p 0.9
+ 14010p -0.3
+ 16000p -0.3
+ 16010p 0.9
+ 18000p 0.9
+ 18010p -0.3
+ 20000p -0.3
+ 20010p 0.9
+ 22000p 0.9
+ 22010p -0.3
+ 24000p -0.3
+ 24010p 0.9
+ 26000p 0.9
+ 26010p -0.3
+ 28000p -0.3
+ 28010p 0.9
+ 30000p 0.9
+ 30010p -0.3
+ 32000p -0.3
+ 32010p 0.9
+ 34000p 0.9
+ 34010p -0.3
+ 36000p -0.3
+ 36010p 0.9
+ 38000p 0.9
+ 38010p -0.3
+ 40000p -0.3
+ 40010p 0.9
+ 42000p 0.9
+ 42010p -0.3
+ 44000p -0.3
+ 44010p 0.9
+ 46000p 0.9
+ 46010p -0.3
+ 48000p -0.3
+ 48010p 0.9
+ 50000p 0.9
+ 50010p -0.3
+ 52000p -0.3
+ 52010p 0.9
+ 54000p 0.9
+ 54010p -0.3
+ 56000p -0.3
+ 56010p 0.9
+ 58000p 0.9
+ 58010p -0.3
+ 60000p -0.3
+ 60010p 0.9
+ 62000p 0.9
+ 62010p -0.3
+ 64000p -0.3
+ 64010p 0.9
+ 66000p 0.9
+ 66010p -0.3
+ 68000p -0.3
+ 68010p 0.9
+ 70000p 0.9
+ 70010p -0.3
+ 72000p -0.3
+ 72010p 0.9
+ 74000p 0.9
+ 74010p -0.3
+ 76000p -0.3
+ 76010p 0.9
+ 78000p 0.9
+ 78010p -0.3
+ 80000p -0.3
+ 80010p 0.9
+ 82000p 0.9
+ 82010p -0.3
+ 84000p -0.3
+ 84010p 0.9
+ 86000p 0.9
+ 86010p -0.3
+ 88000p -0.3
+ 88010p 0.9
+ 90000p 0.9
+ 90010p -0.3
+ 92000p -0.3
+ 92010p 0.9
+ 94000p 0.9
+ 94010p -0.3
+ 96000p -0.3
+ 96010p 0.9
+ 98000p 0.9
+ 98010p -0.3
+ 100000p -0.3
+ 100010p 0.9
+ 102000p 0.9
+ 102010p -0.3
+ 104000p -0.3
+ 104010p 0.9
+ 106000p 0.9
+ 106010p -0.3
+ 108000p -0.3
+ 108010p 0.9
+ 110000p 0.9
+ 110010p -0.3
+ 112000p -0.3
+ 112010p 0.9
+ 114000p 0.9
+ 114010p -0.3
+ 116000p -0.3
+ 116010p 0.9
+ 118000p 0.9
+ 118010p -0.3
+ 120000p -0.3
+ 120010p 0.9
+ 122000p 0.9
+ 122010p -0.3
+ 124000p -0.3
+ 124010p 0.9
+ 126000p 0.9
+ 126010p -0.3
+ 128000p -0.3
+ 128010p 0.9
+ 130000p 0.9
+ 130010p -0.3
+ 132000p -0.3
+ 132010p 0.9
+ 134000p 0.9
+ 134010p -0.3
+ 136000p -0.3
+ 136010p 0.9
+ 138000p 0.9
+ 138010p -0.3
+ 140000p -0.3
+ 140010p 0.9
+ 142000p 0.9
+ 142010p -0.3
+ 144000p -0.3
+ 144010p 0.9
+ 146000p 0.9
+ 146010p -0.3
+ 148000p -0.3
+ 148010p 0.9
+ 150000p 0.9
+ 150010p -0.3
+ 152000p -0.3
+ 152010p 0.9
+ 154000p 0.9
+ 154010p -0.3
+ 156000p -0.3
+ 156010p 0.9
+ 158000p 0.9
+ 158010p -0.3
+ 160000p -0.3
+ 160010p 0.9
+ 162000p 0.9
+ 162010p -0.3
+ 164000p -0.3
+ 164010p 0.9
+ 166000p 0.9
+ 166010p -0.3
+ 168000p -0.3
+ 168010p 0.9
+ 170000p 0.9
+ 170010p -0.3
+ 172000p -0.3
+ 172010p 0.9
+ 174000p 0.9
+ 174010p -0.3
+ 176000p -0.3
+ 176010p 0.9
+ 178000p 0.9
+ 178010p -0.3
+ 180000p -0.3
+ 180010p 0.9
+ 182000p 0.9
+ 182010p -0.3
+ 184000p -0.3
+ 184010p 0.9
+ 186000p 0.9
+ 186010p -0.3
+ 188000p -0.3
+ 188010p 0.9
+ 190000p 0.9
+ 190010p -0.3
+ 192000p -0.3
+ 192010p 0.9
+ 194000p 0.9
+ 194010p -0.3
+ 196000p -0.3
+ 196010p 0.9
+ 198000p 0.9
+ 198010p -0.3
+ 200000p -0.3
+ 200010p 0.9
+ 202000p 0.9
+ 202010p -0.3
+ 204000p -0.3
+ 204010p 0.9
+ 206000p 0.9
+ 206010p -0.3
+ 208000p -0.3
+ 208010p 0.9
+ 210000p 0.9
+ 210010p -0.3
+ 212000p -0.3
+ 212010p 0.9
+ 214000p 0.9
+ 214010p -0.3
+ 216000p -0.3
+ 216010p 0.9
+ 218000p 0.9
+ 218010p -0.3
+ 220000p -0.3
+ 220010p 0.9
+ 222000p 0.9
+ 222010p -0.3
+ 224000p -0.3
+ 224010p 0.9
+ 226000p 0.9
+ 226010p -0.3
+ 228000p -0.3
+ 228010p 0.9
+ 230000p 0.9
+ 230010p -0.3
+ 232000p -0.3
+ 232010p 0.9
+ 234000p 0.9
+ 234010p -0.3
+ 236000p -0.3
+ 236010p 0.9
+ 238000p 0.9
+ 238010p -0.3
+ 240000p -0.3
+ 240010p 0.9
+ 242000p 0.9
+ 242010p -0.3
+ 244000p -0.3
+ 244010p 0.9
+ 246000p 0.9
+ 246010p -0.3
+ 248000p -0.3
+ 248010p 0.9
+ 250000p 0.9
+ 250010p -0.3
+ 252000p -0.3
+ 252010p 0.9
+ 254000p 0.9
+ 254010p -0.3
+ 256000p -0.3
+ 256010p 0.9
+ 258000p 0.9
+ 258010p -0.3
+ 260000p -0.3
+ 260010p 0.9
+ 262000p 0.9
+ 262010p -0.3
+ 264000p -0.3
+ 264010p 0.9
+ 266000p 0.9
+ 266010p -0.3
+ 268000p -0.3
+ 268010p 0.9
+ 270000p 0.9
+ 270010p -0.3
+ 272000p -0.3
+ 272010p 0.9
+ 274000p 0.9
+ 274010p -0.3
+ 276000p -0.3
+ 276010p 0.9
+ 278000p 0.9
+ 278010p -0.3
+ 280000p -0.3
+ 280010p 0.9
+ 282000p 0.9
+ 282010p -0.3
+ 284000p -0.3
+ 284010p 0.9
+ 286000p 0.9
+ 286010p -0.3
+ 288000p -0.3
+ 288010p 0.9
+ 290000p 0.9
+ 290010p -0.3
+ 292000p -0.3
+ 292010p 0.9
+ 294000p 0.9
+ 294010p -0.3
+ 296000p -0.3
+ 296010p 0.9
+ 298000p 0.9
+ 298010p -0.3
+ 300000p -0.3
+ 300010p 0.9
+ 302000p 0.9
+ 302010p -0.3
+ 304000p -0.3
+ 304010p 0.9
+ 306000p 0.9
+ 306010p -0.3
+ 308000p -0.3
+ 308010p 0.9
+ 310000p 0.9
+ 310010p -0.3
+ 312000p -0.3
+ 312010p 0.9
+ 314000p 0.9
+ 314010p -0.3
+ 316000p -0.3
+ 316010p 0.9
+ 318000p 0.9
+ 318010p -0.3
+ 320000p -0.3
+ 320010p 0.9
+ 322000p 0.9
+ 322010p -0.3
+ 324000p -0.3
+ 324010p 0.9
+ 326000p 0.9
+ 326010p -0.3
+ 328000p -0.3
+ 328010p 0.9
+ 330000p 0.9
+ 330010p -0.3
+ 332000p -0.3
+ 332010p 0.9
+ 334000p 0.9
+ 334010p -0.3
+ 336000p -0.3
+ 336010p 0.9
+ 338000p 0.9
+ 338010p -0.3
+ 340000p -0.3
+ 340010p 0.9
+ 342000p 0.9
+ 342010p -0.3
+ 344000p -0.3
+ 344010p 0.9
+ 346000p 0.9
+ 346010p -0.3
+ 348000p -0.3
+ 348010p 0.9
+ 350000p 0.9
+ 350010p -0.3
+ 352000p -0.3
+ 352010p 0.9
+ 354000p 0.9
+ 354010p -0.3
+ 356000p -0.3
+ 356010p 0.9
+ 358000p 0.9
+ 358010p -0.3
+ 360000p -0.3
+ 360010p 0.9
+ 362000p 0.9
+ 362010p -0.3
+ 364000p -0.3
+ 364010p 0.9
+ 366000p 0.9
+ 366010p -0.3
+ 368000p -0.3
+ 368010p 0.9
+ 370000p 0.9
+ 370010p -0.3
+ 372000p -0.3
+ 372010p 0.9
+ 374000p 0.9
+ 374010p -0.3
+ 376000p -0.3
+ 376010p 0.9
+ 378000p 0.9
+ 378010p -0.3
+ 380000p -0.3
+ 380010p 0.9
+ 382000p 0.9
+ 382010p -0.3
+ 384000p -0.3
+ 384010p 0.9
+ 386000p 0.9
+ 386010p -0.3
+ 388000p -0.3
+ 388010p 0.9
+ 390000p 0.9
+ 390010p -0.3
+ 392000p -0.3
+ 392010p 0.9
+ 394000p 0.9
+ 394010p -0.3
+ 396000p -0.3
+ 396010p 0.9
+ 398000p 0.9
+ 398010p -0.3
+ 400000p -0.3
+ 400010p 0.9
+ 402000p 0.9
+ 402010p -0.3
+ 404000p -0.3
+ 404010p 0.9
+ 406000p 0.9
+ 406010p -0.3
+ 408000p -0.3
+ 408010p 0.9
+ 410000p 0.9
+ 410010p -0.3
+ 412000p -0.3
+ 412010p 0.9
+ 414000p 0.9
+ 414010p -0.3
+ 416000p -0.3
+ 416010p 0.9
+ 418000p 0.9
+ 418010p -0.3
+ 420000p -0.3
+ 420010p 0.9
+ 422000p 0.9
+ 422010p -0.3
+ 424000p -0.3
+ 424010p 0.9
+ 426000p 0.9
+ 426010p -0.3
+ 428000p -0.3
+ 428010p 0.9
+ 430000p 0.9
+ 430010p -0.3
+ 432000p -0.3
+ 432010p 0.9
+ 434000p 0.9
+ 434010p -0.3
+ 436000p -0.3
+ 436010p 0.9
+ 438000p 0.9
+ 438010p -0.3
+ 440000p -0.3
+ 440010p 0.9
+ 442000p 0.9
+ 442010p -0.3
+ 444000p -0.3
+ 444010p 0.9
+ 446000p 0.9
+ 446010p -0.3
+ 448000p -0.3
+ 448010p 0.9
+ 450000p 0.9
+ 450010p -0.3
+ 452000p -0.3
+ 452010p 0.9
+ 454000p 0.9
+ 454010p -0.3
+ 456000p -0.3
+ 456010p 0.9
+ 458000p 0.9
+ 458010p -0.3
+ 460000p -0.3
+ 460010p 0.9
+ 462000p 0.9
+ 462010p -0.3
+ 464000p -0.3
+ 464010p 0.9
+ 466000p 0.9
+ 466010p -0.3
+ 468000p -0.3
+ 468010p 0.9
+ 470000p 0.9
+ 470010p -0.3
+ 472000p -0.3
+ 472010p 0.9
+ 474000p 0.9
+ 474010p -0.3
+ 476000p -0.3
+ 476010p 0.9
+ 478000p 0.9
+ 478010p -0.3
+ 480000p -0.3
+ 480010p 0.9
+ 482000p 0.9
+ 482010p -0.3
+ 484000p -0.3
+ 484010p 0.9
+ 486000p 0.9
+ 486010p -0.3
+ 488000p -0.3
+ 488010p 0.9
+ 490000p 0.9
+ 490010p -0.3
+ 492000p -0.3
+ 492010p 0.9
+ 494000p 0.9
+ 494010p -0.3
+ 496000p -0.3
+ 496010p 0.9
+ 498000p 0.9
+ 498010p -0.3
+ 500000p -0.3
+ 500010p 0.9
+ 502000p 0.9
+ 502010p -0.3
+ 504000p -0.3
+ 504010p 0.9
+ 506000p 0.9
+ 506010p -0.3
+ 508000p -0.3
+ 508010p 0.9
+ 510000p 0.9
+ 510010p -0.3
+ 512000p -0.3
+ 512010p 0.9
+ 514000p 0.9
+ 514010p -0.3
+ 516000p -0.3
+ 516010p 0.9
+ 518000p 0.9
+ 518010p -0.3
+ 520000p -0.3
+ 520010p 0.9
+ 522000p 0.9
+ 522010p -0.3
+ 524000p -0.3
+ 524010p 0.9
+ 526000p 0.9
+ 526010p -0.3
+ 528000p -0.3
+ 528010p 0.9
+ 530000p 0.9
+ 530010p -0.3
+ 532000p -0.3
+ 532010p 0.9
+ 534000p 0.9
+ 534010p -0.3
+ 536000p -0.3
+ 536010p 0.9
+ 538000p 0.9
+ 538010p -0.3
+ 540000p -0.3
+ 540010p 0.9
+ 542000p 0.9
+ 542010p -0.3
+ 544000p -0.3
+ 544010p 0.9
+ 546000p 0.9
+ 546010p -0.3
+ 548000p -0.3
+ 548010p 0.9
+ 550000p 0.9
+ 550010p -0.3
+ 552000p -0.3
+ 552010p 0.9
+ 554000p 0.9
+ 554010p -0.3
+ 556000p -0.3
+ 556010p 0.9
+ 558000p 0.9
+ 558010p -0.3
+ 560000p -0.3
+ 560010p 0.9
+ 562000p 0.9
+ 562010p -0.3
+ 564000p -0.3
+ 564010p 0.9
+ 566000p 0.9
+ 566010p -0.3
+ 568000p -0.3
+ 568010p 0.9
+ 570000p 0.9
+ 570010p -0.3
+ 572000p -0.3
+ 572010p 0.9
+ 574000p 0.9
+ 574010p -0.3
+ 576000p -0.3
+ 576010p 0.9
+ 578000p 0.9
+ 578010p -0.3
+ 580000p -0.3
+ 580010p 0.9
+ 582000p 0.9
+ 582010p -0.3
+ 584000p -0.3
+ 584010p 0.9
+ 586000p 0.9
+ 586010p -0.3
+ 588000p -0.3
+ 588010p 0.9
+ 590000p 0.9
+ 590010p -0.3
+ 592000p -0.3
+ 592010p 0.9
+ 594000p 0.9
+ 594010p -0.3
+ 596000p -0.3
+ 596010p 0.9
+ 598000p 0.9
+ 598010p -0.3
+ 600000p -0.3
+ 600010p 0.9
+ 602000p 0.9
+ 602010p -0.3
+ 604000p -0.3
+ 604010p 0.9
+ 606000p 0.9
+ 606010p -0.3
+ 608000p -0.3
+ 608010p 0.9
+ 610000p 0.9
+ 610010p -0.3
+ 612000p -0.3
+ 612010p 0.9
+ 614000p 0.9
+ 614010p -0.3
+ 616000p -0.3
+ 616010p 0.9
+ 618000p 0.9
+ 618010p -0.3
+ 620000p -0.3
+ 620010p 0.9
+ 622000p 0.9
+ 622010p -0.3
+ 624000p -0.3
+ 624010p 0.9
+ 626000p 0.9
+ 626010p -0.3
+ 628000p -0.3
+ 628010p 0.9
+ 630000p 0.9
+ 630010p -0.3
+ 632000p -0.3
+ 632010p 0.9
+ 634000p 0.9
+ 634010p -0.3
+ 636000p -0.3
+ 636010p 0.9
+ 638000p 0.9
+ 638010p -0.3
+ 640000p -0.3
+ 640010p 0.9
+ 642000p 0.9
+ 642010p -0.3
+ 644000p -0.3
+ 644010p 0.9
+ 646000p 0.9
+ 646010p -0.3
+ 648000p -0.3
+ 648010p 0.9
+ 650000p 0.9
+ 650010p -0.3
+ 652000p -0.3
+ 652010p 0.9
+ 654000p 0.9
+ 654010p -0.3
+ 656000p -0.3
+ 656010p 0.9
+ 658000p 0.9
+ 658010p -0.3
+ 660000p -0.3
+ 660010p 0.9
+ 662000p 0.9
+ 662010p -0.3
+ 664000p -0.3
+ 664010p 0.9
+ 666000p 0.9
+ 666010p -0.3
+ 668000p -0.3
+ 668010p 0.9
+ 670000p 0.9
+ 670010p -0.3
+ 672000p -0.3
+ 672010p 0.9
+ 674000p 0.9
+ 674010p -0.3
+ 676000p -0.3
+ 676010p 0.9
+ 678000p 0.9
+ 678010p -0.3
+ 680000p -0.3
+ 680010p 0.9
+ 682000p 0.9
+ 682010p -0.3
+ 684000p -0.3
+ 684010p 0.9
+ 686000p 0.9
+ 686010p -0.3
+ 688000p -0.3
+ 688010p 0.9
+ 690000p 0.9
+ 690010p -0.3
+ 692000p -0.3
+ 692010p 0.9
+ 694000p 0.9
+ 694010p -0.3
+ 696000p -0.3
+ 696010p 0.9
+ 698000p 0.9
+ 698010p -0.3
+ 700000p -0.3
+ 700010p 0.9
+ 702000p 0.9
+ 702010p -0.3
+ 704000p -0.3
+ 704010p 0.9
+ 706000p 0.9
+ 706010p -0.3
+ 708000p -0.3
+ 708010p 0.9
+ 710000p 0.9
+ 710010p -0.3
+ 712000p -0.3
+ 712010p 0.9
+ 714000p 0.9
+ 714010p -0.3
+ 716000p -0.3
+ 716010p 0.9
+ 718000p 0.9
+ 718010p -0.3
+ 720000p -0.3
+ 720010p 0.9
+ 722000p 0.9
+ 722010p -0.3
+ 724000p -0.3
+ 724010p 0.9
+ 726000p 0.9
+ 726010p -0.3
+ 728000p -0.3
+ 728010p 0.9
+ 730000p 0.9
+ 730010p -0.3
+ 732000p -0.3
+ 732010p 0.9
+ 734000p 0.9
+ 734010p -0.3
+ 736000p -0.3
+ 736010p 0.9
+ 738000p 0.9
+ 738010p -0.3
+ 740000p -0.3
+ 740010p 0.9
+ 742000p 0.9
+ 742010p -0.3
+ 744000p -0.3
+ 744010p 0.9
+ 746000p 0.9
+ 746010p -0.3
+ 748000p -0.3
+ 748010p 0.9
+ 750000p 0.9
+ 750010p -0.3
+ 752000p -0.3
+ 752010p 0.9
+ 754000p 0.9
+ 754010p -0.3
+ 756000p -0.3
+ 756010p 0.9
+ 758000p 0.9
+ 758010p -0.3
+ 760000p -0.3
+ 760010p 0.9
+ 762000p 0.9
+ 762010p -0.3
+ 764000p -0.3
+ 764010p 0.9
+ 766000p 0.9
+ 766010p -0.3
+ 768000p -0.3
+ 768010p 0.9
+ 770000p 0.9
+ 770010p -0.3
+ 772000p -0.3
+ 772010p 0.9
+ 774000p 0.9
+ 774010p -0.3
+ 776000p -0.3
+ 776010p 0.9
+ 778000p 0.9
+ 778010p -0.3
+ 780000p -0.3
+ 780010p 0.9
+ 782000p 0.9
+ 782010p -0.3
+ 784000p -0.3
+ 784010p 0.9
+ 786000p 0.9
+ 786010p -0.3
+ 788000p -0.3
+ 788010p 0.9
+ 790000p 0.9
+ 790010p -0.3
+ 792000p -0.3
+ 792010p 0.9
+ 794000p 0.9
+ 794010p -0.3
+ 796000p -0.3
+ 796010p 0.9
+ 798000p 0.9
+ 798010p -0.3
+ 800000p -0.3
+ 800010p 0.9
+ 802000p 0.9
+ 802010p -0.3
+ 804000p -0.3
+ 804010p 0.9
+ 806000p 0.9
+ 806010p -0.3
+ 808000p -0.3
+ 808010p 0.9
+ 810000p 0.9
+ 810010p -0.3
+ 812000p -0.3
+ 812010p 0.9
+ 814000p 0.9
+ 814010p -0.3
+ 816000p -0.3
+ 816010p 0.9
+ 818000p 0.9
+ 818010p -0.3
+ 820000p -0.3
+ 820010p 0.9
+ 822000p 0.9
+ 822010p -0.3
+ 824000p -0.3
+ 824010p 0.9
+ 826000p 0.9
+ 826010p -0.3
+ 828000p -0.3
+ 828010p 0.9
+ 830000p 0.9
+ 830010p -0.3
+ 832000p -0.3
+ 832010p 0.9
+ 834000p 0.9
+ 834010p -0.3
+ 836000p -0.3
+ 836010p 0.9
+ 838000p 0.9
+ 838010p -0.3
+ 840000p -0.3
+ 840010p 0.9
+ 842000p 0.9
+ 842010p -0.3
+ 844000p -0.3
+ 844010p 0.9
+ 846000p 0.9
+ 846010p -0.3
+ 848000p -0.3
+ 848010p 0.9
+ 850000p 0.9
+ 850010p -0.3
+ 852000p -0.3
+ 852010p 0.9
+ 854000p 0.9
+ 854010p -0.3
+ 856000p -0.3
+ 856010p 0.9
+ 858000p 0.9
+ 858010p -0.3
+ 860000p -0.3
+ 860010p 0.9
+ 862000p 0.9
+ 862010p -0.3
+ 864000p -0.3
+ 864010p 0.9
+ 866000p 0.9
+ 866010p -0.3
+ 868000p -0.3
+ 868010p 0.9
+ 870000p 0.9
+ 870010p -0.3
+ 872000p -0.3
+ 872010p 0.9
+ 874000p 0.9
+ 874010p -0.3
+ 876000p -0.3
+ 876010p 0.9
+ 878000p 0.9
+ 878010p -0.3
+ 880000p -0.3
+ 880010p 0.9
+ 882000p 0.9
+ 882010p -0.3
+ 884000p -0.3
+ 884010p 0.9
+ 886000p 0.9
+ 886010p -0.3
+ 888000p -0.3
+ 888010p 0.9
+ 890000p 0.9
+ 890010p -0.3
+ 892000p -0.3
+ 892010p 0.9
+ 894000p 0.9
+ 894010p -0.3
+ 896000p -0.3
+ 896010p 0.9
+ 898000p 0.9
+ 898010p -0.3
+ 900000p -0.3
+ 900010p 0.9
+ 902000p 0.9
+ 902010p -0.3
+ 904000p -0.3
+ 904010p 0.9
+ 906000p 0.9
+ 906010p -0.3
+ 908000p -0.3
+ 908010p 0.9
+ 910000p 0.9
+ 910010p -0.3
+ 912000p -0.3
+ 912010p 0.9
+ 914000p 0.9
+ 914010p -0.3
+ 916000p -0.3
+ 916010p 0.9
+ 918000p 0.9
+ 918010p -0.3
+ 920000p -0.3
+ 920010p 0.9
+ 922000p 0.9
+ 922010p -0.3
+ 924000p -0.3
+ 924010p 0.9
+ 926000p 0.9
+ 926010p -0.3
+ 928000p -0.3
+ 928010p 0.9
+ 930000p 0.9
+ 930010p -0.3
+ 932000p -0.3
+ 932010p 0.9
+ 934000p 0.9
+ 934010p -0.3
+ 936000p -0.3
+ 936010p 0.9
+ 938000p 0.9
+ 938010p -0.3
+ 940000p -0.3
+ 940010p 0.9
+ 942000p 0.9
+ 942010p -0.3
+ 944000p -0.3
+ 944010p 0.9
+ 946000p 0.9
+ 946010p -0.3
+ 948000p -0.3
+ 948010p 0.9
+ 950000p 0.9
+ 950010p -0.3
+ 952000p -0.3
+ 952010p 0.9
+ 954000p 0.9
+ 954010p -0.3
+ 956000p -0.3
+ 956010p 0.9
+ 958000p 0.9
+ 958010p -0.3
+ 960000p -0.3
+ 960010p 0.9
+ 962000p 0.9
+ 962010p -0.3
+ 964000p -0.3
+ 964010p 0.9
+ 966000p 0.9
+ 966010p -0.3
+ 968000p -0.3
+ 968010p 0.9
+ 970000p 0.9
+ 970010p -0.3
+ 972000p -0.3
+ 972010p 0.9
+ 974000p 0.9
+ 974010p -0.3
+ 976000p -0.3
+ 976010p 0.9
+ 978000p 0.9
+ 978010p -0.3
+ 980000p -0.3
+ 980010p 0.9
+ 982000p 0.9
+ 982010p -0.3
+ 984000p -0.3
+ 984010p 0.9
+ 986000p 0.9
+ 986010p -0.3
+ 988000p -0.3
+ 988010p 0.9
+ 990000p 0.9
+ 990010p -0.3
+ 992000p -0.3
+ 992010p 0.9
+ 994000p 0.9
+ 994010p -0.3
+ 996000p -0.3
+ 996010p 0.9
+ 998000p 0.9
+ 998010p -0.3
+ 1000000p -0.3
+ 1000010p 0.9
+ 1002000p 0.9
+ 1002010p -0.3
+ 1004000p -0.3
+ 1004010p 0.9
+ 1006000p 0.9
+ 1006010p -0.3
+ 1008000p -0.3
+ 1008010p 0.9
+ 1010000p 0.9
+ 1010010p -0.3
+ 1012000p -0.3
+ 1012010p 0.9
+ 1014000p 0.9
+ 1014010p -0.3
+ 1016000p -0.3
+ 1016010p 0.9
+ 1018000p 0.9
+ 1018010p -0.3
+ 1020000p -0.3
+ 1020010p 0.9
+ 1022000p 0.9
+ 1022010p -0.3
+ 1024000p -0.3
+ 1024010p 0.9
+ 1026000p 0.9
+ 1026010p -0.3
+ 1028000p -0.3
+ 1028010p 0.9
+ 1030000p 0.9
+ 1030010p -0.3
+ 1032000p -0.3
+ 1032010p 0.9
+ 1034000p 0.9
+ 1034010p -0.3
+ 1036000p -0.3
+ 1036010p 0.9
+ 1038000p 0.9
+ 1038010p -0.3
+ 1040000p -0.3
+ 1040010p 0.9
+ 1042000p 0.9
+ 1042010p -0.3
+ 1044000p -0.3
+ 1044010p 0.9
+ 1046000p 0.9
+ 1046010p -0.3
+ 1048000p -0.3
+ 1048010p 0.9
+ 1050000p 0.9
+ 1050010p -0.3
+ 1052000p -0.3
+ 1052010p 0.9
+ 1054000p 0.9
+ 1054010p -0.3
+ 1056000p -0.3
+ 1056010p 0.9
+ 1058000p 0.9
+ 1058010p -0.3
+ 1060000p -0.3
+ 1060010p 0.9
+ 1062000p 0.9
+ 1062010p -0.3
+ 1064000p -0.3
+ 1064010p 0.9
+ 1066000p 0.9
+ 1066010p -0.3
+ 1068000p -0.3
+ 1068010p 0.9
+ 1070000p 0.9
+ 1070010p -0.3
+ 1072000p -0.3
+ 1072010p 0.9
+ 1074000p 0.9
+ 1074010p -0.3
+ 1076000p -0.3
+ 1076010p 0.9
+ 1078000p 0.9
+ 1078010p -0.3
+ 1080000p -0.3
+ 1080010p 0.9
+ 1082000p 0.9
+ 1082010p -0.3
+ 1084000p -0.3
+ 1084010p 0.9
+ 1086000p 0.9
+ 1086010p -0.3
+ 1088000p -0.3
+ 1088010p 0.9
+ 1090000p 0.9
+ 1090010p -0.3
+ 1092000p -0.3
+ 1092010p 0.9
+ 1094000p 0.9
+ 1094010p -0.3
+ 1096000p -0.3
+ 1096010p 0.9
+ 1098000p 0.9
+ 1098010p -0.3
+ 1100000p -0.3
+ 1100010p 0.9
+ 1102000p 0.9
+ 1102010p -0.3
+ 1104000p -0.3
+ 1104010p 0.9
+ 1106000p 0.9
+ 1106010p -0.3
+ 1108000p -0.3
+ 1108010p 0.9
+ 1110000p 0.9
+ 1110010p -0.3
+ 1112000p -0.3
+ 1112010p 0.9
+ 1114000p 0.9
+ 1114010p -0.3
+ 1116000p -0.3
+ 1116010p 0.9
+ 1118000p 0.9
+ 1118010p -0.3
+ 1120000p -0.3
+ 1120010p 0.9
+ 1122000p 0.9
+ 1122010p -0.3
+ 1124000p -0.3
+ 1124010p 0.9
+ 1126000p 0.9
+ 1126010p -0.3
+ 1128000p -0.3
+ 1128010p 0.9
+ 1130000p 0.9
+ 1130010p -0.3
+ 1132000p -0.3
+ 1132010p 0.9
+ 1134000p 0.9
+ 1134010p -0.3
+ 1136000p -0.3
+ 1136010p 0.9
+ 1138000p 0.9
+ 1138010p -0.3
+ 1140000p -0.3
+ 1140010p 0.9
+ 1142000p 0.9
+ 1142010p -0.3
+ 1144000p -0.3
+ 1144010p 0.9
+ 1146000p 0.9
+ 1146010p -0.3
+ 1148000p -0.3
+ 1148010p 0.9
+ 1150000p 0.9
+ 1150010p -0.3
+ 1152000p -0.3
+ 1152010p 0.9
+ 1154000p 0.9
+ 1154010p -0.3
+ 1156000p -0.3
+ 1156010p 0.9
+ 1158000p 0.9
+ 1158010p -0.3
+ 1160000p -0.3
+ 1160010p 0.9
+ 1162000p 0.9
+ 1162010p -0.3
+ 1164000p -0.3
+ 1164010p 0.9
+ 1166000p 0.9
+ 1166010p -0.3
+ 1168000p -0.3
+ 1168010p 0.9
+ 1170000p 0.9
+ 1170010p -0.3
+ 1172000p -0.3
+ 1172010p 0.9
+ 1174000p 0.9
+ 1174010p -0.3
+ 1176000p -0.3
+ 1176010p 0.9
+ 1178000p 0.9
+ 1178010p -0.3
+ 1180000p -0.3
+ 1180010p 0.9
+ 1182000p 0.9
+ 1182010p -0.3
+ 1184000p -0.3
+ 1184010p 0.9
+ 1186000p 0.9
+ 1186010p -0.3
+ 1188000p -0.3
+ 1188010p 0.9
+ 1190000p 0.9
+ 1190010p -0.3
+ 1192000p -0.3
+ 1192010p 0.9
+ 1194000p 0.9
+ 1194010p -0.3
+ 1196000p -0.3
+ 1196010p 0.9
+ 1198000p 0.9
+ 1198010p -0.3
+ 1200000p -0.3
+ 1200010p 0.9
+ 1202000p 0.9
+ 1202010p -0.3
+ 1204000p -0.3
+ 1204010p 0.9
+ 1206000p 0.9
+ 1206010p -0.3
+ 1208000p -0.3
+ 1208010p 0.9
+ 1210000p 0.9
+ 1210010p -0.3
+ 1212000p -0.3
+ 1212010p 0.9
+ 1214000p 0.9
+ 1214010p -0.3
+ 1216000p -0.3
+ 1216010p 0.9
+ 1218000p 0.9
+ 1218010p -0.3
+ 1220000p -0.3
+ 1220010p 0.9
+ 1222000p 0.9
+ 1222010p -0.3
+ 1224000p -0.3
+ 1224010p 0.9
+ 1226000p 0.9
+ 1226010p -0.3
+ 1228000p -0.3
+ 1228010p 0.9
+ 1230000p 0.9
+ 1230010p -0.3
+ 1232000p -0.3
+ 1232010p 0.9
+ 1234000p 0.9
+ 1234010p -0.3
+ 1236000p -0.3
+ 1236010p 0.9
+ 1238000p 0.9
+ 1238010p -0.3
+ 1240000p -0.3
+ 1240010p 0.9
+ 1242000p 0.9
+ 1242010p -0.3
+ 1244000p -0.3
+ 1244010p 0.9
+ 1246000p 0.9
+ 1246010p -0.3
+ 1248000p -0.3
+ 1248010p 0.9
+ 1250000p 0.9
+ 1250010p -0.3
+ 1252000p -0.3
+ 1252010p 0.9
+ 1254000p 0.9
+ 1254010p -0.3
+ 1256000p -0.3
+ 1256010p 0.9
+ 1258000p 0.9
+ 1258010p -0.3
+ 1260000p -0.3
+ 1260010p 0.9
+ 1262000p 0.9
+ 1262010p -0.3
+ 1264000p -0.3
+ 1264010p 0.9
+ 1266000p 0.9
+ 1266010p -0.3
+ 1268000p -0.3
+ 1268010p 0.9
+ 1270000p 0.9
+ 1270010p -0.3
+ 1272000p -0.3
+ 1272010p 0.9
+ 1274000p 0.9
+ 1274010p -0.3
+ 1276000p -0.3
+ 1276010p 0.9
+ 1278000p 0.9
+ 1278010p -0.3
+ 1280000p -0.3
+ 1280010p 0.9
+ 1282000p 0.9
+ 1282010p -0.3
+ 1284000p -0.3
+ 1284010p 0.9
+ 1286000p 0.9
+ 1286010p -0.3
+ 1288000p -0.3
+ 1288010p 0.9
+ 1290000p 0.9
+ 1290010p -0.3
+ 1292000p -0.3
+ 1292010p 0.9
+ 1294000p 0.9
+ 1294010p -0.3
+ 1296000p -0.3
+ 1296010p 0.9
+ 1298000p 0.9
+ 1298010p -0.3
+ 1300000p -0.3
+ 1300010p 0.9
+ 1302000p 0.9
+ 1302010p -0.3
+ 1304000p -0.3
+ 1304010p 0.9
+ 1306000p 0.9
+ 1306010p -0.3
+ 1308000p -0.3
+ 1308010p 0.9
+ 1310000p 0.9
+ 1310010p -0.3
+ 1312000p -0.3
+ 1312010p 0.9
+ 1314000p 0.9
+ 1314010p -0.3
+ 1316000p -0.3
+ 1316010p 0.9
+ 1318000p 0.9
+ 1318010p -0.3
+ 1320000p -0.3
+ 1320010p 0.9
+ 1322000p 0.9
+ 1322010p -0.3
+ 1324000p -0.3
+ 1324010p 0.9
+ 1326000p 0.9
+ 1326010p -0.3
+ 1328000p -0.3
+ 1328010p 0.9
+ 1330000p 0.9
+ 1330010p -0.3
+ 1332000p -0.3
+ 1332010p 0.9
+ 1334000p 0.9
+ 1334010p -0.3
+ 1336000p -0.3
+ 1336010p 0.9
+ 1338000p 0.9
+ 1338010p -0.3
+ 1340000p -0.3
+ 1340010p 0.9
+ 1342000p 0.9
+ 1342010p -0.3
+ 1344000p -0.3
+ 1344010p 0.9
+ 1346000p 0.9
+ 1346010p -0.3
+ 1348000p -0.3
+ 1348010p 0.9
+ 1350000p 0.9
+ 1350010p -0.3
+ 1352000p -0.3
+ 1352010p 0.9
+ 1354000p 0.9
+ 1354010p -0.3
+ 1356000p -0.3
+ 1356010p 0.9
+ 1358000p 0.9
+ 1358010p -0.3
+ 1360000p -0.3
+ 1360010p 0.9
+ 1362000p 0.9
+ 1362010p -0.3
+ 1364000p -0.3
+ 1364010p 0.9
+ 1366000p 0.9
+ 1366010p -0.3
+ 1368000p -0.3
+ 1368010p 0.9
+ 1370000p 0.9
+ 1370010p -0.3
+ 1372000p -0.3
+ 1372010p 0.9
+ 1374000p 0.9
+ 1374010p -0.3
+ 1376000p -0.3
+ 1376010p 0.9
+ 1378000p 0.9
+ 1378010p -0.3
+ 1380000p -0.3
+ 1380010p 0.9
+ 1382000p 0.9
+ 1382010p -0.3
+ 1384000p -0.3
+ 1384010p 0.9
+ 1386000p 0.9
+ 1386010p -0.3
+ 1388000p -0.3
+ 1388010p 0.9
+ 1390000p 0.9
+ 1390010p -0.3
+ 1392000p -0.3
+ 1392010p 0.9
+ 1394000p 0.9
+ 1394010p -0.3
+ 1396000p -0.3
+ 1396010p 0.9
+ 1398000p 0.9
+ 1398010p -0.3
+ 1400000p -0.3
+ 1400010p 0.9
+ 1402000p 0.9
+ 1402010p -0.3
+ 1404000p -0.3
+ 1404010p 0.9
+ 1406000p 0.9
+ 1406010p -0.3
+ 1408000p -0.3
+ 1408010p 0.9
+ 1410000p 0.9
+ 1410010p -0.3
+ 1412000p -0.3
+ 1412010p 0.9
+ 1414000p 0.9
+ 1414010p -0.3
+ 1416000p -0.3
+ 1416010p 0.9
+ 1418000p 0.9
+ 1418010p -0.3
+ 1420000p -0.3
+ 1420010p 0.9
+ 1422000p 0.9
+ 1422010p -0.3
+ 1424000p -0.3
+ 1424010p 0.9
+ 1426000p 0.9
+ 1426010p -0.3
+ 1428000p -0.3
+ 1428010p 0.9
+ 1430000p 0.9
+ 1430010p -0.3
+ 1432000p -0.3
+ 1432010p 0.9
+ 1434000p 0.9
+ 1434010p -0.3
+ 1436000p -0.3
+ 1436010p 0.9
+ 1438000p 0.9
+ 1438010p -0.3
+ 1440000p -0.3
+ 1440010p 0.9
+ 1442000p 0.9
+ 1442010p -0.3
+ 1444000p -0.3
+ 1444010p 0.9
+ 1446000p 0.9
+ 1446010p -0.3
+ 1448000p -0.3
+ 1448010p 0.9
+ 1450000p 0.9
+ 1450010p -0.3
+ 1452000p -0.3
+ 1452010p 0.9
+ 1454000p 0.9
+ 1454010p -0.3
+ 1456000p -0.3
+ 1456010p 0.9
+ 1458000p 0.9
+ 1458010p -0.3
+ 1460000p -0.3
+ 1460010p 0.9
+ 1462000p 0.9
+ 1462010p -0.3
+ 1464000p -0.3
+ 1464010p 0.9
+ 1466000p 0.9
+ 1466010p -0.3
+ 1468000p -0.3
+ 1468010p 0.9
+ 1470000p 0.9
+ 1470010p -0.3
+ 1472000p -0.3
+ 1472010p 0.9
+ 1474000p 0.9
+ 1474010p -0.3
+ 1476000p -0.3
+ 1476010p 0.9
+ 1478000p 0.9
+ 1478010p -0.3
+ 1480000p -0.3
+ 1480010p 0.9
+ 1482000p 0.9
+ 1482010p -0.3
+ 1484000p -0.3
+ 1484010p 0.9
+ 1486000p 0.9
+ 1486010p -0.3
+ 1488000p -0.3
+ 1488010p 0.9
+ 1490000p 0.9
+ 1490010p -0.3
+ 1492000p -0.3
+ 1492010p 0.9
+ 1494000p 0.9
+ 1494010p -0.3
+ 1496000p -0.3
+ 1496010p 0.9
+ 1498000p 0.9
+ 1498010p -0.3
+ 1500000p -0.3
+ 1500010p 0.9
+ 1502000p 0.9
+ 1502010p -0.3
+ 1504000p -0.3
+ 1504010p 0.9
+ 1506000p 0.9
+ 1506010p -0.3
+ 1508000p -0.3
+ 1508010p 0.9
+ 1510000p 0.9
+ 1510010p -0.3
+ 1512000p -0.3
+ 1512010p 0.9
+ 1514000p 0.9
+ 1514010p -0.3
+ 1516000p -0.3
+ 1516010p 0.9
+ 1518000p 0.9
+ 1518010p -0.3
+ 1520000p -0.3
+ 1520010p 0.9
+ 1522000p 0.9
+ 1522010p -0.3
+ 1524000p -0.3
+ 1524010p 0.9
+ 1526000p 0.9
+ 1526010p -0.3
+ 1528000p -0.3
+ 1528010p 0.9
+ 1530000p 0.9
+ 1530010p -0.3
+ 1532000p -0.3
+ 1532010p 0.9
+ 1534000p 0.9
+ 1534010p -0.3
+ 1536000p -0.3
+ 1536010p 0.9
+ 1538000p 0.9
+ 1538010p -0.3
+ 1540000p -0.3
+ 1540010p 0.9
+ 1542000p 0.9
+ 1542010p -0.3
+ 1544000p -0.3
+ 1544010p 0.9
+ 1546000p 0.9
+ 1546010p -0.3
+ 1548000p -0.3
+ 1548010p 0.9
+ 1550000p 0.9
+ 1550010p -0.3
+ 1552000p -0.3
+ 1552010p 0.9
+ 1554000p 0.9
+ 1554010p -0.3
+ 1556000p -0.3
+ 1556010p 0.9
+ 1558000p 0.9
+ 1558010p -0.3
+ 1560000p -0.3
+ 1560010p 0.9
+ 1562000p 0.9
+ 1562010p -0.3
+ 1564000p -0.3
+ 1564010p 0.9
+ 1566000p 0.9
+ 1566010p -0.3
+ 1568000p -0.3
+ 1568010p 0.9
+ 1570000p 0.9
+ 1570010p -0.3
+ 1572000p -0.3
+ 1572010p 0.9
+ 1574000p 0.9
+ 1574010p -0.3
+ 1576000p -0.3
+ 1576010p 0.9
+ 1578000p 0.9
+ 1578010p -0.3
+ 1580000p -0.3
+ 1580010p 0.9
+ 1582000p 0.9
+ 1582010p -0.3
+ 1584000p -0.3
+ 1584010p 0.9
+ 1586000p 0.9
+ 1586010p -0.3
+ 1588000p -0.3
+ 1588010p 0.9
+ 1590000p 0.9
+ 1590010p -0.3
+ 1592000p -0.3
+ 1592010p 0.9
+ 1594000p 0.9
+ 1594010p -0.3
+ 1596000p -0.3
+ 1596010p 0.9
+ 1598000p 0.9
+ 1598010p -0.3
+ 1600000p -0.3
+ 1600010p 0.9
+ 1602000p 0.9
+ 1602010p -0.3
+ 1604000p -0.3
+ 1604010p 0.9
+ 1606000p 0.9
+ 1606010p -0.3
+ 1608000p -0.3
+ 1608010p 0.9
+ 1610000p 0.9
+ 1610010p -0.3
+ 1612000p -0.3
+ 1612010p 0.9
+ 1614000p 0.9
+ 1614010p -0.3
+ 1616000p -0.3
+ 1616010p 0.9
+ 1618000p 0.9
+ 1618010p -0.3
+ 1620000p -0.3
+ 1620010p 0.9
+ 1622000p 0.9
+ 1622010p -0.3
+ 1624000p -0.3
+ 1624010p 0.9
+ 1626000p 0.9
+ 1626010p -0.3
+ 1628000p -0.3
+ 1628010p 0.9
+ 1630000p 0.9
+ 1630010p -0.3
+ 1632000p -0.3
+ 1632010p 0.9
+ 1634000p 0.9
+ 1634010p -0.3
+ 1636000p -0.3
+ 1636010p 0.9
+ 1638000p 0.9
+ 1638010p -0.3
+ 1640000p -0.3
+ 1640010p 0.9
+ 1642000p 0.9
+ 1642010p -0.3
+ 1644000p -0.3
+ 1644010p 0.9
+ 1646000p 0.9
+ 1646010p -0.3
+ 1648000p -0.3
+ 1648010p 0.9
+ 1650000p 0.9
+ 1650010p -0.3
+ 1652000p -0.3
+ 1652010p 0.9
+ 1654000p 0.9
+ 1654010p -0.3
+ 1656000p -0.3
+ 1656010p 0.9
+ 1658000p 0.9
+ 1658010p -0.3
+ 1660000p -0.3
+ 1660010p 0.9
+ 1662000p 0.9
+ 1662010p -0.3
+ 1664000p -0.3
+ 1664010p 0.9
+ 1666000p 0.9
+ 1666010p -0.3
+ 1668000p -0.3
+ 1668010p 0.9
+ 1670000p 0.9
+ 1670010p -0.3
+ 1672000p -0.3
+ 1672010p 0.9
+ 1674000p 0.9
+ 1674010p -0.3
+ 1676000p -0.3
+ 1676010p 0.9
+ 1678000p 0.9
+ 1678010p -0.3
+ 1680000p -0.3
+ 1680010p 0.9
+ 1682000p 0.9
+ 1682010p -0.3
+ 1684000p -0.3
+ 1684010p 0.9
+ 1686000p 0.9
+ 1686010p -0.3
+ 1688000p -0.3
+ 1688010p 0.9
+ 1690000p 0.9
+ 1690010p -0.3
+ 1692000p -0.3
+ 1692010p 0.9
+ 1694000p 0.9
+ 1694010p -0.3
+ 1696000p -0.3
+ 1696010p 0.9
+ 1698000p 0.9
+ 1698010p -0.3
+ 1700000p -0.3
+ 1700010p 0.9
+ 1702000p 0.9
+ 1702010p -0.3
+ 1704000p -0.3
+ 1704010p 0.9
+ 1706000p 0.9
+ 1706010p -0.3
+ 1708000p -0.3
+ 1708010p 0.9
+ 1710000p 0.9
+ 1710010p -0.3
+ 1712000p -0.3
+ 1712010p 0.9
+ 1714000p 0.9
+ 1714010p -0.3
+ 1716000p -0.3
+ 1716010p 0.9
+ 1718000p 0.9
+ 1718010p -0.3
+ 1720000p -0.3
+ 1720010p 0.9
+ 1722000p 0.9
+ 1722010p -0.3
+ 1724000p -0.3
+ 1724010p 0.9
+ 1726000p 0.9
+ 1726010p -0.3
+ 1728000p -0.3
+ 1728010p 0.9
+ 1730000p 0.9
+ 1730010p -0.3
+ 1732000p -0.3
+ 1732010p 0.9
+ 1734000p 0.9
+ 1734010p -0.3
+ 1736000p -0.3
+ 1736010p 0.9
+ 1738000p 0.9
+ 1738010p -0.3
+ 1740000p -0.3
+ 1740010p 0.9
+ 1742000p 0.9
+ 1742010p -0.3
+ 1744000p -0.3
+ 1744010p 0.9
+ 1746000p 0.9
+ 1746010p -0.3
+ 1748000p -0.3
+ 1748010p 0.9
+ 1750000p 0.9
+ 1750010p -0.3
+ 1752000p -0.3
+ 1752010p 0.9
+ 1754000p 0.9
+ 1754010p -0.3
+ 1756000p -0.3
+ 1756010p 0.9
+ 1758000p 0.9
+ 1758010p -0.3
+ 1760000p -0.3
+ 1760010p 0.9
+ 1762000p 0.9
+ 1762010p -0.3
+ 1764000p -0.3
+ 1764010p 0.9
+ 1766000p 0.9
+ 1766010p -0.3
+ 1768000p -0.3
+ 1768010p 0.9
+ 1770000p 0.9
+ 1770010p -0.3
+ 1772000p -0.3
+ 1772010p 0.9
+ 1774000p 0.9
+ 1774010p -0.3
+ 1776000p -0.3
+ 1776010p 0.9
+ 1778000p 0.9
+ 1778010p -0.3
+ 1780000p -0.3
+ 1780010p 0.9
+ 1782000p 0.9
+ 1782010p -0.3
+ 1784000p -0.3
+ 1784010p 0.9
+ 1786000p 0.9
+ 1786010p -0.3
+ 1788000p -0.3
+ 1788010p 0.9
+ 1790000p 0.9
+ 1790010p -0.3
+ 1792000p -0.3
+ 1792010p 0.9
+ 1794000p 0.9
+ 1794010p -0.3
+ 1796000p -0.3
+ 1796010p 0.9
+ 1798000p 0.9
+ 1798010p -0.3
+ 1800000p -0.3
+ 1800010p 0.9
+ 1802000p 0.9
+ 1802010p -0.3
+ 1804000p -0.3
+ 1804010p 0.9
+ 1806000p 0.9
+ 1806010p -0.3
+ 1808000p -0.3
+ 1808010p 0.9
+ 1810000p 0.9
+ 1810010p -0.3
+ 1812000p -0.3
+ 1812010p 0.9
+ 1814000p 0.9
+ 1814010p -0.3
+ 1816000p -0.3
+ 1816010p 0.9
+ 1818000p 0.9
+ 1818010p -0.3
+ 1820000p -0.3
+ 1820010p 0.9
+ 1822000p 0.9
+ 1822010p -0.3
+ 1824000p -0.3
+ 1824010p 0.9
+ 1826000p 0.9
+ 1826010p -0.3
+ 1828000p -0.3
+ 1828010p 0.9
+ 1830000p 0.9
+ 1830010p -0.3
+ 1832000p -0.3
+ 1832010p 0.9
+ 1834000p 0.9
+ 1834010p -0.3
+ 1836000p -0.3
+ 1836010p 0.9
+ 1838000p 0.9
+ 1838010p -0.3
+ 1840000p -0.3
+ 1840010p 0.9
+ 1842000p 0.9
+ 1842010p -0.3
+ 1844000p -0.3
+ 1844010p 0.9
+ 1846000p 0.9
+ 1846010p -0.3
+ 1848000p -0.3
+ 1848010p 0.9
+ 1850000p 0.9
+ 1850010p -0.3
+ 1852000p -0.3
+ 1852010p 0.9
+ 1854000p 0.9
+ 1854010p -0.3
+ 1856000p -0.3
+ 1856010p 0.9
+ 1858000p 0.9
+ 1858010p -0.3
+ 1860000p -0.3
+ 1860010p 0.9
+ 1862000p 0.9
+ 1862010p -0.3
+ 1864000p -0.3
+ 1864010p 0.9
+ 1866000p 0.9
+ 1866010p -0.3
+ 1868000p -0.3
+ 1868010p 0.9
+ 1870000p 0.9
+ 1870010p -0.3
+ 1872000p -0.3
+ 1872010p 0.9
+ 1874000p 0.9
+ 1874010p -0.3
+ 1876000p -0.3
+ 1876010p 0.9
+ 1878000p 0.9
+ 1878010p -0.3
+ 1880000p -0.3
+ 1880010p 0.9
+ 1882000p 0.9
+ 1882010p -0.3
+ 1884000p -0.3
+ 1884010p 0.9
+ 1886000p 0.9
+ 1886010p -0.3
+ 1888000p -0.3
+ 1888010p 0.9
+ 1890000p 0.9
+ 1890010p -0.3
+ 1892000p -0.3
+ 1892010p 0.9
+ 1894000p 0.9
+ 1894010p -0.3
+ 1896000p -0.3
+ 1896010p 0.9
+ 1898000p 0.9
+ 1898010p -0.3
+ 1900000p -0.3
+ 1900010p 0.9
+ 1902000p 0.9
+ 1902010p -0.3
+ 1904000p -0.3
+ 1904010p 0.9
+ 1906000p 0.9
+ 1906010p -0.3
+ 1908000p -0.3
+ 1908010p 0.9
+ 1910000p 0.9
+ 1910010p -0.3
+ 1912000p -0.3
+ 1912010p 0.9
+ 1914000p 0.9
+ 1914010p -0.3
+ 1916000p -0.3
+ 1916010p 0.9
+ 1918000p 0.9
+ 1918010p -0.3
+ 1920000p -0.3
+ 1920010p 0.9
+ 1922000p 0.9
+ 1922010p -0.3
+ 1924000p -0.3
+ 1924010p 0.9
+ 1926000p 0.9
+ 1926010p -0.3
+ 1928000p -0.3
+ 1928010p 0.9
+ 1930000p 0.9
+ 1930010p -0.3
+ 1932000p -0.3
+ 1932010p 0.9
+ 1934000p 0.9
+ 1934010p -0.3
+ 1936000p -0.3
+ 1936010p 0.9
+ 1938000p 0.9
+ 1938010p -0.3
+ 1940000p -0.3
+ 1940010p 0.9
+ 1942000p 0.9
+ 1942010p -0.3
+ 1944000p -0.3
+ 1944010p 0.9
+ 1946000p 0.9
+ 1946010p -0.3
+ 1948000p -0.3
+ 1948010p 0.9
+ 1950000p 0.9
+ 1950010p -0.3
+ 1952000p -0.3
+ 1952010p 0.9
+ 1954000p 0.9
+ 1954010p -0.3
+ 1956000p -0.3
+ 1956010p 0.9
+ 1958000p 0.9
+ 1958010p -0.3
+ 1960000p -0.3
+ 1960010p 0.9
+ 1962000p 0.9
+ 1962010p -0.3
+ 1964000p -0.3
+ 1964010p 0.9
+ 1966000p 0.9
+ 1966010p -0.3
+ 1968000p -0.3
+ 1968010p 0.9
+ 1970000p 0.9
+ 1970010p -0.3
+ 1972000p -0.3
+ 1972010p 0.9
+ 1974000p 0.9
+ 1974010p -0.3
+ 1976000p -0.3
+ 1976010p 0.9
+ 1978000p 0.9
+ 1978010p -0.3
+ 1980000p -0.3
+ 1980010p 0.9
+ 1982000p 0.9
+ 1982010p -0.3
+ 1984000p -0.3
+ 1984010p 0.9
+ 1986000p 0.9
+ 1986010p -0.3
+ 1988000p -0.3
+ 1988010p 0.9
+ 1990000p 0.9
+ 1990010p -0.3
+ 1992000p -0.3
+ 1992010p 0.9
+ 1994000p 0.9
+ 1994010p -0.3
+ 1996000p -0.3
+ 1996010p 0.9
+ 1998000p 0.9
+ 1998010p -0.3
+ 2000000p -0.3
+ 2000010p 0.9
+ 2002000p 0.9
+ 2002010p -0.3
+ 2004000p -0.3
+ 2004010p 0.9
+ 2006000p 0.9
+ 2006010p -0.3
+ 2008000p -0.3
+ 2008010p 0.9
+ 2010000p 0.9
+ 2010010p -0.3
+ 2012000p -0.3
+ 2012010p 0.9
+ 2014000p 0.9
+ 2014010p -0.3
+ 2016000p -0.3
+ 2016010p 0.9
+ 2018000p 0.9
+ 2018010p -0.3
+ 2020000p -0.3
+ 2020010p 0.9
+ 2022000p 0.9
+ 2022010p -0.3
+ 2024000p -0.3
+ 2024010p 0.9
+ 2026000p 0.9
+ 2026010p -0.3
+ 2028000p -0.3
+ 2028010p 0.9
+ 2030000p 0.9
+ 2030010p -0.3
+ 2032000p -0.3
+ 2032010p 0.9
+ 2034000p 0.9
+ 2034010p -0.3
+ 2036000p -0.3
+ 2036010p 0.9
+ 2038000p 0.9
+ 2038010p -0.3
+ 2040000p -0.3
+ 2040010p 0.9
+ 2042000p 0.9
+ 2042010p -0.3
+ 2044000p -0.3
+ 2044010p 0.9
+ 2046000p 0.9
+ 2046010p -0.3
+ 2048000p -0.3
+ 2048010p 0.9
+ \]
V_data_bar_30 (Data_bar\\<30\\> gnd!) vsource type=pwl wave=\[
+ 0    -0.3
+ 2000p -0.3
+ 2010p 0.9
+ 4000p 0.9
+ 4010p -0.3
+ 6000p -0.3
+ 6010p 0.9
+ 8000p 0.9
+ 8010p -0.3
+ 10000p -0.3
+ 10010p 0.9
+ 12000p 0.9
+ 12010p -0.3
+ 14000p -0.3
+ 14010p 0.9
+ 16000p 0.9
+ 16010p -0.3
+ 18000p -0.3
+ 18010p 0.9
+ 20000p 0.9
+ 20010p -0.3
+ 22000p -0.3
+ 22010p 0.9
+ 24000p 0.9
+ 24010p -0.3
+ 26000p -0.3
+ 26010p 0.9
+ 28000p 0.9
+ 28010p -0.3
+ 30000p -0.3
+ 30010p 0.9
+ 32000p 0.9
+ 32010p -0.3
+ 34000p -0.3
+ 34010p 0.9
+ 36000p 0.9
+ 36010p -0.3
+ 38000p -0.3
+ 38010p 0.9
+ 40000p 0.9
+ 40010p -0.3
+ 42000p -0.3
+ 42010p 0.9
+ 44000p 0.9
+ 44010p -0.3
+ 46000p -0.3
+ 46010p 0.9
+ 48000p 0.9
+ 48010p -0.3
+ 50000p -0.3
+ 50010p 0.9
+ 52000p 0.9
+ 52010p -0.3
+ 54000p -0.3
+ 54010p 0.9
+ 56000p 0.9
+ 56010p -0.3
+ 58000p -0.3
+ 58010p 0.9
+ 60000p 0.9
+ 60010p -0.3
+ 62000p -0.3
+ 62010p 0.9
+ 64000p 0.9
+ 64010p -0.3
+ 66000p -0.3
+ 66010p 0.9
+ 68000p 0.9
+ 68010p -0.3
+ 70000p -0.3
+ 70010p 0.9
+ 72000p 0.9
+ 72010p -0.3
+ 74000p -0.3
+ 74010p 0.9
+ 76000p 0.9
+ 76010p -0.3
+ 78000p -0.3
+ 78010p 0.9
+ 80000p 0.9
+ 80010p -0.3
+ 82000p -0.3
+ 82010p 0.9
+ 84000p 0.9
+ 84010p -0.3
+ 86000p -0.3
+ 86010p 0.9
+ 88000p 0.9
+ 88010p -0.3
+ 90000p -0.3
+ 90010p 0.9
+ 92000p 0.9
+ 92010p -0.3
+ 94000p -0.3
+ 94010p 0.9
+ 96000p 0.9
+ 96010p -0.3
+ 98000p -0.3
+ 98010p 0.9
+ 100000p 0.9
+ 100010p -0.3
+ 102000p -0.3
+ 102010p 0.9
+ 104000p 0.9
+ 104010p -0.3
+ 106000p -0.3
+ 106010p 0.9
+ 108000p 0.9
+ 108010p -0.3
+ 110000p -0.3
+ 110010p 0.9
+ 112000p 0.9
+ 112010p -0.3
+ 114000p -0.3
+ 114010p 0.9
+ 116000p 0.9
+ 116010p -0.3
+ 118000p -0.3
+ 118010p 0.9
+ 120000p 0.9
+ 120010p -0.3
+ 122000p -0.3
+ 122010p 0.9
+ 124000p 0.9
+ 124010p -0.3
+ 126000p -0.3
+ 126010p 0.9
+ 128000p 0.9
+ 128010p -0.3
+ 130000p -0.3
+ 130010p 0.9
+ 132000p 0.9
+ 132010p -0.3
+ 134000p -0.3
+ 134010p 0.9
+ 136000p 0.9
+ 136010p -0.3
+ 138000p -0.3
+ 138010p 0.9
+ 140000p 0.9
+ 140010p -0.3
+ 142000p -0.3
+ 142010p 0.9
+ 144000p 0.9
+ 144010p -0.3
+ 146000p -0.3
+ 146010p 0.9
+ 148000p 0.9
+ 148010p -0.3
+ 150000p -0.3
+ 150010p 0.9
+ 152000p 0.9
+ 152010p -0.3
+ 154000p -0.3
+ 154010p 0.9
+ 156000p 0.9
+ 156010p -0.3
+ 158000p -0.3
+ 158010p 0.9
+ 160000p 0.9
+ 160010p -0.3
+ 162000p -0.3
+ 162010p 0.9
+ 164000p 0.9
+ 164010p -0.3
+ 166000p -0.3
+ 166010p 0.9
+ 168000p 0.9
+ 168010p -0.3
+ 170000p -0.3
+ 170010p 0.9
+ 172000p 0.9
+ 172010p -0.3
+ 174000p -0.3
+ 174010p 0.9
+ 176000p 0.9
+ 176010p -0.3
+ 178000p -0.3
+ 178010p 0.9
+ 180000p 0.9
+ 180010p -0.3
+ 182000p -0.3
+ 182010p 0.9
+ 184000p 0.9
+ 184010p -0.3
+ 186000p -0.3
+ 186010p 0.9
+ 188000p 0.9
+ 188010p -0.3
+ 190000p -0.3
+ 190010p 0.9
+ 192000p 0.9
+ 192010p -0.3
+ 194000p -0.3
+ 194010p 0.9
+ 196000p 0.9
+ 196010p -0.3
+ 198000p -0.3
+ 198010p 0.9
+ 200000p 0.9
+ 200010p -0.3
+ 202000p -0.3
+ 202010p 0.9
+ 204000p 0.9
+ 204010p -0.3
+ 206000p -0.3
+ 206010p 0.9
+ 208000p 0.9
+ 208010p -0.3
+ 210000p -0.3
+ 210010p 0.9
+ 212000p 0.9
+ 212010p -0.3
+ 214000p -0.3
+ 214010p 0.9
+ 216000p 0.9
+ 216010p -0.3
+ 218000p -0.3
+ 218010p 0.9
+ 220000p 0.9
+ 220010p -0.3
+ 222000p -0.3
+ 222010p 0.9
+ 224000p 0.9
+ 224010p -0.3
+ 226000p -0.3
+ 226010p 0.9
+ 228000p 0.9
+ 228010p -0.3
+ 230000p -0.3
+ 230010p 0.9
+ 232000p 0.9
+ 232010p -0.3
+ 234000p -0.3
+ 234010p 0.9
+ 236000p 0.9
+ 236010p -0.3
+ 238000p -0.3
+ 238010p 0.9
+ 240000p 0.9
+ 240010p -0.3
+ 242000p -0.3
+ 242010p 0.9
+ 244000p 0.9
+ 244010p -0.3
+ 246000p -0.3
+ 246010p 0.9
+ 248000p 0.9
+ 248010p -0.3
+ 250000p -0.3
+ 250010p 0.9
+ 252000p 0.9
+ 252010p -0.3
+ 254000p -0.3
+ 254010p 0.9
+ 256000p 0.9
+ 256010p -0.3
+ 258000p -0.3
+ 258010p 0.9
+ 260000p 0.9
+ 260010p -0.3
+ 262000p -0.3
+ 262010p 0.9
+ 264000p 0.9
+ 264010p -0.3
+ 266000p -0.3
+ 266010p 0.9
+ 268000p 0.9
+ 268010p -0.3
+ 270000p -0.3
+ 270010p 0.9
+ 272000p 0.9
+ 272010p -0.3
+ 274000p -0.3
+ 274010p 0.9
+ 276000p 0.9
+ 276010p -0.3
+ 278000p -0.3
+ 278010p 0.9
+ 280000p 0.9
+ 280010p -0.3
+ 282000p -0.3
+ 282010p 0.9
+ 284000p 0.9
+ 284010p -0.3
+ 286000p -0.3
+ 286010p 0.9
+ 288000p 0.9
+ 288010p -0.3
+ 290000p -0.3
+ 290010p 0.9
+ 292000p 0.9
+ 292010p -0.3
+ 294000p -0.3
+ 294010p 0.9
+ 296000p 0.9
+ 296010p -0.3
+ 298000p -0.3
+ 298010p 0.9
+ 300000p 0.9
+ 300010p -0.3
+ 302000p -0.3
+ 302010p 0.9
+ 304000p 0.9
+ 304010p -0.3
+ 306000p -0.3
+ 306010p 0.9
+ 308000p 0.9
+ 308010p -0.3
+ 310000p -0.3
+ 310010p 0.9
+ 312000p 0.9
+ 312010p -0.3
+ 314000p -0.3
+ 314010p 0.9
+ 316000p 0.9
+ 316010p -0.3
+ 318000p -0.3
+ 318010p 0.9
+ 320000p 0.9
+ 320010p -0.3
+ 322000p -0.3
+ 322010p 0.9
+ 324000p 0.9
+ 324010p -0.3
+ 326000p -0.3
+ 326010p 0.9
+ 328000p 0.9
+ 328010p -0.3
+ 330000p -0.3
+ 330010p 0.9
+ 332000p 0.9
+ 332010p -0.3
+ 334000p -0.3
+ 334010p 0.9
+ 336000p 0.9
+ 336010p -0.3
+ 338000p -0.3
+ 338010p 0.9
+ 340000p 0.9
+ 340010p -0.3
+ 342000p -0.3
+ 342010p 0.9
+ 344000p 0.9
+ 344010p -0.3
+ 346000p -0.3
+ 346010p 0.9
+ 348000p 0.9
+ 348010p -0.3
+ 350000p -0.3
+ 350010p 0.9
+ 352000p 0.9
+ 352010p -0.3
+ 354000p -0.3
+ 354010p 0.9
+ 356000p 0.9
+ 356010p -0.3
+ 358000p -0.3
+ 358010p 0.9
+ 360000p 0.9
+ 360010p -0.3
+ 362000p -0.3
+ 362010p 0.9
+ 364000p 0.9
+ 364010p -0.3
+ 366000p -0.3
+ 366010p 0.9
+ 368000p 0.9
+ 368010p -0.3
+ 370000p -0.3
+ 370010p 0.9
+ 372000p 0.9
+ 372010p -0.3
+ 374000p -0.3
+ 374010p 0.9
+ 376000p 0.9
+ 376010p -0.3
+ 378000p -0.3
+ 378010p 0.9
+ 380000p 0.9
+ 380010p -0.3
+ 382000p -0.3
+ 382010p 0.9
+ 384000p 0.9
+ 384010p -0.3
+ 386000p -0.3
+ 386010p 0.9
+ 388000p 0.9
+ 388010p -0.3
+ 390000p -0.3
+ 390010p 0.9
+ 392000p 0.9
+ 392010p -0.3
+ 394000p -0.3
+ 394010p 0.9
+ 396000p 0.9
+ 396010p -0.3
+ 398000p -0.3
+ 398010p 0.9
+ 400000p 0.9
+ 400010p -0.3
+ 402000p -0.3
+ 402010p 0.9
+ 404000p 0.9
+ 404010p -0.3
+ 406000p -0.3
+ 406010p 0.9
+ 408000p 0.9
+ 408010p -0.3
+ 410000p -0.3
+ 410010p 0.9
+ 412000p 0.9
+ 412010p -0.3
+ 414000p -0.3
+ 414010p 0.9
+ 416000p 0.9
+ 416010p -0.3
+ 418000p -0.3
+ 418010p 0.9
+ 420000p 0.9
+ 420010p -0.3
+ 422000p -0.3
+ 422010p 0.9
+ 424000p 0.9
+ 424010p -0.3
+ 426000p -0.3
+ 426010p 0.9
+ 428000p 0.9
+ 428010p -0.3
+ 430000p -0.3
+ 430010p 0.9
+ 432000p 0.9
+ 432010p -0.3
+ 434000p -0.3
+ 434010p 0.9
+ 436000p 0.9
+ 436010p -0.3
+ 438000p -0.3
+ 438010p 0.9
+ 440000p 0.9
+ 440010p -0.3
+ 442000p -0.3
+ 442010p 0.9
+ 444000p 0.9
+ 444010p -0.3
+ 446000p -0.3
+ 446010p 0.9
+ 448000p 0.9
+ 448010p -0.3
+ 450000p -0.3
+ 450010p 0.9
+ 452000p 0.9
+ 452010p -0.3
+ 454000p -0.3
+ 454010p 0.9
+ 456000p 0.9
+ 456010p -0.3
+ 458000p -0.3
+ 458010p 0.9
+ 460000p 0.9
+ 460010p -0.3
+ 462000p -0.3
+ 462010p 0.9
+ 464000p 0.9
+ 464010p -0.3
+ 466000p -0.3
+ 466010p 0.9
+ 468000p 0.9
+ 468010p -0.3
+ 470000p -0.3
+ 470010p 0.9
+ 472000p 0.9
+ 472010p -0.3
+ 474000p -0.3
+ 474010p 0.9
+ 476000p 0.9
+ 476010p -0.3
+ 478000p -0.3
+ 478010p 0.9
+ 480000p 0.9
+ 480010p -0.3
+ 482000p -0.3
+ 482010p 0.9
+ 484000p 0.9
+ 484010p -0.3
+ 486000p -0.3
+ 486010p 0.9
+ 488000p 0.9
+ 488010p -0.3
+ 490000p -0.3
+ 490010p 0.9
+ 492000p 0.9
+ 492010p -0.3
+ 494000p -0.3
+ 494010p 0.9
+ 496000p 0.9
+ 496010p -0.3
+ 498000p -0.3
+ 498010p 0.9
+ 500000p 0.9
+ 500010p -0.3
+ 502000p -0.3
+ 502010p 0.9
+ 504000p 0.9
+ 504010p -0.3
+ 506000p -0.3
+ 506010p 0.9
+ 508000p 0.9
+ 508010p -0.3
+ 510000p -0.3
+ 510010p 0.9
+ 512000p 0.9
+ 512010p -0.3
+ 514000p -0.3
+ 514010p 0.9
+ 516000p 0.9
+ 516010p -0.3
+ 518000p -0.3
+ 518010p 0.9
+ 520000p 0.9
+ 520010p -0.3
+ 522000p -0.3
+ 522010p 0.9
+ 524000p 0.9
+ 524010p -0.3
+ 526000p -0.3
+ 526010p 0.9
+ 528000p 0.9
+ 528010p -0.3
+ 530000p -0.3
+ 530010p 0.9
+ 532000p 0.9
+ 532010p -0.3
+ 534000p -0.3
+ 534010p 0.9
+ 536000p 0.9
+ 536010p -0.3
+ 538000p -0.3
+ 538010p 0.9
+ 540000p 0.9
+ 540010p -0.3
+ 542000p -0.3
+ 542010p 0.9
+ 544000p 0.9
+ 544010p -0.3
+ 546000p -0.3
+ 546010p 0.9
+ 548000p 0.9
+ 548010p -0.3
+ 550000p -0.3
+ 550010p 0.9
+ 552000p 0.9
+ 552010p -0.3
+ 554000p -0.3
+ 554010p 0.9
+ 556000p 0.9
+ 556010p -0.3
+ 558000p -0.3
+ 558010p 0.9
+ 560000p 0.9
+ 560010p -0.3
+ 562000p -0.3
+ 562010p 0.9
+ 564000p 0.9
+ 564010p -0.3
+ 566000p -0.3
+ 566010p 0.9
+ 568000p 0.9
+ 568010p -0.3
+ 570000p -0.3
+ 570010p 0.9
+ 572000p 0.9
+ 572010p -0.3
+ 574000p -0.3
+ 574010p 0.9
+ 576000p 0.9
+ 576010p -0.3
+ 578000p -0.3
+ 578010p 0.9
+ 580000p 0.9
+ 580010p -0.3
+ 582000p -0.3
+ 582010p 0.9
+ 584000p 0.9
+ 584010p -0.3
+ 586000p -0.3
+ 586010p 0.9
+ 588000p 0.9
+ 588010p -0.3
+ 590000p -0.3
+ 590010p 0.9
+ 592000p 0.9
+ 592010p -0.3
+ 594000p -0.3
+ 594010p 0.9
+ 596000p 0.9
+ 596010p -0.3
+ 598000p -0.3
+ 598010p 0.9
+ 600000p 0.9
+ 600010p -0.3
+ 602000p -0.3
+ 602010p 0.9
+ 604000p 0.9
+ 604010p -0.3
+ 606000p -0.3
+ 606010p 0.9
+ 608000p 0.9
+ 608010p -0.3
+ 610000p -0.3
+ 610010p 0.9
+ 612000p 0.9
+ 612010p -0.3
+ 614000p -0.3
+ 614010p 0.9
+ 616000p 0.9
+ 616010p -0.3
+ 618000p -0.3
+ 618010p 0.9
+ 620000p 0.9
+ 620010p -0.3
+ 622000p -0.3
+ 622010p 0.9
+ 624000p 0.9
+ 624010p -0.3
+ 626000p -0.3
+ 626010p 0.9
+ 628000p 0.9
+ 628010p -0.3
+ 630000p -0.3
+ 630010p 0.9
+ 632000p 0.9
+ 632010p -0.3
+ 634000p -0.3
+ 634010p 0.9
+ 636000p 0.9
+ 636010p -0.3
+ 638000p -0.3
+ 638010p 0.9
+ 640000p 0.9
+ 640010p -0.3
+ 642000p -0.3
+ 642010p 0.9
+ 644000p 0.9
+ 644010p -0.3
+ 646000p -0.3
+ 646010p 0.9
+ 648000p 0.9
+ 648010p -0.3
+ 650000p -0.3
+ 650010p 0.9
+ 652000p 0.9
+ 652010p -0.3
+ 654000p -0.3
+ 654010p 0.9
+ 656000p 0.9
+ 656010p -0.3
+ 658000p -0.3
+ 658010p 0.9
+ 660000p 0.9
+ 660010p -0.3
+ 662000p -0.3
+ 662010p 0.9
+ 664000p 0.9
+ 664010p -0.3
+ 666000p -0.3
+ 666010p 0.9
+ 668000p 0.9
+ 668010p -0.3
+ 670000p -0.3
+ 670010p 0.9
+ 672000p 0.9
+ 672010p -0.3
+ 674000p -0.3
+ 674010p 0.9
+ 676000p 0.9
+ 676010p -0.3
+ 678000p -0.3
+ 678010p 0.9
+ 680000p 0.9
+ 680010p -0.3
+ 682000p -0.3
+ 682010p 0.9
+ 684000p 0.9
+ 684010p -0.3
+ 686000p -0.3
+ 686010p 0.9
+ 688000p 0.9
+ 688010p -0.3
+ 690000p -0.3
+ 690010p 0.9
+ 692000p 0.9
+ 692010p -0.3
+ 694000p -0.3
+ 694010p 0.9
+ 696000p 0.9
+ 696010p -0.3
+ 698000p -0.3
+ 698010p 0.9
+ 700000p 0.9
+ 700010p -0.3
+ 702000p -0.3
+ 702010p 0.9
+ 704000p 0.9
+ 704010p -0.3
+ 706000p -0.3
+ 706010p 0.9
+ 708000p 0.9
+ 708010p -0.3
+ 710000p -0.3
+ 710010p 0.9
+ 712000p 0.9
+ 712010p -0.3
+ 714000p -0.3
+ 714010p 0.9
+ 716000p 0.9
+ 716010p -0.3
+ 718000p -0.3
+ 718010p 0.9
+ 720000p 0.9
+ 720010p -0.3
+ 722000p -0.3
+ 722010p 0.9
+ 724000p 0.9
+ 724010p -0.3
+ 726000p -0.3
+ 726010p 0.9
+ 728000p 0.9
+ 728010p -0.3
+ 730000p -0.3
+ 730010p 0.9
+ 732000p 0.9
+ 732010p -0.3
+ 734000p -0.3
+ 734010p 0.9
+ 736000p 0.9
+ 736010p -0.3
+ 738000p -0.3
+ 738010p 0.9
+ 740000p 0.9
+ 740010p -0.3
+ 742000p -0.3
+ 742010p 0.9
+ 744000p 0.9
+ 744010p -0.3
+ 746000p -0.3
+ 746010p 0.9
+ 748000p 0.9
+ 748010p -0.3
+ 750000p -0.3
+ 750010p 0.9
+ 752000p 0.9
+ 752010p -0.3
+ 754000p -0.3
+ 754010p 0.9
+ 756000p 0.9
+ 756010p -0.3
+ 758000p -0.3
+ 758010p 0.9
+ 760000p 0.9
+ 760010p -0.3
+ 762000p -0.3
+ 762010p 0.9
+ 764000p 0.9
+ 764010p -0.3
+ 766000p -0.3
+ 766010p 0.9
+ 768000p 0.9
+ 768010p -0.3
+ 770000p -0.3
+ 770010p 0.9
+ 772000p 0.9
+ 772010p -0.3
+ 774000p -0.3
+ 774010p 0.9
+ 776000p 0.9
+ 776010p -0.3
+ 778000p -0.3
+ 778010p 0.9
+ 780000p 0.9
+ 780010p -0.3
+ 782000p -0.3
+ 782010p 0.9
+ 784000p 0.9
+ 784010p -0.3
+ 786000p -0.3
+ 786010p 0.9
+ 788000p 0.9
+ 788010p -0.3
+ 790000p -0.3
+ 790010p 0.9
+ 792000p 0.9
+ 792010p -0.3
+ 794000p -0.3
+ 794010p 0.9
+ 796000p 0.9
+ 796010p -0.3
+ 798000p -0.3
+ 798010p 0.9
+ 800000p 0.9
+ 800010p -0.3
+ 802000p -0.3
+ 802010p 0.9
+ 804000p 0.9
+ 804010p -0.3
+ 806000p -0.3
+ 806010p 0.9
+ 808000p 0.9
+ 808010p -0.3
+ 810000p -0.3
+ 810010p 0.9
+ 812000p 0.9
+ 812010p -0.3
+ 814000p -0.3
+ 814010p 0.9
+ 816000p 0.9
+ 816010p -0.3
+ 818000p -0.3
+ 818010p 0.9
+ 820000p 0.9
+ 820010p -0.3
+ 822000p -0.3
+ 822010p 0.9
+ 824000p 0.9
+ 824010p -0.3
+ 826000p -0.3
+ 826010p 0.9
+ 828000p 0.9
+ 828010p -0.3
+ 830000p -0.3
+ 830010p 0.9
+ 832000p 0.9
+ 832010p -0.3
+ 834000p -0.3
+ 834010p 0.9
+ 836000p 0.9
+ 836010p -0.3
+ 838000p -0.3
+ 838010p 0.9
+ 840000p 0.9
+ 840010p -0.3
+ 842000p -0.3
+ 842010p 0.9
+ 844000p 0.9
+ 844010p -0.3
+ 846000p -0.3
+ 846010p 0.9
+ 848000p 0.9
+ 848010p -0.3
+ 850000p -0.3
+ 850010p 0.9
+ 852000p 0.9
+ 852010p -0.3
+ 854000p -0.3
+ 854010p 0.9
+ 856000p 0.9
+ 856010p -0.3
+ 858000p -0.3
+ 858010p 0.9
+ 860000p 0.9
+ 860010p -0.3
+ 862000p -0.3
+ 862010p 0.9
+ 864000p 0.9
+ 864010p -0.3
+ 866000p -0.3
+ 866010p 0.9
+ 868000p 0.9
+ 868010p -0.3
+ 870000p -0.3
+ 870010p 0.9
+ 872000p 0.9
+ 872010p -0.3
+ 874000p -0.3
+ 874010p 0.9
+ 876000p 0.9
+ 876010p -0.3
+ 878000p -0.3
+ 878010p 0.9
+ 880000p 0.9
+ 880010p -0.3
+ 882000p -0.3
+ 882010p 0.9
+ 884000p 0.9
+ 884010p -0.3
+ 886000p -0.3
+ 886010p 0.9
+ 888000p 0.9
+ 888010p -0.3
+ 890000p -0.3
+ 890010p 0.9
+ 892000p 0.9
+ 892010p -0.3
+ 894000p -0.3
+ 894010p 0.9
+ 896000p 0.9
+ 896010p -0.3
+ 898000p -0.3
+ 898010p 0.9
+ 900000p 0.9
+ 900010p -0.3
+ 902000p -0.3
+ 902010p 0.9
+ 904000p 0.9
+ 904010p -0.3
+ 906000p -0.3
+ 906010p 0.9
+ 908000p 0.9
+ 908010p -0.3
+ 910000p -0.3
+ 910010p 0.9
+ 912000p 0.9
+ 912010p -0.3
+ 914000p -0.3
+ 914010p 0.9
+ 916000p 0.9
+ 916010p -0.3
+ 918000p -0.3
+ 918010p 0.9
+ 920000p 0.9
+ 920010p -0.3
+ 922000p -0.3
+ 922010p 0.9
+ 924000p 0.9
+ 924010p -0.3
+ 926000p -0.3
+ 926010p 0.9
+ 928000p 0.9
+ 928010p -0.3
+ 930000p -0.3
+ 930010p 0.9
+ 932000p 0.9
+ 932010p -0.3
+ 934000p -0.3
+ 934010p 0.9
+ 936000p 0.9
+ 936010p -0.3
+ 938000p -0.3
+ 938010p 0.9
+ 940000p 0.9
+ 940010p -0.3
+ 942000p -0.3
+ 942010p 0.9
+ 944000p 0.9
+ 944010p -0.3
+ 946000p -0.3
+ 946010p 0.9
+ 948000p 0.9
+ 948010p -0.3
+ 950000p -0.3
+ 950010p 0.9
+ 952000p 0.9
+ 952010p -0.3
+ 954000p -0.3
+ 954010p 0.9
+ 956000p 0.9
+ 956010p -0.3
+ 958000p -0.3
+ 958010p 0.9
+ 960000p 0.9
+ 960010p -0.3
+ 962000p -0.3
+ 962010p 0.9
+ 964000p 0.9
+ 964010p -0.3
+ 966000p -0.3
+ 966010p 0.9
+ 968000p 0.9
+ 968010p -0.3
+ 970000p -0.3
+ 970010p 0.9
+ 972000p 0.9
+ 972010p -0.3
+ 974000p -0.3
+ 974010p 0.9
+ 976000p 0.9
+ 976010p -0.3
+ 978000p -0.3
+ 978010p 0.9
+ 980000p 0.9
+ 980010p -0.3
+ 982000p -0.3
+ 982010p 0.9
+ 984000p 0.9
+ 984010p -0.3
+ 986000p -0.3
+ 986010p 0.9
+ 988000p 0.9
+ 988010p -0.3
+ 990000p -0.3
+ 990010p 0.9
+ 992000p 0.9
+ 992010p -0.3
+ 994000p -0.3
+ 994010p 0.9
+ 996000p 0.9
+ 996010p -0.3
+ 998000p -0.3
+ 998010p 0.9
+ 1000000p 0.9
+ 1000010p -0.3
+ 1002000p -0.3
+ 1002010p 0.9
+ 1004000p 0.9
+ 1004010p -0.3
+ 1006000p -0.3
+ 1006010p 0.9
+ 1008000p 0.9
+ 1008010p -0.3
+ 1010000p -0.3
+ 1010010p 0.9
+ 1012000p 0.9
+ 1012010p -0.3
+ 1014000p -0.3
+ 1014010p 0.9
+ 1016000p 0.9
+ 1016010p -0.3
+ 1018000p -0.3
+ 1018010p 0.9
+ 1020000p 0.9
+ 1020010p -0.3
+ 1022000p -0.3
+ 1022010p 0.9
+ 1024000p 0.9
+ 1024010p -0.3
+ 1026000p -0.3
+ 1026010p 0.9
+ 1028000p 0.9
+ 1028010p -0.3
+ 1030000p -0.3
+ 1030010p 0.9
+ 1032000p 0.9
+ 1032010p -0.3
+ 1034000p -0.3
+ 1034010p 0.9
+ 1036000p 0.9
+ 1036010p -0.3
+ 1038000p -0.3
+ 1038010p 0.9
+ 1040000p 0.9
+ 1040010p -0.3
+ 1042000p -0.3
+ 1042010p 0.9
+ 1044000p 0.9
+ 1044010p -0.3
+ 1046000p -0.3
+ 1046010p 0.9
+ 1048000p 0.9
+ 1048010p -0.3
+ 1050000p -0.3
+ 1050010p 0.9
+ 1052000p 0.9
+ 1052010p -0.3
+ 1054000p -0.3
+ 1054010p 0.9
+ 1056000p 0.9
+ 1056010p -0.3
+ 1058000p -0.3
+ 1058010p 0.9
+ 1060000p 0.9
+ 1060010p -0.3
+ 1062000p -0.3
+ 1062010p 0.9
+ 1064000p 0.9
+ 1064010p -0.3
+ 1066000p -0.3
+ 1066010p 0.9
+ 1068000p 0.9
+ 1068010p -0.3
+ 1070000p -0.3
+ 1070010p 0.9
+ 1072000p 0.9
+ 1072010p -0.3
+ 1074000p -0.3
+ 1074010p 0.9
+ 1076000p 0.9
+ 1076010p -0.3
+ 1078000p -0.3
+ 1078010p 0.9
+ 1080000p 0.9
+ 1080010p -0.3
+ 1082000p -0.3
+ 1082010p 0.9
+ 1084000p 0.9
+ 1084010p -0.3
+ 1086000p -0.3
+ 1086010p 0.9
+ 1088000p 0.9
+ 1088010p -0.3
+ 1090000p -0.3
+ 1090010p 0.9
+ 1092000p 0.9
+ 1092010p -0.3
+ 1094000p -0.3
+ 1094010p 0.9
+ 1096000p 0.9
+ 1096010p -0.3
+ 1098000p -0.3
+ 1098010p 0.9
+ 1100000p 0.9
+ 1100010p -0.3
+ 1102000p -0.3
+ 1102010p 0.9
+ 1104000p 0.9
+ 1104010p -0.3
+ 1106000p -0.3
+ 1106010p 0.9
+ 1108000p 0.9
+ 1108010p -0.3
+ 1110000p -0.3
+ 1110010p 0.9
+ 1112000p 0.9
+ 1112010p -0.3
+ 1114000p -0.3
+ 1114010p 0.9
+ 1116000p 0.9
+ 1116010p -0.3
+ 1118000p -0.3
+ 1118010p 0.9
+ 1120000p 0.9
+ 1120010p -0.3
+ 1122000p -0.3
+ 1122010p 0.9
+ 1124000p 0.9
+ 1124010p -0.3
+ 1126000p -0.3
+ 1126010p 0.9
+ 1128000p 0.9
+ 1128010p -0.3
+ 1130000p -0.3
+ 1130010p 0.9
+ 1132000p 0.9
+ 1132010p -0.3
+ 1134000p -0.3
+ 1134010p 0.9
+ 1136000p 0.9
+ 1136010p -0.3
+ 1138000p -0.3
+ 1138010p 0.9
+ 1140000p 0.9
+ 1140010p -0.3
+ 1142000p -0.3
+ 1142010p 0.9
+ 1144000p 0.9
+ 1144010p -0.3
+ 1146000p -0.3
+ 1146010p 0.9
+ 1148000p 0.9
+ 1148010p -0.3
+ 1150000p -0.3
+ 1150010p 0.9
+ 1152000p 0.9
+ 1152010p -0.3
+ 1154000p -0.3
+ 1154010p 0.9
+ 1156000p 0.9
+ 1156010p -0.3
+ 1158000p -0.3
+ 1158010p 0.9
+ 1160000p 0.9
+ 1160010p -0.3
+ 1162000p -0.3
+ 1162010p 0.9
+ 1164000p 0.9
+ 1164010p -0.3
+ 1166000p -0.3
+ 1166010p 0.9
+ 1168000p 0.9
+ 1168010p -0.3
+ 1170000p -0.3
+ 1170010p 0.9
+ 1172000p 0.9
+ 1172010p -0.3
+ 1174000p -0.3
+ 1174010p 0.9
+ 1176000p 0.9
+ 1176010p -0.3
+ 1178000p -0.3
+ 1178010p 0.9
+ 1180000p 0.9
+ 1180010p -0.3
+ 1182000p -0.3
+ 1182010p 0.9
+ 1184000p 0.9
+ 1184010p -0.3
+ 1186000p -0.3
+ 1186010p 0.9
+ 1188000p 0.9
+ 1188010p -0.3
+ 1190000p -0.3
+ 1190010p 0.9
+ 1192000p 0.9
+ 1192010p -0.3
+ 1194000p -0.3
+ 1194010p 0.9
+ 1196000p 0.9
+ 1196010p -0.3
+ 1198000p -0.3
+ 1198010p 0.9
+ 1200000p 0.9
+ 1200010p -0.3
+ 1202000p -0.3
+ 1202010p 0.9
+ 1204000p 0.9
+ 1204010p -0.3
+ 1206000p -0.3
+ 1206010p 0.9
+ 1208000p 0.9
+ 1208010p -0.3
+ 1210000p -0.3
+ 1210010p 0.9
+ 1212000p 0.9
+ 1212010p -0.3
+ 1214000p -0.3
+ 1214010p 0.9
+ 1216000p 0.9
+ 1216010p -0.3
+ 1218000p -0.3
+ 1218010p 0.9
+ 1220000p 0.9
+ 1220010p -0.3
+ 1222000p -0.3
+ 1222010p 0.9
+ 1224000p 0.9
+ 1224010p -0.3
+ 1226000p -0.3
+ 1226010p 0.9
+ 1228000p 0.9
+ 1228010p -0.3
+ 1230000p -0.3
+ 1230010p 0.9
+ 1232000p 0.9
+ 1232010p -0.3
+ 1234000p -0.3
+ 1234010p 0.9
+ 1236000p 0.9
+ 1236010p -0.3
+ 1238000p -0.3
+ 1238010p 0.9
+ 1240000p 0.9
+ 1240010p -0.3
+ 1242000p -0.3
+ 1242010p 0.9
+ 1244000p 0.9
+ 1244010p -0.3
+ 1246000p -0.3
+ 1246010p 0.9
+ 1248000p 0.9
+ 1248010p -0.3
+ 1250000p -0.3
+ 1250010p 0.9
+ 1252000p 0.9
+ 1252010p -0.3
+ 1254000p -0.3
+ 1254010p 0.9
+ 1256000p 0.9
+ 1256010p -0.3
+ 1258000p -0.3
+ 1258010p 0.9
+ 1260000p 0.9
+ 1260010p -0.3
+ 1262000p -0.3
+ 1262010p 0.9
+ 1264000p 0.9
+ 1264010p -0.3
+ 1266000p -0.3
+ 1266010p 0.9
+ 1268000p 0.9
+ 1268010p -0.3
+ 1270000p -0.3
+ 1270010p 0.9
+ 1272000p 0.9
+ 1272010p -0.3
+ 1274000p -0.3
+ 1274010p 0.9
+ 1276000p 0.9
+ 1276010p -0.3
+ 1278000p -0.3
+ 1278010p 0.9
+ 1280000p 0.9
+ 1280010p -0.3
+ 1282000p -0.3
+ 1282010p 0.9
+ 1284000p 0.9
+ 1284010p -0.3
+ 1286000p -0.3
+ 1286010p 0.9
+ 1288000p 0.9
+ 1288010p -0.3
+ 1290000p -0.3
+ 1290010p 0.9
+ 1292000p 0.9
+ 1292010p -0.3
+ 1294000p -0.3
+ 1294010p 0.9
+ 1296000p 0.9
+ 1296010p -0.3
+ 1298000p -0.3
+ 1298010p 0.9
+ 1300000p 0.9
+ 1300010p -0.3
+ 1302000p -0.3
+ 1302010p 0.9
+ 1304000p 0.9
+ 1304010p -0.3
+ 1306000p -0.3
+ 1306010p 0.9
+ 1308000p 0.9
+ 1308010p -0.3
+ 1310000p -0.3
+ 1310010p 0.9
+ 1312000p 0.9
+ 1312010p -0.3
+ 1314000p -0.3
+ 1314010p 0.9
+ 1316000p 0.9
+ 1316010p -0.3
+ 1318000p -0.3
+ 1318010p 0.9
+ 1320000p 0.9
+ 1320010p -0.3
+ 1322000p -0.3
+ 1322010p 0.9
+ 1324000p 0.9
+ 1324010p -0.3
+ 1326000p -0.3
+ 1326010p 0.9
+ 1328000p 0.9
+ 1328010p -0.3
+ 1330000p -0.3
+ 1330010p 0.9
+ 1332000p 0.9
+ 1332010p -0.3
+ 1334000p -0.3
+ 1334010p 0.9
+ 1336000p 0.9
+ 1336010p -0.3
+ 1338000p -0.3
+ 1338010p 0.9
+ 1340000p 0.9
+ 1340010p -0.3
+ 1342000p -0.3
+ 1342010p 0.9
+ 1344000p 0.9
+ 1344010p -0.3
+ 1346000p -0.3
+ 1346010p 0.9
+ 1348000p 0.9
+ 1348010p -0.3
+ 1350000p -0.3
+ 1350010p 0.9
+ 1352000p 0.9
+ 1352010p -0.3
+ 1354000p -0.3
+ 1354010p 0.9
+ 1356000p 0.9
+ 1356010p -0.3
+ 1358000p -0.3
+ 1358010p 0.9
+ 1360000p 0.9
+ 1360010p -0.3
+ 1362000p -0.3
+ 1362010p 0.9
+ 1364000p 0.9
+ 1364010p -0.3
+ 1366000p -0.3
+ 1366010p 0.9
+ 1368000p 0.9
+ 1368010p -0.3
+ 1370000p -0.3
+ 1370010p 0.9
+ 1372000p 0.9
+ 1372010p -0.3
+ 1374000p -0.3
+ 1374010p 0.9
+ 1376000p 0.9
+ 1376010p -0.3
+ 1378000p -0.3
+ 1378010p 0.9
+ 1380000p 0.9
+ 1380010p -0.3
+ 1382000p -0.3
+ 1382010p 0.9
+ 1384000p 0.9
+ 1384010p -0.3
+ 1386000p -0.3
+ 1386010p 0.9
+ 1388000p 0.9
+ 1388010p -0.3
+ 1390000p -0.3
+ 1390010p 0.9
+ 1392000p 0.9
+ 1392010p -0.3
+ 1394000p -0.3
+ 1394010p 0.9
+ 1396000p 0.9
+ 1396010p -0.3
+ 1398000p -0.3
+ 1398010p 0.9
+ 1400000p 0.9
+ 1400010p -0.3
+ 1402000p -0.3
+ 1402010p 0.9
+ 1404000p 0.9
+ 1404010p -0.3
+ 1406000p -0.3
+ 1406010p 0.9
+ 1408000p 0.9
+ 1408010p -0.3
+ 1410000p -0.3
+ 1410010p 0.9
+ 1412000p 0.9
+ 1412010p -0.3
+ 1414000p -0.3
+ 1414010p 0.9
+ 1416000p 0.9
+ 1416010p -0.3
+ 1418000p -0.3
+ 1418010p 0.9
+ 1420000p 0.9
+ 1420010p -0.3
+ 1422000p -0.3
+ 1422010p 0.9
+ 1424000p 0.9
+ 1424010p -0.3
+ 1426000p -0.3
+ 1426010p 0.9
+ 1428000p 0.9
+ 1428010p -0.3
+ 1430000p -0.3
+ 1430010p 0.9
+ 1432000p 0.9
+ 1432010p -0.3
+ 1434000p -0.3
+ 1434010p 0.9
+ 1436000p 0.9
+ 1436010p -0.3
+ 1438000p -0.3
+ 1438010p 0.9
+ 1440000p 0.9
+ 1440010p -0.3
+ 1442000p -0.3
+ 1442010p 0.9
+ 1444000p 0.9
+ 1444010p -0.3
+ 1446000p -0.3
+ 1446010p 0.9
+ 1448000p 0.9
+ 1448010p -0.3
+ 1450000p -0.3
+ 1450010p 0.9
+ 1452000p 0.9
+ 1452010p -0.3
+ 1454000p -0.3
+ 1454010p 0.9
+ 1456000p 0.9
+ 1456010p -0.3
+ 1458000p -0.3
+ 1458010p 0.9
+ 1460000p 0.9
+ 1460010p -0.3
+ 1462000p -0.3
+ 1462010p 0.9
+ 1464000p 0.9
+ 1464010p -0.3
+ 1466000p -0.3
+ 1466010p 0.9
+ 1468000p 0.9
+ 1468010p -0.3
+ 1470000p -0.3
+ 1470010p 0.9
+ 1472000p 0.9
+ 1472010p -0.3
+ 1474000p -0.3
+ 1474010p 0.9
+ 1476000p 0.9
+ 1476010p -0.3
+ 1478000p -0.3
+ 1478010p 0.9
+ 1480000p 0.9
+ 1480010p -0.3
+ 1482000p -0.3
+ 1482010p 0.9
+ 1484000p 0.9
+ 1484010p -0.3
+ 1486000p -0.3
+ 1486010p 0.9
+ 1488000p 0.9
+ 1488010p -0.3
+ 1490000p -0.3
+ 1490010p 0.9
+ 1492000p 0.9
+ 1492010p -0.3
+ 1494000p -0.3
+ 1494010p 0.9
+ 1496000p 0.9
+ 1496010p -0.3
+ 1498000p -0.3
+ 1498010p 0.9
+ 1500000p 0.9
+ 1500010p -0.3
+ 1502000p -0.3
+ 1502010p 0.9
+ 1504000p 0.9
+ 1504010p -0.3
+ 1506000p -0.3
+ 1506010p 0.9
+ 1508000p 0.9
+ 1508010p -0.3
+ 1510000p -0.3
+ 1510010p 0.9
+ 1512000p 0.9
+ 1512010p -0.3
+ 1514000p -0.3
+ 1514010p 0.9
+ 1516000p 0.9
+ 1516010p -0.3
+ 1518000p -0.3
+ 1518010p 0.9
+ 1520000p 0.9
+ 1520010p -0.3
+ 1522000p -0.3
+ 1522010p 0.9
+ 1524000p 0.9
+ 1524010p -0.3
+ 1526000p -0.3
+ 1526010p 0.9
+ 1528000p 0.9
+ 1528010p -0.3
+ 1530000p -0.3
+ 1530010p 0.9
+ 1532000p 0.9
+ 1532010p -0.3
+ 1534000p -0.3
+ 1534010p 0.9
+ 1536000p 0.9
+ 1536010p -0.3
+ 1538000p -0.3
+ 1538010p 0.9
+ 1540000p 0.9
+ 1540010p -0.3
+ 1542000p -0.3
+ 1542010p 0.9
+ 1544000p 0.9
+ 1544010p -0.3
+ 1546000p -0.3
+ 1546010p 0.9
+ 1548000p 0.9
+ 1548010p -0.3
+ 1550000p -0.3
+ 1550010p 0.9
+ 1552000p 0.9
+ 1552010p -0.3
+ 1554000p -0.3
+ 1554010p 0.9
+ 1556000p 0.9
+ 1556010p -0.3
+ 1558000p -0.3
+ 1558010p 0.9
+ 1560000p 0.9
+ 1560010p -0.3
+ 1562000p -0.3
+ 1562010p 0.9
+ 1564000p 0.9
+ 1564010p -0.3
+ 1566000p -0.3
+ 1566010p 0.9
+ 1568000p 0.9
+ 1568010p -0.3
+ 1570000p -0.3
+ 1570010p 0.9
+ 1572000p 0.9
+ 1572010p -0.3
+ 1574000p -0.3
+ 1574010p 0.9
+ 1576000p 0.9
+ 1576010p -0.3
+ 1578000p -0.3
+ 1578010p 0.9
+ 1580000p 0.9
+ 1580010p -0.3
+ 1582000p -0.3
+ 1582010p 0.9
+ 1584000p 0.9
+ 1584010p -0.3
+ 1586000p -0.3
+ 1586010p 0.9
+ 1588000p 0.9
+ 1588010p -0.3
+ 1590000p -0.3
+ 1590010p 0.9
+ 1592000p 0.9
+ 1592010p -0.3
+ 1594000p -0.3
+ 1594010p 0.9
+ 1596000p 0.9
+ 1596010p -0.3
+ 1598000p -0.3
+ 1598010p 0.9
+ 1600000p 0.9
+ 1600010p -0.3
+ 1602000p -0.3
+ 1602010p 0.9
+ 1604000p 0.9
+ 1604010p -0.3
+ 1606000p -0.3
+ 1606010p 0.9
+ 1608000p 0.9
+ 1608010p -0.3
+ 1610000p -0.3
+ 1610010p 0.9
+ 1612000p 0.9
+ 1612010p -0.3
+ 1614000p -0.3
+ 1614010p 0.9
+ 1616000p 0.9
+ 1616010p -0.3
+ 1618000p -0.3
+ 1618010p 0.9
+ 1620000p 0.9
+ 1620010p -0.3
+ 1622000p -0.3
+ 1622010p 0.9
+ 1624000p 0.9
+ 1624010p -0.3
+ 1626000p -0.3
+ 1626010p 0.9
+ 1628000p 0.9
+ 1628010p -0.3
+ 1630000p -0.3
+ 1630010p 0.9
+ 1632000p 0.9
+ 1632010p -0.3
+ 1634000p -0.3
+ 1634010p 0.9
+ 1636000p 0.9
+ 1636010p -0.3
+ 1638000p -0.3
+ 1638010p 0.9
+ 1640000p 0.9
+ 1640010p -0.3
+ 1642000p -0.3
+ 1642010p 0.9
+ 1644000p 0.9
+ 1644010p -0.3
+ 1646000p -0.3
+ 1646010p 0.9
+ 1648000p 0.9
+ 1648010p -0.3
+ 1650000p -0.3
+ 1650010p 0.9
+ 1652000p 0.9
+ 1652010p -0.3
+ 1654000p -0.3
+ 1654010p 0.9
+ 1656000p 0.9
+ 1656010p -0.3
+ 1658000p -0.3
+ 1658010p 0.9
+ 1660000p 0.9
+ 1660010p -0.3
+ 1662000p -0.3
+ 1662010p 0.9
+ 1664000p 0.9
+ 1664010p -0.3
+ 1666000p -0.3
+ 1666010p 0.9
+ 1668000p 0.9
+ 1668010p -0.3
+ 1670000p -0.3
+ 1670010p 0.9
+ 1672000p 0.9
+ 1672010p -0.3
+ 1674000p -0.3
+ 1674010p 0.9
+ 1676000p 0.9
+ 1676010p -0.3
+ 1678000p -0.3
+ 1678010p 0.9
+ 1680000p 0.9
+ 1680010p -0.3
+ 1682000p -0.3
+ 1682010p 0.9
+ 1684000p 0.9
+ 1684010p -0.3
+ 1686000p -0.3
+ 1686010p 0.9
+ 1688000p 0.9
+ 1688010p -0.3
+ 1690000p -0.3
+ 1690010p 0.9
+ 1692000p 0.9
+ 1692010p -0.3
+ 1694000p -0.3
+ 1694010p 0.9
+ 1696000p 0.9
+ 1696010p -0.3
+ 1698000p -0.3
+ 1698010p 0.9
+ 1700000p 0.9
+ 1700010p -0.3
+ 1702000p -0.3
+ 1702010p 0.9
+ 1704000p 0.9
+ 1704010p -0.3
+ 1706000p -0.3
+ 1706010p 0.9
+ 1708000p 0.9
+ 1708010p -0.3
+ 1710000p -0.3
+ 1710010p 0.9
+ 1712000p 0.9
+ 1712010p -0.3
+ 1714000p -0.3
+ 1714010p 0.9
+ 1716000p 0.9
+ 1716010p -0.3
+ 1718000p -0.3
+ 1718010p 0.9
+ 1720000p 0.9
+ 1720010p -0.3
+ 1722000p -0.3
+ 1722010p 0.9
+ 1724000p 0.9
+ 1724010p -0.3
+ 1726000p -0.3
+ 1726010p 0.9
+ 1728000p 0.9
+ 1728010p -0.3
+ 1730000p -0.3
+ 1730010p 0.9
+ 1732000p 0.9
+ 1732010p -0.3
+ 1734000p -0.3
+ 1734010p 0.9
+ 1736000p 0.9
+ 1736010p -0.3
+ 1738000p -0.3
+ 1738010p 0.9
+ 1740000p 0.9
+ 1740010p -0.3
+ 1742000p -0.3
+ 1742010p 0.9
+ 1744000p 0.9
+ 1744010p -0.3
+ 1746000p -0.3
+ 1746010p 0.9
+ 1748000p 0.9
+ 1748010p -0.3
+ 1750000p -0.3
+ 1750010p 0.9
+ 1752000p 0.9
+ 1752010p -0.3
+ 1754000p -0.3
+ 1754010p 0.9
+ 1756000p 0.9
+ 1756010p -0.3
+ 1758000p -0.3
+ 1758010p 0.9
+ 1760000p 0.9
+ 1760010p -0.3
+ 1762000p -0.3
+ 1762010p 0.9
+ 1764000p 0.9
+ 1764010p -0.3
+ 1766000p -0.3
+ 1766010p 0.9
+ 1768000p 0.9
+ 1768010p -0.3
+ 1770000p -0.3
+ 1770010p 0.9
+ 1772000p 0.9
+ 1772010p -0.3
+ 1774000p -0.3
+ 1774010p 0.9
+ 1776000p 0.9
+ 1776010p -0.3
+ 1778000p -0.3
+ 1778010p 0.9
+ 1780000p 0.9
+ 1780010p -0.3
+ 1782000p -0.3
+ 1782010p 0.9
+ 1784000p 0.9
+ 1784010p -0.3
+ 1786000p -0.3
+ 1786010p 0.9
+ 1788000p 0.9
+ 1788010p -0.3
+ 1790000p -0.3
+ 1790010p 0.9
+ 1792000p 0.9
+ 1792010p -0.3
+ 1794000p -0.3
+ 1794010p 0.9
+ 1796000p 0.9
+ 1796010p -0.3
+ 1798000p -0.3
+ 1798010p 0.9
+ 1800000p 0.9
+ 1800010p -0.3
+ 1802000p -0.3
+ 1802010p 0.9
+ 1804000p 0.9
+ 1804010p -0.3
+ 1806000p -0.3
+ 1806010p 0.9
+ 1808000p 0.9
+ 1808010p -0.3
+ 1810000p -0.3
+ 1810010p 0.9
+ 1812000p 0.9
+ 1812010p -0.3
+ 1814000p -0.3
+ 1814010p 0.9
+ 1816000p 0.9
+ 1816010p -0.3
+ 1818000p -0.3
+ 1818010p 0.9
+ 1820000p 0.9
+ 1820010p -0.3
+ 1822000p -0.3
+ 1822010p 0.9
+ 1824000p 0.9
+ 1824010p -0.3
+ 1826000p -0.3
+ 1826010p 0.9
+ 1828000p 0.9
+ 1828010p -0.3
+ 1830000p -0.3
+ 1830010p 0.9
+ 1832000p 0.9
+ 1832010p -0.3
+ 1834000p -0.3
+ 1834010p 0.9
+ 1836000p 0.9
+ 1836010p -0.3
+ 1838000p -0.3
+ 1838010p 0.9
+ 1840000p 0.9
+ 1840010p -0.3
+ 1842000p -0.3
+ 1842010p 0.9
+ 1844000p 0.9
+ 1844010p -0.3
+ 1846000p -0.3
+ 1846010p 0.9
+ 1848000p 0.9
+ 1848010p -0.3
+ 1850000p -0.3
+ 1850010p 0.9
+ 1852000p 0.9
+ 1852010p -0.3
+ 1854000p -0.3
+ 1854010p 0.9
+ 1856000p 0.9
+ 1856010p -0.3
+ 1858000p -0.3
+ 1858010p 0.9
+ 1860000p 0.9
+ 1860010p -0.3
+ 1862000p -0.3
+ 1862010p 0.9
+ 1864000p 0.9
+ 1864010p -0.3
+ 1866000p -0.3
+ 1866010p 0.9
+ 1868000p 0.9
+ 1868010p -0.3
+ 1870000p -0.3
+ 1870010p 0.9
+ 1872000p 0.9
+ 1872010p -0.3
+ 1874000p -0.3
+ 1874010p 0.9
+ 1876000p 0.9
+ 1876010p -0.3
+ 1878000p -0.3
+ 1878010p 0.9
+ 1880000p 0.9
+ 1880010p -0.3
+ 1882000p -0.3
+ 1882010p 0.9
+ 1884000p 0.9
+ 1884010p -0.3
+ 1886000p -0.3
+ 1886010p 0.9
+ 1888000p 0.9
+ 1888010p -0.3
+ 1890000p -0.3
+ 1890010p 0.9
+ 1892000p 0.9
+ 1892010p -0.3
+ 1894000p -0.3
+ 1894010p 0.9
+ 1896000p 0.9
+ 1896010p -0.3
+ 1898000p -0.3
+ 1898010p 0.9
+ 1900000p 0.9
+ 1900010p -0.3
+ 1902000p -0.3
+ 1902010p 0.9
+ 1904000p 0.9
+ 1904010p -0.3
+ 1906000p -0.3
+ 1906010p 0.9
+ 1908000p 0.9
+ 1908010p -0.3
+ 1910000p -0.3
+ 1910010p 0.9
+ 1912000p 0.9
+ 1912010p -0.3
+ 1914000p -0.3
+ 1914010p 0.9
+ 1916000p 0.9
+ 1916010p -0.3
+ 1918000p -0.3
+ 1918010p 0.9
+ 1920000p 0.9
+ 1920010p -0.3
+ 1922000p -0.3
+ 1922010p 0.9
+ 1924000p 0.9
+ 1924010p -0.3
+ 1926000p -0.3
+ 1926010p 0.9
+ 1928000p 0.9
+ 1928010p -0.3
+ 1930000p -0.3
+ 1930010p 0.9
+ 1932000p 0.9
+ 1932010p -0.3
+ 1934000p -0.3
+ 1934010p 0.9
+ 1936000p 0.9
+ 1936010p -0.3
+ 1938000p -0.3
+ 1938010p 0.9
+ 1940000p 0.9
+ 1940010p -0.3
+ 1942000p -0.3
+ 1942010p 0.9
+ 1944000p 0.9
+ 1944010p -0.3
+ 1946000p -0.3
+ 1946010p 0.9
+ 1948000p 0.9
+ 1948010p -0.3
+ 1950000p -0.3
+ 1950010p 0.9
+ 1952000p 0.9
+ 1952010p -0.3
+ 1954000p -0.3
+ 1954010p 0.9
+ 1956000p 0.9
+ 1956010p -0.3
+ 1958000p -0.3
+ 1958010p 0.9
+ 1960000p 0.9
+ 1960010p -0.3
+ 1962000p -0.3
+ 1962010p 0.9
+ 1964000p 0.9
+ 1964010p -0.3
+ 1966000p -0.3
+ 1966010p 0.9
+ 1968000p 0.9
+ 1968010p -0.3
+ 1970000p -0.3
+ 1970010p 0.9
+ 1972000p 0.9
+ 1972010p -0.3
+ 1974000p -0.3
+ 1974010p 0.9
+ 1976000p 0.9
+ 1976010p -0.3
+ 1978000p -0.3
+ 1978010p 0.9
+ 1980000p 0.9
+ 1980010p -0.3
+ 1982000p -0.3
+ 1982010p 0.9
+ 1984000p 0.9
+ 1984010p -0.3
+ 1986000p -0.3
+ 1986010p 0.9
+ 1988000p 0.9
+ 1988010p -0.3
+ 1990000p -0.3
+ 1990010p 0.9
+ 1992000p 0.9
+ 1992010p -0.3
+ 1994000p -0.3
+ 1994010p 0.9
+ 1996000p 0.9
+ 1996010p -0.3
+ 1998000p -0.3
+ 1998010p 0.9
+ 2000000p 0.9
+ 2000010p -0.3
+ 2002000p -0.3
+ 2002010p 0.9
+ 2004000p 0.9
+ 2004010p -0.3
+ 2006000p -0.3
+ 2006010p 0.9
+ 2008000p 0.9
+ 2008010p -0.3
+ 2010000p -0.3
+ 2010010p 0.9
+ 2012000p 0.9
+ 2012010p -0.3
+ 2014000p -0.3
+ 2014010p 0.9
+ 2016000p 0.9
+ 2016010p -0.3
+ 2018000p -0.3
+ 2018010p 0.9
+ 2020000p 0.9
+ 2020010p -0.3
+ 2022000p -0.3
+ 2022010p 0.9
+ 2024000p 0.9
+ 2024010p -0.3
+ 2026000p -0.3
+ 2026010p 0.9
+ 2028000p 0.9
+ 2028010p -0.3
+ 2030000p -0.3
+ 2030010p 0.9
+ 2032000p 0.9
+ 2032010p -0.3
+ 2034000p -0.3
+ 2034010p 0.9
+ 2036000p 0.9
+ 2036010p -0.3
+ 2038000p -0.3
+ 2038010p 0.9
+ 2040000p 0.9
+ 2040010p -0.3
+ 2042000p -0.3
+ 2042010p 0.9
+ 2044000p 0.9
+ 2044010p -0.3
+ 2046000p -0.3
+ 2046010p 0.9
+ 2048000p 0.9
+ 2048010p -0.3
+ \]
V_data_31 (Data\\<31\\> gnd!) vsource type=pwl wave=\[
+ 0    0.9
+ 2000p 0.9
+ 2010p -0.3
+ 4000p -0.3
+ 4010p 0.9
+ 6000p 0.9
+ 6010p -0.3
+ 8000p -0.3
+ 8010p 0.9
+ 10000p 0.9
+ 10010p -0.3
+ 12000p -0.3
+ 12010p 0.9
+ 14000p 0.9
+ 14010p -0.3
+ 16000p -0.3
+ 16010p 0.9
+ 18000p 0.9
+ 18010p -0.3
+ 20000p -0.3
+ 20010p 0.9
+ 22000p 0.9
+ 22010p -0.3
+ 24000p -0.3
+ 24010p 0.9
+ 26000p 0.9
+ 26010p -0.3
+ 28000p -0.3
+ 28010p 0.9
+ 30000p 0.9
+ 30010p -0.3
+ 32000p -0.3
+ 32010p 0.9
+ 34000p 0.9
+ 34010p -0.3
+ 36000p -0.3
+ 36010p 0.9
+ 38000p 0.9
+ 38010p -0.3
+ 40000p -0.3
+ 40010p 0.9
+ 42000p 0.9
+ 42010p -0.3
+ 44000p -0.3
+ 44010p 0.9
+ 46000p 0.9
+ 46010p -0.3
+ 48000p -0.3
+ 48010p 0.9
+ 50000p 0.9
+ 50010p -0.3
+ 52000p -0.3
+ 52010p 0.9
+ 54000p 0.9
+ 54010p -0.3
+ 56000p -0.3
+ 56010p 0.9
+ 58000p 0.9
+ 58010p -0.3
+ 60000p -0.3
+ 60010p 0.9
+ 62000p 0.9
+ 62010p -0.3
+ 64000p -0.3
+ 64010p 0.9
+ 66000p 0.9
+ 66010p -0.3
+ 68000p -0.3
+ 68010p 0.9
+ 70000p 0.9
+ 70010p -0.3
+ 72000p -0.3
+ 72010p 0.9
+ 74000p 0.9
+ 74010p -0.3
+ 76000p -0.3
+ 76010p 0.9
+ 78000p 0.9
+ 78010p -0.3
+ 80000p -0.3
+ 80010p 0.9
+ 82000p 0.9
+ 82010p -0.3
+ 84000p -0.3
+ 84010p 0.9
+ 86000p 0.9
+ 86010p -0.3
+ 88000p -0.3
+ 88010p 0.9
+ 90000p 0.9
+ 90010p -0.3
+ 92000p -0.3
+ 92010p 0.9
+ 94000p 0.9
+ 94010p -0.3
+ 96000p -0.3
+ 96010p 0.9
+ 98000p 0.9
+ 98010p -0.3
+ 100000p -0.3
+ 100010p 0.9
+ 102000p 0.9
+ 102010p -0.3
+ 104000p -0.3
+ 104010p 0.9
+ 106000p 0.9
+ 106010p -0.3
+ 108000p -0.3
+ 108010p 0.9
+ 110000p 0.9
+ 110010p -0.3
+ 112000p -0.3
+ 112010p 0.9
+ 114000p 0.9
+ 114010p -0.3
+ 116000p -0.3
+ 116010p 0.9
+ 118000p 0.9
+ 118010p -0.3
+ 120000p -0.3
+ 120010p 0.9
+ 122000p 0.9
+ 122010p -0.3
+ 124000p -0.3
+ 124010p 0.9
+ 126000p 0.9
+ 126010p -0.3
+ 128000p -0.3
+ 128010p 0.9
+ 130000p 0.9
+ 130010p -0.3
+ 132000p -0.3
+ 132010p 0.9
+ 134000p 0.9
+ 134010p -0.3
+ 136000p -0.3
+ 136010p 0.9
+ 138000p 0.9
+ 138010p -0.3
+ 140000p -0.3
+ 140010p 0.9
+ 142000p 0.9
+ 142010p -0.3
+ 144000p -0.3
+ 144010p 0.9
+ 146000p 0.9
+ 146010p -0.3
+ 148000p -0.3
+ 148010p 0.9
+ 150000p 0.9
+ 150010p -0.3
+ 152000p -0.3
+ 152010p 0.9
+ 154000p 0.9
+ 154010p -0.3
+ 156000p -0.3
+ 156010p 0.9
+ 158000p 0.9
+ 158010p -0.3
+ 160000p -0.3
+ 160010p 0.9
+ 162000p 0.9
+ 162010p -0.3
+ 164000p -0.3
+ 164010p 0.9
+ 166000p 0.9
+ 166010p -0.3
+ 168000p -0.3
+ 168010p 0.9
+ 170000p 0.9
+ 170010p -0.3
+ 172000p -0.3
+ 172010p 0.9
+ 174000p 0.9
+ 174010p -0.3
+ 176000p -0.3
+ 176010p 0.9
+ 178000p 0.9
+ 178010p -0.3
+ 180000p -0.3
+ 180010p 0.9
+ 182000p 0.9
+ 182010p -0.3
+ 184000p -0.3
+ 184010p 0.9
+ 186000p 0.9
+ 186010p -0.3
+ 188000p -0.3
+ 188010p 0.9
+ 190000p 0.9
+ 190010p -0.3
+ 192000p -0.3
+ 192010p 0.9
+ 194000p 0.9
+ 194010p -0.3
+ 196000p -0.3
+ 196010p 0.9
+ 198000p 0.9
+ 198010p -0.3
+ 200000p -0.3
+ 200010p 0.9
+ 202000p 0.9
+ 202010p -0.3
+ 204000p -0.3
+ 204010p 0.9
+ 206000p 0.9
+ 206010p -0.3
+ 208000p -0.3
+ 208010p 0.9
+ 210000p 0.9
+ 210010p -0.3
+ 212000p -0.3
+ 212010p 0.9
+ 214000p 0.9
+ 214010p -0.3
+ 216000p -0.3
+ 216010p 0.9
+ 218000p 0.9
+ 218010p -0.3
+ 220000p -0.3
+ 220010p 0.9
+ 222000p 0.9
+ 222010p -0.3
+ 224000p -0.3
+ 224010p 0.9
+ 226000p 0.9
+ 226010p -0.3
+ 228000p -0.3
+ 228010p 0.9
+ 230000p 0.9
+ 230010p -0.3
+ 232000p -0.3
+ 232010p 0.9
+ 234000p 0.9
+ 234010p -0.3
+ 236000p -0.3
+ 236010p 0.9
+ 238000p 0.9
+ 238010p -0.3
+ 240000p -0.3
+ 240010p 0.9
+ 242000p 0.9
+ 242010p -0.3
+ 244000p -0.3
+ 244010p 0.9
+ 246000p 0.9
+ 246010p -0.3
+ 248000p -0.3
+ 248010p 0.9
+ 250000p 0.9
+ 250010p -0.3
+ 252000p -0.3
+ 252010p 0.9
+ 254000p 0.9
+ 254010p -0.3
+ 256000p -0.3
+ 256010p 0.9
+ 258000p 0.9
+ 258010p -0.3
+ 260000p -0.3
+ 260010p 0.9
+ 262000p 0.9
+ 262010p -0.3
+ 264000p -0.3
+ 264010p 0.9
+ 266000p 0.9
+ 266010p -0.3
+ 268000p -0.3
+ 268010p 0.9
+ 270000p 0.9
+ 270010p -0.3
+ 272000p -0.3
+ 272010p 0.9
+ 274000p 0.9
+ 274010p -0.3
+ 276000p -0.3
+ 276010p 0.9
+ 278000p 0.9
+ 278010p -0.3
+ 280000p -0.3
+ 280010p 0.9
+ 282000p 0.9
+ 282010p -0.3
+ 284000p -0.3
+ 284010p 0.9
+ 286000p 0.9
+ 286010p -0.3
+ 288000p -0.3
+ 288010p 0.9
+ 290000p 0.9
+ 290010p -0.3
+ 292000p -0.3
+ 292010p 0.9
+ 294000p 0.9
+ 294010p -0.3
+ 296000p -0.3
+ 296010p 0.9
+ 298000p 0.9
+ 298010p -0.3
+ 300000p -0.3
+ 300010p 0.9
+ 302000p 0.9
+ 302010p -0.3
+ 304000p -0.3
+ 304010p 0.9
+ 306000p 0.9
+ 306010p -0.3
+ 308000p -0.3
+ 308010p 0.9
+ 310000p 0.9
+ 310010p -0.3
+ 312000p -0.3
+ 312010p 0.9
+ 314000p 0.9
+ 314010p -0.3
+ 316000p -0.3
+ 316010p 0.9
+ 318000p 0.9
+ 318010p -0.3
+ 320000p -0.3
+ 320010p 0.9
+ 322000p 0.9
+ 322010p -0.3
+ 324000p -0.3
+ 324010p 0.9
+ 326000p 0.9
+ 326010p -0.3
+ 328000p -0.3
+ 328010p 0.9
+ 330000p 0.9
+ 330010p -0.3
+ 332000p -0.3
+ 332010p 0.9
+ 334000p 0.9
+ 334010p -0.3
+ 336000p -0.3
+ 336010p 0.9
+ 338000p 0.9
+ 338010p -0.3
+ 340000p -0.3
+ 340010p 0.9
+ 342000p 0.9
+ 342010p -0.3
+ 344000p -0.3
+ 344010p 0.9
+ 346000p 0.9
+ 346010p -0.3
+ 348000p -0.3
+ 348010p 0.9
+ 350000p 0.9
+ 350010p -0.3
+ 352000p -0.3
+ 352010p 0.9
+ 354000p 0.9
+ 354010p -0.3
+ 356000p -0.3
+ 356010p 0.9
+ 358000p 0.9
+ 358010p -0.3
+ 360000p -0.3
+ 360010p 0.9
+ 362000p 0.9
+ 362010p -0.3
+ 364000p -0.3
+ 364010p 0.9
+ 366000p 0.9
+ 366010p -0.3
+ 368000p -0.3
+ 368010p 0.9
+ 370000p 0.9
+ 370010p -0.3
+ 372000p -0.3
+ 372010p 0.9
+ 374000p 0.9
+ 374010p -0.3
+ 376000p -0.3
+ 376010p 0.9
+ 378000p 0.9
+ 378010p -0.3
+ 380000p -0.3
+ 380010p 0.9
+ 382000p 0.9
+ 382010p -0.3
+ 384000p -0.3
+ 384010p 0.9
+ 386000p 0.9
+ 386010p -0.3
+ 388000p -0.3
+ 388010p 0.9
+ 390000p 0.9
+ 390010p -0.3
+ 392000p -0.3
+ 392010p 0.9
+ 394000p 0.9
+ 394010p -0.3
+ 396000p -0.3
+ 396010p 0.9
+ 398000p 0.9
+ 398010p -0.3
+ 400000p -0.3
+ 400010p 0.9
+ 402000p 0.9
+ 402010p -0.3
+ 404000p -0.3
+ 404010p 0.9
+ 406000p 0.9
+ 406010p -0.3
+ 408000p -0.3
+ 408010p 0.9
+ 410000p 0.9
+ 410010p -0.3
+ 412000p -0.3
+ 412010p 0.9
+ 414000p 0.9
+ 414010p -0.3
+ 416000p -0.3
+ 416010p 0.9
+ 418000p 0.9
+ 418010p -0.3
+ 420000p -0.3
+ 420010p 0.9
+ 422000p 0.9
+ 422010p -0.3
+ 424000p -0.3
+ 424010p 0.9
+ 426000p 0.9
+ 426010p -0.3
+ 428000p -0.3
+ 428010p 0.9
+ 430000p 0.9
+ 430010p -0.3
+ 432000p -0.3
+ 432010p 0.9
+ 434000p 0.9
+ 434010p -0.3
+ 436000p -0.3
+ 436010p 0.9
+ 438000p 0.9
+ 438010p -0.3
+ 440000p -0.3
+ 440010p 0.9
+ 442000p 0.9
+ 442010p -0.3
+ 444000p -0.3
+ 444010p 0.9
+ 446000p 0.9
+ 446010p -0.3
+ 448000p -0.3
+ 448010p 0.9
+ 450000p 0.9
+ 450010p -0.3
+ 452000p -0.3
+ 452010p 0.9
+ 454000p 0.9
+ 454010p -0.3
+ 456000p -0.3
+ 456010p 0.9
+ 458000p 0.9
+ 458010p -0.3
+ 460000p -0.3
+ 460010p 0.9
+ 462000p 0.9
+ 462010p -0.3
+ 464000p -0.3
+ 464010p 0.9
+ 466000p 0.9
+ 466010p -0.3
+ 468000p -0.3
+ 468010p 0.9
+ 470000p 0.9
+ 470010p -0.3
+ 472000p -0.3
+ 472010p 0.9
+ 474000p 0.9
+ 474010p -0.3
+ 476000p -0.3
+ 476010p 0.9
+ 478000p 0.9
+ 478010p -0.3
+ 480000p -0.3
+ 480010p 0.9
+ 482000p 0.9
+ 482010p -0.3
+ 484000p -0.3
+ 484010p 0.9
+ 486000p 0.9
+ 486010p -0.3
+ 488000p -0.3
+ 488010p 0.9
+ 490000p 0.9
+ 490010p -0.3
+ 492000p -0.3
+ 492010p 0.9
+ 494000p 0.9
+ 494010p -0.3
+ 496000p -0.3
+ 496010p 0.9
+ 498000p 0.9
+ 498010p -0.3
+ 500000p -0.3
+ 500010p 0.9
+ 502000p 0.9
+ 502010p -0.3
+ 504000p -0.3
+ 504010p 0.9
+ 506000p 0.9
+ 506010p -0.3
+ 508000p -0.3
+ 508010p 0.9
+ 510000p 0.9
+ 510010p -0.3
+ 512000p -0.3
+ 512010p 0.9
+ 514000p 0.9
+ 514010p -0.3
+ 516000p -0.3
+ 516010p 0.9
+ 518000p 0.9
+ 518010p -0.3
+ 520000p -0.3
+ 520010p 0.9
+ 522000p 0.9
+ 522010p -0.3
+ 524000p -0.3
+ 524010p 0.9
+ 526000p 0.9
+ 526010p -0.3
+ 528000p -0.3
+ 528010p 0.9
+ 530000p 0.9
+ 530010p -0.3
+ 532000p -0.3
+ 532010p 0.9
+ 534000p 0.9
+ 534010p -0.3
+ 536000p -0.3
+ 536010p 0.9
+ 538000p 0.9
+ 538010p -0.3
+ 540000p -0.3
+ 540010p 0.9
+ 542000p 0.9
+ 542010p -0.3
+ 544000p -0.3
+ 544010p 0.9
+ 546000p 0.9
+ 546010p -0.3
+ 548000p -0.3
+ 548010p 0.9
+ 550000p 0.9
+ 550010p -0.3
+ 552000p -0.3
+ 552010p 0.9
+ 554000p 0.9
+ 554010p -0.3
+ 556000p -0.3
+ 556010p 0.9
+ 558000p 0.9
+ 558010p -0.3
+ 560000p -0.3
+ 560010p 0.9
+ 562000p 0.9
+ 562010p -0.3
+ 564000p -0.3
+ 564010p 0.9
+ 566000p 0.9
+ 566010p -0.3
+ 568000p -0.3
+ 568010p 0.9
+ 570000p 0.9
+ 570010p -0.3
+ 572000p -0.3
+ 572010p 0.9
+ 574000p 0.9
+ 574010p -0.3
+ 576000p -0.3
+ 576010p 0.9
+ 578000p 0.9
+ 578010p -0.3
+ 580000p -0.3
+ 580010p 0.9
+ 582000p 0.9
+ 582010p -0.3
+ 584000p -0.3
+ 584010p 0.9
+ 586000p 0.9
+ 586010p -0.3
+ 588000p -0.3
+ 588010p 0.9
+ 590000p 0.9
+ 590010p -0.3
+ 592000p -0.3
+ 592010p 0.9
+ 594000p 0.9
+ 594010p -0.3
+ 596000p -0.3
+ 596010p 0.9
+ 598000p 0.9
+ 598010p -0.3
+ 600000p -0.3
+ 600010p 0.9
+ 602000p 0.9
+ 602010p -0.3
+ 604000p -0.3
+ 604010p 0.9
+ 606000p 0.9
+ 606010p -0.3
+ 608000p -0.3
+ 608010p 0.9
+ 610000p 0.9
+ 610010p -0.3
+ 612000p -0.3
+ 612010p 0.9
+ 614000p 0.9
+ 614010p -0.3
+ 616000p -0.3
+ 616010p 0.9
+ 618000p 0.9
+ 618010p -0.3
+ 620000p -0.3
+ 620010p 0.9
+ 622000p 0.9
+ 622010p -0.3
+ 624000p -0.3
+ 624010p 0.9
+ 626000p 0.9
+ 626010p -0.3
+ 628000p -0.3
+ 628010p 0.9
+ 630000p 0.9
+ 630010p -0.3
+ 632000p -0.3
+ 632010p 0.9
+ 634000p 0.9
+ 634010p -0.3
+ 636000p -0.3
+ 636010p 0.9
+ 638000p 0.9
+ 638010p -0.3
+ 640000p -0.3
+ 640010p 0.9
+ 642000p 0.9
+ 642010p -0.3
+ 644000p -0.3
+ 644010p 0.9
+ 646000p 0.9
+ 646010p -0.3
+ 648000p -0.3
+ 648010p 0.9
+ 650000p 0.9
+ 650010p -0.3
+ 652000p -0.3
+ 652010p 0.9
+ 654000p 0.9
+ 654010p -0.3
+ 656000p -0.3
+ 656010p 0.9
+ 658000p 0.9
+ 658010p -0.3
+ 660000p -0.3
+ 660010p 0.9
+ 662000p 0.9
+ 662010p -0.3
+ 664000p -0.3
+ 664010p 0.9
+ 666000p 0.9
+ 666010p -0.3
+ 668000p -0.3
+ 668010p 0.9
+ 670000p 0.9
+ 670010p -0.3
+ 672000p -0.3
+ 672010p 0.9
+ 674000p 0.9
+ 674010p -0.3
+ 676000p -0.3
+ 676010p 0.9
+ 678000p 0.9
+ 678010p -0.3
+ 680000p -0.3
+ 680010p 0.9
+ 682000p 0.9
+ 682010p -0.3
+ 684000p -0.3
+ 684010p 0.9
+ 686000p 0.9
+ 686010p -0.3
+ 688000p -0.3
+ 688010p 0.9
+ 690000p 0.9
+ 690010p -0.3
+ 692000p -0.3
+ 692010p 0.9
+ 694000p 0.9
+ 694010p -0.3
+ 696000p -0.3
+ 696010p 0.9
+ 698000p 0.9
+ 698010p -0.3
+ 700000p -0.3
+ 700010p 0.9
+ 702000p 0.9
+ 702010p -0.3
+ 704000p -0.3
+ 704010p 0.9
+ 706000p 0.9
+ 706010p -0.3
+ 708000p -0.3
+ 708010p 0.9
+ 710000p 0.9
+ 710010p -0.3
+ 712000p -0.3
+ 712010p 0.9
+ 714000p 0.9
+ 714010p -0.3
+ 716000p -0.3
+ 716010p 0.9
+ 718000p 0.9
+ 718010p -0.3
+ 720000p -0.3
+ 720010p 0.9
+ 722000p 0.9
+ 722010p -0.3
+ 724000p -0.3
+ 724010p 0.9
+ 726000p 0.9
+ 726010p -0.3
+ 728000p -0.3
+ 728010p 0.9
+ 730000p 0.9
+ 730010p -0.3
+ 732000p -0.3
+ 732010p 0.9
+ 734000p 0.9
+ 734010p -0.3
+ 736000p -0.3
+ 736010p 0.9
+ 738000p 0.9
+ 738010p -0.3
+ 740000p -0.3
+ 740010p 0.9
+ 742000p 0.9
+ 742010p -0.3
+ 744000p -0.3
+ 744010p 0.9
+ 746000p 0.9
+ 746010p -0.3
+ 748000p -0.3
+ 748010p 0.9
+ 750000p 0.9
+ 750010p -0.3
+ 752000p -0.3
+ 752010p 0.9
+ 754000p 0.9
+ 754010p -0.3
+ 756000p -0.3
+ 756010p 0.9
+ 758000p 0.9
+ 758010p -0.3
+ 760000p -0.3
+ 760010p 0.9
+ 762000p 0.9
+ 762010p -0.3
+ 764000p -0.3
+ 764010p 0.9
+ 766000p 0.9
+ 766010p -0.3
+ 768000p -0.3
+ 768010p 0.9
+ 770000p 0.9
+ 770010p -0.3
+ 772000p -0.3
+ 772010p 0.9
+ 774000p 0.9
+ 774010p -0.3
+ 776000p -0.3
+ 776010p 0.9
+ 778000p 0.9
+ 778010p -0.3
+ 780000p -0.3
+ 780010p 0.9
+ 782000p 0.9
+ 782010p -0.3
+ 784000p -0.3
+ 784010p 0.9
+ 786000p 0.9
+ 786010p -0.3
+ 788000p -0.3
+ 788010p 0.9
+ 790000p 0.9
+ 790010p -0.3
+ 792000p -0.3
+ 792010p 0.9
+ 794000p 0.9
+ 794010p -0.3
+ 796000p -0.3
+ 796010p 0.9
+ 798000p 0.9
+ 798010p -0.3
+ 800000p -0.3
+ 800010p 0.9
+ 802000p 0.9
+ 802010p -0.3
+ 804000p -0.3
+ 804010p 0.9
+ 806000p 0.9
+ 806010p -0.3
+ 808000p -0.3
+ 808010p 0.9
+ 810000p 0.9
+ 810010p -0.3
+ 812000p -0.3
+ 812010p 0.9
+ 814000p 0.9
+ 814010p -0.3
+ 816000p -0.3
+ 816010p 0.9
+ 818000p 0.9
+ 818010p -0.3
+ 820000p -0.3
+ 820010p 0.9
+ 822000p 0.9
+ 822010p -0.3
+ 824000p -0.3
+ 824010p 0.9
+ 826000p 0.9
+ 826010p -0.3
+ 828000p -0.3
+ 828010p 0.9
+ 830000p 0.9
+ 830010p -0.3
+ 832000p -0.3
+ 832010p 0.9
+ 834000p 0.9
+ 834010p -0.3
+ 836000p -0.3
+ 836010p 0.9
+ 838000p 0.9
+ 838010p -0.3
+ 840000p -0.3
+ 840010p 0.9
+ 842000p 0.9
+ 842010p -0.3
+ 844000p -0.3
+ 844010p 0.9
+ 846000p 0.9
+ 846010p -0.3
+ 848000p -0.3
+ 848010p 0.9
+ 850000p 0.9
+ 850010p -0.3
+ 852000p -0.3
+ 852010p 0.9
+ 854000p 0.9
+ 854010p -0.3
+ 856000p -0.3
+ 856010p 0.9
+ 858000p 0.9
+ 858010p -0.3
+ 860000p -0.3
+ 860010p 0.9
+ 862000p 0.9
+ 862010p -0.3
+ 864000p -0.3
+ 864010p 0.9
+ 866000p 0.9
+ 866010p -0.3
+ 868000p -0.3
+ 868010p 0.9
+ 870000p 0.9
+ 870010p -0.3
+ 872000p -0.3
+ 872010p 0.9
+ 874000p 0.9
+ 874010p -0.3
+ 876000p -0.3
+ 876010p 0.9
+ 878000p 0.9
+ 878010p -0.3
+ 880000p -0.3
+ 880010p 0.9
+ 882000p 0.9
+ 882010p -0.3
+ 884000p -0.3
+ 884010p 0.9
+ 886000p 0.9
+ 886010p -0.3
+ 888000p -0.3
+ 888010p 0.9
+ 890000p 0.9
+ 890010p -0.3
+ 892000p -0.3
+ 892010p 0.9
+ 894000p 0.9
+ 894010p -0.3
+ 896000p -0.3
+ 896010p 0.9
+ 898000p 0.9
+ 898010p -0.3
+ 900000p -0.3
+ 900010p 0.9
+ 902000p 0.9
+ 902010p -0.3
+ 904000p -0.3
+ 904010p 0.9
+ 906000p 0.9
+ 906010p -0.3
+ 908000p -0.3
+ 908010p 0.9
+ 910000p 0.9
+ 910010p -0.3
+ 912000p -0.3
+ 912010p 0.9
+ 914000p 0.9
+ 914010p -0.3
+ 916000p -0.3
+ 916010p 0.9
+ 918000p 0.9
+ 918010p -0.3
+ 920000p -0.3
+ 920010p 0.9
+ 922000p 0.9
+ 922010p -0.3
+ 924000p -0.3
+ 924010p 0.9
+ 926000p 0.9
+ 926010p -0.3
+ 928000p -0.3
+ 928010p 0.9
+ 930000p 0.9
+ 930010p -0.3
+ 932000p -0.3
+ 932010p 0.9
+ 934000p 0.9
+ 934010p -0.3
+ 936000p -0.3
+ 936010p 0.9
+ 938000p 0.9
+ 938010p -0.3
+ 940000p -0.3
+ 940010p 0.9
+ 942000p 0.9
+ 942010p -0.3
+ 944000p -0.3
+ 944010p 0.9
+ 946000p 0.9
+ 946010p -0.3
+ 948000p -0.3
+ 948010p 0.9
+ 950000p 0.9
+ 950010p -0.3
+ 952000p -0.3
+ 952010p 0.9
+ 954000p 0.9
+ 954010p -0.3
+ 956000p -0.3
+ 956010p 0.9
+ 958000p 0.9
+ 958010p -0.3
+ 960000p -0.3
+ 960010p 0.9
+ 962000p 0.9
+ 962010p -0.3
+ 964000p -0.3
+ 964010p 0.9
+ 966000p 0.9
+ 966010p -0.3
+ 968000p -0.3
+ 968010p 0.9
+ 970000p 0.9
+ 970010p -0.3
+ 972000p -0.3
+ 972010p 0.9
+ 974000p 0.9
+ 974010p -0.3
+ 976000p -0.3
+ 976010p 0.9
+ 978000p 0.9
+ 978010p -0.3
+ 980000p -0.3
+ 980010p 0.9
+ 982000p 0.9
+ 982010p -0.3
+ 984000p -0.3
+ 984010p 0.9
+ 986000p 0.9
+ 986010p -0.3
+ 988000p -0.3
+ 988010p 0.9
+ 990000p 0.9
+ 990010p -0.3
+ 992000p -0.3
+ 992010p 0.9
+ 994000p 0.9
+ 994010p -0.3
+ 996000p -0.3
+ 996010p 0.9
+ 998000p 0.9
+ 998010p -0.3
+ 1000000p -0.3
+ 1000010p 0.9
+ 1002000p 0.9
+ 1002010p -0.3
+ 1004000p -0.3
+ 1004010p 0.9
+ 1006000p 0.9
+ 1006010p -0.3
+ 1008000p -0.3
+ 1008010p 0.9
+ 1010000p 0.9
+ 1010010p -0.3
+ 1012000p -0.3
+ 1012010p 0.9
+ 1014000p 0.9
+ 1014010p -0.3
+ 1016000p -0.3
+ 1016010p 0.9
+ 1018000p 0.9
+ 1018010p -0.3
+ 1020000p -0.3
+ 1020010p 0.9
+ 1022000p 0.9
+ 1022010p -0.3
+ 1024000p -0.3
+ 1024010p 0.9
+ 1026000p 0.9
+ 1026010p -0.3
+ 1028000p -0.3
+ 1028010p 0.9
+ 1030000p 0.9
+ 1030010p -0.3
+ 1032000p -0.3
+ 1032010p 0.9
+ 1034000p 0.9
+ 1034010p -0.3
+ 1036000p -0.3
+ 1036010p 0.9
+ 1038000p 0.9
+ 1038010p -0.3
+ 1040000p -0.3
+ 1040010p 0.9
+ 1042000p 0.9
+ 1042010p -0.3
+ 1044000p -0.3
+ 1044010p 0.9
+ 1046000p 0.9
+ 1046010p -0.3
+ 1048000p -0.3
+ 1048010p 0.9
+ 1050000p 0.9
+ 1050010p -0.3
+ 1052000p -0.3
+ 1052010p 0.9
+ 1054000p 0.9
+ 1054010p -0.3
+ 1056000p -0.3
+ 1056010p 0.9
+ 1058000p 0.9
+ 1058010p -0.3
+ 1060000p -0.3
+ 1060010p 0.9
+ 1062000p 0.9
+ 1062010p -0.3
+ 1064000p -0.3
+ 1064010p 0.9
+ 1066000p 0.9
+ 1066010p -0.3
+ 1068000p -0.3
+ 1068010p 0.9
+ 1070000p 0.9
+ 1070010p -0.3
+ 1072000p -0.3
+ 1072010p 0.9
+ 1074000p 0.9
+ 1074010p -0.3
+ 1076000p -0.3
+ 1076010p 0.9
+ 1078000p 0.9
+ 1078010p -0.3
+ 1080000p -0.3
+ 1080010p 0.9
+ 1082000p 0.9
+ 1082010p -0.3
+ 1084000p -0.3
+ 1084010p 0.9
+ 1086000p 0.9
+ 1086010p -0.3
+ 1088000p -0.3
+ 1088010p 0.9
+ 1090000p 0.9
+ 1090010p -0.3
+ 1092000p -0.3
+ 1092010p 0.9
+ 1094000p 0.9
+ 1094010p -0.3
+ 1096000p -0.3
+ 1096010p 0.9
+ 1098000p 0.9
+ 1098010p -0.3
+ 1100000p -0.3
+ 1100010p 0.9
+ 1102000p 0.9
+ 1102010p -0.3
+ 1104000p -0.3
+ 1104010p 0.9
+ 1106000p 0.9
+ 1106010p -0.3
+ 1108000p -0.3
+ 1108010p 0.9
+ 1110000p 0.9
+ 1110010p -0.3
+ 1112000p -0.3
+ 1112010p 0.9
+ 1114000p 0.9
+ 1114010p -0.3
+ 1116000p -0.3
+ 1116010p 0.9
+ 1118000p 0.9
+ 1118010p -0.3
+ 1120000p -0.3
+ 1120010p 0.9
+ 1122000p 0.9
+ 1122010p -0.3
+ 1124000p -0.3
+ 1124010p 0.9
+ 1126000p 0.9
+ 1126010p -0.3
+ 1128000p -0.3
+ 1128010p 0.9
+ 1130000p 0.9
+ 1130010p -0.3
+ 1132000p -0.3
+ 1132010p 0.9
+ 1134000p 0.9
+ 1134010p -0.3
+ 1136000p -0.3
+ 1136010p 0.9
+ 1138000p 0.9
+ 1138010p -0.3
+ 1140000p -0.3
+ 1140010p 0.9
+ 1142000p 0.9
+ 1142010p -0.3
+ 1144000p -0.3
+ 1144010p 0.9
+ 1146000p 0.9
+ 1146010p -0.3
+ 1148000p -0.3
+ 1148010p 0.9
+ 1150000p 0.9
+ 1150010p -0.3
+ 1152000p -0.3
+ 1152010p 0.9
+ 1154000p 0.9
+ 1154010p -0.3
+ 1156000p -0.3
+ 1156010p 0.9
+ 1158000p 0.9
+ 1158010p -0.3
+ 1160000p -0.3
+ 1160010p 0.9
+ 1162000p 0.9
+ 1162010p -0.3
+ 1164000p -0.3
+ 1164010p 0.9
+ 1166000p 0.9
+ 1166010p -0.3
+ 1168000p -0.3
+ 1168010p 0.9
+ 1170000p 0.9
+ 1170010p -0.3
+ 1172000p -0.3
+ 1172010p 0.9
+ 1174000p 0.9
+ 1174010p -0.3
+ 1176000p -0.3
+ 1176010p 0.9
+ 1178000p 0.9
+ 1178010p -0.3
+ 1180000p -0.3
+ 1180010p 0.9
+ 1182000p 0.9
+ 1182010p -0.3
+ 1184000p -0.3
+ 1184010p 0.9
+ 1186000p 0.9
+ 1186010p -0.3
+ 1188000p -0.3
+ 1188010p 0.9
+ 1190000p 0.9
+ 1190010p -0.3
+ 1192000p -0.3
+ 1192010p 0.9
+ 1194000p 0.9
+ 1194010p -0.3
+ 1196000p -0.3
+ 1196010p 0.9
+ 1198000p 0.9
+ 1198010p -0.3
+ 1200000p -0.3
+ 1200010p 0.9
+ 1202000p 0.9
+ 1202010p -0.3
+ 1204000p -0.3
+ 1204010p 0.9
+ 1206000p 0.9
+ 1206010p -0.3
+ 1208000p -0.3
+ 1208010p 0.9
+ 1210000p 0.9
+ 1210010p -0.3
+ 1212000p -0.3
+ 1212010p 0.9
+ 1214000p 0.9
+ 1214010p -0.3
+ 1216000p -0.3
+ 1216010p 0.9
+ 1218000p 0.9
+ 1218010p -0.3
+ 1220000p -0.3
+ 1220010p 0.9
+ 1222000p 0.9
+ 1222010p -0.3
+ 1224000p -0.3
+ 1224010p 0.9
+ 1226000p 0.9
+ 1226010p -0.3
+ 1228000p -0.3
+ 1228010p 0.9
+ 1230000p 0.9
+ 1230010p -0.3
+ 1232000p -0.3
+ 1232010p 0.9
+ 1234000p 0.9
+ 1234010p -0.3
+ 1236000p -0.3
+ 1236010p 0.9
+ 1238000p 0.9
+ 1238010p -0.3
+ 1240000p -0.3
+ 1240010p 0.9
+ 1242000p 0.9
+ 1242010p -0.3
+ 1244000p -0.3
+ 1244010p 0.9
+ 1246000p 0.9
+ 1246010p -0.3
+ 1248000p -0.3
+ 1248010p 0.9
+ 1250000p 0.9
+ 1250010p -0.3
+ 1252000p -0.3
+ 1252010p 0.9
+ 1254000p 0.9
+ 1254010p -0.3
+ 1256000p -0.3
+ 1256010p 0.9
+ 1258000p 0.9
+ 1258010p -0.3
+ 1260000p -0.3
+ 1260010p 0.9
+ 1262000p 0.9
+ 1262010p -0.3
+ 1264000p -0.3
+ 1264010p 0.9
+ 1266000p 0.9
+ 1266010p -0.3
+ 1268000p -0.3
+ 1268010p 0.9
+ 1270000p 0.9
+ 1270010p -0.3
+ 1272000p -0.3
+ 1272010p 0.9
+ 1274000p 0.9
+ 1274010p -0.3
+ 1276000p -0.3
+ 1276010p 0.9
+ 1278000p 0.9
+ 1278010p -0.3
+ 1280000p -0.3
+ 1280010p 0.9
+ 1282000p 0.9
+ 1282010p -0.3
+ 1284000p -0.3
+ 1284010p 0.9
+ 1286000p 0.9
+ 1286010p -0.3
+ 1288000p -0.3
+ 1288010p 0.9
+ 1290000p 0.9
+ 1290010p -0.3
+ 1292000p -0.3
+ 1292010p 0.9
+ 1294000p 0.9
+ 1294010p -0.3
+ 1296000p -0.3
+ 1296010p 0.9
+ 1298000p 0.9
+ 1298010p -0.3
+ 1300000p -0.3
+ 1300010p 0.9
+ 1302000p 0.9
+ 1302010p -0.3
+ 1304000p -0.3
+ 1304010p 0.9
+ 1306000p 0.9
+ 1306010p -0.3
+ 1308000p -0.3
+ 1308010p 0.9
+ 1310000p 0.9
+ 1310010p -0.3
+ 1312000p -0.3
+ 1312010p 0.9
+ 1314000p 0.9
+ 1314010p -0.3
+ 1316000p -0.3
+ 1316010p 0.9
+ 1318000p 0.9
+ 1318010p -0.3
+ 1320000p -0.3
+ 1320010p 0.9
+ 1322000p 0.9
+ 1322010p -0.3
+ 1324000p -0.3
+ 1324010p 0.9
+ 1326000p 0.9
+ 1326010p -0.3
+ 1328000p -0.3
+ 1328010p 0.9
+ 1330000p 0.9
+ 1330010p -0.3
+ 1332000p -0.3
+ 1332010p 0.9
+ 1334000p 0.9
+ 1334010p -0.3
+ 1336000p -0.3
+ 1336010p 0.9
+ 1338000p 0.9
+ 1338010p -0.3
+ 1340000p -0.3
+ 1340010p 0.9
+ 1342000p 0.9
+ 1342010p -0.3
+ 1344000p -0.3
+ 1344010p 0.9
+ 1346000p 0.9
+ 1346010p -0.3
+ 1348000p -0.3
+ 1348010p 0.9
+ 1350000p 0.9
+ 1350010p -0.3
+ 1352000p -0.3
+ 1352010p 0.9
+ 1354000p 0.9
+ 1354010p -0.3
+ 1356000p -0.3
+ 1356010p 0.9
+ 1358000p 0.9
+ 1358010p -0.3
+ 1360000p -0.3
+ 1360010p 0.9
+ 1362000p 0.9
+ 1362010p -0.3
+ 1364000p -0.3
+ 1364010p 0.9
+ 1366000p 0.9
+ 1366010p -0.3
+ 1368000p -0.3
+ 1368010p 0.9
+ 1370000p 0.9
+ 1370010p -0.3
+ 1372000p -0.3
+ 1372010p 0.9
+ 1374000p 0.9
+ 1374010p -0.3
+ 1376000p -0.3
+ 1376010p 0.9
+ 1378000p 0.9
+ 1378010p -0.3
+ 1380000p -0.3
+ 1380010p 0.9
+ 1382000p 0.9
+ 1382010p -0.3
+ 1384000p -0.3
+ 1384010p 0.9
+ 1386000p 0.9
+ 1386010p -0.3
+ 1388000p -0.3
+ 1388010p 0.9
+ 1390000p 0.9
+ 1390010p -0.3
+ 1392000p -0.3
+ 1392010p 0.9
+ 1394000p 0.9
+ 1394010p -0.3
+ 1396000p -0.3
+ 1396010p 0.9
+ 1398000p 0.9
+ 1398010p -0.3
+ 1400000p -0.3
+ 1400010p 0.9
+ 1402000p 0.9
+ 1402010p -0.3
+ 1404000p -0.3
+ 1404010p 0.9
+ 1406000p 0.9
+ 1406010p -0.3
+ 1408000p -0.3
+ 1408010p 0.9
+ 1410000p 0.9
+ 1410010p -0.3
+ 1412000p -0.3
+ 1412010p 0.9
+ 1414000p 0.9
+ 1414010p -0.3
+ 1416000p -0.3
+ 1416010p 0.9
+ 1418000p 0.9
+ 1418010p -0.3
+ 1420000p -0.3
+ 1420010p 0.9
+ 1422000p 0.9
+ 1422010p -0.3
+ 1424000p -0.3
+ 1424010p 0.9
+ 1426000p 0.9
+ 1426010p -0.3
+ 1428000p -0.3
+ 1428010p 0.9
+ 1430000p 0.9
+ 1430010p -0.3
+ 1432000p -0.3
+ 1432010p 0.9
+ 1434000p 0.9
+ 1434010p -0.3
+ 1436000p -0.3
+ 1436010p 0.9
+ 1438000p 0.9
+ 1438010p -0.3
+ 1440000p -0.3
+ 1440010p 0.9
+ 1442000p 0.9
+ 1442010p -0.3
+ 1444000p -0.3
+ 1444010p 0.9
+ 1446000p 0.9
+ 1446010p -0.3
+ 1448000p -0.3
+ 1448010p 0.9
+ 1450000p 0.9
+ 1450010p -0.3
+ 1452000p -0.3
+ 1452010p 0.9
+ 1454000p 0.9
+ 1454010p -0.3
+ 1456000p -0.3
+ 1456010p 0.9
+ 1458000p 0.9
+ 1458010p -0.3
+ 1460000p -0.3
+ 1460010p 0.9
+ 1462000p 0.9
+ 1462010p -0.3
+ 1464000p -0.3
+ 1464010p 0.9
+ 1466000p 0.9
+ 1466010p -0.3
+ 1468000p -0.3
+ 1468010p 0.9
+ 1470000p 0.9
+ 1470010p -0.3
+ 1472000p -0.3
+ 1472010p 0.9
+ 1474000p 0.9
+ 1474010p -0.3
+ 1476000p -0.3
+ 1476010p 0.9
+ 1478000p 0.9
+ 1478010p -0.3
+ 1480000p -0.3
+ 1480010p 0.9
+ 1482000p 0.9
+ 1482010p -0.3
+ 1484000p -0.3
+ 1484010p 0.9
+ 1486000p 0.9
+ 1486010p -0.3
+ 1488000p -0.3
+ 1488010p 0.9
+ 1490000p 0.9
+ 1490010p -0.3
+ 1492000p -0.3
+ 1492010p 0.9
+ 1494000p 0.9
+ 1494010p -0.3
+ 1496000p -0.3
+ 1496010p 0.9
+ 1498000p 0.9
+ 1498010p -0.3
+ 1500000p -0.3
+ 1500010p 0.9
+ 1502000p 0.9
+ 1502010p -0.3
+ 1504000p -0.3
+ 1504010p 0.9
+ 1506000p 0.9
+ 1506010p -0.3
+ 1508000p -0.3
+ 1508010p 0.9
+ 1510000p 0.9
+ 1510010p -0.3
+ 1512000p -0.3
+ 1512010p 0.9
+ 1514000p 0.9
+ 1514010p -0.3
+ 1516000p -0.3
+ 1516010p 0.9
+ 1518000p 0.9
+ 1518010p -0.3
+ 1520000p -0.3
+ 1520010p 0.9
+ 1522000p 0.9
+ 1522010p -0.3
+ 1524000p -0.3
+ 1524010p 0.9
+ 1526000p 0.9
+ 1526010p -0.3
+ 1528000p -0.3
+ 1528010p 0.9
+ 1530000p 0.9
+ 1530010p -0.3
+ 1532000p -0.3
+ 1532010p 0.9
+ 1534000p 0.9
+ 1534010p -0.3
+ 1536000p -0.3
+ 1536010p 0.9
+ 1538000p 0.9
+ 1538010p -0.3
+ 1540000p -0.3
+ 1540010p 0.9
+ 1542000p 0.9
+ 1542010p -0.3
+ 1544000p -0.3
+ 1544010p 0.9
+ 1546000p 0.9
+ 1546010p -0.3
+ 1548000p -0.3
+ 1548010p 0.9
+ 1550000p 0.9
+ 1550010p -0.3
+ 1552000p -0.3
+ 1552010p 0.9
+ 1554000p 0.9
+ 1554010p -0.3
+ 1556000p -0.3
+ 1556010p 0.9
+ 1558000p 0.9
+ 1558010p -0.3
+ 1560000p -0.3
+ 1560010p 0.9
+ 1562000p 0.9
+ 1562010p -0.3
+ 1564000p -0.3
+ 1564010p 0.9
+ 1566000p 0.9
+ 1566010p -0.3
+ 1568000p -0.3
+ 1568010p 0.9
+ 1570000p 0.9
+ 1570010p -0.3
+ 1572000p -0.3
+ 1572010p 0.9
+ 1574000p 0.9
+ 1574010p -0.3
+ 1576000p -0.3
+ 1576010p 0.9
+ 1578000p 0.9
+ 1578010p -0.3
+ 1580000p -0.3
+ 1580010p 0.9
+ 1582000p 0.9
+ 1582010p -0.3
+ 1584000p -0.3
+ 1584010p 0.9
+ 1586000p 0.9
+ 1586010p -0.3
+ 1588000p -0.3
+ 1588010p 0.9
+ 1590000p 0.9
+ 1590010p -0.3
+ 1592000p -0.3
+ 1592010p 0.9
+ 1594000p 0.9
+ 1594010p -0.3
+ 1596000p -0.3
+ 1596010p 0.9
+ 1598000p 0.9
+ 1598010p -0.3
+ 1600000p -0.3
+ 1600010p 0.9
+ 1602000p 0.9
+ 1602010p -0.3
+ 1604000p -0.3
+ 1604010p 0.9
+ 1606000p 0.9
+ 1606010p -0.3
+ 1608000p -0.3
+ 1608010p 0.9
+ 1610000p 0.9
+ 1610010p -0.3
+ 1612000p -0.3
+ 1612010p 0.9
+ 1614000p 0.9
+ 1614010p -0.3
+ 1616000p -0.3
+ 1616010p 0.9
+ 1618000p 0.9
+ 1618010p -0.3
+ 1620000p -0.3
+ 1620010p 0.9
+ 1622000p 0.9
+ 1622010p -0.3
+ 1624000p -0.3
+ 1624010p 0.9
+ 1626000p 0.9
+ 1626010p -0.3
+ 1628000p -0.3
+ 1628010p 0.9
+ 1630000p 0.9
+ 1630010p -0.3
+ 1632000p -0.3
+ 1632010p 0.9
+ 1634000p 0.9
+ 1634010p -0.3
+ 1636000p -0.3
+ 1636010p 0.9
+ 1638000p 0.9
+ 1638010p -0.3
+ 1640000p -0.3
+ 1640010p 0.9
+ 1642000p 0.9
+ 1642010p -0.3
+ 1644000p -0.3
+ 1644010p 0.9
+ 1646000p 0.9
+ 1646010p -0.3
+ 1648000p -0.3
+ 1648010p 0.9
+ 1650000p 0.9
+ 1650010p -0.3
+ 1652000p -0.3
+ 1652010p 0.9
+ 1654000p 0.9
+ 1654010p -0.3
+ 1656000p -0.3
+ 1656010p 0.9
+ 1658000p 0.9
+ 1658010p -0.3
+ 1660000p -0.3
+ 1660010p 0.9
+ 1662000p 0.9
+ 1662010p -0.3
+ 1664000p -0.3
+ 1664010p 0.9
+ 1666000p 0.9
+ 1666010p -0.3
+ 1668000p -0.3
+ 1668010p 0.9
+ 1670000p 0.9
+ 1670010p -0.3
+ 1672000p -0.3
+ 1672010p 0.9
+ 1674000p 0.9
+ 1674010p -0.3
+ 1676000p -0.3
+ 1676010p 0.9
+ 1678000p 0.9
+ 1678010p -0.3
+ 1680000p -0.3
+ 1680010p 0.9
+ 1682000p 0.9
+ 1682010p -0.3
+ 1684000p -0.3
+ 1684010p 0.9
+ 1686000p 0.9
+ 1686010p -0.3
+ 1688000p -0.3
+ 1688010p 0.9
+ 1690000p 0.9
+ 1690010p -0.3
+ 1692000p -0.3
+ 1692010p 0.9
+ 1694000p 0.9
+ 1694010p -0.3
+ 1696000p -0.3
+ 1696010p 0.9
+ 1698000p 0.9
+ 1698010p -0.3
+ 1700000p -0.3
+ 1700010p 0.9
+ 1702000p 0.9
+ 1702010p -0.3
+ 1704000p -0.3
+ 1704010p 0.9
+ 1706000p 0.9
+ 1706010p -0.3
+ 1708000p -0.3
+ 1708010p 0.9
+ 1710000p 0.9
+ 1710010p -0.3
+ 1712000p -0.3
+ 1712010p 0.9
+ 1714000p 0.9
+ 1714010p -0.3
+ 1716000p -0.3
+ 1716010p 0.9
+ 1718000p 0.9
+ 1718010p -0.3
+ 1720000p -0.3
+ 1720010p 0.9
+ 1722000p 0.9
+ 1722010p -0.3
+ 1724000p -0.3
+ 1724010p 0.9
+ 1726000p 0.9
+ 1726010p -0.3
+ 1728000p -0.3
+ 1728010p 0.9
+ 1730000p 0.9
+ 1730010p -0.3
+ 1732000p -0.3
+ 1732010p 0.9
+ 1734000p 0.9
+ 1734010p -0.3
+ 1736000p -0.3
+ 1736010p 0.9
+ 1738000p 0.9
+ 1738010p -0.3
+ 1740000p -0.3
+ 1740010p 0.9
+ 1742000p 0.9
+ 1742010p -0.3
+ 1744000p -0.3
+ 1744010p 0.9
+ 1746000p 0.9
+ 1746010p -0.3
+ 1748000p -0.3
+ 1748010p 0.9
+ 1750000p 0.9
+ 1750010p -0.3
+ 1752000p -0.3
+ 1752010p 0.9
+ 1754000p 0.9
+ 1754010p -0.3
+ 1756000p -0.3
+ 1756010p 0.9
+ 1758000p 0.9
+ 1758010p -0.3
+ 1760000p -0.3
+ 1760010p 0.9
+ 1762000p 0.9
+ 1762010p -0.3
+ 1764000p -0.3
+ 1764010p 0.9
+ 1766000p 0.9
+ 1766010p -0.3
+ 1768000p -0.3
+ 1768010p 0.9
+ 1770000p 0.9
+ 1770010p -0.3
+ 1772000p -0.3
+ 1772010p 0.9
+ 1774000p 0.9
+ 1774010p -0.3
+ 1776000p -0.3
+ 1776010p 0.9
+ 1778000p 0.9
+ 1778010p -0.3
+ 1780000p -0.3
+ 1780010p 0.9
+ 1782000p 0.9
+ 1782010p -0.3
+ 1784000p -0.3
+ 1784010p 0.9
+ 1786000p 0.9
+ 1786010p -0.3
+ 1788000p -0.3
+ 1788010p 0.9
+ 1790000p 0.9
+ 1790010p -0.3
+ 1792000p -0.3
+ 1792010p 0.9
+ 1794000p 0.9
+ 1794010p -0.3
+ 1796000p -0.3
+ 1796010p 0.9
+ 1798000p 0.9
+ 1798010p -0.3
+ 1800000p -0.3
+ 1800010p 0.9
+ 1802000p 0.9
+ 1802010p -0.3
+ 1804000p -0.3
+ 1804010p 0.9
+ 1806000p 0.9
+ 1806010p -0.3
+ 1808000p -0.3
+ 1808010p 0.9
+ 1810000p 0.9
+ 1810010p -0.3
+ 1812000p -0.3
+ 1812010p 0.9
+ 1814000p 0.9
+ 1814010p -0.3
+ 1816000p -0.3
+ 1816010p 0.9
+ 1818000p 0.9
+ 1818010p -0.3
+ 1820000p -0.3
+ 1820010p 0.9
+ 1822000p 0.9
+ 1822010p -0.3
+ 1824000p -0.3
+ 1824010p 0.9
+ 1826000p 0.9
+ 1826010p -0.3
+ 1828000p -0.3
+ 1828010p 0.9
+ 1830000p 0.9
+ 1830010p -0.3
+ 1832000p -0.3
+ 1832010p 0.9
+ 1834000p 0.9
+ 1834010p -0.3
+ 1836000p -0.3
+ 1836010p 0.9
+ 1838000p 0.9
+ 1838010p -0.3
+ 1840000p -0.3
+ 1840010p 0.9
+ 1842000p 0.9
+ 1842010p -0.3
+ 1844000p -0.3
+ 1844010p 0.9
+ 1846000p 0.9
+ 1846010p -0.3
+ 1848000p -0.3
+ 1848010p 0.9
+ 1850000p 0.9
+ 1850010p -0.3
+ 1852000p -0.3
+ 1852010p 0.9
+ 1854000p 0.9
+ 1854010p -0.3
+ 1856000p -0.3
+ 1856010p 0.9
+ 1858000p 0.9
+ 1858010p -0.3
+ 1860000p -0.3
+ 1860010p 0.9
+ 1862000p 0.9
+ 1862010p -0.3
+ 1864000p -0.3
+ 1864010p 0.9
+ 1866000p 0.9
+ 1866010p -0.3
+ 1868000p -0.3
+ 1868010p 0.9
+ 1870000p 0.9
+ 1870010p -0.3
+ 1872000p -0.3
+ 1872010p 0.9
+ 1874000p 0.9
+ 1874010p -0.3
+ 1876000p -0.3
+ 1876010p 0.9
+ 1878000p 0.9
+ 1878010p -0.3
+ 1880000p -0.3
+ 1880010p 0.9
+ 1882000p 0.9
+ 1882010p -0.3
+ 1884000p -0.3
+ 1884010p 0.9
+ 1886000p 0.9
+ 1886010p -0.3
+ 1888000p -0.3
+ 1888010p 0.9
+ 1890000p 0.9
+ 1890010p -0.3
+ 1892000p -0.3
+ 1892010p 0.9
+ 1894000p 0.9
+ 1894010p -0.3
+ 1896000p -0.3
+ 1896010p 0.9
+ 1898000p 0.9
+ 1898010p -0.3
+ 1900000p -0.3
+ 1900010p 0.9
+ 1902000p 0.9
+ 1902010p -0.3
+ 1904000p -0.3
+ 1904010p 0.9
+ 1906000p 0.9
+ 1906010p -0.3
+ 1908000p -0.3
+ 1908010p 0.9
+ 1910000p 0.9
+ 1910010p -0.3
+ 1912000p -0.3
+ 1912010p 0.9
+ 1914000p 0.9
+ 1914010p -0.3
+ 1916000p -0.3
+ 1916010p 0.9
+ 1918000p 0.9
+ 1918010p -0.3
+ 1920000p -0.3
+ 1920010p 0.9
+ 1922000p 0.9
+ 1922010p -0.3
+ 1924000p -0.3
+ 1924010p 0.9
+ 1926000p 0.9
+ 1926010p -0.3
+ 1928000p -0.3
+ 1928010p 0.9
+ 1930000p 0.9
+ 1930010p -0.3
+ 1932000p -0.3
+ 1932010p 0.9
+ 1934000p 0.9
+ 1934010p -0.3
+ 1936000p -0.3
+ 1936010p 0.9
+ 1938000p 0.9
+ 1938010p -0.3
+ 1940000p -0.3
+ 1940010p 0.9
+ 1942000p 0.9
+ 1942010p -0.3
+ 1944000p -0.3
+ 1944010p 0.9
+ 1946000p 0.9
+ 1946010p -0.3
+ 1948000p -0.3
+ 1948010p 0.9
+ 1950000p 0.9
+ 1950010p -0.3
+ 1952000p -0.3
+ 1952010p 0.9
+ 1954000p 0.9
+ 1954010p -0.3
+ 1956000p -0.3
+ 1956010p 0.9
+ 1958000p 0.9
+ 1958010p -0.3
+ 1960000p -0.3
+ 1960010p 0.9
+ 1962000p 0.9
+ 1962010p -0.3
+ 1964000p -0.3
+ 1964010p 0.9
+ 1966000p 0.9
+ 1966010p -0.3
+ 1968000p -0.3
+ 1968010p 0.9
+ 1970000p 0.9
+ 1970010p -0.3
+ 1972000p -0.3
+ 1972010p 0.9
+ 1974000p 0.9
+ 1974010p -0.3
+ 1976000p -0.3
+ 1976010p 0.9
+ 1978000p 0.9
+ 1978010p -0.3
+ 1980000p -0.3
+ 1980010p 0.9
+ 1982000p 0.9
+ 1982010p -0.3
+ 1984000p -0.3
+ 1984010p 0.9
+ 1986000p 0.9
+ 1986010p -0.3
+ 1988000p -0.3
+ 1988010p 0.9
+ 1990000p 0.9
+ 1990010p -0.3
+ 1992000p -0.3
+ 1992010p 0.9
+ 1994000p 0.9
+ 1994010p -0.3
+ 1996000p -0.3
+ 1996010p 0.9
+ 1998000p 0.9
+ 1998010p -0.3
+ 2000000p -0.3
+ 2000010p 0.9
+ 2002000p 0.9
+ 2002010p -0.3
+ 2004000p -0.3
+ 2004010p 0.9
+ 2006000p 0.9
+ 2006010p -0.3
+ 2008000p -0.3
+ 2008010p 0.9
+ 2010000p 0.9
+ 2010010p -0.3
+ 2012000p -0.3
+ 2012010p 0.9
+ 2014000p 0.9
+ 2014010p -0.3
+ 2016000p -0.3
+ 2016010p 0.9
+ 2018000p 0.9
+ 2018010p -0.3
+ 2020000p -0.3
+ 2020010p 0.9
+ 2022000p 0.9
+ 2022010p -0.3
+ 2024000p -0.3
+ 2024010p 0.9
+ 2026000p 0.9
+ 2026010p -0.3
+ 2028000p -0.3
+ 2028010p 0.9
+ 2030000p 0.9
+ 2030010p -0.3
+ 2032000p -0.3
+ 2032010p 0.9
+ 2034000p 0.9
+ 2034010p -0.3
+ 2036000p -0.3
+ 2036010p 0.9
+ 2038000p 0.9
+ 2038010p -0.3
+ 2040000p -0.3
+ 2040010p 0.9
+ 2042000p 0.9
+ 2042010p -0.3
+ 2044000p -0.3
+ 2044010p 0.9
+ 2046000p 0.9
+ 2046010p -0.3
+ 2048000p -0.3
+ 2048010p 0.9
+ \]
V_data_bar_31 (Data_bar\\<31\\> gnd!) vsource type=pwl wave=\[
+ 0    -0.3
+ 2000p -0.3
+ 2010p 0.9
+ 4000p 0.9
+ 4010p -0.3
+ 6000p -0.3
+ 6010p 0.9
+ 8000p 0.9
+ 8010p -0.3
+ 10000p -0.3
+ 10010p 0.9
+ 12000p 0.9
+ 12010p -0.3
+ 14000p -0.3
+ 14010p 0.9
+ 16000p 0.9
+ 16010p -0.3
+ 18000p -0.3
+ 18010p 0.9
+ 20000p 0.9
+ 20010p -0.3
+ 22000p -0.3
+ 22010p 0.9
+ 24000p 0.9
+ 24010p -0.3
+ 26000p -0.3
+ 26010p 0.9
+ 28000p 0.9
+ 28010p -0.3
+ 30000p -0.3
+ 30010p 0.9
+ 32000p 0.9
+ 32010p -0.3
+ 34000p -0.3
+ 34010p 0.9
+ 36000p 0.9
+ 36010p -0.3
+ 38000p -0.3
+ 38010p 0.9
+ 40000p 0.9
+ 40010p -0.3
+ 42000p -0.3
+ 42010p 0.9
+ 44000p 0.9
+ 44010p -0.3
+ 46000p -0.3
+ 46010p 0.9
+ 48000p 0.9
+ 48010p -0.3
+ 50000p -0.3
+ 50010p 0.9
+ 52000p 0.9
+ 52010p -0.3
+ 54000p -0.3
+ 54010p 0.9
+ 56000p 0.9
+ 56010p -0.3
+ 58000p -0.3
+ 58010p 0.9
+ 60000p 0.9
+ 60010p -0.3
+ 62000p -0.3
+ 62010p 0.9
+ 64000p 0.9
+ 64010p -0.3
+ 66000p -0.3
+ 66010p 0.9
+ 68000p 0.9
+ 68010p -0.3
+ 70000p -0.3
+ 70010p 0.9
+ 72000p 0.9
+ 72010p -0.3
+ 74000p -0.3
+ 74010p 0.9
+ 76000p 0.9
+ 76010p -0.3
+ 78000p -0.3
+ 78010p 0.9
+ 80000p 0.9
+ 80010p -0.3
+ 82000p -0.3
+ 82010p 0.9
+ 84000p 0.9
+ 84010p -0.3
+ 86000p -0.3
+ 86010p 0.9
+ 88000p 0.9
+ 88010p -0.3
+ 90000p -0.3
+ 90010p 0.9
+ 92000p 0.9
+ 92010p -0.3
+ 94000p -0.3
+ 94010p 0.9
+ 96000p 0.9
+ 96010p -0.3
+ 98000p -0.3
+ 98010p 0.9
+ 100000p 0.9
+ 100010p -0.3
+ 102000p -0.3
+ 102010p 0.9
+ 104000p 0.9
+ 104010p -0.3
+ 106000p -0.3
+ 106010p 0.9
+ 108000p 0.9
+ 108010p -0.3
+ 110000p -0.3
+ 110010p 0.9
+ 112000p 0.9
+ 112010p -0.3
+ 114000p -0.3
+ 114010p 0.9
+ 116000p 0.9
+ 116010p -0.3
+ 118000p -0.3
+ 118010p 0.9
+ 120000p 0.9
+ 120010p -0.3
+ 122000p -0.3
+ 122010p 0.9
+ 124000p 0.9
+ 124010p -0.3
+ 126000p -0.3
+ 126010p 0.9
+ 128000p 0.9
+ 128010p -0.3
+ 130000p -0.3
+ 130010p 0.9
+ 132000p 0.9
+ 132010p -0.3
+ 134000p -0.3
+ 134010p 0.9
+ 136000p 0.9
+ 136010p -0.3
+ 138000p -0.3
+ 138010p 0.9
+ 140000p 0.9
+ 140010p -0.3
+ 142000p -0.3
+ 142010p 0.9
+ 144000p 0.9
+ 144010p -0.3
+ 146000p -0.3
+ 146010p 0.9
+ 148000p 0.9
+ 148010p -0.3
+ 150000p -0.3
+ 150010p 0.9
+ 152000p 0.9
+ 152010p -0.3
+ 154000p -0.3
+ 154010p 0.9
+ 156000p 0.9
+ 156010p -0.3
+ 158000p -0.3
+ 158010p 0.9
+ 160000p 0.9
+ 160010p -0.3
+ 162000p -0.3
+ 162010p 0.9
+ 164000p 0.9
+ 164010p -0.3
+ 166000p -0.3
+ 166010p 0.9
+ 168000p 0.9
+ 168010p -0.3
+ 170000p -0.3
+ 170010p 0.9
+ 172000p 0.9
+ 172010p -0.3
+ 174000p -0.3
+ 174010p 0.9
+ 176000p 0.9
+ 176010p -0.3
+ 178000p -0.3
+ 178010p 0.9
+ 180000p 0.9
+ 180010p -0.3
+ 182000p -0.3
+ 182010p 0.9
+ 184000p 0.9
+ 184010p -0.3
+ 186000p -0.3
+ 186010p 0.9
+ 188000p 0.9
+ 188010p -0.3
+ 190000p -0.3
+ 190010p 0.9
+ 192000p 0.9
+ 192010p -0.3
+ 194000p -0.3
+ 194010p 0.9
+ 196000p 0.9
+ 196010p -0.3
+ 198000p -0.3
+ 198010p 0.9
+ 200000p 0.9
+ 200010p -0.3
+ 202000p -0.3
+ 202010p 0.9
+ 204000p 0.9
+ 204010p -0.3
+ 206000p -0.3
+ 206010p 0.9
+ 208000p 0.9
+ 208010p -0.3
+ 210000p -0.3
+ 210010p 0.9
+ 212000p 0.9
+ 212010p -0.3
+ 214000p -0.3
+ 214010p 0.9
+ 216000p 0.9
+ 216010p -0.3
+ 218000p -0.3
+ 218010p 0.9
+ 220000p 0.9
+ 220010p -0.3
+ 222000p -0.3
+ 222010p 0.9
+ 224000p 0.9
+ 224010p -0.3
+ 226000p -0.3
+ 226010p 0.9
+ 228000p 0.9
+ 228010p -0.3
+ 230000p -0.3
+ 230010p 0.9
+ 232000p 0.9
+ 232010p -0.3
+ 234000p -0.3
+ 234010p 0.9
+ 236000p 0.9
+ 236010p -0.3
+ 238000p -0.3
+ 238010p 0.9
+ 240000p 0.9
+ 240010p -0.3
+ 242000p -0.3
+ 242010p 0.9
+ 244000p 0.9
+ 244010p -0.3
+ 246000p -0.3
+ 246010p 0.9
+ 248000p 0.9
+ 248010p -0.3
+ 250000p -0.3
+ 250010p 0.9
+ 252000p 0.9
+ 252010p -0.3
+ 254000p -0.3
+ 254010p 0.9
+ 256000p 0.9
+ 256010p -0.3
+ 258000p -0.3
+ 258010p 0.9
+ 260000p 0.9
+ 260010p -0.3
+ 262000p -0.3
+ 262010p 0.9
+ 264000p 0.9
+ 264010p -0.3
+ 266000p -0.3
+ 266010p 0.9
+ 268000p 0.9
+ 268010p -0.3
+ 270000p -0.3
+ 270010p 0.9
+ 272000p 0.9
+ 272010p -0.3
+ 274000p -0.3
+ 274010p 0.9
+ 276000p 0.9
+ 276010p -0.3
+ 278000p -0.3
+ 278010p 0.9
+ 280000p 0.9
+ 280010p -0.3
+ 282000p -0.3
+ 282010p 0.9
+ 284000p 0.9
+ 284010p -0.3
+ 286000p -0.3
+ 286010p 0.9
+ 288000p 0.9
+ 288010p -0.3
+ 290000p -0.3
+ 290010p 0.9
+ 292000p 0.9
+ 292010p -0.3
+ 294000p -0.3
+ 294010p 0.9
+ 296000p 0.9
+ 296010p -0.3
+ 298000p -0.3
+ 298010p 0.9
+ 300000p 0.9
+ 300010p -0.3
+ 302000p -0.3
+ 302010p 0.9
+ 304000p 0.9
+ 304010p -0.3
+ 306000p -0.3
+ 306010p 0.9
+ 308000p 0.9
+ 308010p -0.3
+ 310000p -0.3
+ 310010p 0.9
+ 312000p 0.9
+ 312010p -0.3
+ 314000p -0.3
+ 314010p 0.9
+ 316000p 0.9
+ 316010p -0.3
+ 318000p -0.3
+ 318010p 0.9
+ 320000p 0.9
+ 320010p -0.3
+ 322000p -0.3
+ 322010p 0.9
+ 324000p 0.9
+ 324010p -0.3
+ 326000p -0.3
+ 326010p 0.9
+ 328000p 0.9
+ 328010p -0.3
+ 330000p -0.3
+ 330010p 0.9
+ 332000p 0.9
+ 332010p -0.3
+ 334000p -0.3
+ 334010p 0.9
+ 336000p 0.9
+ 336010p -0.3
+ 338000p -0.3
+ 338010p 0.9
+ 340000p 0.9
+ 340010p -0.3
+ 342000p -0.3
+ 342010p 0.9
+ 344000p 0.9
+ 344010p -0.3
+ 346000p -0.3
+ 346010p 0.9
+ 348000p 0.9
+ 348010p -0.3
+ 350000p -0.3
+ 350010p 0.9
+ 352000p 0.9
+ 352010p -0.3
+ 354000p -0.3
+ 354010p 0.9
+ 356000p 0.9
+ 356010p -0.3
+ 358000p -0.3
+ 358010p 0.9
+ 360000p 0.9
+ 360010p -0.3
+ 362000p -0.3
+ 362010p 0.9
+ 364000p 0.9
+ 364010p -0.3
+ 366000p -0.3
+ 366010p 0.9
+ 368000p 0.9
+ 368010p -0.3
+ 370000p -0.3
+ 370010p 0.9
+ 372000p 0.9
+ 372010p -0.3
+ 374000p -0.3
+ 374010p 0.9
+ 376000p 0.9
+ 376010p -0.3
+ 378000p -0.3
+ 378010p 0.9
+ 380000p 0.9
+ 380010p -0.3
+ 382000p -0.3
+ 382010p 0.9
+ 384000p 0.9
+ 384010p -0.3
+ 386000p -0.3
+ 386010p 0.9
+ 388000p 0.9
+ 388010p -0.3
+ 390000p -0.3
+ 390010p 0.9
+ 392000p 0.9
+ 392010p -0.3
+ 394000p -0.3
+ 394010p 0.9
+ 396000p 0.9
+ 396010p -0.3
+ 398000p -0.3
+ 398010p 0.9
+ 400000p 0.9
+ 400010p -0.3
+ 402000p -0.3
+ 402010p 0.9
+ 404000p 0.9
+ 404010p -0.3
+ 406000p -0.3
+ 406010p 0.9
+ 408000p 0.9
+ 408010p -0.3
+ 410000p -0.3
+ 410010p 0.9
+ 412000p 0.9
+ 412010p -0.3
+ 414000p -0.3
+ 414010p 0.9
+ 416000p 0.9
+ 416010p -0.3
+ 418000p -0.3
+ 418010p 0.9
+ 420000p 0.9
+ 420010p -0.3
+ 422000p -0.3
+ 422010p 0.9
+ 424000p 0.9
+ 424010p -0.3
+ 426000p -0.3
+ 426010p 0.9
+ 428000p 0.9
+ 428010p -0.3
+ 430000p -0.3
+ 430010p 0.9
+ 432000p 0.9
+ 432010p -0.3
+ 434000p -0.3
+ 434010p 0.9
+ 436000p 0.9
+ 436010p -0.3
+ 438000p -0.3
+ 438010p 0.9
+ 440000p 0.9
+ 440010p -0.3
+ 442000p -0.3
+ 442010p 0.9
+ 444000p 0.9
+ 444010p -0.3
+ 446000p -0.3
+ 446010p 0.9
+ 448000p 0.9
+ 448010p -0.3
+ 450000p -0.3
+ 450010p 0.9
+ 452000p 0.9
+ 452010p -0.3
+ 454000p -0.3
+ 454010p 0.9
+ 456000p 0.9
+ 456010p -0.3
+ 458000p -0.3
+ 458010p 0.9
+ 460000p 0.9
+ 460010p -0.3
+ 462000p -0.3
+ 462010p 0.9
+ 464000p 0.9
+ 464010p -0.3
+ 466000p -0.3
+ 466010p 0.9
+ 468000p 0.9
+ 468010p -0.3
+ 470000p -0.3
+ 470010p 0.9
+ 472000p 0.9
+ 472010p -0.3
+ 474000p -0.3
+ 474010p 0.9
+ 476000p 0.9
+ 476010p -0.3
+ 478000p -0.3
+ 478010p 0.9
+ 480000p 0.9
+ 480010p -0.3
+ 482000p -0.3
+ 482010p 0.9
+ 484000p 0.9
+ 484010p -0.3
+ 486000p -0.3
+ 486010p 0.9
+ 488000p 0.9
+ 488010p -0.3
+ 490000p -0.3
+ 490010p 0.9
+ 492000p 0.9
+ 492010p -0.3
+ 494000p -0.3
+ 494010p 0.9
+ 496000p 0.9
+ 496010p -0.3
+ 498000p -0.3
+ 498010p 0.9
+ 500000p 0.9
+ 500010p -0.3
+ 502000p -0.3
+ 502010p 0.9
+ 504000p 0.9
+ 504010p -0.3
+ 506000p -0.3
+ 506010p 0.9
+ 508000p 0.9
+ 508010p -0.3
+ 510000p -0.3
+ 510010p 0.9
+ 512000p 0.9
+ 512010p -0.3
+ 514000p -0.3
+ 514010p 0.9
+ 516000p 0.9
+ 516010p -0.3
+ 518000p -0.3
+ 518010p 0.9
+ 520000p 0.9
+ 520010p -0.3
+ 522000p -0.3
+ 522010p 0.9
+ 524000p 0.9
+ 524010p -0.3
+ 526000p -0.3
+ 526010p 0.9
+ 528000p 0.9
+ 528010p -0.3
+ 530000p -0.3
+ 530010p 0.9
+ 532000p 0.9
+ 532010p -0.3
+ 534000p -0.3
+ 534010p 0.9
+ 536000p 0.9
+ 536010p -0.3
+ 538000p -0.3
+ 538010p 0.9
+ 540000p 0.9
+ 540010p -0.3
+ 542000p -0.3
+ 542010p 0.9
+ 544000p 0.9
+ 544010p -0.3
+ 546000p -0.3
+ 546010p 0.9
+ 548000p 0.9
+ 548010p -0.3
+ 550000p -0.3
+ 550010p 0.9
+ 552000p 0.9
+ 552010p -0.3
+ 554000p -0.3
+ 554010p 0.9
+ 556000p 0.9
+ 556010p -0.3
+ 558000p -0.3
+ 558010p 0.9
+ 560000p 0.9
+ 560010p -0.3
+ 562000p -0.3
+ 562010p 0.9
+ 564000p 0.9
+ 564010p -0.3
+ 566000p -0.3
+ 566010p 0.9
+ 568000p 0.9
+ 568010p -0.3
+ 570000p -0.3
+ 570010p 0.9
+ 572000p 0.9
+ 572010p -0.3
+ 574000p -0.3
+ 574010p 0.9
+ 576000p 0.9
+ 576010p -0.3
+ 578000p -0.3
+ 578010p 0.9
+ 580000p 0.9
+ 580010p -0.3
+ 582000p -0.3
+ 582010p 0.9
+ 584000p 0.9
+ 584010p -0.3
+ 586000p -0.3
+ 586010p 0.9
+ 588000p 0.9
+ 588010p -0.3
+ 590000p -0.3
+ 590010p 0.9
+ 592000p 0.9
+ 592010p -0.3
+ 594000p -0.3
+ 594010p 0.9
+ 596000p 0.9
+ 596010p -0.3
+ 598000p -0.3
+ 598010p 0.9
+ 600000p 0.9
+ 600010p -0.3
+ 602000p -0.3
+ 602010p 0.9
+ 604000p 0.9
+ 604010p -0.3
+ 606000p -0.3
+ 606010p 0.9
+ 608000p 0.9
+ 608010p -0.3
+ 610000p -0.3
+ 610010p 0.9
+ 612000p 0.9
+ 612010p -0.3
+ 614000p -0.3
+ 614010p 0.9
+ 616000p 0.9
+ 616010p -0.3
+ 618000p -0.3
+ 618010p 0.9
+ 620000p 0.9
+ 620010p -0.3
+ 622000p -0.3
+ 622010p 0.9
+ 624000p 0.9
+ 624010p -0.3
+ 626000p -0.3
+ 626010p 0.9
+ 628000p 0.9
+ 628010p -0.3
+ 630000p -0.3
+ 630010p 0.9
+ 632000p 0.9
+ 632010p -0.3
+ 634000p -0.3
+ 634010p 0.9
+ 636000p 0.9
+ 636010p -0.3
+ 638000p -0.3
+ 638010p 0.9
+ 640000p 0.9
+ 640010p -0.3
+ 642000p -0.3
+ 642010p 0.9
+ 644000p 0.9
+ 644010p -0.3
+ 646000p -0.3
+ 646010p 0.9
+ 648000p 0.9
+ 648010p -0.3
+ 650000p -0.3
+ 650010p 0.9
+ 652000p 0.9
+ 652010p -0.3
+ 654000p -0.3
+ 654010p 0.9
+ 656000p 0.9
+ 656010p -0.3
+ 658000p -0.3
+ 658010p 0.9
+ 660000p 0.9
+ 660010p -0.3
+ 662000p -0.3
+ 662010p 0.9
+ 664000p 0.9
+ 664010p -0.3
+ 666000p -0.3
+ 666010p 0.9
+ 668000p 0.9
+ 668010p -0.3
+ 670000p -0.3
+ 670010p 0.9
+ 672000p 0.9
+ 672010p -0.3
+ 674000p -0.3
+ 674010p 0.9
+ 676000p 0.9
+ 676010p -0.3
+ 678000p -0.3
+ 678010p 0.9
+ 680000p 0.9
+ 680010p -0.3
+ 682000p -0.3
+ 682010p 0.9
+ 684000p 0.9
+ 684010p -0.3
+ 686000p -0.3
+ 686010p 0.9
+ 688000p 0.9
+ 688010p -0.3
+ 690000p -0.3
+ 690010p 0.9
+ 692000p 0.9
+ 692010p -0.3
+ 694000p -0.3
+ 694010p 0.9
+ 696000p 0.9
+ 696010p -0.3
+ 698000p -0.3
+ 698010p 0.9
+ 700000p 0.9
+ 700010p -0.3
+ 702000p -0.3
+ 702010p 0.9
+ 704000p 0.9
+ 704010p -0.3
+ 706000p -0.3
+ 706010p 0.9
+ 708000p 0.9
+ 708010p -0.3
+ 710000p -0.3
+ 710010p 0.9
+ 712000p 0.9
+ 712010p -0.3
+ 714000p -0.3
+ 714010p 0.9
+ 716000p 0.9
+ 716010p -0.3
+ 718000p -0.3
+ 718010p 0.9
+ 720000p 0.9
+ 720010p -0.3
+ 722000p -0.3
+ 722010p 0.9
+ 724000p 0.9
+ 724010p -0.3
+ 726000p -0.3
+ 726010p 0.9
+ 728000p 0.9
+ 728010p -0.3
+ 730000p -0.3
+ 730010p 0.9
+ 732000p 0.9
+ 732010p -0.3
+ 734000p -0.3
+ 734010p 0.9
+ 736000p 0.9
+ 736010p -0.3
+ 738000p -0.3
+ 738010p 0.9
+ 740000p 0.9
+ 740010p -0.3
+ 742000p -0.3
+ 742010p 0.9
+ 744000p 0.9
+ 744010p -0.3
+ 746000p -0.3
+ 746010p 0.9
+ 748000p 0.9
+ 748010p -0.3
+ 750000p -0.3
+ 750010p 0.9
+ 752000p 0.9
+ 752010p -0.3
+ 754000p -0.3
+ 754010p 0.9
+ 756000p 0.9
+ 756010p -0.3
+ 758000p -0.3
+ 758010p 0.9
+ 760000p 0.9
+ 760010p -0.3
+ 762000p -0.3
+ 762010p 0.9
+ 764000p 0.9
+ 764010p -0.3
+ 766000p -0.3
+ 766010p 0.9
+ 768000p 0.9
+ 768010p -0.3
+ 770000p -0.3
+ 770010p 0.9
+ 772000p 0.9
+ 772010p -0.3
+ 774000p -0.3
+ 774010p 0.9
+ 776000p 0.9
+ 776010p -0.3
+ 778000p -0.3
+ 778010p 0.9
+ 780000p 0.9
+ 780010p -0.3
+ 782000p -0.3
+ 782010p 0.9
+ 784000p 0.9
+ 784010p -0.3
+ 786000p -0.3
+ 786010p 0.9
+ 788000p 0.9
+ 788010p -0.3
+ 790000p -0.3
+ 790010p 0.9
+ 792000p 0.9
+ 792010p -0.3
+ 794000p -0.3
+ 794010p 0.9
+ 796000p 0.9
+ 796010p -0.3
+ 798000p -0.3
+ 798010p 0.9
+ 800000p 0.9
+ 800010p -0.3
+ 802000p -0.3
+ 802010p 0.9
+ 804000p 0.9
+ 804010p -0.3
+ 806000p -0.3
+ 806010p 0.9
+ 808000p 0.9
+ 808010p -0.3
+ 810000p -0.3
+ 810010p 0.9
+ 812000p 0.9
+ 812010p -0.3
+ 814000p -0.3
+ 814010p 0.9
+ 816000p 0.9
+ 816010p -0.3
+ 818000p -0.3
+ 818010p 0.9
+ 820000p 0.9
+ 820010p -0.3
+ 822000p -0.3
+ 822010p 0.9
+ 824000p 0.9
+ 824010p -0.3
+ 826000p -0.3
+ 826010p 0.9
+ 828000p 0.9
+ 828010p -0.3
+ 830000p -0.3
+ 830010p 0.9
+ 832000p 0.9
+ 832010p -0.3
+ 834000p -0.3
+ 834010p 0.9
+ 836000p 0.9
+ 836010p -0.3
+ 838000p -0.3
+ 838010p 0.9
+ 840000p 0.9
+ 840010p -0.3
+ 842000p -0.3
+ 842010p 0.9
+ 844000p 0.9
+ 844010p -0.3
+ 846000p -0.3
+ 846010p 0.9
+ 848000p 0.9
+ 848010p -0.3
+ 850000p -0.3
+ 850010p 0.9
+ 852000p 0.9
+ 852010p -0.3
+ 854000p -0.3
+ 854010p 0.9
+ 856000p 0.9
+ 856010p -0.3
+ 858000p -0.3
+ 858010p 0.9
+ 860000p 0.9
+ 860010p -0.3
+ 862000p -0.3
+ 862010p 0.9
+ 864000p 0.9
+ 864010p -0.3
+ 866000p -0.3
+ 866010p 0.9
+ 868000p 0.9
+ 868010p -0.3
+ 870000p -0.3
+ 870010p 0.9
+ 872000p 0.9
+ 872010p -0.3
+ 874000p -0.3
+ 874010p 0.9
+ 876000p 0.9
+ 876010p -0.3
+ 878000p -0.3
+ 878010p 0.9
+ 880000p 0.9
+ 880010p -0.3
+ 882000p -0.3
+ 882010p 0.9
+ 884000p 0.9
+ 884010p -0.3
+ 886000p -0.3
+ 886010p 0.9
+ 888000p 0.9
+ 888010p -0.3
+ 890000p -0.3
+ 890010p 0.9
+ 892000p 0.9
+ 892010p -0.3
+ 894000p -0.3
+ 894010p 0.9
+ 896000p 0.9
+ 896010p -0.3
+ 898000p -0.3
+ 898010p 0.9
+ 900000p 0.9
+ 900010p -0.3
+ 902000p -0.3
+ 902010p 0.9
+ 904000p 0.9
+ 904010p -0.3
+ 906000p -0.3
+ 906010p 0.9
+ 908000p 0.9
+ 908010p -0.3
+ 910000p -0.3
+ 910010p 0.9
+ 912000p 0.9
+ 912010p -0.3
+ 914000p -0.3
+ 914010p 0.9
+ 916000p 0.9
+ 916010p -0.3
+ 918000p -0.3
+ 918010p 0.9
+ 920000p 0.9
+ 920010p -0.3
+ 922000p -0.3
+ 922010p 0.9
+ 924000p 0.9
+ 924010p -0.3
+ 926000p -0.3
+ 926010p 0.9
+ 928000p 0.9
+ 928010p -0.3
+ 930000p -0.3
+ 930010p 0.9
+ 932000p 0.9
+ 932010p -0.3
+ 934000p -0.3
+ 934010p 0.9
+ 936000p 0.9
+ 936010p -0.3
+ 938000p -0.3
+ 938010p 0.9
+ 940000p 0.9
+ 940010p -0.3
+ 942000p -0.3
+ 942010p 0.9
+ 944000p 0.9
+ 944010p -0.3
+ 946000p -0.3
+ 946010p 0.9
+ 948000p 0.9
+ 948010p -0.3
+ 950000p -0.3
+ 950010p 0.9
+ 952000p 0.9
+ 952010p -0.3
+ 954000p -0.3
+ 954010p 0.9
+ 956000p 0.9
+ 956010p -0.3
+ 958000p -0.3
+ 958010p 0.9
+ 960000p 0.9
+ 960010p -0.3
+ 962000p -0.3
+ 962010p 0.9
+ 964000p 0.9
+ 964010p -0.3
+ 966000p -0.3
+ 966010p 0.9
+ 968000p 0.9
+ 968010p -0.3
+ 970000p -0.3
+ 970010p 0.9
+ 972000p 0.9
+ 972010p -0.3
+ 974000p -0.3
+ 974010p 0.9
+ 976000p 0.9
+ 976010p -0.3
+ 978000p -0.3
+ 978010p 0.9
+ 980000p 0.9
+ 980010p -0.3
+ 982000p -0.3
+ 982010p 0.9
+ 984000p 0.9
+ 984010p -0.3
+ 986000p -0.3
+ 986010p 0.9
+ 988000p 0.9
+ 988010p -0.3
+ 990000p -0.3
+ 990010p 0.9
+ 992000p 0.9
+ 992010p -0.3
+ 994000p -0.3
+ 994010p 0.9
+ 996000p 0.9
+ 996010p -0.3
+ 998000p -0.3
+ 998010p 0.9
+ 1000000p 0.9
+ 1000010p -0.3
+ 1002000p -0.3
+ 1002010p 0.9
+ 1004000p 0.9
+ 1004010p -0.3
+ 1006000p -0.3
+ 1006010p 0.9
+ 1008000p 0.9
+ 1008010p -0.3
+ 1010000p -0.3
+ 1010010p 0.9
+ 1012000p 0.9
+ 1012010p -0.3
+ 1014000p -0.3
+ 1014010p 0.9
+ 1016000p 0.9
+ 1016010p -0.3
+ 1018000p -0.3
+ 1018010p 0.9
+ 1020000p 0.9
+ 1020010p -0.3
+ 1022000p -0.3
+ 1022010p 0.9
+ 1024000p 0.9
+ 1024010p -0.3
+ 1026000p -0.3
+ 1026010p 0.9
+ 1028000p 0.9
+ 1028010p -0.3
+ 1030000p -0.3
+ 1030010p 0.9
+ 1032000p 0.9
+ 1032010p -0.3
+ 1034000p -0.3
+ 1034010p 0.9
+ 1036000p 0.9
+ 1036010p -0.3
+ 1038000p -0.3
+ 1038010p 0.9
+ 1040000p 0.9
+ 1040010p -0.3
+ 1042000p -0.3
+ 1042010p 0.9
+ 1044000p 0.9
+ 1044010p -0.3
+ 1046000p -0.3
+ 1046010p 0.9
+ 1048000p 0.9
+ 1048010p -0.3
+ 1050000p -0.3
+ 1050010p 0.9
+ 1052000p 0.9
+ 1052010p -0.3
+ 1054000p -0.3
+ 1054010p 0.9
+ 1056000p 0.9
+ 1056010p -0.3
+ 1058000p -0.3
+ 1058010p 0.9
+ 1060000p 0.9
+ 1060010p -0.3
+ 1062000p -0.3
+ 1062010p 0.9
+ 1064000p 0.9
+ 1064010p -0.3
+ 1066000p -0.3
+ 1066010p 0.9
+ 1068000p 0.9
+ 1068010p -0.3
+ 1070000p -0.3
+ 1070010p 0.9
+ 1072000p 0.9
+ 1072010p -0.3
+ 1074000p -0.3
+ 1074010p 0.9
+ 1076000p 0.9
+ 1076010p -0.3
+ 1078000p -0.3
+ 1078010p 0.9
+ 1080000p 0.9
+ 1080010p -0.3
+ 1082000p -0.3
+ 1082010p 0.9
+ 1084000p 0.9
+ 1084010p -0.3
+ 1086000p -0.3
+ 1086010p 0.9
+ 1088000p 0.9
+ 1088010p -0.3
+ 1090000p -0.3
+ 1090010p 0.9
+ 1092000p 0.9
+ 1092010p -0.3
+ 1094000p -0.3
+ 1094010p 0.9
+ 1096000p 0.9
+ 1096010p -0.3
+ 1098000p -0.3
+ 1098010p 0.9
+ 1100000p 0.9
+ 1100010p -0.3
+ 1102000p -0.3
+ 1102010p 0.9
+ 1104000p 0.9
+ 1104010p -0.3
+ 1106000p -0.3
+ 1106010p 0.9
+ 1108000p 0.9
+ 1108010p -0.3
+ 1110000p -0.3
+ 1110010p 0.9
+ 1112000p 0.9
+ 1112010p -0.3
+ 1114000p -0.3
+ 1114010p 0.9
+ 1116000p 0.9
+ 1116010p -0.3
+ 1118000p -0.3
+ 1118010p 0.9
+ 1120000p 0.9
+ 1120010p -0.3
+ 1122000p -0.3
+ 1122010p 0.9
+ 1124000p 0.9
+ 1124010p -0.3
+ 1126000p -0.3
+ 1126010p 0.9
+ 1128000p 0.9
+ 1128010p -0.3
+ 1130000p -0.3
+ 1130010p 0.9
+ 1132000p 0.9
+ 1132010p -0.3
+ 1134000p -0.3
+ 1134010p 0.9
+ 1136000p 0.9
+ 1136010p -0.3
+ 1138000p -0.3
+ 1138010p 0.9
+ 1140000p 0.9
+ 1140010p -0.3
+ 1142000p -0.3
+ 1142010p 0.9
+ 1144000p 0.9
+ 1144010p -0.3
+ 1146000p -0.3
+ 1146010p 0.9
+ 1148000p 0.9
+ 1148010p -0.3
+ 1150000p -0.3
+ 1150010p 0.9
+ 1152000p 0.9
+ 1152010p -0.3
+ 1154000p -0.3
+ 1154010p 0.9
+ 1156000p 0.9
+ 1156010p -0.3
+ 1158000p -0.3
+ 1158010p 0.9
+ 1160000p 0.9
+ 1160010p -0.3
+ 1162000p -0.3
+ 1162010p 0.9
+ 1164000p 0.9
+ 1164010p -0.3
+ 1166000p -0.3
+ 1166010p 0.9
+ 1168000p 0.9
+ 1168010p -0.3
+ 1170000p -0.3
+ 1170010p 0.9
+ 1172000p 0.9
+ 1172010p -0.3
+ 1174000p -0.3
+ 1174010p 0.9
+ 1176000p 0.9
+ 1176010p -0.3
+ 1178000p -0.3
+ 1178010p 0.9
+ 1180000p 0.9
+ 1180010p -0.3
+ 1182000p -0.3
+ 1182010p 0.9
+ 1184000p 0.9
+ 1184010p -0.3
+ 1186000p -0.3
+ 1186010p 0.9
+ 1188000p 0.9
+ 1188010p -0.3
+ 1190000p -0.3
+ 1190010p 0.9
+ 1192000p 0.9
+ 1192010p -0.3
+ 1194000p -0.3
+ 1194010p 0.9
+ 1196000p 0.9
+ 1196010p -0.3
+ 1198000p -0.3
+ 1198010p 0.9
+ 1200000p 0.9
+ 1200010p -0.3
+ 1202000p -0.3
+ 1202010p 0.9
+ 1204000p 0.9
+ 1204010p -0.3
+ 1206000p -0.3
+ 1206010p 0.9
+ 1208000p 0.9
+ 1208010p -0.3
+ 1210000p -0.3
+ 1210010p 0.9
+ 1212000p 0.9
+ 1212010p -0.3
+ 1214000p -0.3
+ 1214010p 0.9
+ 1216000p 0.9
+ 1216010p -0.3
+ 1218000p -0.3
+ 1218010p 0.9
+ 1220000p 0.9
+ 1220010p -0.3
+ 1222000p -0.3
+ 1222010p 0.9
+ 1224000p 0.9
+ 1224010p -0.3
+ 1226000p -0.3
+ 1226010p 0.9
+ 1228000p 0.9
+ 1228010p -0.3
+ 1230000p -0.3
+ 1230010p 0.9
+ 1232000p 0.9
+ 1232010p -0.3
+ 1234000p -0.3
+ 1234010p 0.9
+ 1236000p 0.9
+ 1236010p -0.3
+ 1238000p -0.3
+ 1238010p 0.9
+ 1240000p 0.9
+ 1240010p -0.3
+ 1242000p -0.3
+ 1242010p 0.9
+ 1244000p 0.9
+ 1244010p -0.3
+ 1246000p -0.3
+ 1246010p 0.9
+ 1248000p 0.9
+ 1248010p -0.3
+ 1250000p -0.3
+ 1250010p 0.9
+ 1252000p 0.9
+ 1252010p -0.3
+ 1254000p -0.3
+ 1254010p 0.9
+ 1256000p 0.9
+ 1256010p -0.3
+ 1258000p -0.3
+ 1258010p 0.9
+ 1260000p 0.9
+ 1260010p -0.3
+ 1262000p -0.3
+ 1262010p 0.9
+ 1264000p 0.9
+ 1264010p -0.3
+ 1266000p -0.3
+ 1266010p 0.9
+ 1268000p 0.9
+ 1268010p -0.3
+ 1270000p -0.3
+ 1270010p 0.9
+ 1272000p 0.9
+ 1272010p -0.3
+ 1274000p -0.3
+ 1274010p 0.9
+ 1276000p 0.9
+ 1276010p -0.3
+ 1278000p -0.3
+ 1278010p 0.9
+ 1280000p 0.9
+ 1280010p -0.3
+ 1282000p -0.3
+ 1282010p 0.9
+ 1284000p 0.9
+ 1284010p -0.3
+ 1286000p -0.3
+ 1286010p 0.9
+ 1288000p 0.9
+ 1288010p -0.3
+ 1290000p -0.3
+ 1290010p 0.9
+ 1292000p 0.9
+ 1292010p -0.3
+ 1294000p -0.3
+ 1294010p 0.9
+ 1296000p 0.9
+ 1296010p -0.3
+ 1298000p -0.3
+ 1298010p 0.9
+ 1300000p 0.9
+ 1300010p -0.3
+ 1302000p -0.3
+ 1302010p 0.9
+ 1304000p 0.9
+ 1304010p -0.3
+ 1306000p -0.3
+ 1306010p 0.9
+ 1308000p 0.9
+ 1308010p -0.3
+ 1310000p -0.3
+ 1310010p 0.9
+ 1312000p 0.9
+ 1312010p -0.3
+ 1314000p -0.3
+ 1314010p 0.9
+ 1316000p 0.9
+ 1316010p -0.3
+ 1318000p -0.3
+ 1318010p 0.9
+ 1320000p 0.9
+ 1320010p -0.3
+ 1322000p -0.3
+ 1322010p 0.9
+ 1324000p 0.9
+ 1324010p -0.3
+ 1326000p -0.3
+ 1326010p 0.9
+ 1328000p 0.9
+ 1328010p -0.3
+ 1330000p -0.3
+ 1330010p 0.9
+ 1332000p 0.9
+ 1332010p -0.3
+ 1334000p -0.3
+ 1334010p 0.9
+ 1336000p 0.9
+ 1336010p -0.3
+ 1338000p -0.3
+ 1338010p 0.9
+ 1340000p 0.9
+ 1340010p -0.3
+ 1342000p -0.3
+ 1342010p 0.9
+ 1344000p 0.9
+ 1344010p -0.3
+ 1346000p -0.3
+ 1346010p 0.9
+ 1348000p 0.9
+ 1348010p -0.3
+ 1350000p -0.3
+ 1350010p 0.9
+ 1352000p 0.9
+ 1352010p -0.3
+ 1354000p -0.3
+ 1354010p 0.9
+ 1356000p 0.9
+ 1356010p -0.3
+ 1358000p -0.3
+ 1358010p 0.9
+ 1360000p 0.9
+ 1360010p -0.3
+ 1362000p -0.3
+ 1362010p 0.9
+ 1364000p 0.9
+ 1364010p -0.3
+ 1366000p -0.3
+ 1366010p 0.9
+ 1368000p 0.9
+ 1368010p -0.3
+ 1370000p -0.3
+ 1370010p 0.9
+ 1372000p 0.9
+ 1372010p -0.3
+ 1374000p -0.3
+ 1374010p 0.9
+ 1376000p 0.9
+ 1376010p -0.3
+ 1378000p -0.3
+ 1378010p 0.9
+ 1380000p 0.9
+ 1380010p -0.3
+ 1382000p -0.3
+ 1382010p 0.9
+ 1384000p 0.9
+ 1384010p -0.3
+ 1386000p -0.3
+ 1386010p 0.9
+ 1388000p 0.9
+ 1388010p -0.3
+ 1390000p -0.3
+ 1390010p 0.9
+ 1392000p 0.9
+ 1392010p -0.3
+ 1394000p -0.3
+ 1394010p 0.9
+ 1396000p 0.9
+ 1396010p -0.3
+ 1398000p -0.3
+ 1398010p 0.9
+ 1400000p 0.9
+ 1400010p -0.3
+ 1402000p -0.3
+ 1402010p 0.9
+ 1404000p 0.9
+ 1404010p -0.3
+ 1406000p -0.3
+ 1406010p 0.9
+ 1408000p 0.9
+ 1408010p -0.3
+ 1410000p -0.3
+ 1410010p 0.9
+ 1412000p 0.9
+ 1412010p -0.3
+ 1414000p -0.3
+ 1414010p 0.9
+ 1416000p 0.9
+ 1416010p -0.3
+ 1418000p -0.3
+ 1418010p 0.9
+ 1420000p 0.9
+ 1420010p -0.3
+ 1422000p -0.3
+ 1422010p 0.9
+ 1424000p 0.9
+ 1424010p -0.3
+ 1426000p -0.3
+ 1426010p 0.9
+ 1428000p 0.9
+ 1428010p -0.3
+ 1430000p -0.3
+ 1430010p 0.9
+ 1432000p 0.9
+ 1432010p -0.3
+ 1434000p -0.3
+ 1434010p 0.9
+ 1436000p 0.9
+ 1436010p -0.3
+ 1438000p -0.3
+ 1438010p 0.9
+ 1440000p 0.9
+ 1440010p -0.3
+ 1442000p -0.3
+ 1442010p 0.9
+ 1444000p 0.9
+ 1444010p -0.3
+ 1446000p -0.3
+ 1446010p 0.9
+ 1448000p 0.9
+ 1448010p -0.3
+ 1450000p -0.3
+ 1450010p 0.9
+ 1452000p 0.9
+ 1452010p -0.3
+ 1454000p -0.3
+ 1454010p 0.9
+ 1456000p 0.9
+ 1456010p -0.3
+ 1458000p -0.3
+ 1458010p 0.9
+ 1460000p 0.9
+ 1460010p -0.3
+ 1462000p -0.3
+ 1462010p 0.9
+ 1464000p 0.9
+ 1464010p -0.3
+ 1466000p -0.3
+ 1466010p 0.9
+ 1468000p 0.9
+ 1468010p -0.3
+ 1470000p -0.3
+ 1470010p 0.9
+ 1472000p 0.9
+ 1472010p -0.3
+ 1474000p -0.3
+ 1474010p 0.9
+ 1476000p 0.9
+ 1476010p -0.3
+ 1478000p -0.3
+ 1478010p 0.9
+ 1480000p 0.9
+ 1480010p -0.3
+ 1482000p -0.3
+ 1482010p 0.9
+ 1484000p 0.9
+ 1484010p -0.3
+ 1486000p -0.3
+ 1486010p 0.9
+ 1488000p 0.9
+ 1488010p -0.3
+ 1490000p -0.3
+ 1490010p 0.9
+ 1492000p 0.9
+ 1492010p -0.3
+ 1494000p -0.3
+ 1494010p 0.9
+ 1496000p 0.9
+ 1496010p -0.3
+ 1498000p -0.3
+ 1498010p 0.9
+ 1500000p 0.9
+ 1500010p -0.3
+ 1502000p -0.3
+ 1502010p 0.9
+ 1504000p 0.9
+ 1504010p -0.3
+ 1506000p -0.3
+ 1506010p 0.9
+ 1508000p 0.9
+ 1508010p -0.3
+ 1510000p -0.3
+ 1510010p 0.9
+ 1512000p 0.9
+ 1512010p -0.3
+ 1514000p -0.3
+ 1514010p 0.9
+ 1516000p 0.9
+ 1516010p -0.3
+ 1518000p -0.3
+ 1518010p 0.9
+ 1520000p 0.9
+ 1520010p -0.3
+ 1522000p -0.3
+ 1522010p 0.9
+ 1524000p 0.9
+ 1524010p -0.3
+ 1526000p -0.3
+ 1526010p 0.9
+ 1528000p 0.9
+ 1528010p -0.3
+ 1530000p -0.3
+ 1530010p 0.9
+ 1532000p 0.9
+ 1532010p -0.3
+ 1534000p -0.3
+ 1534010p 0.9
+ 1536000p 0.9
+ 1536010p -0.3
+ 1538000p -0.3
+ 1538010p 0.9
+ 1540000p 0.9
+ 1540010p -0.3
+ 1542000p -0.3
+ 1542010p 0.9
+ 1544000p 0.9
+ 1544010p -0.3
+ 1546000p -0.3
+ 1546010p 0.9
+ 1548000p 0.9
+ 1548010p -0.3
+ 1550000p -0.3
+ 1550010p 0.9
+ 1552000p 0.9
+ 1552010p -0.3
+ 1554000p -0.3
+ 1554010p 0.9
+ 1556000p 0.9
+ 1556010p -0.3
+ 1558000p -0.3
+ 1558010p 0.9
+ 1560000p 0.9
+ 1560010p -0.3
+ 1562000p -0.3
+ 1562010p 0.9
+ 1564000p 0.9
+ 1564010p -0.3
+ 1566000p -0.3
+ 1566010p 0.9
+ 1568000p 0.9
+ 1568010p -0.3
+ 1570000p -0.3
+ 1570010p 0.9
+ 1572000p 0.9
+ 1572010p -0.3
+ 1574000p -0.3
+ 1574010p 0.9
+ 1576000p 0.9
+ 1576010p -0.3
+ 1578000p -0.3
+ 1578010p 0.9
+ 1580000p 0.9
+ 1580010p -0.3
+ 1582000p -0.3
+ 1582010p 0.9
+ 1584000p 0.9
+ 1584010p -0.3
+ 1586000p -0.3
+ 1586010p 0.9
+ 1588000p 0.9
+ 1588010p -0.3
+ 1590000p -0.3
+ 1590010p 0.9
+ 1592000p 0.9
+ 1592010p -0.3
+ 1594000p -0.3
+ 1594010p 0.9
+ 1596000p 0.9
+ 1596010p -0.3
+ 1598000p -0.3
+ 1598010p 0.9
+ 1600000p 0.9
+ 1600010p -0.3
+ 1602000p -0.3
+ 1602010p 0.9
+ 1604000p 0.9
+ 1604010p -0.3
+ 1606000p -0.3
+ 1606010p 0.9
+ 1608000p 0.9
+ 1608010p -0.3
+ 1610000p -0.3
+ 1610010p 0.9
+ 1612000p 0.9
+ 1612010p -0.3
+ 1614000p -0.3
+ 1614010p 0.9
+ 1616000p 0.9
+ 1616010p -0.3
+ 1618000p -0.3
+ 1618010p 0.9
+ 1620000p 0.9
+ 1620010p -0.3
+ 1622000p -0.3
+ 1622010p 0.9
+ 1624000p 0.9
+ 1624010p -0.3
+ 1626000p -0.3
+ 1626010p 0.9
+ 1628000p 0.9
+ 1628010p -0.3
+ 1630000p -0.3
+ 1630010p 0.9
+ 1632000p 0.9
+ 1632010p -0.3
+ 1634000p -0.3
+ 1634010p 0.9
+ 1636000p 0.9
+ 1636010p -0.3
+ 1638000p -0.3
+ 1638010p 0.9
+ 1640000p 0.9
+ 1640010p -0.3
+ 1642000p -0.3
+ 1642010p 0.9
+ 1644000p 0.9
+ 1644010p -0.3
+ 1646000p -0.3
+ 1646010p 0.9
+ 1648000p 0.9
+ 1648010p -0.3
+ 1650000p -0.3
+ 1650010p 0.9
+ 1652000p 0.9
+ 1652010p -0.3
+ 1654000p -0.3
+ 1654010p 0.9
+ 1656000p 0.9
+ 1656010p -0.3
+ 1658000p -0.3
+ 1658010p 0.9
+ 1660000p 0.9
+ 1660010p -0.3
+ 1662000p -0.3
+ 1662010p 0.9
+ 1664000p 0.9
+ 1664010p -0.3
+ 1666000p -0.3
+ 1666010p 0.9
+ 1668000p 0.9
+ 1668010p -0.3
+ 1670000p -0.3
+ 1670010p 0.9
+ 1672000p 0.9
+ 1672010p -0.3
+ 1674000p -0.3
+ 1674010p 0.9
+ 1676000p 0.9
+ 1676010p -0.3
+ 1678000p -0.3
+ 1678010p 0.9
+ 1680000p 0.9
+ 1680010p -0.3
+ 1682000p -0.3
+ 1682010p 0.9
+ 1684000p 0.9
+ 1684010p -0.3
+ 1686000p -0.3
+ 1686010p 0.9
+ 1688000p 0.9
+ 1688010p -0.3
+ 1690000p -0.3
+ 1690010p 0.9
+ 1692000p 0.9
+ 1692010p -0.3
+ 1694000p -0.3
+ 1694010p 0.9
+ 1696000p 0.9
+ 1696010p -0.3
+ 1698000p -0.3
+ 1698010p 0.9
+ 1700000p 0.9
+ 1700010p -0.3
+ 1702000p -0.3
+ 1702010p 0.9
+ 1704000p 0.9
+ 1704010p -0.3
+ 1706000p -0.3
+ 1706010p 0.9
+ 1708000p 0.9
+ 1708010p -0.3
+ 1710000p -0.3
+ 1710010p 0.9
+ 1712000p 0.9
+ 1712010p -0.3
+ 1714000p -0.3
+ 1714010p 0.9
+ 1716000p 0.9
+ 1716010p -0.3
+ 1718000p -0.3
+ 1718010p 0.9
+ 1720000p 0.9
+ 1720010p -0.3
+ 1722000p -0.3
+ 1722010p 0.9
+ 1724000p 0.9
+ 1724010p -0.3
+ 1726000p -0.3
+ 1726010p 0.9
+ 1728000p 0.9
+ 1728010p -0.3
+ 1730000p -0.3
+ 1730010p 0.9
+ 1732000p 0.9
+ 1732010p -0.3
+ 1734000p -0.3
+ 1734010p 0.9
+ 1736000p 0.9
+ 1736010p -0.3
+ 1738000p -0.3
+ 1738010p 0.9
+ 1740000p 0.9
+ 1740010p -0.3
+ 1742000p -0.3
+ 1742010p 0.9
+ 1744000p 0.9
+ 1744010p -0.3
+ 1746000p -0.3
+ 1746010p 0.9
+ 1748000p 0.9
+ 1748010p -0.3
+ 1750000p -0.3
+ 1750010p 0.9
+ 1752000p 0.9
+ 1752010p -0.3
+ 1754000p -0.3
+ 1754010p 0.9
+ 1756000p 0.9
+ 1756010p -0.3
+ 1758000p -0.3
+ 1758010p 0.9
+ 1760000p 0.9
+ 1760010p -0.3
+ 1762000p -0.3
+ 1762010p 0.9
+ 1764000p 0.9
+ 1764010p -0.3
+ 1766000p -0.3
+ 1766010p 0.9
+ 1768000p 0.9
+ 1768010p -0.3
+ 1770000p -0.3
+ 1770010p 0.9
+ 1772000p 0.9
+ 1772010p -0.3
+ 1774000p -0.3
+ 1774010p 0.9
+ 1776000p 0.9
+ 1776010p -0.3
+ 1778000p -0.3
+ 1778010p 0.9
+ 1780000p 0.9
+ 1780010p -0.3
+ 1782000p -0.3
+ 1782010p 0.9
+ 1784000p 0.9
+ 1784010p -0.3
+ 1786000p -0.3
+ 1786010p 0.9
+ 1788000p 0.9
+ 1788010p -0.3
+ 1790000p -0.3
+ 1790010p 0.9
+ 1792000p 0.9
+ 1792010p -0.3
+ 1794000p -0.3
+ 1794010p 0.9
+ 1796000p 0.9
+ 1796010p -0.3
+ 1798000p -0.3
+ 1798010p 0.9
+ 1800000p 0.9
+ 1800010p -0.3
+ 1802000p -0.3
+ 1802010p 0.9
+ 1804000p 0.9
+ 1804010p -0.3
+ 1806000p -0.3
+ 1806010p 0.9
+ 1808000p 0.9
+ 1808010p -0.3
+ 1810000p -0.3
+ 1810010p 0.9
+ 1812000p 0.9
+ 1812010p -0.3
+ 1814000p -0.3
+ 1814010p 0.9
+ 1816000p 0.9
+ 1816010p -0.3
+ 1818000p -0.3
+ 1818010p 0.9
+ 1820000p 0.9
+ 1820010p -0.3
+ 1822000p -0.3
+ 1822010p 0.9
+ 1824000p 0.9
+ 1824010p -0.3
+ 1826000p -0.3
+ 1826010p 0.9
+ 1828000p 0.9
+ 1828010p -0.3
+ 1830000p -0.3
+ 1830010p 0.9
+ 1832000p 0.9
+ 1832010p -0.3
+ 1834000p -0.3
+ 1834010p 0.9
+ 1836000p 0.9
+ 1836010p -0.3
+ 1838000p -0.3
+ 1838010p 0.9
+ 1840000p 0.9
+ 1840010p -0.3
+ 1842000p -0.3
+ 1842010p 0.9
+ 1844000p 0.9
+ 1844010p -0.3
+ 1846000p -0.3
+ 1846010p 0.9
+ 1848000p 0.9
+ 1848010p -0.3
+ 1850000p -0.3
+ 1850010p 0.9
+ 1852000p 0.9
+ 1852010p -0.3
+ 1854000p -0.3
+ 1854010p 0.9
+ 1856000p 0.9
+ 1856010p -0.3
+ 1858000p -0.3
+ 1858010p 0.9
+ 1860000p 0.9
+ 1860010p -0.3
+ 1862000p -0.3
+ 1862010p 0.9
+ 1864000p 0.9
+ 1864010p -0.3
+ 1866000p -0.3
+ 1866010p 0.9
+ 1868000p 0.9
+ 1868010p -0.3
+ 1870000p -0.3
+ 1870010p 0.9
+ 1872000p 0.9
+ 1872010p -0.3
+ 1874000p -0.3
+ 1874010p 0.9
+ 1876000p 0.9
+ 1876010p -0.3
+ 1878000p -0.3
+ 1878010p 0.9
+ 1880000p 0.9
+ 1880010p -0.3
+ 1882000p -0.3
+ 1882010p 0.9
+ 1884000p 0.9
+ 1884010p -0.3
+ 1886000p -0.3
+ 1886010p 0.9
+ 1888000p 0.9
+ 1888010p -0.3
+ 1890000p -0.3
+ 1890010p 0.9
+ 1892000p 0.9
+ 1892010p -0.3
+ 1894000p -0.3
+ 1894010p 0.9
+ 1896000p 0.9
+ 1896010p -0.3
+ 1898000p -0.3
+ 1898010p 0.9
+ 1900000p 0.9
+ 1900010p -0.3
+ 1902000p -0.3
+ 1902010p 0.9
+ 1904000p 0.9
+ 1904010p -0.3
+ 1906000p -0.3
+ 1906010p 0.9
+ 1908000p 0.9
+ 1908010p -0.3
+ 1910000p -0.3
+ 1910010p 0.9
+ 1912000p 0.9
+ 1912010p -0.3
+ 1914000p -0.3
+ 1914010p 0.9
+ 1916000p 0.9
+ 1916010p -0.3
+ 1918000p -0.3
+ 1918010p 0.9
+ 1920000p 0.9
+ 1920010p -0.3
+ 1922000p -0.3
+ 1922010p 0.9
+ 1924000p 0.9
+ 1924010p -0.3
+ 1926000p -0.3
+ 1926010p 0.9
+ 1928000p 0.9
+ 1928010p -0.3
+ 1930000p -0.3
+ 1930010p 0.9
+ 1932000p 0.9
+ 1932010p -0.3
+ 1934000p -0.3
+ 1934010p 0.9
+ 1936000p 0.9
+ 1936010p -0.3
+ 1938000p -0.3
+ 1938010p 0.9
+ 1940000p 0.9
+ 1940010p -0.3
+ 1942000p -0.3
+ 1942010p 0.9
+ 1944000p 0.9
+ 1944010p -0.3
+ 1946000p -0.3
+ 1946010p 0.9
+ 1948000p 0.9
+ 1948010p -0.3
+ 1950000p -0.3
+ 1950010p 0.9
+ 1952000p 0.9
+ 1952010p -0.3
+ 1954000p -0.3
+ 1954010p 0.9
+ 1956000p 0.9
+ 1956010p -0.3
+ 1958000p -0.3
+ 1958010p 0.9
+ 1960000p 0.9
+ 1960010p -0.3
+ 1962000p -0.3
+ 1962010p 0.9
+ 1964000p 0.9
+ 1964010p -0.3
+ 1966000p -0.3
+ 1966010p 0.9
+ 1968000p 0.9
+ 1968010p -0.3
+ 1970000p -0.3
+ 1970010p 0.9
+ 1972000p 0.9
+ 1972010p -0.3
+ 1974000p -0.3
+ 1974010p 0.9
+ 1976000p 0.9
+ 1976010p -0.3
+ 1978000p -0.3
+ 1978010p 0.9
+ 1980000p 0.9
+ 1980010p -0.3
+ 1982000p -0.3
+ 1982010p 0.9
+ 1984000p 0.9
+ 1984010p -0.3
+ 1986000p -0.3
+ 1986010p 0.9
+ 1988000p 0.9
+ 1988010p -0.3
+ 1990000p -0.3
+ 1990010p 0.9
+ 1992000p 0.9
+ 1992010p -0.3
+ 1994000p -0.3
+ 1994010p 0.9
+ 1996000p 0.9
+ 1996010p -0.3
+ 1998000p -0.3
+ 1998010p 0.9
+ 2000000p 0.9
+ 2000010p -0.3
+ 2002000p -0.3
+ 2002010p 0.9
+ 2004000p 0.9
+ 2004010p -0.3
+ 2006000p -0.3
+ 2006010p 0.9
+ 2008000p 0.9
+ 2008010p -0.3
+ 2010000p -0.3
+ 2010010p 0.9
+ 2012000p 0.9
+ 2012010p -0.3
+ 2014000p -0.3
+ 2014010p 0.9
+ 2016000p 0.9
+ 2016010p -0.3
+ 2018000p -0.3
+ 2018010p 0.9
+ 2020000p 0.9
+ 2020010p -0.3
+ 2022000p -0.3
+ 2022010p 0.9
+ 2024000p 0.9
+ 2024010p -0.3
+ 2026000p -0.3
+ 2026010p 0.9
+ 2028000p 0.9
+ 2028010p -0.3
+ 2030000p -0.3
+ 2030010p 0.9
+ 2032000p 0.9
+ 2032010p -0.3
+ 2034000p -0.3
+ 2034010p 0.9
+ 2036000p 0.9
+ 2036010p -0.3
+ 2038000p -0.3
+ 2038010p 0.9
+ 2040000p 0.9
+ 2040010p -0.3
+ 2042000p -0.3
+ 2042010p 0.9
+ 2044000p 0.9
+ 2044010p -0.3
+ 2046000p -0.3
+ 2046010p 0.9
+ 2048000p 0.9
+ 2048010p -0.3
+ \]
