V_wl_bar_0 (WordLine_bar\\<0\\> gnd!) vsource type=pwl wave=\[
+ 0    0.9
+ 2000p 0.9
+ 2010p -0.3
+ 4000p -0.3
+ 4010p 0.9
+ \]
V_wl_bar_1 (WordLine_bar\\<1\\> gnd!) vsource type=pwl wave=\[
+ 0    0.9
+ 4000p 0.9
+ 4010p -0.3
+ 6000p -0.3
+ 6010p 0.9
+ \]
V_wl_bar_2 (WordLine_bar\\<2\\> gnd!) vsource type=pwl wave=\[
+ 0    0.9
+ 6000p 0.9
+ 6010p -0.3
+ 8000p -0.3
+ 8010p 0.9
+ \]
V_wl_bar_3 (WordLine_bar\\<3\\> gnd!) vsource type=pwl wave=\[
+ 0    0.9
+ 8000p 0.9
+ 8010p -0.3
+ 10000p -0.3
+ 10010p 0.9
+ \]
V_wl_bar_4 (WordLine_bar\\<4\\> gnd!) vsource type=pwl wave=\[
+ 0    0.9
+ 10000p 0.9
+ 10010p -0.3
+ 12000p -0.3
+ 12010p 0.9
+ \]
V_wl_bar_5 (WordLine_bar\\<5\\> gnd!) vsource type=pwl wave=\[
+ 0    0.9
+ 12000p 0.9
+ 12010p -0.3
+ 14000p -0.3
+ 14010p 0.9
+ \]
V_wl_bar_6 (WordLine_bar\\<6\\> gnd!) vsource type=pwl wave=\[
+ 0    0.9
+ 14000p 0.9
+ 14010p -0.3
+ 16000p -0.3
+ 16010p 0.9
+ \]
V_wl_bar_7 (WordLine_bar\\<7\\> gnd!) vsource type=pwl wave=\[
+ 0    0.9
+ 16000p 0.9
+ 16010p -0.3
+ 18000p -0.3
+ 18010p 0.9
+ \]
V_wl_bar_8 (WordLine_bar\\<8\\> gnd!) vsource type=pwl wave=\[
+ 0    0.9
+ 18000p 0.9
+ 18010p -0.3
+ 20000p -0.3
+ 20010p 0.9
+ \]
V_wl_bar_9 (WordLine_bar\\<9\\> gnd!) vsource type=pwl wave=\[
+ 0    0.9
+ 20000p 0.9
+ 20010p -0.3
+ 22000p -0.3
+ 22010p 0.9
+ \]
V_wl_bar_10 (WordLine_bar\\<10\\> gnd!) vsource type=pwl wave=\[
+ 0    0.9
+ 22000p 0.9
+ 22010p -0.3
+ 24000p -0.3
+ 24010p 0.9
+ \]
V_wl_bar_11 (WordLine_bar\\<11\\> gnd!) vsource type=pwl wave=\[
+ 0    0.9
+ 24000p 0.9
+ 24010p -0.3
+ 26000p -0.3
+ 26010p 0.9
+ \]
V_wl_bar_12 (WordLine_bar\\<12\\> gnd!) vsource type=pwl wave=\[
+ 0    0.9
+ 26000p 0.9
+ 26010p -0.3
+ 28000p -0.3
+ 28010p 0.9
+ \]
V_wl_bar_13 (WordLine_bar\\<13\\> gnd!) vsource type=pwl wave=\[
+ 0    0.9
+ 28000p 0.9
+ 28010p -0.3
+ 30000p -0.3
+ 30010p 0.9
+ \]
V_wl_bar_14 (WordLine_bar\\<14\\> gnd!) vsource type=pwl wave=\[
+ 0    0.9
+ 30000p 0.9
+ 30010p -0.3
+ 32000p -0.3
+ 32010p 0.9
+ \]
V_wl_bar_15 (WordLine_bar\\<15\\> gnd!) vsource type=pwl wave=\[
+ 0    0.9
+ 32000p 0.9
+ 32010p -0.3
+ 34000p -0.3
+ 34010p 0.9
+ \]
V_wl_bar_16 (WordLine_bar\\<16\\> gnd!) vsource type=pwl wave=\[
+ 0    0.9
+ 34000p 0.9
+ 34010p -0.3
+ 36000p -0.3
+ 36010p 0.9
+ \]
V_wl_bar_17 (WordLine_bar\\<17\\> gnd!) vsource type=pwl wave=\[
+ 0    0.9
+ 36000p 0.9
+ 36010p -0.3
+ 38000p -0.3
+ 38010p 0.9
+ \]
V_wl_bar_18 (WordLine_bar\\<18\\> gnd!) vsource type=pwl wave=\[
+ 0    0.9
+ 38000p 0.9
+ 38010p -0.3
+ 40000p -0.3
+ 40010p 0.9
+ \]
V_wl_bar_19 (WordLine_bar\\<19\\> gnd!) vsource type=pwl wave=\[
+ 0    0.9
+ 40000p 0.9
+ 40010p -0.3
+ 42000p -0.3
+ 42010p 0.9
+ \]
V_wl_bar_20 (WordLine_bar\\<20\\> gnd!) vsource type=pwl wave=\[
+ 0    0.9
+ 42000p 0.9
+ 42010p -0.3
+ 44000p -0.3
+ 44010p 0.9
+ \]
V_wl_bar_21 (WordLine_bar\\<21\\> gnd!) vsource type=pwl wave=\[
+ 0    0.9
+ 44000p 0.9
+ 44010p -0.3
+ 46000p -0.3
+ 46010p 0.9
+ \]
V_wl_bar_22 (WordLine_bar\\<22\\> gnd!) vsource type=pwl wave=\[
+ 0    0.9
+ 46000p 0.9
+ 46010p -0.3
+ 48000p -0.3
+ 48010p 0.9
+ \]
V_wl_bar_23 (WordLine_bar\\<23\\> gnd!) vsource type=pwl wave=\[
+ 0    0.9
+ 48000p 0.9
+ 48010p -0.3
+ 50000p -0.3
+ 50010p 0.9
+ \]
V_wl_bar_24 (WordLine_bar\\<24\\> gnd!) vsource type=pwl wave=\[
+ 0    0.9
+ 50000p 0.9
+ 50010p -0.3
+ 52000p -0.3
+ 52010p 0.9
+ \]
V_wl_bar_25 (WordLine_bar\\<25\\> gnd!) vsource type=pwl wave=\[
+ 0    0.9
+ 52000p 0.9
+ 52010p -0.3
+ 54000p -0.3
+ 54010p 0.9
+ \]
V_wl_bar_26 (WordLine_bar\\<26\\> gnd!) vsource type=pwl wave=\[
+ 0    0.9
+ 54000p 0.9
+ 54010p -0.3
+ 56000p -0.3
+ 56010p 0.9
+ \]
V_wl_bar_27 (WordLine_bar\\<27\\> gnd!) vsource type=pwl wave=\[
+ 0    0.9
+ 56000p 0.9
+ 56010p -0.3
+ 58000p -0.3
+ 58010p 0.9
+ \]
V_wl_bar_28 (WordLine_bar\\<28\\> gnd!) vsource type=pwl wave=\[
+ 0    0.9
+ 58000p 0.9
+ 58010p -0.3
+ 60000p -0.3
+ 60010p 0.9
+ \]
V_wl_bar_29 (WordLine_bar\\<29\\> gnd!) vsource type=pwl wave=\[
+ 0    0.9
+ 60000p 0.9
+ 60010p -0.3
+ 62000p -0.3
+ 62010p 0.9
+ \]
V_wl_bar_30 (WordLine_bar\\<30\\> gnd!) vsource type=pwl wave=\[
+ 0    0.9
+ 62000p 0.9
+ 62010p -0.3
+ 64000p -0.3
+ 64010p 0.9
+ \]
V_wl_bar_31 (WordLine_bar\\<31\\> gnd!) vsource type=pwl wave=\[
+ 0    0.9
+ 64000p 0.9
+ 64010p -0.3
+ 66000p -0.3
+ 66010p 0.9
+ \]
V_wl_bar_32 (WordLine_bar\\<32\\> gnd!) vsource type=pwl wave=\[
+ 0    0.9
+ 66000p 0.9
+ 66010p -0.3
+ 68000p -0.3
+ 68010p 0.9
+ \]
V_wl_bar_33 (WordLine_bar\\<33\\> gnd!) vsource type=pwl wave=\[
+ 0    0.9
+ 68000p 0.9
+ 68010p -0.3
+ 70000p -0.3
+ 70010p 0.9
+ \]
V_wl_bar_34 (WordLine_bar\\<34\\> gnd!) vsource type=pwl wave=\[
+ 0    0.9
+ 70000p 0.9
+ 70010p -0.3
+ 72000p -0.3
+ 72010p 0.9
+ \]
V_wl_bar_35 (WordLine_bar\\<35\\> gnd!) vsource type=pwl wave=\[
+ 0    0.9
+ 72000p 0.9
+ 72010p -0.3
+ 74000p -0.3
+ 74010p 0.9
+ \]
V_wl_bar_36 (WordLine_bar\\<36\\> gnd!) vsource type=pwl wave=\[
+ 0    0.9
+ 74000p 0.9
+ 74010p -0.3
+ 76000p -0.3
+ 76010p 0.9
+ \]
V_wl_bar_37 (WordLine_bar\\<37\\> gnd!) vsource type=pwl wave=\[
+ 0    0.9
+ 76000p 0.9
+ 76010p -0.3
+ 78000p -0.3
+ 78010p 0.9
+ \]
V_wl_bar_38 (WordLine_bar\\<38\\> gnd!) vsource type=pwl wave=\[
+ 0    0.9
+ 78000p 0.9
+ 78010p -0.3
+ 80000p -0.3
+ 80010p 0.9
+ \]
V_wl_bar_39 (WordLine_bar\\<39\\> gnd!) vsource type=pwl wave=\[
+ 0    0.9
+ 80000p 0.9
+ 80010p -0.3
+ 82000p -0.3
+ 82010p 0.9
+ \]
V_wl_bar_40 (WordLine_bar\\<40\\> gnd!) vsource type=pwl wave=\[
+ 0    0.9
+ 82000p 0.9
+ 82010p -0.3
+ 84000p -0.3
+ 84010p 0.9
+ \]
V_wl_bar_41 (WordLine_bar\\<41\\> gnd!) vsource type=pwl wave=\[
+ 0    0.9
+ 84000p 0.9
+ 84010p -0.3
+ 86000p -0.3
+ 86010p 0.9
+ \]
V_wl_bar_42 (WordLine_bar\\<42\\> gnd!) vsource type=pwl wave=\[
+ 0    0.9
+ 86000p 0.9
+ 86010p -0.3
+ 88000p -0.3
+ 88010p 0.9
+ \]
V_wl_bar_43 (WordLine_bar\\<43\\> gnd!) vsource type=pwl wave=\[
+ 0    0.9
+ 88000p 0.9
+ 88010p -0.3
+ 90000p -0.3
+ 90010p 0.9
+ \]
V_wl_bar_44 (WordLine_bar\\<44\\> gnd!) vsource type=pwl wave=\[
+ 0    0.9
+ 90000p 0.9
+ 90010p -0.3
+ 92000p -0.3
+ 92010p 0.9
+ \]
V_wl_bar_45 (WordLine_bar\\<45\\> gnd!) vsource type=pwl wave=\[
+ 0    0.9
+ 92000p 0.9
+ 92010p -0.3
+ 94000p -0.3
+ 94010p 0.9
+ \]
V_wl_bar_46 (WordLine_bar\\<46\\> gnd!) vsource type=pwl wave=\[
+ 0    0.9
+ 94000p 0.9
+ 94010p -0.3
+ 96000p -0.3
+ 96010p 0.9
+ \]
V_wl_bar_47 (WordLine_bar\\<47\\> gnd!) vsource type=pwl wave=\[
+ 0    0.9
+ 96000p 0.9
+ 96010p -0.3
+ 98000p -0.3
+ 98010p 0.9
+ \]
V_wl_bar_48 (WordLine_bar\\<48\\> gnd!) vsource type=pwl wave=\[
+ 0    0.9
+ 98000p 0.9
+ 98010p -0.3
+ 100000p -0.3
+ 100010p 0.9
+ \]
V_wl_bar_49 (WordLine_bar\\<49\\> gnd!) vsource type=pwl wave=\[
+ 0    0.9
+ 100000p 0.9
+ 100010p -0.3
+ 102000p -0.3
+ 102010p 0.9
+ \]
V_wl_bar_50 (WordLine_bar\\<50\\> gnd!) vsource type=pwl wave=\[
+ 0    0.9
+ 102000p 0.9
+ 102010p -0.3
+ 104000p -0.3
+ 104010p 0.9
+ \]
V_wl_bar_51 (WordLine_bar\\<51\\> gnd!) vsource type=pwl wave=\[
+ 0    0.9
+ 104000p 0.9
+ 104010p -0.3
+ 106000p -0.3
+ 106010p 0.9
+ \]
V_wl_bar_52 (WordLine_bar\\<52\\> gnd!) vsource type=pwl wave=\[
+ 0    0.9
+ 106000p 0.9
+ 106010p -0.3
+ 108000p -0.3
+ 108010p 0.9
+ \]
V_wl_bar_53 (WordLine_bar\\<53\\> gnd!) vsource type=pwl wave=\[
+ 0    0.9
+ 108000p 0.9
+ 108010p -0.3
+ 110000p -0.3
+ 110010p 0.9
+ \]
V_wl_bar_54 (WordLine_bar\\<54\\> gnd!) vsource type=pwl wave=\[
+ 0    0.9
+ 110000p 0.9
+ 110010p -0.3
+ 112000p -0.3
+ 112010p 0.9
+ \]
V_wl_bar_55 (WordLine_bar\\<55\\> gnd!) vsource type=pwl wave=\[
+ 0    0.9
+ 112000p 0.9
+ 112010p -0.3
+ 114000p -0.3
+ 114010p 0.9
+ \]
V_wl_bar_56 (WordLine_bar\\<56\\> gnd!) vsource type=pwl wave=\[
+ 0    0.9
+ 114000p 0.9
+ 114010p -0.3
+ 116000p -0.3
+ 116010p 0.9
+ \]
V_wl_bar_57 (WordLine_bar\\<57\\> gnd!) vsource type=pwl wave=\[
+ 0    0.9
+ 116000p 0.9
+ 116010p -0.3
+ 118000p -0.3
+ 118010p 0.9
+ \]
V_wl_bar_58 (WordLine_bar\\<58\\> gnd!) vsource type=pwl wave=\[
+ 0    0.9
+ 118000p 0.9
+ 118010p -0.3
+ 120000p -0.3
+ 120010p 0.9
+ \]
V_wl_bar_59 (WordLine_bar\\<59\\> gnd!) vsource type=pwl wave=\[
+ 0    0.9
+ 120000p 0.9
+ 120010p -0.3
+ 122000p -0.3
+ 122010p 0.9
+ \]
V_wl_bar_60 (WordLine_bar\\<60\\> gnd!) vsource type=pwl wave=\[
+ 0    0.9
+ 122000p 0.9
+ 122010p -0.3
+ 124000p -0.3
+ 124010p 0.9
+ \]
V_wl_bar_61 (WordLine_bar\\<61\\> gnd!) vsource type=pwl wave=\[
+ 0    0.9
+ 124000p 0.9
+ 124010p -0.3
+ 126000p -0.3
+ 126010p 0.9
+ \]
V_wl_bar_62 (WordLine_bar\\<62\\> gnd!) vsource type=pwl wave=\[
+ 0    0.9
+ 126000p 0.9
+ 126010p -0.3
+ 128000p -0.3
+ 128010p 0.9
+ \]
V_wl_bar_63 (WordLine_bar\\<63\\> gnd!) vsource type=pwl wave=\[
+ 0    0.9
+ 128000p 0.9
+ 128010p -0.3
+ 130000p -0.3
+ 130010p 0.9
+ \]
V_wl_0 (WordLine\\<0\\> gnd!) vsource type=pwl wave=\[
+ 0    -0.3
+ 2000p -0.3
+ 2010p 0.9
+ 4000p 0.9
+ 4010p -0.3
+ \]
V_wl_1 (WordLine\\<1\\> gnd!) vsource type=pwl wave=\[
+ 0    -0.3
+ 4000p -0.3
+ 4010p 0.9
+ 6000p 0.9
+ 6010p -0.3
+ \]
V_wl_2 (WordLine\\<2\\> gnd!) vsource type=pwl wave=\[
+ 0    -0.3
+ 6000p -0.3
+ 6010p 0.9
+ 8000p 0.9
+ 8010p -0.3
+ \]
V_wl_3 (WordLine\\<3\\> gnd!) vsource type=pwl wave=\[
+ 0    -0.3
+ 8000p -0.3
+ 8010p 0.9
+ 10000p 0.9
+ 10010p -0.3
+ \]
V_wl_4 (WordLine\\<4\\> gnd!) vsource type=pwl wave=\[
+ 0    -0.3
+ 10000p -0.3
+ 10010p 0.9
+ 12000p 0.9
+ 12010p -0.3
+ \]
V_wl_5 (WordLine\\<5\\> gnd!) vsource type=pwl wave=\[
+ 0    -0.3
+ 12000p -0.3
+ 12010p 0.9
+ 14000p 0.9
+ 14010p -0.3
+ \]
V_wl_6 (WordLine\\<6\\> gnd!) vsource type=pwl wave=\[
+ 0    -0.3
+ 14000p -0.3
+ 14010p 0.9
+ 16000p 0.9
+ 16010p -0.3
+ \]
V_wl_7 (WordLine\\<7\\> gnd!) vsource type=pwl wave=\[
+ 0    -0.3
+ 16000p -0.3
+ 16010p 0.9
+ 18000p 0.9
+ 18010p -0.3
+ \]
V_wl_8 (WordLine\\<8\\> gnd!) vsource type=pwl wave=\[
+ 0    -0.3
+ 18000p -0.3
+ 18010p 0.9
+ 20000p 0.9
+ 20010p -0.3
+ \]
V_wl_9 (WordLine\\<9\\> gnd!) vsource type=pwl wave=\[
+ 0    -0.3
+ 20000p -0.3
+ 20010p 0.9
+ 22000p 0.9
+ 22010p -0.3
+ \]
V_wl_10 (WordLine\\<10\\> gnd!) vsource type=pwl wave=\[
+ 0    -0.3
+ 22000p -0.3
+ 22010p 0.9
+ 24000p 0.9
+ 24010p -0.3
+ \]
V_wl_11 (WordLine\\<11\\> gnd!) vsource type=pwl wave=\[
+ 0    -0.3
+ 24000p -0.3
+ 24010p 0.9
+ 26000p 0.9
+ 26010p -0.3
+ \]
V_wl_12 (WordLine\\<12\\> gnd!) vsource type=pwl wave=\[
+ 0    -0.3
+ 26000p -0.3
+ 26010p 0.9
+ 28000p 0.9
+ 28010p -0.3
+ \]
V_wl_13 (WordLine\\<13\\> gnd!) vsource type=pwl wave=\[
+ 0    -0.3
+ 28000p -0.3
+ 28010p 0.9
+ 30000p 0.9
+ 30010p -0.3
+ \]
V_wl_14 (WordLine\\<14\\> gnd!) vsource type=pwl wave=\[
+ 0    -0.3
+ 30000p -0.3
+ 30010p 0.9
+ 32000p 0.9
+ 32010p -0.3
+ \]
V_wl_15 (WordLine\\<15\\> gnd!) vsource type=pwl wave=\[
+ 0    -0.3
+ 32000p -0.3
+ 32010p 0.9
+ 34000p 0.9
+ 34010p -0.3
+ \]
V_wl_16 (WordLine\\<16\\> gnd!) vsource type=pwl wave=\[
+ 0    -0.3
+ 34000p -0.3
+ 34010p 0.9
+ 36000p 0.9
+ 36010p -0.3
+ \]
V_wl_17 (WordLine\\<17\\> gnd!) vsource type=pwl wave=\[
+ 0    -0.3
+ 36000p -0.3
+ 36010p 0.9
+ 38000p 0.9
+ 38010p -0.3
+ \]
V_wl_18 (WordLine\\<18\\> gnd!) vsource type=pwl wave=\[
+ 0    -0.3
+ 38000p -0.3
+ 38010p 0.9
+ 40000p 0.9
+ 40010p -0.3
+ \]
V_wl_19 (WordLine\\<19\\> gnd!) vsource type=pwl wave=\[
+ 0    -0.3
+ 40000p -0.3
+ 40010p 0.9
+ 42000p 0.9
+ 42010p -0.3
+ \]
V_wl_20 (WordLine\\<20\\> gnd!) vsource type=pwl wave=\[
+ 0    -0.3
+ 42000p -0.3
+ 42010p 0.9
+ 44000p 0.9
+ 44010p -0.3
+ \]
V_wl_21 (WordLine\\<21\\> gnd!) vsource type=pwl wave=\[
+ 0    -0.3
+ 44000p -0.3
+ 44010p 0.9
+ 46000p 0.9
+ 46010p -0.3
+ \]
V_wl_22 (WordLine\\<22\\> gnd!) vsource type=pwl wave=\[
+ 0    -0.3
+ 46000p -0.3
+ 46010p 0.9
+ 48000p 0.9
+ 48010p -0.3
+ \]
V_wl_23 (WordLine\\<23\\> gnd!) vsource type=pwl wave=\[
+ 0    -0.3
+ 48000p -0.3
+ 48010p 0.9
+ 50000p 0.9
+ 50010p -0.3
+ \]
V_wl_24 (WordLine\\<24\\> gnd!) vsource type=pwl wave=\[
+ 0    -0.3
+ 50000p -0.3
+ 50010p 0.9
+ 52000p 0.9
+ 52010p -0.3
+ \]
V_wl_25 (WordLine\\<25\\> gnd!) vsource type=pwl wave=\[
+ 0    -0.3
+ 52000p -0.3
+ 52010p 0.9
+ 54000p 0.9
+ 54010p -0.3
+ \]
V_wl_26 (WordLine\\<26\\> gnd!) vsource type=pwl wave=\[
+ 0    -0.3
+ 54000p -0.3
+ 54010p 0.9
+ 56000p 0.9
+ 56010p -0.3
+ \]
V_wl_27 (WordLine\\<27\\> gnd!) vsource type=pwl wave=\[
+ 0    -0.3
+ 56000p -0.3
+ 56010p 0.9
+ 58000p 0.9
+ 58010p -0.3
+ \]
V_wl_28 (WordLine\\<28\\> gnd!) vsource type=pwl wave=\[
+ 0    -0.3
+ 58000p -0.3
+ 58010p 0.9
+ 60000p 0.9
+ 60010p -0.3
+ \]
V_wl_29 (WordLine\\<29\\> gnd!) vsource type=pwl wave=\[
+ 0    -0.3
+ 60000p -0.3
+ 60010p 0.9
+ 62000p 0.9
+ 62010p -0.3
+ \]
V_wl_30 (WordLine\\<30\\> gnd!) vsource type=pwl wave=\[
+ 0    -0.3
+ 62000p -0.3
+ 62010p 0.9
+ 64000p 0.9
+ 64010p -0.3
+ \]
V_wl_31 (WordLine\\<31\\> gnd!) vsource type=pwl wave=\[
+ 0    -0.3
+ 64000p -0.3
+ 64010p 0.9
+ 66000p 0.9
+ 66010p -0.3
+ \]
V_wl_32 (WordLine\\<32\\> gnd!) vsource type=pwl wave=\[
+ 0    -0.3
+ 66000p -0.3
+ 66010p 0.9
+ 68000p 0.9
+ 68010p -0.3
+ \]
V_wl_33 (WordLine\\<33\\> gnd!) vsource type=pwl wave=\[
+ 0    -0.3
+ 68000p -0.3
+ 68010p 0.9
+ 70000p 0.9
+ 70010p -0.3
+ \]
V_wl_34 (WordLine\\<34\\> gnd!) vsource type=pwl wave=\[
+ 0    -0.3
+ 70000p -0.3
+ 70010p 0.9
+ 72000p 0.9
+ 72010p -0.3
+ \]
V_wl_35 (WordLine\\<35\\> gnd!) vsource type=pwl wave=\[
+ 0    -0.3
+ 72000p -0.3
+ 72010p 0.9
+ 74000p 0.9
+ 74010p -0.3
+ \]
V_wl_36 (WordLine\\<36\\> gnd!) vsource type=pwl wave=\[
+ 0    -0.3
+ 74000p -0.3
+ 74010p 0.9
+ 76000p 0.9
+ 76010p -0.3
+ \]
V_wl_37 (WordLine\\<37\\> gnd!) vsource type=pwl wave=\[
+ 0    -0.3
+ 76000p -0.3
+ 76010p 0.9
+ 78000p 0.9
+ 78010p -0.3
+ \]
V_wl_38 (WordLine\\<38\\> gnd!) vsource type=pwl wave=\[
+ 0    -0.3
+ 78000p -0.3
+ 78010p 0.9
+ 80000p 0.9
+ 80010p -0.3
+ \]
V_wl_39 (WordLine\\<39\\> gnd!) vsource type=pwl wave=\[
+ 0    -0.3
+ 80000p -0.3
+ 80010p 0.9
+ 82000p 0.9
+ 82010p -0.3
+ \]
V_wl_40 (WordLine\\<40\\> gnd!) vsource type=pwl wave=\[
+ 0    -0.3
+ 82000p -0.3
+ 82010p 0.9
+ 84000p 0.9
+ 84010p -0.3
+ \]
V_wl_41 (WordLine\\<41\\> gnd!) vsource type=pwl wave=\[
+ 0    -0.3
+ 84000p -0.3
+ 84010p 0.9
+ 86000p 0.9
+ 86010p -0.3
+ \]
V_wl_42 (WordLine\\<42\\> gnd!) vsource type=pwl wave=\[
+ 0    -0.3
+ 86000p -0.3
+ 86010p 0.9
+ 88000p 0.9
+ 88010p -0.3
+ \]
V_wl_43 (WordLine\\<43\\> gnd!) vsource type=pwl wave=\[
+ 0    -0.3
+ 88000p -0.3
+ 88010p 0.9
+ 90000p 0.9
+ 90010p -0.3
+ \]
V_wl_44 (WordLine\\<44\\> gnd!) vsource type=pwl wave=\[
+ 0    -0.3
+ 90000p -0.3
+ 90010p 0.9
+ 92000p 0.9
+ 92010p -0.3
+ \]
V_wl_45 (WordLine\\<45\\> gnd!) vsource type=pwl wave=\[
+ 0    -0.3
+ 92000p -0.3
+ 92010p 0.9
+ 94000p 0.9
+ 94010p -0.3
+ \]
V_wl_46 (WordLine\\<46\\> gnd!) vsource type=pwl wave=\[
+ 0    -0.3
+ 94000p -0.3
+ 94010p 0.9
+ 96000p 0.9
+ 96010p -0.3
+ \]
V_wl_47 (WordLine\\<47\\> gnd!) vsource type=pwl wave=\[
+ 0    -0.3
+ 96000p -0.3
+ 96010p 0.9
+ 98000p 0.9
+ 98010p -0.3
+ \]
V_wl_48 (WordLine\\<48\\> gnd!) vsource type=pwl wave=\[
+ 0    -0.3
+ 98000p -0.3
+ 98010p 0.9
+ 100000p 0.9
+ 100010p -0.3
+ \]
V_wl_49 (WordLine\\<49\\> gnd!) vsource type=pwl wave=\[
+ 0    -0.3
+ 100000p -0.3
+ 100010p 0.9
+ 102000p 0.9
+ 102010p -0.3
+ \]
V_wl_50 (WordLine\\<50\\> gnd!) vsource type=pwl wave=\[
+ 0    -0.3
+ 102000p -0.3
+ 102010p 0.9
+ 104000p 0.9
+ 104010p -0.3
+ \]
V_wl_51 (WordLine\\<51\\> gnd!) vsource type=pwl wave=\[
+ 0    -0.3
+ 104000p -0.3
+ 104010p 0.9
+ 106000p 0.9
+ 106010p -0.3
+ \]
V_wl_52 (WordLine\\<52\\> gnd!) vsource type=pwl wave=\[
+ 0    -0.3
+ 106000p -0.3
+ 106010p 0.9
+ 108000p 0.9
+ 108010p -0.3
+ \]
V_wl_53 (WordLine\\<53\\> gnd!) vsource type=pwl wave=\[
+ 0    -0.3
+ 108000p -0.3
+ 108010p 0.9
+ 110000p 0.9
+ 110010p -0.3
+ \]
V_wl_54 (WordLine\\<54\\> gnd!) vsource type=pwl wave=\[
+ 0    -0.3
+ 110000p -0.3
+ 110010p 0.9
+ 112000p 0.9
+ 112010p -0.3
+ \]
V_wl_55 (WordLine\\<55\\> gnd!) vsource type=pwl wave=\[
+ 0    -0.3
+ 112000p -0.3
+ 112010p 0.9
+ 114000p 0.9
+ 114010p -0.3
+ \]
V_wl_56 (WordLine\\<56\\> gnd!) vsource type=pwl wave=\[
+ 0    -0.3
+ 114000p -0.3
+ 114010p 0.9
+ 116000p 0.9
+ 116010p -0.3
+ \]
V_wl_57 (WordLine\\<57\\> gnd!) vsource type=pwl wave=\[
+ 0    -0.3
+ 116000p -0.3
+ 116010p 0.9
+ 118000p 0.9
+ 118010p -0.3
+ \]
V_wl_58 (WordLine\\<58\\> gnd!) vsource type=pwl wave=\[
+ 0    -0.3
+ 118000p -0.3
+ 118010p 0.9
+ 120000p 0.9
+ 120010p -0.3
+ \]
V_wl_59 (WordLine\\<59\\> gnd!) vsource type=pwl wave=\[
+ 0    -0.3
+ 120000p -0.3
+ 120010p 0.9
+ 122000p 0.9
+ 122010p -0.3
+ \]
V_wl_60 (WordLine\\<60\\> gnd!) vsource type=pwl wave=\[
+ 0    -0.3
+ 122000p -0.3
+ 122010p 0.9
+ 124000p 0.9
+ 124010p -0.3
+ \]
V_wl_61 (WordLine\\<61\\> gnd!) vsource type=pwl wave=\[
+ 0    -0.3
+ 124000p -0.3
+ 124010p 0.9
+ 126000p 0.9
+ 126010p -0.3
+ \]
V_wl_62 (WordLine\\<62\\> gnd!) vsource type=pwl wave=\[
+ 0    -0.3
+ 126000p -0.3
+ 126010p 0.9
+ 128000p 0.9
+ 128010p -0.3
+ \]
V_wl_63 (WordLine\\<63\\> gnd!) vsource type=pwl wave=\[
+ 0    -0.3
+ 128000p -0.3
+ 128010p 0.9
+ 130000p 0.9
+ 130010p -0.3
+ \]
