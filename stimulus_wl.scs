V_wl_0 (WordLine_bar\\<0\\> gnd!) vsource type=pwl wave=\[
+ 0    0
+ 400p 0
+ 410p 1.2
+ \]
V_wl_1 (WordLine_bar\\<1\\> gnd!) vsource type=pwl wave=\[
+ 0    1.2
+ 400p 1.2
+ 410p 0
+ \]
