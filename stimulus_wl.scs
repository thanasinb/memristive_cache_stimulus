V_wl\\<0\\>  (WordLine_bar\\<0\\> gnd!) vsource type=pwl wave=\[
+ 0    0
+ 500p 0
+ 510p 1.2
+ \]
V_wl\\<1\\> (WordLine_bar\\<1\\> gnd!) vsource type=pwl wave=\[
+ 0    1.2
+ 500p 1.2
+ 510p 0
+ \]
