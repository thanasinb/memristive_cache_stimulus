V_wl_bar_0 (WordLine_bar\\<0\\> gnd!) vsource type=pwl wave=\[
+ 0    0.9
+ 500p 0.9
+ 510p -0.3
+ 1000p -0.3
+ 1010p 0.9
+ \]
V_wl_bar_1 (WordLine_bar\\<1\\> gnd!) vsource type=pwl wave=\[
+ 0    0.9
+ 1500p 0.9
+ 1510p -0.3
+ 2000p -0.3
+ 2010p 0.9
+ \]
V_wl_bar_2 (WordLine_bar\\<2\\> gnd!) vsource type=pwl wave=\[
+ 0    0.9
+ 3500p 0.9
+ 3510p -0.3
+ 4000p -0.3
+ 4010p 0.9
+ \]
V_wl_bar_3 (WordLine_bar\\<3\\> gnd!) vsource type=pwl wave=\[
+ 0    0.9
+ 7500p 0.9
+ 7510p -0.3
+ 8000p -0.3
+ 8010p 0.9
+ \]
V_wl_bar_4 (WordLine_bar\\<4\\> gnd!) vsource type=pwl wave=\[
+ 0    0.9
+ 15500p 0.9
+ 15510p -0.3
+ 16000p -0.3
+ 16010p 0.9
+ \]
V_wl_bar_5 (WordLine_bar\\<5\\> gnd!) vsource type=pwl wave=\[
+ 0    0.9
+ 31500p 0.9
+ 31510p -0.3
+ 32000p -0.3
+ 32010p 0.9
+ \]
V_wl_bar_6 (WordLine_bar\\<6\\> gnd!) vsource type=pwl wave=\[
+ 0    0.9
+ 63500p 0.9
+ 63510p -0.3
+ 64000p -0.3
+ 64010p 0.9
+ \]
V_wl_bar_7 (WordLine_bar\\<7\\> gnd!) vsource type=pwl wave=\[
+ 0    0.9
+ 127500p 0.9
+ 127510p -0.3
+ 128000p -0.3
+ 128010p 0.9
+ \]
V_wl_bar_8 (WordLine_bar\\<8\\> gnd!) vsource type=pwl wave=\[
+ 0    0.9
+ 255500p 0.9
+ 255510p -0.3
+ 256000p -0.3
+ 256010p 0.9
+ \]
V_wl_bar_9 (WordLine_bar\\<9\\> gnd!) vsource type=pwl wave=\[
+ 0    0.9
+ 511500p 0.9
+ 511510p -0.3
+ 512000p -0.3
+ 512010p 0.9
+ \]
V_wl_bar_10 (WordLine_bar\\<10\\> gnd!) vsource type=pwl wave=\[
+ 0    0.9
+ 1023500p 0.9
+ 1023510p -0.3
+ 1024000p -0.3
+ 1024010p 0.9
+ \]
V_wl_bar_11 (WordLine_bar\\<11\\> gnd!) vsource type=pwl wave=\[
+ 0    0.9
+ 2047500p 0.9
+ 2047510p -0.3
+ 2048000p -0.3
+ 2048010p 0.9
+ \]
V_wl_bar_12 (WordLine_bar\\<12\\> gnd!) vsource type=pwl wave=\[
+ 0    0.9
+ 4095500p 0.9
+ 4095510p -0.3
+ 4096000p -0.3
+ 4096010p 0.9
+ \]
V_wl_bar_13 (WordLine_bar\\<13\\> gnd!) vsource type=pwl wave=\[
+ 0    0.9
+ 8191500p 0.9
+ 8191510p -0.3
+ 8192000p -0.3
+ 8192010p 0.9
+ \]
V_wl_bar_14 (WordLine_bar\\<14\\> gnd!) vsource type=pwl wave=\[
+ 0    0.9
+ 16383500p 0.9
+ 16383510p -0.3
+ 16384000p -0.3
+ 16384010p 0.9
+ \]
V_wl_bar_15 (WordLine_bar\\<15\\> gnd!) vsource type=pwl wave=\[
+ 0    0.9
+ 32767500p 0.9
+ 32767510p -0.3
+ 32768000p -0.3
+ 32768010p 0.9
+ \]
V_wl_bar_16 (WordLine_bar\\<16\\> gnd!) vsource type=pwl wave=\[
+ 0    0.9
+ 65535500p 0.9
+ 65535510p -0.3
+ 65536000p -0.3
+ 65536010p 0.9
+ \]
V_wl_bar_17 (WordLine_bar\\<17\\> gnd!) vsource type=pwl wave=\[
+ 0    0.9
+ 131071500p 0.9
+ 131071510p -0.3
+ 131072000p -0.3
+ 131072010p 0.9
+ \]
V_wl_bar_18 (WordLine_bar\\<18\\> gnd!) vsource type=pwl wave=\[
+ 0    0.9
+ 262143500p 0.9
+ 262143510p -0.3
+ 262144000p -0.3
+ 262144010p 0.9
+ \]
V_wl_bar_19 (WordLine_bar\\<19\\> gnd!) vsource type=pwl wave=\[
+ 0    0.9
+ 524287500p 0.9
+ 524287510p -0.3
+ 524288000p -0.3
+ 524288010p 0.9
+ \]
V_wl_bar_20 (WordLine_bar\\<20\\> gnd!) vsource type=pwl wave=\[
+ 0    0.9
+ 1048575500p 0.9
+ 1048575510p -0.3
+ 1048576000p -0.3
+ 1048576010p 0.9
+ \]
V_wl_bar_21 (WordLine_bar\\<21\\> gnd!) vsource type=pwl wave=\[
+ 0    0.9
+ 2097151500p 0.9
+ 2097151510p -0.3
+ 2097152000p -0.3
+ 2097152010p 0.9
+ \]
V_wl_bar_22 (WordLine_bar\\<22\\> gnd!) vsource type=pwl wave=\[
+ 0    0.9
+ 4194303500p 0.9
+ 4194303510p -0.3
+ 4194304000p -0.3
+ 4194304010p 0.9
+ \]
V_wl_bar_23 (WordLine_bar\\<23\\> gnd!) vsource type=pwl wave=\[
+ 0    0.9
+ 8388607500p 0.9
+ 8388607510p -0.3
+ 8388608000p -0.3
+ 8388608010p 0.9
+ \]
V_wl_bar_24 (WordLine_bar\\<24\\> gnd!) vsource type=pwl wave=\[
+ 0    0.9
+ 16777215500p 0.9
+ 16777215510p -0.3
+ 16777216000p -0.3
+ 16777216010p 0.9
+ \]
V_wl_bar_25 (WordLine_bar\\<25\\> gnd!) vsource type=pwl wave=\[
+ 0    0.9
+ 33554431500p 0.9
+ 33554431510p -0.3
+ 33554432000p -0.3
+ 33554432010p 0.9
+ \]
V_wl_bar_26 (WordLine_bar\\<26\\> gnd!) vsource type=pwl wave=\[
+ 0    0.9
+ 67108863500p 0.9
+ 67108863510p -0.3
+ 67108864000p -0.3
+ 67108864010p 0.9
+ \]
V_wl_bar_27 (WordLine_bar\\<27\\> gnd!) vsource type=pwl wave=\[
+ 0    0.9
+ 134217727500p 0.9
+ 134217727510p -0.3
+ 134217728000p -0.3
+ 134217728010p 0.9
+ \]
V_wl_bar_28 (WordLine_bar\\<28\\> gnd!) vsource type=pwl wave=\[
+ 0    0.9
+ 268435455500p 0.9
+ 268435455510p -0.3
+ 268435456000p -0.3
+ 268435456010p 0.9
+ \]
V_wl_bar_29 (WordLine_bar\\<29\\> gnd!) vsource type=pwl wave=\[
+ 0    0.9
+ 536870911500p 0.9
+ 536870911510p -0.3
+ 536870912000p -0.3
+ 536870912010p 0.9
+ \]
V_wl_bar_30 (WordLine_bar\\<30\\> gnd!) vsource type=pwl wave=\[
+ 0    0.9
+ 1073741823500p 0.9
+ 1073741823510p -0.3
+ 1073741824000p -0.3
+ 1073741824010p 0.9
+ \]
V_wl_bar_31 (WordLine_bar\\<31\\> gnd!) vsource type=pwl wave=\[
+ 0    0.9
+ 2147483647500p 0.9
+ 2147483647510p -0.3
+ 2147483648000p -0.3
+ 2147483648010p 0.9
+ \]
V_wl_bar_32 (WordLine_bar\\<32\\> gnd!) vsource type=pwl wave=\[
+ 0    0.9
+ 4294967295500p 0.9
+ 4294967295510p -0.3
+ 4294967296000p -0.3
+ 4294967296010p 0.9
+ \]
V_wl_bar_33 (WordLine_bar\\<33\\> gnd!) vsource type=pwl wave=\[
+ 0    0.9
+ 8589934591500p 0.9
+ 8589934591510p -0.3
+ 8589934592000p -0.3
+ 8589934592010p 0.9
+ \]
V_wl_bar_34 (WordLine_bar\\<34\\> gnd!) vsource type=pwl wave=\[
+ 0    0.9
+ 17179869183500p 0.9
+ 17179869183510p -0.3
+ 17179869184000p -0.3
+ 17179869184010p 0.9
+ \]
V_wl_bar_35 (WordLine_bar\\<35\\> gnd!) vsource type=pwl wave=\[
+ 0    0.9
+ 34359738367500p 0.9
+ 34359738367510p -0.3
+ 34359738368000p -0.3
+ 34359738368010p 0.9
+ \]
V_wl_bar_36 (WordLine_bar\\<36\\> gnd!) vsource type=pwl wave=\[
+ 0    0.9
+ 68719476735500p 0.9
+ 68719476735510p -0.3
+ 68719476736000p -0.3
+ 68719476736010p 0.9
+ \]
V_wl_bar_37 (WordLine_bar\\<37\\> gnd!) vsource type=pwl wave=\[
+ 0    0.9
+ 137438953471500p 0.9
+ 137438953471510p -0.3
+ 137438953472000p -0.3
+ 137438953472010p 0.9
+ \]
V_wl_bar_38 (WordLine_bar\\<38\\> gnd!) vsource type=pwl wave=\[
+ 0    0.9
+ 274877906943500p 0.9
+ 274877906943510p -0.3
+ 274877906944000p -0.3
+ 274877906944010p 0.9
+ \]
V_wl_bar_39 (WordLine_bar\\<39\\> gnd!) vsource type=pwl wave=\[
+ 0    0.9
+ 549755813887500p 0.9
+ 549755813887510p -0.3
+ 549755813888000p -0.3
+ 549755813888010p 0.9
+ \]
V_wl_bar_40 (WordLine_bar\\<40\\> gnd!) vsource type=pwl wave=\[
+ 0    0.9
+ 1099511627775500p 0.9
+ 1099511627775510p -0.3
+ 1099511627776000p -0.3
+ 1099511627776010p 0.9
+ \]
V_wl_bar_41 (WordLine_bar\\<41\\> gnd!) vsource type=pwl wave=\[
+ 0    0.9
+ 2199023255551500p 0.9
+ 2199023255551510p -0.3
+ 2199023255552000p -0.3
+ 2199023255552010p 0.9
+ \]
V_wl_bar_42 (WordLine_bar\\<42\\> gnd!) vsource type=pwl wave=\[
+ 0    0.9
+ 4398046511103500p 0.9
+ 4398046511103510p -0.3
+ 4398046511104000p -0.3
+ 4398046511104010p 0.9
+ \]
V_wl_bar_43 (WordLine_bar\\<43\\> gnd!) vsource type=pwl wave=\[
+ 0    0.9
+ 8796093022207500p 0.9
+ 8796093022207510p -0.3
+ 8796093022208000p -0.3
+ 8796093022208010p 0.9
+ \]
V_wl_bar_44 (WordLine_bar\\<44\\> gnd!) vsource type=pwl wave=\[
+ 0    0.9
+ 17592186044415500p 0.9
+ 17592186044415510p -0.3
+ 17592186044416000p -0.3
+ 17592186044416010p 0.9
+ \]
V_wl_bar_45 (WordLine_bar\\<45\\> gnd!) vsource type=pwl wave=\[
+ 0    0.9
+ 35184372088831500p 0.9
+ 35184372088831510p -0.3
+ 35184372088832000p -0.3
+ 35184372088832010p 0.9
+ \]
V_wl_bar_46 (WordLine_bar\\<46\\> gnd!) vsource type=pwl wave=\[
+ 0    0.9
+ 70368744177663500p 0.9
+ 70368744177663510p -0.3
+ 70368744177664000p -0.3
+ 70368744177664010p 0.9
+ \]
V_wl_bar_47 (WordLine_bar\\<47\\> gnd!) vsource type=pwl wave=\[
+ 0    0.9
+ 140737488355327500p 0.9
+ 140737488355327510p -0.3
+ 140737488355328000p -0.3
+ 140737488355328010p 0.9
+ \]
V_wl_bar_48 (WordLine_bar\\<48\\> gnd!) vsource type=pwl wave=\[
+ 0    0.9
+ 281474976710655500p 0.9
+ 281474976710655510p -0.3
+ 281474976710656000p -0.3
+ 281474976710656010p 0.9
+ \]
V_wl_bar_49 (WordLine_bar\\<49\\> gnd!) vsource type=pwl wave=\[
+ 0    0.9
+ 562949953421311500p 0.9
+ 562949953421311510p -0.3
+ 562949953421312000p -0.3
+ 562949953421312010p 0.9
+ \]
V_wl_bar_50 (WordLine_bar\\<50\\> gnd!) vsource type=pwl wave=\[
+ 0    0.9
+ 1125899906842623500p 0.9
+ 1125899906842623510p -0.3
+ 1125899906842624000p -0.3
+ 1125899906842624010p 0.9
+ \]
V_wl_bar_51 (WordLine_bar\\<51\\> gnd!) vsource type=pwl wave=\[
+ 0    0.9
+ 2251799813685247500p 0.9
+ 2251799813685247510p -0.3
+ 2251799813685248000p -0.3
+ 2251799813685248010p 0.9
+ \]
V_wl_bar_52 (WordLine_bar\\<52\\> gnd!) vsource type=pwl wave=\[
+ 0    0.9
+ 4503599627370495500p 0.9
+ 4503599627370495510p -0.3
+ 4503599627370496000p -0.3
+ 4503599627370496010p 0.9
+ \]
V_wl_bar_53 (WordLine_bar\\<53\\> gnd!) vsource type=pwl wave=\[
+ 0    0.9
+ 9007199254740991500p 0.9
+ 9007199254740991510p -0.3
+ 9007199254740992000p -0.3
+ 9007199254740992010p 0.9
+ \]
V_wl_bar_54 (WordLine_bar\\<54\\> gnd!) vsource type=pwl wave=\[
+ 0    0.9
+ 18014398509481983500p 0.9
+ 18014398509481983510p -0.3
+ 18014398509481984000p -0.3
+ 18014398509481984010p 0.9
+ \]
V_wl_bar_55 (WordLine_bar\\<55\\> gnd!) vsource type=pwl wave=\[
+ 0    0.9
+ 36028797018963967500p 0.9
+ 36028797018963967510p -0.3
+ 36028797018963968000p -0.3
+ 36028797018963968010p 0.9
+ \]
V_wl_bar_56 (WordLine_bar\\<56\\> gnd!) vsource type=pwl wave=\[
+ 0    0.9
+ 72057594037927935500p 0.9
+ 72057594037927935510p -0.3
+ 72057594037927936000p -0.3
+ 72057594037927936010p 0.9
+ \]
V_wl_bar_57 (WordLine_bar\\<57\\> gnd!) vsource type=pwl wave=\[
+ 0    0.9
+ 144115188075855871500p 0.9
+ 144115188075855871510p -0.3
+ 144115188075855872000p -0.3
+ 144115188075855872010p 0.9
+ \]
V_wl_bar_58 (WordLine_bar\\<58\\> gnd!) vsource type=pwl wave=\[
+ 0    0.9
+ 288230376151711743500p 0.9
+ 288230376151711743510p -0.3
+ 288230376151711744000p -0.3
+ 288230376151711744010p 0.9
+ \]
V_wl_bar_59 (WordLine_bar\\<59\\> gnd!) vsource type=pwl wave=\[
+ 0    0.9
+ 576460752303423487500p 0.9
+ 576460752303423487510p -0.3
+ 576460752303423488000p -0.3
+ 576460752303423488010p 0.9
+ \]
V_wl_bar_60 (WordLine_bar\\<60\\> gnd!) vsource type=pwl wave=\[
+ 0    0.9
+ 1152921504606846975500p 0.9
+ 1152921504606846975510p -0.3
+ 1152921504606846976000p -0.3
+ 1152921504606846976010p 0.9
+ \]
V_wl_bar_61 (WordLine_bar\\<61\\> gnd!) vsource type=pwl wave=\[
+ 0    0.9
+ 2305843009213693951500p 0.9
+ 2305843009213693951510p -0.3
+ 2305843009213693952000p -0.3
+ 2305843009213693952010p 0.9
+ \]
V_wl_bar_62 (WordLine_bar\\<62\\> gnd!) vsource type=pwl wave=\[
+ 0    0.9
+ 4611686018427387903500p 0.9
+ 4611686018427387903510p -0.3
+ 4611686018427387904000p -0.3
+ 4611686018427387904010p 0.9
+ \]
V_wl_bar_63 (WordLine_bar\\<63\\> gnd!) vsource type=pwl wave=\[
+ 0    0.9
+ 9223372036854775807500p 0.9
+ 9223372036854775807510p -0.3
+ 9223372036854775808000p -0.3
+ 9223372036854775808010p 0.9
+ \]
V_wl_bar_64 (WordLine_bar\\<64\\> gnd!) vsource type=pwl wave=\[
+ 0    0.9
+ 18446744073709551615500p 0.9
+ 18446744073709551615510p -0.3
+ 18446744073709551616000p -0.3
+ 18446744073709551616010p 0.9
+ \]
V_wl_bar_65 (WordLine_bar\\<65\\> gnd!) vsource type=pwl wave=\[
+ 0    0.9
+ 36893488147419103231500p 0.9
+ 36893488147419103231510p -0.3
+ 36893488147419103232000p -0.3
+ 36893488147419103232010p 0.9
+ \]
V_wl_bar_66 (WordLine_bar\\<66\\> gnd!) vsource type=pwl wave=\[
+ 0    0.9
+ 73786976294838206463500p 0.9
+ 73786976294838206463510p -0.3
+ 73786976294838206464000p -0.3
+ 73786976294838206464010p 0.9
+ \]
V_wl_bar_67 (WordLine_bar\\<67\\> gnd!) vsource type=pwl wave=\[
+ 0    0.9
+ 147573952589676412927500p 0.9
+ 147573952589676412927510p -0.3
+ 147573952589676412928000p -0.3
+ 147573952589676412928010p 0.9
+ \]
V_wl_bar_68 (WordLine_bar\\<68\\> gnd!) vsource type=pwl wave=\[
+ 0    0.9
+ 295147905179352825855500p 0.9
+ 295147905179352825855510p -0.3
+ 295147905179352825856000p -0.3
+ 295147905179352825856010p 0.9
+ \]
V_wl_bar_69 (WordLine_bar\\<69\\> gnd!) vsource type=pwl wave=\[
+ 0    0.9
+ 590295810358705651711500p 0.9
+ 590295810358705651711510p -0.3
+ 590295810358705651712000p -0.3
+ 590295810358705651712010p 0.9
+ \]
V_wl_bar_70 (WordLine_bar\\<70\\> gnd!) vsource type=pwl wave=\[
+ 0    0.9
+ 1180591620717411303423500p 0.9
+ 1180591620717411303423510p -0.3
+ 1180591620717411303424000p -0.3
+ 1180591620717411303424010p 0.9
+ \]
V_wl_bar_71 (WordLine_bar\\<71\\> gnd!) vsource type=pwl wave=\[
+ 0    0.9
+ 2361183241434822606847500p 0.9
+ 2361183241434822606847510p -0.3
+ 2361183241434822606848000p -0.3
+ 2361183241434822606848010p 0.9
+ \]
V_wl_bar_72 (WordLine_bar\\<72\\> gnd!) vsource type=pwl wave=\[
+ 0    0.9
+ 4722366482869645213695500p 0.9
+ 4722366482869645213695510p -0.3
+ 4722366482869645213696000p -0.3
+ 4722366482869645213696010p 0.9
+ \]
V_wl_bar_73 (WordLine_bar\\<73\\> gnd!) vsource type=pwl wave=\[
+ 0    0.9
+ 9444732965739290427391500p 0.9
+ 9444732965739290427391510p -0.3
+ 9444732965739290427392000p -0.3
+ 9444732965739290427392010p 0.9
+ \]
V_wl_bar_74 (WordLine_bar\\<74\\> gnd!) vsource type=pwl wave=\[
+ 0    0.9
+ 18889465931478580854783500p 0.9
+ 18889465931478580854783510p -0.3
+ 18889465931478580854784000p -0.3
+ 18889465931478580854784010p 0.9
+ \]
V_wl_bar_75 (WordLine_bar\\<75\\> gnd!) vsource type=pwl wave=\[
+ 0    0.9
+ 37778931862957161709567500p 0.9
+ 37778931862957161709567510p -0.3
+ 37778931862957161709568000p -0.3
+ 37778931862957161709568010p 0.9
+ \]
V_wl_bar_76 (WordLine_bar\\<76\\> gnd!) vsource type=pwl wave=\[
+ 0    0.9
+ 75557863725914323419135500p 0.9
+ 75557863725914323419135510p -0.3
+ 75557863725914323419136000p -0.3
+ 75557863725914323419136010p 0.9
+ \]
V_wl_bar_77 (WordLine_bar\\<77\\> gnd!) vsource type=pwl wave=\[
+ 0    0.9
+ 151115727451828646838271500p 0.9
+ 151115727451828646838271510p -0.3
+ 151115727451828646838272000p -0.3
+ 151115727451828646838272010p 0.9
+ \]
V_wl_bar_78 (WordLine_bar\\<78\\> gnd!) vsource type=pwl wave=\[
+ 0    0.9
+ 302231454903657293676543500p 0.9
+ 302231454903657293676543510p -0.3
+ 302231454903657293676544000p -0.3
+ 302231454903657293676544010p 0.9
+ \]
V_wl_bar_79 (WordLine_bar\\<79\\> gnd!) vsource type=pwl wave=\[
+ 0    0.9
+ 604462909807314587353087500p 0.9
+ 604462909807314587353087510p -0.3
+ 604462909807314587353088000p -0.3
+ 604462909807314587353088010p 0.9
+ \]
V_wl_bar_80 (WordLine_bar\\<80\\> gnd!) vsource type=pwl wave=\[
+ 0    0.9
+ 1208925819614629174706175500p 0.9
+ 1208925819614629174706175510p -0.3
+ 1208925819614629174706176000p -0.3
+ 1208925819614629174706176010p 0.9
+ \]
V_wl_bar_81 (WordLine_bar\\<81\\> gnd!) vsource type=pwl wave=\[
+ 0    0.9
+ 2417851639229258349412351500p 0.9
+ 2417851639229258349412351510p -0.3
+ 2417851639229258349412352000p -0.3
+ 2417851639229258349412352010p 0.9
+ \]
V_wl_bar_82 (WordLine_bar\\<82\\> gnd!) vsource type=pwl wave=\[
+ 0    0.9
+ 4835703278458516698824703500p 0.9
+ 4835703278458516698824703510p -0.3
+ 4835703278458516698824704000p -0.3
+ 4835703278458516698824704010p 0.9
+ \]
V_wl_bar_83 (WordLine_bar\\<83\\> gnd!) vsource type=pwl wave=\[
+ 0    0.9
+ 9671406556917033397649407500p 0.9
+ 9671406556917033397649407510p -0.3
+ 9671406556917033397649408000p -0.3
+ 9671406556917033397649408010p 0.9
+ \]
V_wl_bar_84 (WordLine_bar\\<84\\> gnd!) vsource type=pwl wave=\[
+ 0    0.9
+ 19342813113834066795298815500p 0.9
+ 19342813113834066795298815510p -0.3
+ 19342813113834066795298816000p -0.3
+ 19342813113834066795298816010p 0.9
+ \]
V_wl_bar_85 (WordLine_bar\\<85\\> gnd!) vsource type=pwl wave=\[
+ 0    0.9
+ 38685626227668133590597631500p 0.9
+ 38685626227668133590597631510p -0.3
+ 38685626227668133590597632000p -0.3
+ 38685626227668133590597632010p 0.9
+ \]
V_wl_bar_86 (WordLine_bar\\<86\\> gnd!) vsource type=pwl wave=\[
+ 0    0.9
+ 77371252455336267181195263500p 0.9
+ 77371252455336267181195263510p -0.3
+ 77371252455336267181195264000p -0.3
+ 77371252455336267181195264010p 0.9
+ \]
V_wl_bar_87 (WordLine_bar\\<87\\> gnd!) vsource type=pwl wave=\[
+ 0    0.9
+ 154742504910672534362390527500p 0.9
+ 154742504910672534362390527510p -0.3
+ 154742504910672534362390528000p -0.3
+ 154742504910672534362390528010p 0.9
+ \]
V_wl_bar_88 (WordLine_bar\\<88\\> gnd!) vsource type=pwl wave=\[
+ 0    0.9
+ 309485009821345068724781055500p 0.9
+ 309485009821345068724781055510p -0.3
+ 309485009821345068724781056000p -0.3
+ 309485009821345068724781056010p 0.9
+ \]
V_wl_bar_89 (WordLine_bar\\<89\\> gnd!) vsource type=pwl wave=\[
+ 0    0.9
+ 618970019642690137449562111500p 0.9
+ 618970019642690137449562111510p -0.3
+ 618970019642690137449562112000p -0.3
+ 618970019642690137449562112010p 0.9
+ \]
V_wl_bar_90 (WordLine_bar\\<90\\> gnd!) vsource type=pwl wave=\[
+ 0    0.9
+ 1237940039285380274899124223500p 0.9
+ 1237940039285380274899124223510p -0.3
+ 1237940039285380274899124224000p -0.3
+ 1237940039285380274899124224010p 0.9
+ \]
V_wl_bar_91 (WordLine_bar\\<91\\> gnd!) vsource type=pwl wave=\[
+ 0    0.9
+ 2475880078570760549798248447500p 0.9
+ 2475880078570760549798248447510p -0.3
+ 2475880078570760549798248448000p -0.3
+ 2475880078570760549798248448010p 0.9
+ \]
V_wl_bar_92 (WordLine_bar\\<92\\> gnd!) vsource type=pwl wave=\[
+ 0    0.9
+ 4951760157141521099596496895500p 0.9
+ 4951760157141521099596496895510p -0.3
+ 4951760157141521099596496896000p -0.3
+ 4951760157141521099596496896010p 0.9
+ \]
V_wl_bar_93 (WordLine_bar\\<93\\> gnd!) vsource type=pwl wave=\[
+ 0    0.9
+ 9903520314283042199192993791500p 0.9
+ 9903520314283042199192993791510p -0.3
+ 9903520314283042199192993792000p -0.3
+ 9903520314283042199192993792010p 0.9
+ \]
V_wl_bar_94 (WordLine_bar\\<94\\> gnd!) vsource type=pwl wave=\[
+ 0    0.9
+ 19807040628566084398385987583500p 0.9
+ 19807040628566084398385987583510p -0.3
+ 19807040628566084398385987584000p -0.3
+ 19807040628566084398385987584010p 0.9
+ \]
V_wl_bar_95 (WordLine_bar\\<95\\> gnd!) vsource type=pwl wave=\[
+ 0    0.9
+ 39614081257132168796771975167500p 0.9
+ 39614081257132168796771975167510p -0.3
+ 39614081257132168796771975168000p -0.3
+ 39614081257132168796771975168010p 0.9
+ \]
V_wl_bar_96 (WordLine_bar\\<96\\> gnd!) vsource type=pwl wave=\[
+ 0    0.9
+ 79228162514264337593543950335500p 0.9
+ 79228162514264337593543950335510p -0.3
+ 79228162514264337593543950336000p -0.3
+ 79228162514264337593543950336010p 0.9
+ \]
V_wl_bar_97 (WordLine_bar\\<97\\> gnd!) vsource type=pwl wave=\[
+ 0    0.9
+ 158456325028528675187087900671500p 0.9
+ 158456325028528675187087900671510p -0.3
+ 158456325028528675187087900672000p -0.3
+ 158456325028528675187087900672010p 0.9
+ \]
V_wl_bar_98 (WordLine_bar\\<98\\> gnd!) vsource type=pwl wave=\[
+ 0    0.9
+ 316912650057057350374175801343500p 0.9
+ 316912650057057350374175801343510p -0.3
+ 316912650057057350374175801344000p -0.3
+ 316912650057057350374175801344010p 0.9
+ \]
V_wl_bar_99 (WordLine_bar\\<99\\> gnd!) vsource type=pwl wave=\[
+ 0    0.9
+ 633825300114114700748351602687500p 0.9
+ 633825300114114700748351602687510p -0.3
+ 633825300114114700748351602688000p -0.3
+ 633825300114114700748351602688010p 0.9
+ \]
V_wl_bar_100 (WordLine_bar\\<100\\> gnd!) vsource type=pwl wave=\[
+ 0    0.9
+ 1267650600228229401496703205375500p 0.9
+ 1267650600228229401496703205375510p -0.3
+ 1267650600228229401496703205376000p -0.3
+ 1267650600228229401496703205376010p 0.9
+ \]
V_wl_bar_101 (WordLine_bar\\<101\\> gnd!) vsource type=pwl wave=\[
+ 0    0.9
+ 2535301200456458802993406410751500p 0.9
+ 2535301200456458802993406410751510p -0.3
+ 2535301200456458802993406410752000p -0.3
+ 2535301200456458802993406410752010p 0.9
+ \]
V_wl_bar_102 (WordLine_bar\\<102\\> gnd!) vsource type=pwl wave=\[
+ 0    0.9
+ 5070602400912917605986812821503500p 0.9
+ 5070602400912917605986812821503510p -0.3
+ 5070602400912917605986812821504000p -0.3
+ 5070602400912917605986812821504010p 0.9
+ \]
V_wl_bar_103 (WordLine_bar\\<103\\> gnd!) vsource type=pwl wave=\[
+ 0    0.9
+ 10141204801825835211973625643007500p 0.9
+ 10141204801825835211973625643007510p -0.3
+ 10141204801825835211973625643008000p -0.3
+ 10141204801825835211973625643008010p 0.9
+ \]
V_wl_bar_104 (WordLine_bar\\<104\\> gnd!) vsource type=pwl wave=\[
+ 0    0.9
+ 20282409603651670423947251286015500p 0.9
+ 20282409603651670423947251286015510p -0.3
+ 20282409603651670423947251286016000p -0.3
+ 20282409603651670423947251286016010p 0.9
+ \]
V_wl_bar_105 (WordLine_bar\\<105\\> gnd!) vsource type=pwl wave=\[
+ 0    0.9
+ 40564819207303340847894502572031500p 0.9
+ 40564819207303340847894502572031510p -0.3
+ 40564819207303340847894502572032000p -0.3
+ 40564819207303340847894502572032010p 0.9
+ \]
V_wl_bar_106 (WordLine_bar\\<106\\> gnd!) vsource type=pwl wave=\[
+ 0    0.9
+ 81129638414606681695789005144063500p 0.9
+ 81129638414606681695789005144063510p -0.3
+ 81129638414606681695789005144064000p -0.3
+ 81129638414606681695789005144064010p 0.9
+ \]
V_wl_bar_107 (WordLine_bar\\<107\\> gnd!) vsource type=pwl wave=\[
+ 0    0.9
+ 162259276829213363391578010288127500p 0.9
+ 162259276829213363391578010288127510p -0.3
+ 162259276829213363391578010288128000p -0.3
+ 162259276829213363391578010288128010p 0.9
+ \]
V_wl_bar_108 (WordLine_bar\\<108\\> gnd!) vsource type=pwl wave=\[
+ 0    0.9
+ 324518553658426726783156020576255500p 0.9
+ 324518553658426726783156020576255510p -0.3
+ 324518553658426726783156020576256000p -0.3
+ 324518553658426726783156020576256010p 0.9
+ \]
V_wl_bar_109 (WordLine_bar\\<109\\> gnd!) vsource type=pwl wave=\[
+ 0    0.9
+ 649037107316853453566312041152511500p 0.9
+ 649037107316853453566312041152511510p -0.3
+ 649037107316853453566312041152512000p -0.3
+ 649037107316853453566312041152512010p 0.9
+ \]
V_wl_bar_110 (WordLine_bar\\<110\\> gnd!) vsource type=pwl wave=\[
+ 0    0.9
+ 1298074214633706907132624082305023500p 0.9
+ 1298074214633706907132624082305023510p -0.3
+ 1298074214633706907132624082305024000p -0.3
+ 1298074214633706907132624082305024010p 0.9
+ \]
V_wl_bar_111 (WordLine_bar\\<111\\> gnd!) vsource type=pwl wave=\[
+ 0    0.9
+ 2596148429267413814265248164610047500p 0.9
+ 2596148429267413814265248164610047510p -0.3
+ 2596148429267413814265248164610048000p -0.3
+ 2596148429267413814265248164610048010p 0.9
+ \]
V_wl_bar_112 (WordLine_bar\\<112\\> gnd!) vsource type=pwl wave=\[
+ 0    0.9
+ 5192296858534827628530496329220095500p 0.9
+ 5192296858534827628530496329220095510p -0.3
+ 5192296858534827628530496329220096000p -0.3
+ 5192296858534827628530496329220096010p 0.9
+ \]
V_wl_bar_113 (WordLine_bar\\<113\\> gnd!) vsource type=pwl wave=\[
+ 0    0.9
+ 10384593717069655257060992658440191500p 0.9
+ 10384593717069655257060992658440191510p -0.3
+ 10384593717069655257060992658440192000p -0.3
+ 10384593717069655257060992658440192010p 0.9
+ \]
V_wl_bar_114 (WordLine_bar\\<114\\> gnd!) vsource type=pwl wave=\[
+ 0    0.9
+ 20769187434139310514121985316880383500p 0.9
+ 20769187434139310514121985316880383510p -0.3
+ 20769187434139310514121985316880384000p -0.3
+ 20769187434139310514121985316880384010p 0.9
+ \]
V_wl_bar_115 (WordLine_bar\\<115\\> gnd!) vsource type=pwl wave=\[
+ 0    0.9
+ 41538374868278621028243970633760767500p 0.9
+ 41538374868278621028243970633760767510p -0.3
+ 41538374868278621028243970633760768000p -0.3
+ 41538374868278621028243970633760768010p 0.9
+ \]
V_wl_bar_116 (WordLine_bar\\<116\\> gnd!) vsource type=pwl wave=\[
+ 0    0.9
+ 83076749736557242056487941267521535500p 0.9
+ 83076749736557242056487941267521535510p -0.3
+ 83076749736557242056487941267521536000p -0.3
+ 83076749736557242056487941267521536010p 0.9
+ \]
V_wl_bar_117 (WordLine_bar\\<117\\> gnd!) vsource type=pwl wave=\[
+ 0    0.9
+ 166153499473114484112975882535043071500p 0.9
+ 166153499473114484112975882535043071510p -0.3
+ 166153499473114484112975882535043072000p -0.3
+ 166153499473114484112975882535043072010p 0.9
+ \]
V_wl_bar_118 (WordLine_bar\\<118\\> gnd!) vsource type=pwl wave=\[
+ 0    0.9
+ 332306998946228968225951765070086143500p 0.9
+ 332306998946228968225951765070086143510p -0.3
+ 332306998946228968225951765070086144000p -0.3
+ 332306998946228968225951765070086144010p 0.9
+ \]
V_wl_bar_119 (WordLine_bar\\<119\\> gnd!) vsource type=pwl wave=\[
+ 0    0.9
+ 664613997892457936451903530140172287500p 0.9
+ 664613997892457936451903530140172287510p -0.3
+ 664613997892457936451903530140172288000p -0.3
+ 664613997892457936451903530140172288010p 0.9
+ \]
V_wl_bar_120 (WordLine_bar\\<120\\> gnd!) vsource type=pwl wave=\[
+ 0    0.9
+ 1329227995784915872903807060280344575500p 0.9
+ 1329227995784915872903807060280344575510p -0.3
+ 1329227995784915872903807060280344576000p -0.3
+ 1329227995784915872903807060280344576010p 0.9
+ \]
V_wl_bar_121 (WordLine_bar\\<121\\> gnd!) vsource type=pwl wave=\[
+ 0    0.9
+ 2658455991569831745807614120560689151500p 0.9
+ 2658455991569831745807614120560689151510p -0.3
+ 2658455991569831745807614120560689152000p -0.3
+ 2658455991569831745807614120560689152010p 0.9
+ \]
V_wl_bar_122 (WordLine_bar\\<122\\> gnd!) vsource type=pwl wave=\[
+ 0    0.9
+ 5316911983139663491615228241121378303500p 0.9
+ 5316911983139663491615228241121378303510p -0.3
+ 5316911983139663491615228241121378304000p -0.3
+ 5316911983139663491615228241121378304010p 0.9
+ \]
V_wl_bar_123 (WordLine_bar\\<123\\> gnd!) vsource type=pwl wave=\[
+ 0    0.9
+ 10633823966279326983230456482242756607500p 0.9
+ 10633823966279326983230456482242756607510p -0.3
+ 10633823966279326983230456482242756608000p -0.3
+ 10633823966279326983230456482242756608010p 0.9
+ \]
V_wl_bar_124 (WordLine_bar\\<124\\> gnd!) vsource type=pwl wave=\[
+ 0    0.9
+ 21267647932558653966460912964485513215500p 0.9
+ 21267647932558653966460912964485513215510p -0.3
+ 21267647932558653966460912964485513216000p -0.3
+ 21267647932558653966460912964485513216010p 0.9
+ \]
V_wl_bar_125 (WordLine_bar\\<125\\> gnd!) vsource type=pwl wave=\[
+ 0    0.9
+ 42535295865117307932921825928971026431500p 0.9
+ 42535295865117307932921825928971026431510p -0.3
+ 42535295865117307932921825928971026432000p -0.3
+ 42535295865117307932921825928971026432010p 0.9
+ \]
V_wl_bar_126 (WordLine_bar\\<126\\> gnd!) vsource type=pwl wave=\[
+ 0    0.9
+ 85070591730234615865843651857942052863500p 0.9
+ 85070591730234615865843651857942052863510p -0.3
+ 85070591730234615865843651857942052864000p -0.3
+ 85070591730234615865843651857942052864010p 0.9
+ \]
V_wl_bar_127 (WordLine_bar\\<127\\> gnd!) vsource type=pwl wave=\[
+ 0    0.9
+ 170141183460469231731687303715884105727500p 0.9
+ 170141183460469231731687303715884105727510p -0.3
+ 170141183460469231731687303715884105728000p -0.3
+ 170141183460469231731687303715884105728010p 0.9
+ \]
V_wl_bar_128 (WordLine_bar\\<128\\> gnd!) vsource type=pwl wave=\[
+ 0    0.9
+ 340282366920938463463374607431768211455500p 0.9
+ 340282366920938463463374607431768211455510p -0.3
+ 340282366920938463463374607431768211456000p -0.3
+ 340282366920938463463374607431768211456010p 0.9
+ \]
V_wl_bar_129 (WordLine_bar\\<129\\> gnd!) vsource type=pwl wave=\[
+ 0    0.9
+ 680564733841876926926749214863536422911500p 0.9
+ 680564733841876926926749214863536422911510p -0.3
+ 680564733841876926926749214863536422912000p -0.3
+ 680564733841876926926749214863536422912010p 0.9
+ \]
V_wl_bar_130 (WordLine_bar\\<130\\> gnd!) vsource type=pwl wave=\[
+ 0    0.9
+ 1361129467683753853853498429727072845823500p 0.9
+ 1361129467683753853853498429727072845823510p -0.3
+ 1361129467683753853853498429727072845824000p -0.3
+ 1361129467683753853853498429727072845824010p 0.9
+ \]
V_wl_bar_131 (WordLine_bar\\<131\\> gnd!) vsource type=pwl wave=\[
+ 0    0.9
+ 2722258935367507707706996859454145691647500p 0.9
+ 2722258935367507707706996859454145691647510p -0.3
+ 2722258935367507707706996859454145691648000p -0.3
+ 2722258935367507707706996859454145691648010p 0.9
+ \]
V_wl_bar_132 (WordLine_bar\\<132\\> gnd!) vsource type=pwl wave=\[
+ 0    0.9
+ 5444517870735015415413993718908291383295500p 0.9
+ 5444517870735015415413993718908291383295510p -0.3
+ 5444517870735015415413993718908291383296000p -0.3
+ 5444517870735015415413993718908291383296010p 0.9
+ \]
V_wl_bar_133 (WordLine_bar\\<133\\> gnd!) vsource type=pwl wave=\[
+ 0    0.9
+ 10889035741470030830827987437816582766591500p 0.9
+ 10889035741470030830827987437816582766591510p -0.3
+ 10889035741470030830827987437816582766592000p -0.3
+ 10889035741470030830827987437816582766592010p 0.9
+ \]
V_wl_bar_134 (WordLine_bar\\<134\\> gnd!) vsource type=pwl wave=\[
+ 0    0.9
+ 21778071482940061661655974875633165533183500p 0.9
+ 21778071482940061661655974875633165533183510p -0.3
+ 21778071482940061661655974875633165533184000p -0.3
+ 21778071482940061661655974875633165533184010p 0.9
+ \]
V_wl_bar_135 (WordLine_bar\\<135\\> gnd!) vsource type=pwl wave=\[
+ 0    0.9
+ 43556142965880123323311949751266331066367500p 0.9
+ 43556142965880123323311949751266331066367510p -0.3
+ 43556142965880123323311949751266331066368000p -0.3
+ 43556142965880123323311949751266331066368010p 0.9
+ \]
V_wl_bar_136 (WordLine_bar\\<136\\> gnd!) vsource type=pwl wave=\[
+ 0    0.9
+ 87112285931760246646623899502532662132735500p 0.9
+ 87112285931760246646623899502532662132735510p -0.3
+ 87112285931760246646623899502532662132736000p -0.3
+ 87112285931760246646623899502532662132736010p 0.9
+ \]
V_wl_bar_137 (WordLine_bar\\<137\\> gnd!) vsource type=pwl wave=\[
+ 0    0.9
+ 174224571863520493293247799005065324265471500p 0.9
+ 174224571863520493293247799005065324265471510p -0.3
+ 174224571863520493293247799005065324265472000p -0.3
+ 174224571863520493293247799005065324265472010p 0.9
+ \]
V_wl_bar_138 (WordLine_bar\\<138\\> gnd!) vsource type=pwl wave=\[
+ 0    0.9
+ 348449143727040986586495598010130648530943500p 0.9
+ 348449143727040986586495598010130648530943510p -0.3
+ 348449143727040986586495598010130648530944000p -0.3
+ 348449143727040986586495598010130648530944010p 0.9
+ \]
V_wl_bar_139 (WordLine_bar\\<139\\> gnd!) vsource type=pwl wave=\[
+ 0    0.9
+ 696898287454081973172991196020261297061887500p 0.9
+ 696898287454081973172991196020261297061887510p -0.3
+ 696898287454081973172991196020261297061888000p -0.3
+ 696898287454081973172991196020261297061888010p 0.9
+ \]
V_wl_bar_140 (WordLine_bar\\<140\\> gnd!) vsource type=pwl wave=\[
+ 0    0.9
+ 1393796574908163946345982392040522594123775500p 0.9
+ 1393796574908163946345982392040522594123775510p -0.3
+ 1393796574908163946345982392040522594123776000p -0.3
+ 1393796574908163946345982392040522594123776010p 0.9
+ \]
V_wl_bar_141 (WordLine_bar\\<141\\> gnd!) vsource type=pwl wave=\[
+ 0    0.9
+ 2787593149816327892691964784081045188247551500p 0.9
+ 2787593149816327892691964784081045188247551510p -0.3
+ 2787593149816327892691964784081045188247552000p -0.3
+ 2787593149816327892691964784081045188247552010p 0.9
+ \]
V_wl_bar_142 (WordLine_bar\\<142\\> gnd!) vsource type=pwl wave=\[
+ 0    0.9
+ 5575186299632655785383929568162090376495103500p 0.9
+ 5575186299632655785383929568162090376495103510p -0.3
+ 5575186299632655785383929568162090376495104000p -0.3
+ 5575186299632655785383929568162090376495104010p 0.9
+ \]
V_wl_bar_143 (WordLine_bar\\<143\\> gnd!) vsource type=pwl wave=\[
+ 0    0.9
+ 11150372599265311570767859136324180752990207500p 0.9
+ 11150372599265311570767859136324180752990207510p -0.3
+ 11150372599265311570767859136324180752990208000p -0.3
+ 11150372599265311570767859136324180752990208010p 0.9
+ \]
V_wl_bar_144 (WordLine_bar\\<144\\> gnd!) vsource type=pwl wave=\[
+ 0    0.9
+ 22300745198530623141535718272648361505980415500p 0.9
+ 22300745198530623141535718272648361505980415510p -0.3
+ 22300745198530623141535718272648361505980416000p -0.3
+ 22300745198530623141535718272648361505980416010p 0.9
+ \]
V_wl_bar_145 (WordLine_bar\\<145\\> gnd!) vsource type=pwl wave=\[
+ 0    0.9
+ 44601490397061246283071436545296723011960831500p 0.9
+ 44601490397061246283071436545296723011960831510p -0.3
+ 44601490397061246283071436545296723011960832000p -0.3
+ 44601490397061246283071436545296723011960832010p 0.9
+ \]
V_wl_bar_146 (WordLine_bar\\<146\\> gnd!) vsource type=pwl wave=\[
+ 0    0.9
+ 89202980794122492566142873090593446023921663500p 0.9
+ 89202980794122492566142873090593446023921663510p -0.3
+ 89202980794122492566142873090593446023921664000p -0.3
+ 89202980794122492566142873090593446023921664010p 0.9
+ \]
V_wl_bar_147 (WordLine_bar\\<147\\> gnd!) vsource type=pwl wave=\[
+ 0    0.9
+ 178405961588244985132285746181186892047843327500p 0.9
+ 178405961588244985132285746181186892047843327510p -0.3
+ 178405961588244985132285746181186892047843328000p -0.3
+ 178405961588244985132285746181186892047843328010p 0.9
+ \]
V_wl_bar_148 (WordLine_bar\\<148\\> gnd!) vsource type=pwl wave=\[
+ 0    0.9
+ 356811923176489970264571492362373784095686655500p 0.9
+ 356811923176489970264571492362373784095686655510p -0.3
+ 356811923176489970264571492362373784095686656000p -0.3
+ 356811923176489970264571492362373784095686656010p 0.9
+ \]
V_wl_bar_149 (WordLine_bar\\<149\\> gnd!) vsource type=pwl wave=\[
+ 0    0.9
+ 713623846352979940529142984724747568191373311500p 0.9
+ 713623846352979940529142984724747568191373311510p -0.3
+ 713623846352979940529142984724747568191373312000p -0.3
+ 713623846352979940529142984724747568191373312010p 0.9
+ \]
V_wl_bar_150 (WordLine_bar\\<150\\> gnd!) vsource type=pwl wave=\[
+ 0    0.9
+ 1427247692705959881058285969449495136382746623500p 0.9
+ 1427247692705959881058285969449495136382746623510p -0.3
+ 1427247692705959881058285969449495136382746624000p -0.3
+ 1427247692705959881058285969449495136382746624010p 0.9
+ \]
V_wl_bar_151 (WordLine_bar\\<151\\> gnd!) vsource type=pwl wave=\[
+ 0    0.9
+ 2854495385411919762116571938898990272765493247500p 0.9
+ 2854495385411919762116571938898990272765493247510p -0.3
+ 2854495385411919762116571938898990272765493248000p -0.3
+ 2854495385411919762116571938898990272765493248010p 0.9
+ \]
V_wl_bar_152 (WordLine_bar\\<152\\> gnd!) vsource type=pwl wave=\[
+ 0    0.9
+ 5708990770823839524233143877797980545530986495500p 0.9
+ 5708990770823839524233143877797980545530986495510p -0.3
+ 5708990770823839524233143877797980545530986496000p -0.3
+ 5708990770823839524233143877797980545530986496010p 0.9
+ \]
V_wl_bar_153 (WordLine_bar\\<153\\> gnd!) vsource type=pwl wave=\[
+ 0    0.9
+ 11417981541647679048466287755595961091061972991500p 0.9
+ 11417981541647679048466287755595961091061972991510p -0.3
+ 11417981541647679048466287755595961091061972992000p -0.3
+ 11417981541647679048466287755595961091061972992010p 0.9
+ \]
V_wl_bar_154 (WordLine_bar\\<154\\> gnd!) vsource type=pwl wave=\[
+ 0    0.9
+ 22835963083295358096932575511191922182123945983500p 0.9
+ 22835963083295358096932575511191922182123945983510p -0.3
+ 22835963083295358096932575511191922182123945984000p -0.3
+ 22835963083295358096932575511191922182123945984010p 0.9
+ \]
V_wl_bar_155 (WordLine_bar\\<155\\> gnd!) vsource type=pwl wave=\[
+ 0    0.9
+ 45671926166590716193865151022383844364247891967500p 0.9
+ 45671926166590716193865151022383844364247891967510p -0.3
+ 45671926166590716193865151022383844364247891968000p -0.3
+ 45671926166590716193865151022383844364247891968010p 0.9
+ \]
V_wl_bar_156 (WordLine_bar\\<156\\> gnd!) vsource type=pwl wave=\[
+ 0    0.9
+ 91343852333181432387730302044767688728495783935500p 0.9
+ 91343852333181432387730302044767688728495783935510p -0.3
+ 91343852333181432387730302044767688728495783936000p -0.3
+ 91343852333181432387730302044767688728495783936010p 0.9
+ \]
V_wl_bar_157 (WordLine_bar\\<157\\> gnd!) vsource type=pwl wave=\[
+ 0    0.9
+ 182687704666362864775460604089535377456991567871500p 0.9
+ 182687704666362864775460604089535377456991567871510p -0.3
+ 182687704666362864775460604089535377456991567872000p -0.3
+ 182687704666362864775460604089535377456991567872010p 0.9
+ \]
V_wl_bar_158 (WordLine_bar\\<158\\> gnd!) vsource type=pwl wave=\[
+ 0    0.9
+ 365375409332725729550921208179070754913983135743500p 0.9
+ 365375409332725729550921208179070754913983135743510p -0.3
+ 365375409332725729550921208179070754913983135744000p -0.3
+ 365375409332725729550921208179070754913983135744010p 0.9
+ \]
V_wl_bar_159 (WordLine_bar\\<159\\> gnd!) vsource type=pwl wave=\[
+ 0    0.9
+ 730750818665451459101842416358141509827966271487500p 0.9
+ 730750818665451459101842416358141509827966271487510p -0.3
+ 730750818665451459101842416358141509827966271488000p -0.3
+ 730750818665451459101842416358141509827966271488010p 0.9
+ \]
V_wl_bar_160 (WordLine_bar\\<160\\> gnd!) vsource type=pwl wave=\[
+ 0    0.9
+ 1461501637330902918203684832716283019655932542975500p 0.9
+ 1461501637330902918203684832716283019655932542975510p -0.3
+ 1461501637330902918203684832716283019655932542976000p -0.3
+ 1461501637330902918203684832716283019655932542976010p 0.9
+ \]
V_wl_bar_161 (WordLine_bar\\<161\\> gnd!) vsource type=pwl wave=\[
+ 0    0.9
+ 2923003274661805836407369665432566039311865085951500p 0.9
+ 2923003274661805836407369665432566039311865085951510p -0.3
+ 2923003274661805836407369665432566039311865085952000p -0.3
+ 2923003274661805836407369665432566039311865085952010p 0.9
+ \]
V_wl_bar_162 (WordLine_bar\\<162\\> gnd!) vsource type=pwl wave=\[
+ 0    0.9
+ 5846006549323611672814739330865132078623730171903500p 0.9
+ 5846006549323611672814739330865132078623730171903510p -0.3
+ 5846006549323611672814739330865132078623730171904000p -0.3
+ 5846006549323611672814739330865132078623730171904010p 0.9
+ \]
V_wl_bar_163 (WordLine_bar\\<163\\> gnd!) vsource type=pwl wave=\[
+ 0    0.9
+ 11692013098647223345629478661730264157247460343807500p 0.9
+ 11692013098647223345629478661730264157247460343807510p -0.3
+ 11692013098647223345629478661730264157247460343808000p -0.3
+ 11692013098647223345629478661730264157247460343808010p 0.9
+ \]
V_wl_bar_164 (WordLine_bar\\<164\\> gnd!) vsource type=pwl wave=\[
+ 0    0.9
+ 23384026197294446691258957323460528314494920687615500p 0.9
+ 23384026197294446691258957323460528314494920687615510p -0.3
+ 23384026197294446691258957323460528314494920687616000p -0.3
+ 23384026197294446691258957323460528314494920687616010p 0.9
+ \]
V_wl_bar_165 (WordLine_bar\\<165\\> gnd!) vsource type=pwl wave=\[
+ 0    0.9
+ 46768052394588893382517914646921056628989841375231500p 0.9
+ 46768052394588893382517914646921056628989841375231510p -0.3
+ 46768052394588893382517914646921056628989841375232000p -0.3
+ 46768052394588893382517914646921056628989841375232010p 0.9
+ \]
V_wl_bar_166 (WordLine_bar\\<166\\> gnd!) vsource type=pwl wave=\[
+ 0    0.9
+ 93536104789177786765035829293842113257979682750463500p 0.9
+ 93536104789177786765035829293842113257979682750463510p -0.3
+ 93536104789177786765035829293842113257979682750464000p -0.3
+ 93536104789177786765035829293842113257979682750464010p 0.9
+ \]
V_wl_bar_167 (WordLine_bar\\<167\\> gnd!) vsource type=pwl wave=\[
+ 0    0.9
+ 187072209578355573530071658587684226515959365500927500p 0.9
+ 187072209578355573530071658587684226515959365500927510p -0.3
+ 187072209578355573530071658587684226515959365500928000p -0.3
+ 187072209578355573530071658587684226515959365500928010p 0.9
+ \]
V_wl_bar_168 (WordLine_bar\\<168\\> gnd!) vsource type=pwl wave=\[
+ 0    0.9
+ 374144419156711147060143317175368453031918731001855500p 0.9
+ 374144419156711147060143317175368453031918731001855510p -0.3
+ 374144419156711147060143317175368453031918731001856000p -0.3
+ 374144419156711147060143317175368453031918731001856010p 0.9
+ \]
V_wl_bar_169 (WordLine_bar\\<169\\> gnd!) vsource type=pwl wave=\[
+ 0    0.9
+ 748288838313422294120286634350736906063837462003711500p 0.9
+ 748288838313422294120286634350736906063837462003711510p -0.3
+ 748288838313422294120286634350736906063837462003712000p -0.3
+ 748288838313422294120286634350736906063837462003712010p 0.9
+ \]
V_wl_bar_170 (WordLine_bar\\<170\\> gnd!) vsource type=pwl wave=\[
+ 0    0.9
+ 1496577676626844588240573268701473812127674924007423500p 0.9
+ 1496577676626844588240573268701473812127674924007423510p -0.3
+ 1496577676626844588240573268701473812127674924007424000p -0.3
+ 1496577676626844588240573268701473812127674924007424010p 0.9
+ \]
V_wl_bar_171 (WordLine_bar\\<171\\> gnd!) vsource type=pwl wave=\[
+ 0    0.9
+ 2993155353253689176481146537402947624255349848014847500p 0.9
+ 2993155353253689176481146537402947624255349848014847510p -0.3
+ 2993155353253689176481146537402947624255349848014848000p -0.3
+ 2993155353253689176481146537402947624255349848014848010p 0.9
+ \]
V_wl_bar_172 (WordLine_bar\\<172\\> gnd!) vsource type=pwl wave=\[
+ 0    0.9
+ 5986310706507378352962293074805895248510699696029695500p 0.9
+ 5986310706507378352962293074805895248510699696029695510p -0.3
+ 5986310706507378352962293074805895248510699696029696000p -0.3
+ 5986310706507378352962293074805895248510699696029696010p 0.9
+ \]
V_wl_bar_173 (WordLine_bar\\<173\\> gnd!) vsource type=pwl wave=\[
+ 0    0.9
+ 11972621413014756705924586149611790497021399392059391500p 0.9
+ 11972621413014756705924586149611790497021399392059391510p -0.3
+ 11972621413014756705924586149611790497021399392059392000p -0.3
+ 11972621413014756705924586149611790497021399392059392010p 0.9
+ \]
V_wl_bar_174 (WordLine_bar\\<174\\> gnd!) vsource type=pwl wave=\[
+ 0    0.9
+ 23945242826029513411849172299223580994042798784118783500p 0.9
+ 23945242826029513411849172299223580994042798784118783510p -0.3
+ 23945242826029513411849172299223580994042798784118784000p -0.3
+ 23945242826029513411849172299223580994042798784118784010p 0.9
+ \]
V_wl_bar_175 (WordLine_bar\\<175\\> gnd!) vsource type=pwl wave=\[
+ 0    0.9
+ 47890485652059026823698344598447161988085597568237567500p 0.9
+ 47890485652059026823698344598447161988085597568237567510p -0.3
+ 47890485652059026823698344598447161988085597568237568000p -0.3
+ 47890485652059026823698344598447161988085597568237568010p 0.9
+ \]
V_wl_bar_176 (WordLine_bar\\<176\\> gnd!) vsource type=pwl wave=\[
+ 0    0.9
+ 95780971304118053647396689196894323976171195136475135500p 0.9
+ 95780971304118053647396689196894323976171195136475135510p -0.3
+ 95780971304118053647396689196894323976171195136475136000p -0.3
+ 95780971304118053647396689196894323976171195136475136010p 0.9
+ \]
V_wl_bar_177 (WordLine_bar\\<177\\> gnd!) vsource type=pwl wave=\[
+ 0    0.9
+ 191561942608236107294793378393788647952342390272950271500p 0.9
+ 191561942608236107294793378393788647952342390272950271510p -0.3
+ 191561942608236107294793378393788647952342390272950272000p -0.3
+ 191561942608236107294793378393788647952342390272950272010p 0.9
+ \]
V_wl_bar_178 (WordLine_bar\\<178\\> gnd!) vsource type=pwl wave=\[
+ 0    0.9
+ 383123885216472214589586756787577295904684780545900543500p 0.9
+ 383123885216472214589586756787577295904684780545900543510p -0.3
+ 383123885216472214589586756787577295904684780545900544000p -0.3
+ 383123885216472214589586756787577295904684780545900544010p 0.9
+ \]
V_wl_bar_179 (WordLine_bar\\<179\\> gnd!) vsource type=pwl wave=\[
+ 0    0.9
+ 766247770432944429179173513575154591809369561091801087500p 0.9
+ 766247770432944429179173513575154591809369561091801087510p -0.3
+ 766247770432944429179173513575154591809369561091801088000p -0.3
+ 766247770432944429179173513575154591809369561091801088010p 0.9
+ \]
V_wl_bar_180 (WordLine_bar\\<180\\> gnd!) vsource type=pwl wave=\[
+ 0    0.9
+ 1532495540865888858358347027150309183618739122183602175500p 0.9
+ 1532495540865888858358347027150309183618739122183602175510p -0.3
+ 1532495540865888858358347027150309183618739122183602176000p -0.3
+ 1532495540865888858358347027150309183618739122183602176010p 0.9
+ \]
V_wl_bar_181 (WordLine_bar\\<181\\> gnd!) vsource type=pwl wave=\[
+ 0    0.9
+ 3064991081731777716716694054300618367237478244367204351500p 0.9
+ 3064991081731777716716694054300618367237478244367204351510p -0.3
+ 3064991081731777716716694054300618367237478244367204352000p -0.3
+ 3064991081731777716716694054300618367237478244367204352010p 0.9
+ \]
V_wl_bar_182 (WordLine_bar\\<182\\> gnd!) vsource type=pwl wave=\[
+ 0    0.9
+ 6129982163463555433433388108601236734474956488734408703500p 0.9
+ 6129982163463555433433388108601236734474956488734408703510p -0.3
+ 6129982163463555433433388108601236734474956488734408704000p -0.3
+ 6129982163463555433433388108601236734474956488734408704010p 0.9
+ \]
V_wl_bar_183 (WordLine_bar\\<183\\> gnd!) vsource type=pwl wave=\[
+ 0    0.9
+ 12259964326927110866866776217202473468949912977468817407500p 0.9
+ 12259964326927110866866776217202473468949912977468817407510p -0.3
+ 12259964326927110866866776217202473468949912977468817408000p -0.3
+ 12259964326927110866866776217202473468949912977468817408010p 0.9
+ \]
V_wl_bar_184 (WordLine_bar\\<184\\> gnd!) vsource type=pwl wave=\[
+ 0    0.9
+ 24519928653854221733733552434404946937899825954937634815500p 0.9
+ 24519928653854221733733552434404946937899825954937634815510p -0.3
+ 24519928653854221733733552434404946937899825954937634816000p -0.3
+ 24519928653854221733733552434404946937899825954937634816010p 0.9
+ \]
V_wl_bar_185 (WordLine_bar\\<185\\> gnd!) vsource type=pwl wave=\[
+ 0    0.9
+ 49039857307708443467467104868809893875799651909875269631500p 0.9
+ 49039857307708443467467104868809893875799651909875269631510p -0.3
+ 49039857307708443467467104868809893875799651909875269632000p -0.3
+ 49039857307708443467467104868809893875799651909875269632010p 0.9
+ \]
V_wl_bar_186 (WordLine_bar\\<186\\> gnd!) vsource type=pwl wave=\[
+ 0    0.9
+ 98079714615416886934934209737619787751599303819750539263500p 0.9
+ 98079714615416886934934209737619787751599303819750539263510p -0.3
+ 98079714615416886934934209737619787751599303819750539264000p -0.3
+ 98079714615416886934934209737619787751599303819750539264010p 0.9
+ \]
V_wl_bar_187 (WordLine_bar\\<187\\> gnd!) vsource type=pwl wave=\[
+ 0    0.9
+ 196159429230833773869868419475239575503198607639501078527500p 0.9
+ 196159429230833773869868419475239575503198607639501078527510p -0.3
+ 196159429230833773869868419475239575503198607639501078528000p -0.3
+ 196159429230833773869868419475239575503198607639501078528010p 0.9
+ \]
V_wl_bar_188 (WordLine_bar\\<188\\> gnd!) vsource type=pwl wave=\[
+ 0    0.9
+ 392318858461667547739736838950479151006397215279002157055500p 0.9
+ 392318858461667547739736838950479151006397215279002157055510p -0.3
+ 392318858461667547739736838950479151006397215279002157056000p -0.3
+ 392318858461667547739736838950479151006397215279002157056010p 0.9
+ \]
V_wl_bar_189 (WordLine_bar\\<189\\> gnd!) vsource type=pwl wave=\[
+ 0    0.9
+ 784637716923335095479473677900958302012794430558004314111500p 0.9
+ 784637716923335095479473677900958302012794430558004314111510p -0.3
+ 784637716923335095479473677900958302012794430558004314112000p -0.3
+ 784637716923335095479473677900958302012794430558004314112010p 0.9
+ \]
V_wl_bar_190 (WordLine_bar\\<190\\> gnd!) vsource type=pwl wave=\[
+ 0    0.9
+ 1569275433846670190958947355801916604025588861116008628223500p 0.9
+ 1569275433846670190958947355801916604025588861116008628223510p -0.3
+ 1569275433846670190958947355801916604025588861116008628224000p -0.3
+ 1569275433846670190958947355801916604025588861116008628224010p 0.9
+ \]
V_wl_bar_191 (WordLine_bar\\<191\\> gnd!) vsource type=pwl wave=\[
+ 0    0.9
+ 3138550867693340381917894711603833208051177722232017256447500p 0.9
+ 3138550867693340381917894711603833208051177722232017256447510p -0.3
+ 3138550867693340381917894711603833208051177722232017256448000p -0.3
+ 3138550867693340381917894711603833208051177722232017256448010p 0.9
+ \]
V_wl_bar_192 (WordLine_bar\\<192\\> gnd!) vsource type=pwl wave=\[
+ 0    0.9
+ 6277101735386680763835789423207666416102355444464034512895500p 0.9
+ 6277101735386680763835789423207666416102355444464034512895510p -0.3
+ 6277101735386680763835789423207666416102355444464034512896000p -0.3
+ 6277101735386680763835789423207666416102355444464034512896010p 0.9
+ \]
V_wl_bar_193 (WordLine_bar\\<193\\> gnd!) vsource type=pwl wave=\[
+ 0    0.9
+ 12554203470773361527671578846415332832204710888928069025791500p 0.9
+ 12554203470773361527671578846415332832204710888928069025791510p -0.3
+ 12554203470773361527671578846415332832204710888928069025792000p -0.3
+ 12554203470773361527671578846415332832204710888928069025792010p 0.9
+ \]
V_wl_bar_194 (WordLine_bar\\<194\\> gnd!) vsource type=pwl wave=\[
+ 0    0.9
+ 25108406941546723055343157692830665664409421777856138051583500p 0.9
+ 25108406941546723055343157692830665664409421777856138051583510p -0.3
+ 25108406941546723055343157692830665664409421777856138051584000p -0.3
+ 25108406941546723055343157692830665664409421777856138051584010p 0.9
+ \]
V_wl_bar_195 (WordLine_bar\\<195\\> gnd!) vsource type=pwl wave=\[
+ 0    0.9
+ 50216813883093446110686315385661331328818843555712276103167500p 0.9
+ 50216813883093446110686315385661331328818843555712276103167510p -0.3
+ 50216813883093446110686315385661331328818843555712276103168000p -0.3
+ 50216813883093446110686315385661331328818843555712276103168010p 0.9
+ \]
V_wl_bar_196 (WordLine_bar\\<196\\> gnd!) vsource type=pwl wave=\[
+ 0    0.9
+ 100433627766186892221372630771322662657637687111424552206335500p 0.9
+ 100433627766186892221372630771322662657637687111424552206335510p -0.3
+ 100433627766186892221372630771322662657637687111424552206336000p -0.3
+ 100433627766186892221372630771322662657637687111424552206336010p 0.9
+ \]
V_wl_bar_197 (WordLine_bar\\<197\\> gnd!) vsource type=pwl wave=\[
+ 0    0.9
+ 200867255532373784442745261542645325315275374222849104412671500p 0.9
+ 200867255532373784442745261542645325315275374222849104412671510p -0.3
+ 200867255532373784442745261542645325315275374222849104412672000p -0.3
+ 200867255532373784442745261542645325315275374222849104412672010p 0.9
+ \]
V_wl_bar_198 (WordLine_bar\\<198\\> gnd!) vsource type=pwl wave=\[
+ 0    0.9
+ 401734511064747568885490523085290650630550748445698208825343500p 0.9
+ 401734511064747568885490523085290650630550748445698208825343510p -0.3
+ 401734511064747568885490523085290650630550748445698208825344000p -0.3
+ 401734511064747568885490523085290650630550748445698208825344010p 0.9
+ \]
V_wl_bar_199 (WordLine_bar\\<199\\> gnd!) vsource type=pwl wave=\[
+ 0    0.9
+ 803469022129495137770981046170581301261101496891396417650687500p 0.9
+ 803469022129495137770981046170581301261101496891396417650687510p -0.3
+ 803469022129495137770981046170581301261101496891396417650688000p -0.3
+ 803469022129495137770981046170581301261101496891396417650688010p 0.9
+ \]
V_wl_bar_200 (WordLine_bar\\<200\\> gnd!) vsource type=pwl wave=\[
+ 0    0.9
+ 1606938044258990275541962092341162602522202993782792835301375500p 0.9
+ 1606938044258990275541962092341162602522202993782792835301375510p -0.3
+ 1606938044258990275541962092341162602522202993782792835301376000p -0.3
+ 1606938044258990275541962092341162602522202993782792835301376010p 0.9
+ \]
V_wl_bar_201 (WordLine_bar\\<201\\> gnd!) vsource type=pwl wave=\[
+ 0    0.9
+ 3213876088517980551083924184682325205044405987565585670602751500p 0.9
+ 3213876088517980551083924184682325205044405987565585670602751510p -0.3
+ 3213876088517980551083924184682325205044405987565585670602752000p -0.3
+ 3213876088517980551083924184682325205044405987565585670602752010p 0.9
+ \]
V_wl_bar_202 (WordLine_bar\\<202\\> gnd!) vsource type=pwl wave=\[
+ 0    0.9
+ 6427752177035961102167848369364650410088811975131171341205503500p 0.9
+ 6427752177035961102167848369364650410088811975131171341205503510p -0.3
+ 6427752177035961102167848369364650410088811975131171341205504000p -0.3
+ 6427752177035961102167848369364650410088811975131171341205504010p 0.9
+ \]
V_wl_bar_203 (WordLine_bar\\<203\\> gnd!) vsource type=pwl wave=\[
+ 0    0.9
+ 12855504354071922204335696738729300820177623950262342682411007500p 0.9
+ 12855504354071922204335696738729300820177623950262342682411007510p -0.3
+ 12855504354071922204335696738729300820177623950262342682411008000p -0.3
+ 12855504354071922204335696738729300820177623950262342682411008010p 0.9
+ \]
V_wl_bar_204 (WordLine_bar\\<204\\> gnd!) vsource type=pwl wave=\[
+ 0    0.9
+ 25711008708143844408671393477458601640355247900524685364822015500p 0.9
+ 25711008708143844408671393477458601640355247900524685364822015510p -0.3
+ 25711008708143844408671393477458601640355247900524685364822016000p -0.3
+ 25711008708143844408671393477458601640355247900524685364822016010p 0.9
+ \]
V_wl_bar_205 (WordLine_bar\\<205\\> gnd!) vsource type=pwl wave=\[
+ 0    0.9
+ 51422017416287688817342786954917203280710495801049370729644031500p 0.9
+ 51422017416287688817342786954917203280710495801049370729644031510p -0.3
+ 51422017416287688817342786954917203280710495801049370729644032000p -0.3
+ 51422017416287688817342786954917203280710495801049370729644032010p 0.9
+ \]
V_wl_bar_206 (WordLine_bar\\<206\\> gnd!) vsource type=pwl wave=\[
+ 0    0.9
+ 102844034832575377634685573909834406561420991602098741459288063500p 0.9
+ 102844034832575377634685573909834406561420991602098741459288063510p -0.3
+ 102844034832575377634685573909834406561420991602098741459288064000p -0.3
+ 102844034832575377634685573909834406561420991602098741459288064010p 0.9
+ \]
V_wl_bar_207 (WordLine_bar\\<207\\> gnd!) vsource type=pwl wave=\[
+ 0    0.9
+ 205688069665150755269371147819668813122841983204197482918576127500p 0.9
+ 205688069665150755269371147819668813122841983204197482918576127510p -0.3
+ 205688069665150755269371147819668813122841983204197482918576128000p -0.3
+ 205688069665150755269371147819668813122841983204197482918576128010p 0.9
+ \]
V_wl_bar_208 (WordLine_bar\\<208\\> gnd!) vsource type=pwl wave=\[
+ 0    0.9
+ 411376139330301510538742295639337626245683966408394965837152255500p 0.9
+ 411376139330301510538742295639337626245683966408394965837152255510p -0.3
+ 411376139330301510538742295639337626245683966408394965837152256000p -0.3
+ 411376139330301510538742295639337626245683966408394965837152256010p 0.9
+ \]
V_wl_bar_209 (WordLine_bar\\<209\\> gnd!) vsource type=pwl wave=\[
+ 0    0.9
+ 822752278660603021077484591278675252491367932816789931674304511500p 0.9
+ 822752278660603021077484591278675252491367932816789931674304511510p -0.3
+ 822752278660603021077484591278675252491367932816789931674304512000p -0.3
+ 822752278660603021077484591278675252491367932816789931674304512010p 0.9
+ \]
V_wl_bar_210 (WordLine_bar\\<210\\> gnd!) vsource type=pwl wave=\[
+ 0    0.9
+ 1645504557321206042154969182557350504982735865633579863348609023500p 0.9
+ 1645504557321206042154969182557350504982735865633579863348609023510p -0.3
+ 1645504557321206042154969182557350504982735865633579863348609024000p -0.3
+ 1645504557321206042154969182557350504982735865633579863348609024010p 0.9
+ \]
V_wl_bar_211 (WordLine_bar\\<211\\> gnd!) vsource type=pwl wave=\[
+ 0    0.9
+ 3291009114642412084309938365114701009965471731267159726697218047500p 0.9
+ 3291009114642412084309938365114701009965471731267159726697218047510p -0.3
+ 3291009114642412084309938365114701009965471731267159726697218048000p -0.3
+ 3291009114642412084309938365114701009965471731267159726697218048010p 0.9
+ \]
V_wl_bar_212 (WordLine_bar\\<212\\> gnd!) vsource type=pwl wave=\[
+ 0    0.9
+ 6582018229284824168619876730229402019930943462534319453394436095500p 0.9
+ 6582018229284824168619876730229402019930943462534319453394436095510p -0.3
+ 6582018229284824168619876730229402019930943462534319453394436096000p -0.3
+ 6582018229284824168619876730229402019930943462534319453394436096010p 0.9
+ \]
V_wl_bar_213 (WordLine_bar\\<213\\> gnd!) vsource type=pwl wave=\[
+ 0    0.9
+ 13164036458569648337239753460458804039861886925068638906788872191500p 0.9
+ 13164036458569648337239753460458804039861886925068638906788872191510p -0.3
+ 13164036458569648337239753460458804039861886925068638906788872192000p -0.3
+ 13164036458569648337239753460458804039861886925068638906788872192010p 0.9
+ \]
V_wl_bar_214 (WordLine_bar\\<214\\> gnd!) vsource type=pwl wave=\[
+ 0    0.9
+ 26328072917139296674479506920917608079723773850137277813577744383500p 0.9
+ 26328072917139296674479506920917608079723773850137277813577744383510p -0.3
+ 26328072917139296674479506920917608079723773850137277813577744384000p -0.3
+ 26328072917139296674479506920917608079723773850137277813577744384010p 0.9
+ \]
V_wl_bar_215 (WordLine_bar\\<215\\> gnd!) vsource type=pwl wave=\[
+ 0    0.9
+ 52656145834278593348959013841835216159447547700274555627155488767500p 0.9
+ 52656145834278593348959013841835216159447547700274555627155488767510p -0.3
+ 52656145834278593348959013841835216159447547700274555627155488768000p -0.3
+ 52656145834278593348959013841835216159447547700274555627155488768010p 0.9
+ \]
V_wl_bar_216 (WordLine_bar\\<216\\> gnd!) vsource type=pwl wave=\[
+ 0    0.9
+ 105312291668557186697918027683670432318895095400549111254310977535500p 0.9
+ 105312291668557186697918027683670432318895095400549111254310977535510p -0.3
+ 105312291668557186697918027683670432318895095400549111254310977536000p -0.3
+ 105312291668557186697918027683670432318895095400549111254310977536010p 0.9
+ \]
V_wl_bar_217 (WordLine_bar\\<217\\> gnd!) vsource type=pwl wave=\[
+ 0    0.9
+ 210624583337114373395836055367340864637790190801098222508621955071500p 0.9
+ 210624583337114373395836055367340864637790190801098222508621955071510p -0.3
+ 210624583337114373395836055367340864637790190801098222508621955072000p -0.3
+ 210624583337114373395836055367340864637790190801098222508621955072010p 0.9
+ \]
V_wl_bar_218 (WordLine_bar\\<218\\> gnd!) vsource type=pwl wave=\[
+ 0    0.9
+ 421249166674228746791672110734681729275580381602196445017243910143500p 0.9
+ 421249166674228746791672110734681729275580381602196445017243910143510p -0.3
+ 421249166674228746791672110734681729275580381602196445017243910144000p -0.3
+ 421249166674228746791672110734681729275580381602196445017243910144010p 0.9
+ \]
V_wl_bar_219 (WordLine_bar\\<219\\> gnd!) vsource type=pwl wave=\[
+ 0    0.9
+ 842498333348457493583344221469363458551160763204392890034487820287500p 0.9
+ 842498333348457493583344221469363458551160763204392890034487820287510p -0.3
+ 842498333348457493583344221469363458551160763204392890034487820288000p -0.3
+ 842498333348457493583344221469363458551160763204392890034487820288010p 0.9
+ \]
V_wl_bar_220 (WordLine_bar\\<220\\> gnd!) vsource type=pwl wave=\[
+ 0    0.9
+ 1684996666696914987166688442938726917102321526408785780068975640575500p 0.9
+ 1684996666696914987166688442938726917102321526408785780068975640575510p -0.3
+ 1684996666696914987166688442938726917102321526408785780068975640576000p -0.3
+ 1684996666696914987166688442938726917102321526408785780068975640576010p 0.9
+ \]
V_wl_bar_221 (WordLine_bar\\<221\\> gnd!) vsource type=pwl wave=\[
+ 0    0.9
+ 3369993333393829974333376885877453834204643052817571560137951281151500p 0.9
+ 3369993333393829974333376885877453834204643052817571560137951281151510p -0.3
+ 3369993333393829974333376885877453834204643052817571560137951281152000p -0.3
+ 3369993333393829974333376885877453834204643052817571560137951281152010p 0.9
+ \]
V_wl_bar_222 (WordLine_bar\\<222\\> gnd!) vsource type=pwl wave=\[
+ 0    0.9
+ 6739986666787659948666753771754907668409286105635143120275902562303500p 0.9
+ 6739986666787659948666753771754907668409286105635143120275902562303510p -0.3
+ 6739986666787659948666753771754907668409286105635143120275902562304000p -0.3
+ 6739986666787659948666753771754907668409286105635143120275902562304010p 0.9
+ \]
V_wl_bar_223 (WordLine_bar\\<223\\> gnd!) vsource type=pwl wave=\[
+ 0    0.9
+ 13479973333575319897333507543509815336818572211270286240551805124607500p 0.9
+ 13479973333575319897333507543509815336818572211270286240551805124607510p -0.3
+ 13479973333575319897333507543509815336818572211270286240551805124608000p -0.3
+ 13479973333575319897333507543509815336818572211270286240551805124608010p 0.9
+ \]
V_wl_bar_224 (WordLine_bar\\<224\\> gnd!) vsource type=pwl wave=\[
+ 0    0.9
+ 26959946667150639794667015087019630673637144422540572481103610249215500p 0.9
+ 26959946667150639794667015087019630673637144422540572481103610249215510p -0.3
+ 26959946667150639794667015087019630673637144422540572481103610249216000p -0.3
+ 26959946667150639794667015087019630673637144422540572481103610249216010p 0.9
+ \]
V_wl_bar_225 (WordLine_bar\\<225\\> gnd!) vsource type=pwl wave=\[
+ 0    0.9
+ 53919893334301279589334030174039261347274288845081144962207220498431500p 0.9
+ 53919893334301279589334030174039261347274288845081144962207220498431510p -0.3
+ 53919893334301279589334030174039261347274288845081144962207220498432000p -0.3
+ 53919893334301279589334030174039261347274288845081144962207220498432010p 0.9
+ \]
V_wl_bar_226 (WordLine_bar\\<226\\> gnd!) vsource type=pwl wave=\[
+ 0    0.9
+ 107839786668602559178668060348078522694548577690162289924414440996863500p 0.9
+ 107839786668602559178668060348078522694548577690162289924414440996863510p -0.3
+ 107839786668602559178668060348078522694548577690162289924414440996864000p -0.3
+ 107839786668602559178668060348078522694548577690162289924414440996864010p 0.9
+ \]
V_wl_bar_227 (WordLine_bar\\<227\\> gnd!) vsource type=pwl wave=\[
+ 0    0.9
+ 215679573337205118357336120696157045389097155380324579848828881993727500p 0.9
+ 215679573337205118357336120696157045389097155380324579848828881993727510p -0.3
+ 215679573337205118357336120696157045389097155380324579848828881993728000p -0.3
+ 215679573337205118357336120696157045389097155380324579848828881993728010p 0.9
+ \]
V_wl_bar_228 (WordLine_bar\\<228\\> gnd!) vsource type=pwl wave=\[
+ 0    0.9
+ 431359146674410236714672241392314090778194310760649159697657763987455500p 0.9
+ 431359146674410236714672241392314090778194310760649159697657763987455510p -0.3
+ 431359146674410236714672241392314090778194310760649159697657763987456000p -0.3
+ 431359146674410236714672241392314090778194310760649159697657763987456010p 0.9
+ \]
V_wl_bar_229 (WordLine_bar\\<229\\> gnd!) vsource type=pwl wave=\[
+ 0    0.9
+ 862718293348820473429344482784628181556388621521298319395315527974911500p 0.9
+ 862718293348820473429344482784628181556388621521298319395315527974911510p -0.3
+ 862718293348820473429344482784628181556388621521298319395315527974912000p -0.3
+ 862718293348820473429344482784628181556388621521298319395315527974912010p 0.9
+ \]
V_wl_bar_230 (WordLine_bar\\<230\\> gnd!) vsource type=pwl wave=\[
+ 0    0.9
+ 1725436586697640946858688965569256363112777243042596638790631055949823500p 0.9
+ 1725436586697640946858688965569256363112777243042596638790631055949823510p -0.3
+ 1725436586697640946858688965569256363112777243042596638790631055949824000p -0.3
+ 1725436586697640946858688965569256363112777243042596638790631055949824010p 0.9
+ \]
V_wl_bar_231 (WordLine_bar\\<231\\> gnd!) vsource type=pwl wave=\[
+ 0    0.9
+ 3450873173395281893717377931138512726225554486085193277581262111899647500p 0.9
+ 3450873173395281893717377931138512726225554486085193277581262111899647510p -0.3
+ 3450873173395281893717377931138512726225554486085193277581262111899648000p -0.3
+ 3450873173395281893717377931138512726225554486085193277581262111899648010p 0.9
+ \]
V_wl_bar_232 (WordLine_bar\\<232\\> gnd!) vsource type=pwl wave=\[
+ 0    0.9
+ 6901746346790563787434755862277025452451108972170386555162524223799295500p 0.9
+ 6901746346790563787434755862277025452451108972170386555162524223799295510p -0.3
+ 6901746346790563787434755862277025452451108972170386555162524223799296000p -0.3
+ 6901746346790563787434755862277025452451108972170386555162524223799296010p 0.9
+ \]
V_wl_bar_233 (WordLine_bar\\<233\\> gnd!) vsource type=pwl wave=\[
+ 0    0.9
+ 13803492693581127574869511724554050904902217944340773110325048447598591500p 0.9
+ 13803492693581127574869511724554050904902217944340773110325048447598591510p -0.3
+ 13803492693581127574869511724554050904902217944340773110325048447598592000p -0.3
+ 13803492693581127574869511724554050904902217944340773110325048447598592010p 0.9
+ \]
V_wl_bar_234 (WordLine_bar\\<234\\> gnd!) vsource type=pwl wave=\[
+ 0    0.9
+ 27606985387162255149739023449108101809804435888681546220650096895197183500p 0.9
+ 27606985387162255149739023449108101809804435888681546220650096895197183510p -0.3
+ 27606985387162255149739023449108101809804435888681546220650096895197184000p -0.3
+ 27606985387162255149739023449108101809804435888681546220650096895197184010p 0.9
+ \]
V_wl_bar_235 (WordLine_bar\\<235\\> gnd!) vsource type=pwl wave=\[
+ 0    0.9
+ 55213970774324510299478046898216203619608871777363092441300193790394367500p 0.9
+ 55213970774324510299478046898216203619608871777363092441300193790394367510p -0.3
+ 55213970774324510299478046898216203619608871777363092441300193790394368000p -0.3
+ 55213970774324510299478046898216203619608871777363092441300193790394368010p 0.9
+ \]
V_wl_bar_236 (WordLine_bar\\<236\\> gnd!) vsource type=pwl wave=\[
+ 0    0.9
+ 110427941548649020598956093796432407239217743554726184882600387580788735500p 0.9
+ 110427941548649020598956093796432407239217743554726184882600387580788735510p -0.3
+ 110427941548649020598956093796432407239217743554726184882600387580788736000p -0.3
+ 110427941548649020598956093796432407239217743554726184882600387580788736010p 0.9
+ \]
V_wl_bar_237 (WordLine_bar\\<237\\> gnd!) vsource type=pwl wave=\[
+ 0    0.9
+ 220855883097298041197912187592864814478435487109452369765200775161577471500p 0.9
+ 220855883097298041197912187592864814478435487109452369765200775161577471510p -0.3
+ 220855883097298041197912187592864814478435487109452369765200775161577472000p -0.3
+ 220855883097298041197912187592864814478435487109452369765200775161577472010p 0.9
+ \]
V_wl_bar_238 (WordLine_bar\\<238\\> gnd!) vsource type=pwl wave=\[
+ 0    0.9
+ 441711766194596082395824375185729628956870974218904739530401550323154943500p 0.9
+ 441711766194596082395824375185729628956870974218904739530401550323154943510p -0.3
+ 441711766194596082395824375185729628956870974218904739530401550323154944000p -0.3
+ 441711766194596082395824375185729628956870974218904739530401550323154944010p 0.9
+ \]
V_wl_bar_239 (WordLine_bar\\<239\\> gnd!) vsource type=pwl wave=\[
+ 0    0.9
+ 883423532389192164791648750371459257913741948437809479060803100646309887500p 0.9
+ 883423532389192164791648750371459257913741948437809479060803100646309887510p -0.3
+ 883423532389192164791648750371459257913741948437809479060803100646309888000p -0.3
+ 883423532389192164791648750371459257913741948437809479060803100646309888010p 0.9
+ \]
V_wl_bar_240 (WordLine_bar\\<240\\> gnd!) vsource type=pwl wave=\[
+ 0    0.9
+ 1766847064778384329583297500742918515827483896875618958121606201292619775500p 0.9
+ 1766847064778384329583297500742918515827483896875618958121606201292619775510p -0.3
+ 1766847064778384329583297500742918515827483896875618958121606201292619776000p -0.3
+ 1766847064778384329583297500742918515827483896875618958121606201292619776010p 0.9
+ \]
V_wl_bar_241 (WordLine_bar\\<241\\> gnd!) vsource type=pwl wave=\[
+ 0    0.9
+ 3533694129556768659166595001485837031654967793751237916243212402585239551500p 0.9
+ 3533694129556768659166595001485837031654967793751237916243212402585239551510p -0.3
+ 3533694129556768659166595001485837031654967793751237916243212402585239552000p -0.3
+ 3533694129556768659166595001485837031654967793751237916243212402585239552010p 0.9
+ \]
V_wl_bar_242 (WordLine_bar\\<242\\> gnd!) vsource type=pwl wave=\[
+ 0    0.9
+ 7067388259113537318333190002971674063309935587502475832486424805170479103500p 0.9
+ 7067388259113537318333190002971674063309935587502475832486424805170479103510p -0.3
+ 7067388259113537318333190002971674063309935587502475832486424805170479104000p -0.3
+ 7067388259113537318333190002971674063309935587502475832486424805170479104010p 0.9
+ \]
V_wl_bar_243 (WordLine_bar\\<243\\> gnd!) vsource type=pwl wave=\[
+ 0    0.9
+ 14134776518227074636666380005943348126619871175004951664972849610340958207500p 0.9
+ 14134776518227074636666380005943348126619871175004951664972849610340958207510p -0.3
+ 14134776518227074636666380005943348126619871175004951664972849610340958208000p -0.3
+ 14134776518227074636666380005943348126619871175004951664972849610340958208010p 0.9
+ \]
V_wl_bar_244 (WordLine_bar\\<244\\> gnd!) vsource type=pwl wave=\[
+ 0    0.9
+ 28269553036454149273332760011886696253239742350009903329945699220681916415500p 0.9
+ 28269553036454149273332760011886696253239742350009903329945699220681916415510p -0.3
+ 28269553036454149273332760011886696253239742350009903329945699220681916416000p -0.3
+ 28269553036454149273332760011886696253239742350009903329945699220681916416010p 0.9
+ \]
V_wl_bar_245 (WordLine_bar\\<245\\> gnd!) vsource type=pwl wave=\[
+ 0    0.9
+ 56539106072908298546665520023773392506479484700019806659891398441363832831500p 0.9
+ 56539106072908298546665520023773392506479484700019806659891398441363832831510p -0.3
+ 56539106072908298546665520023773392506479484700019806659891398441363832832000p -0.3
+ 56539106072908298546665520023773392506479484700019806659891398441363832832010p 0.9
+ \]
V_wl_bar_246 (WordLine_bar\\<246\\> gnd!) vsource type=pwl wave=\[
+ 0    0.9
+ 113078212145816597093331040047546785012958969400039613319782796882727665663500p 0.9
+ 113078212145816597093331040047546785012958969400039613319782796882727665663510p -0.3
+ 113078212145816597093331040047546785012958969400039613319782796882727665664000p -0.3
+ 113078212145816597093331040047546785012958969400039613319782796882727665664010p 0.9
+ \]
V_wl_bar_247 (WordLine_bar\\<247\\> gnd!) vsource type=pwl wave=\[
+ 0    0.9
+ 226156424291633194186662080095093570025917938800079226639565593765455331327500p 0.9
+ 226156424291633194186662080095093570025917938800079226639565593765455331327510p -0.3
+ 226156424291633194186662080095093570025917938800079226639565593765455331328000p -0.3
+ 226156424291633194186662080095093570025917938800079226639565593765455331328010p 0.9
+ \]
V_wl_bar_248 (WordLine_bar\\<248\\> gnd!) vsource type=pwl wave=\[
+ 0    0.9
+ 452312848583266388373324160190187140051835877600158453279131187530910662655500p 0.9
+ 452312848583266388373324160190187140051835877600158453279131187530910662655510p -0.3
+ 452312848583266388373324160190187140051835877600158453279131187530910662656000p -0.3
+ 452312848583266388373324160190187140051835877600158453279131187530910662656010p 0.9
+ \]
V_wl_bar_249 (WordLine_bar\\<249\\> gnd!) vsource type=pwl wave=\[
+ 0    0.9
+ 904625697166532776746648320380374280103671755200316906558262375061821325311500p 0.9
+ 904625697166532776746648320380374280103671755200316906558262375061821325311510p -0.3
+ 904625697166532776746648320380374280103671755200316906558262375061821325312000p -0.3
+ 904625697166532776746648320380374280103671755200316906558262375061821325312010p 0.9
+ \]
V_wl_bar_250 (WordLine_bar\\<250\\> gnd!) vsource type=pwl wave=\[
+ 0    0.9
+ 1809251394333065553493296640760748560207343510400633813116524750123642650623500p 0.9
+ 1809251394333065553493296640760748560207343510400633813116524750123642650623510p -0.3
+ 1809251394333065553493296640760748560207343510400633813116524750123642650624000p -0.3
+ 1809251394333065553493296640760748560207343510400633813116524750123642650624010p 0.9
+ \]
V_wl_bar_251 (WordLine_bar\\<251\\> gnd!) vsource type=pwl wave=\[
+ 0    0.9
+ 3618502788666131106986593281521497120414687020801267626233049500247285301247500p 0.9
+ 3618502788666131106986593281521497120414687020801267626233049500247285301247510p -0.3
+ 3618502788666131106986593281521497120414687020801267626233049500247285301248000p -0.3
+ 3618502788666131106986593281521497120414687020801267626233049500247285301248010p 0.9
+ \]
V_wl_bar_252 (WordLine_bar\\<252\\> gnd!) vsource type=pwl wave=\[
+ 0    0.9
+ 7237005577332262213973186563042994240829374041602535252466099000494570602495500p 0.9
+ 7237005577332262213973186563042994240829374041602535252466099000494570602495510p -0.3
+ 7237005577332262213973186563042994240829374041602535252466099000494570602496000p -0.3
+ 7237005577332262213973186563042994240829374041602535252466099000494570602496010p 0.9
+ \]
V_wl_bar_253 (WordLine_bar\\<253\\> gnd!) vsource type=pwl wave=\[
+ 0    0.9
+ 14474011154664524427946373126085988481658748083205070504932198000989141204991500p 0.9
+ 14474011154664524427946373126085988481658748083205070504932198000989141204991510p -0.3
+ 14474011154664524427946373126085988481658748083205070504932198000989141204992000p -0.3
+ 14474011154664524427946373126085988481658748083205070504932198000989141204992010p 0.9
+ \]
V_wl_bar_254 (WordLine_bar\\<254\\> gnd!) vsource type=pwl wave=\[
+ 0    0.9
+ 28948022309329048855892746252171976963317496166410141009864396001978282409983500p 0.9
+ 28948022309329048855892746252171976963317496166410141009864396001978282409983510p -0.3
+ 28948022309329048855892746252171976963317496166410141009864396001978282409984000p -0.3
+ 28948022309329048855892746252171976963317496166410141009864396001978282409984010p 0.9
+ \]
V_wl_bar_255 (WordLine_bar\\<255\\> gnd!) vsource type=pwl wave=\[
+ 0    0.9
+ 57896044618658097711785492504343953926634992332820282019728792003956564819967500p 0.9
+ 57896044618658097711785492504343953926634992332820282019728792003956564819967510p -0.3
+ 57896044618658097711785492504343953926634992332820282019728792003956564819968000p -0.3
+ 57896044618658097711785492504343953926634992332820282019728792003956564819968010p 0.9
+ \]
V_wl_bar_256 (WordLine_bar\\<256\\> gnd!) vsource type=pwl wave=\[
+ 0    0.9
+ 115792089237316195423570985008687907853269984665640564039457584007913129639935500p 0.9
+ 115792089237316195423570985008687907853269984665640564039457584007913129639935510p -0.3
+ 115792089237316195423570985008687907853269984665640564039457584007913129639936000p -0.3
+ 115792089237316195423570985008687907853269984665640564039457584007913129639936010p 0.9
+ \]
V_wl_bar_257 (WordLine_bar\\<257\\> gnd!) vsource type=pwl wave=\[
+ 0    0.9
+ 231584178474632390847141970017375815706539969331281128078915168015826259279871500p 0.9
+ 231584178474632390847141970017375815706539969331281128078915168015826259279871510p -0.3
+ 231584178474632390847141970017375815706539969331281128078915168015826259279872000p -0.3
+ 231584178474632390847141970017375815706539969331281128078915168015826259279872010p 0.9
+ \]
V_wl_bar_258 (WordLine_bar\\<258\\> gnd!) vsource type=pwl wave=\[
+ 0    0.9
+ 463168356949264781694283940034751631413079938662562256157830336031652518559743500p 0.9
+ 463168356949264781694283940034751631413079938662562256157830336031652518559743510p -0.3
+ 463168356949264781694283940034751631413079938662562256157830336031652518559744000p -0.3
+ 463168356949264781694283940034751631413079938662562256157830336031652518559744010p 0.9
+ \]
V_wl_bar_259 (WordLine_bar\\<259\\> gnd!) vsource type=pwl wave=\[
+ 0    0.9
+ 926336713898529563388567880069503262826159877325124512315660672063305037119487500p 0.9
+ 926336713898529563388567880069503262826159877325124512315660672063305037119487510p -0.3
+ 926336713898529563388567880069503262826159877325124512315660672063305037119488000p -0.3
+ 926336713898529563388567880069503262826159877325124512315660672063305037119488010p 0.9
+ \]
V_wl_bar_260 (WordLine_bar\\<260\\> gnd!) vsource type=pwl wave=\[
+ 0    0.9
+ 1852673427797059126777135760139006525652319754650249024631321344126610074238975500p 0.9
+ 1852673427797059126777135760139006525652319754650249024631321344126610074238975510p -0.3
+ 1852673427797059126777135760139006525652319754650249024631321344126610074238976000p -0.3
+ 1852673427797059126777135760139006525652319754650249024631321344126610074238976010p 0.9
+ \]
V_wl_bar_261 (WordLine_bar\\<261\\> gnd!) vsource type=pwl wave=\[
+ 0    0.9
+ 3705346855594118253554271520278013051304639509300498049262642688253220148477951500p 0.9
+ 3705346855594118253554271520278013051304639509300498049262642688253220148477951510p -0.3
+ 3705346855594118253554271520278013051304639509300498049262642688253220148477952000p -0.3
+ 3705346855594118253554271520278013051304639509300498049262642688253220148477952010p 0.9
+ \]
V_wl_bar_262 (WordLine_bar\\<262\\> gnd!) vsource type=pwl wave=\[
+ 0    0.9
+ 7410693711188236507108543040556026102609279018600996098525285376506440296955903500p 0.9
+ 7410693711188236507108543040556026102609279018600996098525285376506440296955903510p -0.3
+ 7410693711188236507108543040556026102609279018600996098525285376506440296955904000p -0.3
+ 7410693711188236507108543040556026102609279018600996098525285376506440296955904010p 0.9
+ \]
V_wl_bar_263 (WordLine_bar\\<263\\> gnd!) vsource type=pwl wave=\[
+ 0    0.9
+ 14821387422376473014217086081112052205218558037201992197050570753012880593911807500p 0.9
+ 14821387422376473014217086081112052205218558037201992197050570753012880593911807510p -0.3
+ 14821387422376473014217086081112052205218558037201992197050570753012880593911808000p -0.3
+ 14821387422376473014217086081112052205218558037201992197050570753012880593911808010p 0.9
+ \]
V_wl_bar_264 (WordLine_bar\\<264\\> gnd!) vsource type=pwl wave=\[
+ 0    0.9
+ 29642774844752946028434172162224104410437116074403984394101141506025761187823615500p 0.9
+ 29642774844752946028434172162224104410437116074403984394101141506025761187823615510p -0.3
+ 29642774844752946028434172162224104410437116074403984394101141506025761187823616000p -0.3
+ 29642774844752946028434172162224104410437116074403984394101141506025761187823616010p 0.9
+ \]
V_wl_bar_265 (WordLine_bar\\<265\\> gnd!) vsource type=pwl wave=\[
+ 0    0.9
+ 59285549689505892056868344324448208820874232148807968788202283012051522375647231500p 0.9
+ 59285549689505892056868344324448208820874232148807968788202283012051522375647231510p -0.3
+ 59285549689505892056868344324448208820874232148807968788202283012051522375647232000p -0.3
+ 59285549689505892056868344324448208820874232148807968788202283012051522375647232010p 0.9
+ \]
V_wl_bar_266 (WordLine_bar\\<266\\> gnd!) vsource type=pwl wave=\[
+ 0    0.9
+ 118571099379011784113736688648896417641748464297615937576404566024103044751294463500p 0.9
+ 118571099379011784113736688648896417641748464297615937576404566024103044751294463510p -0.3
+ 118571099379011784113736688648896417641748464297615937576404566024103044751294464000p -0.3
+ 118571099379011784113736688648896417641748464297615937576404566024103044751294464010p 0.9
+ \]
V_wl_bar_267 (WordLine_bar\\<267\\> gnd!) vsource type=pwl wave=\[
+ 0    0.9
+ 237142198758023568227473377297792835283496928595231875152809132048206089502588927500p 0.9
+ 237142198758023568227473377297792835283496928595231875152809132048206089502588927510p -0.3
+ 237142198758023568227473377297792835283496928595231875152809132048206089502588928000p -0.3
+ 237142198758023568227473377297792835283496928595231875152809132048206089502588928010p 0.9
+ \]
V_wl_bar_268 (WordLine_bar\\<268\\> gnd!) vsource type=pwl wave=\[
+ 0    0.9
+ 474284397516047136454946754595585670566993857190463750305618264096412179005177855500p 0.9
+ 474284397516047136454946754595585670566993857190463750305618264096412179005177855510p -0.3
+ 474284397516047136454946754595585670566993857190463750305618264096412179005177856000p -0.3
+ 474284397516047136454946754595585670566993857190463750305618264096412179005177856010p 0.9
+ \]
V_wl_bar_269 (WordLine_bar\\<269\\> gnd!) vsource type=pwl wave=\[
+ 0    0.9
+ 948568795032094272909893509191171341133987714380927500611236528192824358010355711500p 0.9
+ 948568795032094272909893509191171341133987714380927500611236528192824358010355711510p -0.3
+ 948568795032094272909893509191171341133987714380927500611236528192824358010355712000p -0.3
+ 948568795032094272909893509191171341133987714380927500611236528192824358010355712010p 0.9
+ \]
V_wl_bar_270 (WordLine_bar\\<270\\> gnd!) vsource type=pwl wave=\[
+ 0    0.9
+ 1897137590064188545819787018382342682267975428761855001222473056385648716020711423500p 0.9
+ 1897137590064188545819787018382342682267975428761855001222473056385648716020711423510p -0.3
+ 1897137590064188545819787018382342682267975428761855001222473056385648716020711424000p -0.3
+ 1897137590064188545819787018382342682267975428761855001222473056385648716020711424010p 0.9
+ \]
V_wl_bar_271 (WordLine_bar\\<271\\> gnd!) vsource type=pwl wave=\[
+ 0    0.9
+ 3794275180128377091639574036764685364535950857523710002444946112771297432041422847500p 0.9
+ 3794275180128377091639574036764685364535950857523710002444946112771297432041422847510p -0.3
+ 3794275180128377091639574036764685364535950857523710002444946112771297432041422848000p -0.3
+ 3794275180128377091639574036764685364535950857523710002444946112771297432041422848010p 0.9
+ \]
V_wl_bar_272 (WordLine_bar\\<272\\> gnd!) vsource type=pwl wave=\[
+ 0    0.9
+ 7588550360256754183279148073529370729071901715047420004889892225542594864082845695500p 0.9
+ 7588550360256754183279148073529370729071901715047420004889892225542594864082845695510p -0.3
+ 7588550360256754183279148073529370729071901715047420004889892225542594864082845696000p -0.3
+ 7588550360256754183279148073529370729071901715047420004889892225542594864082845696010p 0.9
+ \]
V_wl_bar_273 (WordLine_bar\\<273\\> gnd!) vsource type=pwl wave=\[
+ 0    0.9
+ 15177100720513508366558296147058741458143803430094840009779784451085189728165691391500p 0.9
+ 15177100720513508366558296147058741458143803430094840009779784451085189728165691391510p -0.3
+ 15177100720513508366558296147058741458143803430094840009779784451085189728165691392000p -0.3
+ 15177100720513508366558296147058741458143803430094840009779784451085189728165691392010p 0.9
+ \]
V_wl_bar_274 (WordLine_bar\\<274\\> gnd!) vsource type=pwl wave=\[
+ 0    0.9
+ 30354201441027016733116592294117482916287606860189680019559568902170379456331382783500p 0.9
+ 30354201441027016733116592294117482916287606860189680019559568902170379456331382783510p -0.3
+ 30354201441027016733116592294117482916287606860189680019559568902170379456331382784000p -0.3
+ 30354201441027016733116592294117482916287606860189680019559568902170379456331382784010p 0.9
+ \]
V_wl_bar_275 (WordLine_bar\\<275\\> gnd!) vsource type=pwl wave=\[
+ 0    0.9
+ 60708402882054033466233184588234965832575213720379360039119137804340758912662765567500p 0.9
+ 60708402882054033466233184588234965832575213720379360039119137804340758912662765567510p -0.3
+ 60708402882054033466233184588234965832575213720379360039119137804340758912662765568000p -0.3
+ 60708402882054033466233184588234965832575213720379360039119137804340758912662765568010p 0.9
+ \]
V_wl_bar_276 (WordLine_bar\\<276\\> gnd!) vsource type=pwl wave=\[
+ 0    0.9
+ 121416805764108066932466369176469931665150427440758720078238275608681517825325531135500p 0.9
+ 121416805764108066932466369176469931665150427440758720078238275608681517825325531135510p -0.3
+ 121416805764108066932466369176469931665150427440758720078238275608681517825325531136000p -0.3
+ 121416805764108066932466369176469931665150427440758720078238275608681517825325531136010p 0.9
+ \]
V_wl_bar_277 (WordLine_bar\\<277\\> gnd!) vsource type=pwl wave=\[
+ 0    0.9
+ 242833611528216133864932738352939863330300854881517440156476551217363035650651062271500p 0.9
+ 242833611528216133864932738352939863330300854881517440156476551217363035650651062271510p -0.3
+ 242833611528216133864932738352939863330300854881517440156476551217363035650651062272000p -0.3
+ 242833611528216133864932738352939863330300854881517440156476551217363035650651062272010p 0.9
+ \]
V_wl_bar_278 (WordLine_bar\\<278\\> gnd!) vsource type=pwl wave=\[
+ 0    0.9
+ 485667223056432267729865476705879726660601709763034880312953102434726071301302124543500p 0.9
+ 485667223056432267729865476705879726660601709763034880312953102434726071301302124543510p -0.3
+ 485667223056432267729865476705879726660601709763034880312953102434726071301302124544000p -0.3
+ 485667223056432267729865476705879726660601709763034880312953102434726071301302124544010p 0.9
+ \]
V_wl_bar_279 (WordLine_bar\\<279\\> gnd!) vsource type=pwl wave=\[
+ 0    0.9
+ 971334446112864535459730953411759453321203419526069760625906204869452142602604249087500p 0.9
+ 971334446112864535459730953411759453321203419526069760625906204869452142602604249087510p -0.3
+ 971334446112864535459730953411759453321203419526069760625906204869452142602604249088000p -0.3
+ 971334446112864535459730953411759453321203419526069760625906204869452142602604249088010p 0.9
+ \]
V_wl_bar_280 (WordLine_bar\\<280\\> gnd!) vsource type=pwl wave=\[
+ 0    0.9
+ 1942668892225729070919461906823518906642406839052139521251812409738904285205208498175500p 0.9
+ 1942668892225729070919461906823518906642406839052139521251812409738904285205208498175510p -0.3
+ 1942668892225729070919461906823518906642406839052139521251812409738904285205208498176000p -0.3
+ 1942668892225729070919461906823518906642406839052139521251812409738904285205208498176010p 0.9
+ \]
V_wl_bar_281 (WordLine_bar\\<281\\> gnd!) vsource type=pwl wave=\[
+ 0    0.9
+ 3885337784451458141838923813647037813284813678104279042503624819477808570410416996351500p 0.9
+ 3885337784451458141838923813647037813284813678104279042503624819477808570410416996351510p -0.3
+ 3885337784451458141838923813647037813284813678104279042503624819477808570410416996352000p -0.3
+ 3885337784451458141838923813647037813284813678104279042503624819477808570410416996352010p 0.9
+ \]
V_wl_bar_282 (WordLine_bar\\<282\\> gnd!) vsource type=pwl wave=\[
+ 0    0.9
+ 7770675568902916283677847627294075626569627356208558085007249638955617140820833992703500p 0.9
+ 7770675568902916283677847627294075626569627356208558085007249638955617140820833992703510p -0.3
+ 7770675568902916283677847627294075626569627356208558085007249638955617140820833992704000p -0.3
+ 7770675568902916283677847627294075626569627356208558085007249638955617140820833992704010p 0.9
+ \]
V_wl_bar_283 (WordLine_bar\\<283\\> gnd!) vsource type=pwl wave=\[
+ 0    0.9
+ 15541351137805832567355695254588151253139254712417116170014499277911234281641667985407500p 0.9
+ 15541351137805832567355695254588151253139254712417116170014499277911234281641667985407510p -0.3
+ 15541351137805832567355695254588151253139254712417116170014499277911234281641667985408000p -0.3
+ 15541351137805832567355695254588151253139254712417116170014499277911234281641667985408010p 0.9
+ \]
V_wl_bar_284 (WordLine_bar\\<284\\> gnd!) vsource type=pwl wave=\[
+ 0    0.9
+ 31082702275611665134711390509176302506278509424834232340028998555822468563283335970815500p 0.9
+ 31082702275611665134711390509176302506278509424834232340028998555822468563283335970815510p -0.3
+ 31082702275611665134711390509176302506278509424834232340028998555822468563283335970816000p -0.3
+ 31082702275611665134711390509176302506278509424834232340028998555822468563283335970816010p 0.9
+ \]
V_wl_bar_285 (WordLine_bar\\<285\\> gnd!) vsource type=pwl wave=\[
+ 0    0.9
+ 62165404551223330269422781018352605012557018849668464680057997111644937126566671941631500p 0.9
+ 62165404551223330269422781018352605012557018849668464680057997111644937126566671941631510p -0.3
+ 62165404551223330269422781018352605012557018849668464680057997111644937126566671941632000p -0.3
+ 62165404551223330269422781018352605012557018849668464680057997111644937126566671941632010p 0.9
+ \]
V_wl_bar_286 (WordLine_bar\\<286\\> gnd!) vsource type=pwl wave=\[
+ 0    0.9
+ 124330809102446660538845562036705210025114037699336929360115994223289874253133343883263500p 0.9
+ 124330809102446660538845562036705210025114037699336929360115994223289874253133343883263510p -0.3
+ 124330809102446660538845562036705210025114037699336929360115994223289874253133343883264000p -0.3
+ 124330809102446660538845562036705210025114037699336929360115994223289874253133343883264010p 0.9
+ \]
V_wl_bar_287 (WordLine_bar\\<287\\> gnd!) vsource type=pwl wave=\[
+ 0    0.9
+ 248661618204893321077691124073410420050228075398673858720231988446579748506266687766527500p 0.9
+ 248661618204893321077691124073410420050228075398673858720231988446579748506266687766527510p -0.3
+ 248661618204893321077691124073410420050228075398673858720231988446579748506266687766528000p -0.3
+ 248661618204893321077691124073410420050228075398673858720231988446579748506266687766528010p 0.9
+ \]
V_wl_bar_288 (WordLine_bar\\<288\\> gnd!) vsource type=pwl wave=\[
+ 0    0.9
+ 497323236409786642155382248146820840100456150797347717440463976893159497012533375533055500p 0.9
+ 497323236409786642155382248146820840100456150797347717440463976893159497012533375533055510p -0.3
+ 497323236409786642155382248146820840100456150797347717440463976893159497012533375533056000p -0.3
+ 497323236409786642155382248146820840100456150797347717440463976893159497012533375533056010p 0.9
+ \]
V_wl_bar_289 (WordLine_bar\\<289\\> gnd!) vsource type=pwl wave=\[
+ 0    0.9
+ 994646472819573284310764496293641680200912301594695434880927953786318994025066751066111500p 0.9
+ 994646472819573284310764496293641680200912301594695434880927953786318994025066751066111510p -0.3
+ 994646472819573284310764496293641680200912301594695434880927953786318994025066751066112000p -0.3
+ 994646472819573284310764496293641680200912301594695434880927953786318994025066751066112010p 0.9
+ \]
V_wl_bar_290 (WordLine_bar\\<290\\> gnd!) vsource type=pwl wave=\[
+ 0    0.9
+ 1989292945639146568621528992587283360401824603189390869761855907572637988050133502132223500p 0.9
+ 1989292945639146568621528992587283360401824603189390869761855907572637988050133502132223510p -0.3
+ 1989292945639146568621528992587283360401824603189390869761855907572637988050133502132224000p -0.3
+ 1989292945639146568621528992587283360401824603189390869761855907572637988050133502132224010p 0.9
+ \]
V_wl_bar_291 (WordLine_bar\\<291\\> gnd!) vsource type=pwl wave=\[
+ 0    0.9
+ 3978585891278293137243057985174566720803649206378781739523711815145275976100267004264447500p 0.9
+ 3978585891278293137243057985174566720803649206378781739523711815145275976100267004264447510p -0.3
+ 3978585891278293137243057985174566720803649206378781739523711815145275976100267004264448000p -0.3
+ 3978585891278293137243057985174566720803649206378781739523711815145275976100267004264448010p 0.9
+ \]
V_wl_bar_292 (WordLine_bar\\<292\\> gnd!) vsource type=pwl wave=\[
+ 0    0.9
+ 7957171782556586274486115970349133441607298412757563479047423630290551952200534008528895500p 0.9
+ 7957171782556586274486115970349133441607298412757563479047423630290551952200534008528895510p -0.3
+ 7957171782556586274486115970349133441607298412757563479047423630290551952200534008528896000p -0.3
+ 7957171782556586274486115970349133441607298412757563479047423630290551952200534008528896010p 0.9
+ \]
V_wl_bar_293 (WordLine_bar\\<293\\> gnd!) vsource type=pwl wave=\[
+ 0    0.9
+ 15914343565113172548972231940698266883214596825515126958094847260581103904401068017057791500p 0.9
+ 15914343565113172548972231940698266883214596825515126958094847260581103904401068017057791510p -0.3
+ 15914343565113172548972231940698266883214596825515126958094847260581103904401068017057792000p -0.3
+ 15914343565113172548972231940698266883214596825515126958094847260581103904401068017057792010p 0.9
+ \]
V_wl_bar_294 (WordLine_bar\\<294\\> gnd!) vsource type=pwl wave=\[
+ 0    0.9
+ 31828687130226345097944463881396533766429193651030253916189694521162207808802136034115583500p 0.9
+ 31828687130226345097944463881396533766429193651030253916189694521162207808802136034115583510p -0.3
+ 31828687130226345097944463881396533766429193651030253916189694521162207808802136034115584000p -0.3
+ 31828687130226345097944463881396533766429193651030253916189694521162207808802136034115584010p 0.9
+ \]
V_wl_bar_295 (WordLine_bar\\<295\\> gnd!) vsource type=pwl wave=\[
+ 0    0.9
+ 63657374260452690195888927762793067532858387302060507832379389042324415617604272068231167500p 0.9
+ 63657374260452690195888927762793067532858387302060507832379389042324415617604272068231167510p -0.3
+ 63657374260452690195888927762793067532858387302060507832379389042324415617604272068231168000p -0.3
+ 63657374260452690195888927762793067532858387302060507832379389042324415617604272068231168010p 0.9
+ \]
V_wl_bar_296 (WordLine_bar\\<296\\> gnd!) vsource type=pwl wave=\[
+ 0    0.9
+ 127314748520905380391777855525586135065716774604121015664758778084648831235208544136462335500p 0.9
+ 127314748520905380391777855525586135065716774604121015664758778084648831235208544136462335510p -0.3
+ 127314748520905380391777855525586135065716774604121015664758778084648831235208544136462336000p -0.3
+ 127314748520905380391777855525586135065716774604121015664758778084648831235208544136462336010p 0.9
+ \]
V_wl_bar_297 (WordLine_bar\\<297\\> gnd!) vsource type=pwl wave=\[
+ 0    0.9
+ 254629497041810760783555711051172270131433549208242031329517556169297662470417088272924671500p 0.9
+ 254629497041810760783555711051172270131433549208242031329517556169297662470417088272924671510p -0.3
+ 254629497041810760783555711051172270131433549208242031329517556169297662470417088272924672000p -0.3
+ 254629497041810760783555711051172270131433549208242031329517556169297662470417088272924672010p 0.9
+ \]
V_wl_bar_298 (WordLine_bar\\<298\\> gnd!) vsource type=pwl wave=\[
+ 0    0.9
+ 509258994083621521567111422102344540262867098416484062659035112338595324940834176545849343500p 0.9
+ 509258994083621521567111422102344540262867098416484062659035112338595324940834176545849343510p -0.3
+ 509258994083621521567111422102344540262867098416484062659035112338595324940834176545849344000p -0.3
+ 509258994083621521567111422102344540262867098416484062659035112338595324940834176545849344010p 0.9
+ \]
V_wl_bar_299 (WordLine_bar\\<299\\> gnd!) vsource type=pwl wave=\[
+ 0    0.9
+ 1018517988167243043134222844204689080525734196832968125318070224677190649881668353091698687500p 0.9
+ 1018517988167243043134222844204689080525734196832968125318070224677190649881668353091698687510p -0.3
+ 1018517988167243043134222844204689080525734196832968125318070224677190649881668353091698688000p -0.3
+ 1018517988167243043134222844204689080525734196832968125318070224677190649881668353091698688010p 0.9
+ \]
V_wl_bar_300 (WordLine_bar\\<300\\> gnd!) vsource type=pwl wave=\[
+ 0    0.9
+ 2037035976334486086268445688409378161051468393665936250636140449354381299763336706183397375500p 0.9
+ 2037035976334486086268445688409378161051468393665936250636140449354381299763336706183397375510p -0.3
+ 2037035976334486086268445688409378161051468393665936250636140449354381299763336706183397376000p -0.3
+ 2037035976334486086268445688409378161051468393665936250636140449354381299763336706183397376010p 0.9
+ \]
V_wl_bar_301 (WordLine_bar\\<301\\> gnd!) vsource type=pwl wave=\[
+ 0    0.9
+ 4074071952668972172536891376818756322102936787331872501272280898708762599526673412366794751500p 0.9
+ 4074071952668972172536891376818756322102936787331872501272280898708762599526673412366794751510p -0.3
+ 4074071952668972172536891376818756322102936787331872501272280898708762599526673412366794752000p -0.3
+ 4074071952668972172536891376818756322102936787331872501272280898708762599526673412366794752010p 0.9
+ \]
V_wl_bar_302 (WordLine_bar\\<302\\> gnd!) vsource type=pwl wave=\[
+ 0    0.9
+ 8148143905337944345073782753637512644205873574663745002544561797417525199053346824733589503500p 0.9
+ 8148143905337944345073782753637512644205873574663745002544561797417525199053346824733589503510p -0.3
+ 8148143905337944345073782753637512644205873574663745002544561797417525199053346824733589504000p -0.3
+ 8148143905337944345073782753637512644205873574663745002544561797417525199053346824733589504010p 0.9
+ \]
V_wl_bar_303 (WordLine_bar\\<303\\> gnd!) vsource type=pwl wave=\[
+ 0    0.9
+ 16296287810675888690147565507275025288411747149327490005089123594835050398106693649467179007500p 0.9
+ 16296287810675888690147565507275025288411747149327490005089123594835050398106693649467179007510p -0.3
+ 16296287810675888690147565507275025288411747149327490005089123594835050398106693649467179008000p -0.3
+ 16296287810675888690147565507275025288411747149327490005089123594835050398106693649467179008010p 0.9
+ \]
V_wl_bar_304 (WordLine_bar\\<304\\> gnd!) vsource type=pwl wave=\[
+ 0    0.9
+ 32592575621351777380295131014550050576823494298654980010178247189670100796213387298934358015500p 0.9
+ 32592575621351777380295131014550050576823494298654980010178247189670100796213387298934358015510p -0.3
+ 32592575621351777380295131014550050576823494298654980010178247189670100796213387298934358016000p -0.3
+ 32592575621351777380295131014550050576823494298654980010178247189670100796213387298934358016010p 0.9
+ \]
V_wl_bar_305 (WordLine_bar\\<305\\> gnd!) vsource type=pwl wave=\[
+ 0    0.9
+ 65185151242703554760590262029100101153646988597309960020356494379340201592426774597868716031500p 0.9
+ 65185151242703554760590262029100101153646988597309960020356494379340201592426774597868716031510p -0.3
+ 65185151242703554760590262029100101153646988597309960020356494379340201592426774597868716032000p -0.3
+ 65185151242703554760590262029100101153646988597309960020356494379340201592426774597868716032010p 0.9
+ \]
V_wl_bar_306 (WordLine_bar\\<306\\> gnd!) vsource type=pwl wave=\[
+ 0    0.9
+ 130370302485407109521180524058200202307293977194619920040712988758680403184853549195737432063500p 0.9
+ 130370302485407109521180524058200202307293977194619920040712988758680403184853549195737432063510p -0.3
+ 130370302485407109521180524058200202307293977194619920040712988758680403184853549195737432064000p -0.3
+ 130370302485407109521180524058200202307293977194619920040712988758680403184853549195737432064010p 0.9
+ \]
V_wl_bar_307 (WordLine_bar\\<307\\> gnd!) vsource type=pwl wave=\[
+ 0    0.9
+ 260740604970814219042361048116400404614587954389239840081425977517360806369707098391474864127500p 0.9
+ 260740604970814219042361048116400404614587954389239840081425977517360806369707098391474864127510p -0.3
+ 260740604970814219042361048116400404614587954389239840081425977517360806369707098391474864128000p -0.3
+ 260740604970814219042361048116400404614587954389239840081425977517360806369707098391474864128010p 0.9
+ \]
V_wl_bar_308 (WordLine_bar\\<308\\> gnd!) vsource type=pwl wave=\[
+ 0    0.9
+ 521481209941628438084722096232800809229175908778479680162851955034721612739414196782949728255500p 0.9
+ 521481209941628438084722096232800809229175908778479680162851955034721612739414196782949728255510p -0.3
+ 521481209941628438084722096232800809229175908778479680162851955034721612739414196782949728256000p -0.3
+ 521481209941628438084722096232800809229175908778479680162851955034721612739414196782949728256010p 0.9
+ \]
V_wl_bar_309 (WordLine_bar\\<309\\> gnd!) vsource type=pwl wave=\[
+ 0    0.9
+ 1042962419883256876169444192465601618458351817556959360325703910069443225478828393565899456511500p 0.9
+ 1042962419883256876169444192465601618458351817556959360325703910069443225478828393565899456511510p -0.3
+ 1042962419883256876169444192465601618458351817556959360325703910069443225478828393565899456512000p -0.3
+ 1042962419883256876169444192465601618458351817556959360325703910069443225478828393565899456512010p 0.9
+ \]
V_wl_bar_310 (WordLine_bar\\<310\\> gnd!) vsource type=pwl wave=\[
+ 0    0.9
+ 2085924839766513752338888384931203236916703635113918720651407820138886450957656787131798913023500p 0.9
+ 2085924839766513752338888384931203236916703635113918720651407820138886450957656787131798913023510p -0.3
+ 2085924839766513752338888384931203236916703635113918720651407820138886450957656787131798913024000p -0.3
+ 2085924839766513752338888384931203236916703635113918720651407820138886450957656787131798913024010p 0.9
+ \]
V_wl_bar_311 (WordLine_bar\\<311\\> gnd!) vsource type=pwl wave=\[
+ 0    0.9
+ 4171849679533027504677776769862406473833407270227837441302815640277772901915313574263597826047500p 0.9
+ 4171849679533027504677776769862406473833407270227837441302815640277772901915313574263597826047510p -0.3
+ 4171849679533027504677776769862406473833407270227837441302815640277772901915313574263597826048000p -0.3
+ 4171849679533027504677776769862406473833407270227837441302815640277772901915313574263597826048010p 0.9
+ \]
V_wl_bar_312 (WordLine_bar\\<312\\> gnd!) vsource type=pwl wave=\[
+ 0    0.9
+ 8343699359066055009355553539724812947666814540455674882605631280555545803830627148527195652095500p 0.9
+ 8343699359066055009355553539724812947666814540455674882605631280555545803830627148527195652095510p -0.3
+ 8343699359066055009355553539724812947666814540455674882605631280555545803830627148527195652096000p -0.3
+ 8343699359066055009355553539724812947666814540455674882605631280555545803830627148527195652096010p 0.9
+ \]
V_wl_bar_313 (WordLine_bar\\<313\\> gnd!) vsource type=pwl wave=\[
+ 0    0.9
+ 16687398718132110018711107079449625895333629080911349765211262561111091607661254297054391304191500p 0.9
+ 16687398718132110018711107079449625895333629080911349765211262561111091607661254297054391304191510p -0.3
+ 16687398718132110018711107079449625895333629080911349765211262561111091607661254297054391304192000p -0.3
+ 16687398718132110018711107079449625895333629080911349765211262561111091607661254297054391304192010p 0.9
+ \]
V_wl_bar_314 (WordLine_bar\\<314\\> gnd!) vsource type=pwl wave=\[
+ 0    0.9
+ 33374797436264220037422214158899251790667258161822699530422525122222183215322508594108782608383500p 0.9
+ 33374797436264220037422214158899251790667258161822699530422525122222183215322508594108782608383510p -0.3
+ 33374797436264220037422214158899251790667258161822699530422525122222183215322508594108782608384000p -0.3
+ 33374797436264220037422214158899251790667258161822699530422525122222183215322508594108782608384010p 0.9
+ \]
V_wl_bar_315 (WordLine_bar\\<315\\> gnd!) vsource type=pwl wave=\[
+ 0    0.9
+ 66749594872528440074844428317798503581334516323645399060845050244444366430645017188217565216767500p 0.9
+ 66749594872528440074844428317798503581334516323645399060845050244444366430645017188217565216767510p -0.3
+ 66749594872528440074844428317798503581334516323645399060845050244444366430645017188217565216768000p -0.3
+ 66749594872528440074844428317798503581334516323645399060845050244444366430645017188217565216768010p 0.9
+ \]
V_wl_bar_316 (WordLine_bar\\<316\\> gnd!) vsource type=pwl wave=\[
+ 0    0.9
+ 133499189745056880149688856635597007162669032647290798121690100488888732861290034376435130433535500p 0.9
+ 133499189745056880149688856635597007162669032647290798121690100488888732861290034376435130433535510p -0.3
+ 133499189745056880149688856635597007162669032647290798121690100488888732861290034376435130433536000p -0.3
+ 133499189745056880149688856635597007162669032647290798121690100488888732861290034376435130433536010p 0.9
+ \]
V_wl_bar_317 (WordLine_bar\\<317\\> gnd!) vsource type=pwl wave=\[
+ 0    0.9
+ 266998379490113760299377713271194014325338065294581596243380200977777465722580068752870260867071500p 0.9
+ 266998379490113760299377713271194014325338065294581596243380200977777465722580068752870260867071510p -0.3
+ 266998379490113760299377713271194014325338065294581596243380200977777465722580068752870260867072000p -0.3
+ 266998379490113760299377713271194014325338065294581596243380200977777465722580068752870260867072010p 0.9
+ \]
V_wl_bar_318 (WordLine_bar\\<318\\> gnd!) vsource type=pwl wave=\[
+ 0    0.9
+ 533996758980227520598755426542388028650676130589163192486760401955554931445160137505740521734143500p 0.9
+ 533996758980227520598755426542388028650676130589163192486760401955554931445160137505740521734143510p -0.3
+ 533996758980227520598755426542388028650676130589163192486760401955554931445160137505740521734144000p -0.3
+ 533996758980227520598755426542388028650676130589163192486760401955554931445160137505740521734144010p 0.9
+ \]
V_wl_bar_319 (WordLine_bar\\<319\\> gnd!) vsource type=pwl wave=\[
+ 0    0.9
+ 1067993517960455041197510853084776057301352261178326384973520803911109862890320275011481043468287500p 0.9
+ 1067993517960455041197510853084776057301352261178326384973520803911109862890320275011481043468287510p -0.3
+ 1067993517960455041197510853084776057301352261178326384973520803911109862890320275011481043468288000p -0.3
+ 1067993517960455041197510853084776057301352261178326384973520803911109862890320275011481043468288010p 0.9
+ \]
V_wl_bar_320 (WordLine_bar\\<320\\> gnd!) vsource type=pwl wave=\[
+ 0    0.9
+ 2135987035920910082395021706169552114602704522356652769947041607822219725780640550022962086936575500p 0.9
+ 2135987035920910082395021706169552114602704522356652769947041607822219725780640550022962086936575510p -0.3
+ 2135987035920910082395021706169552114602704522356652769947041607822219725780640550022962086936576000p -0.3
+ 2135987035920910082395021706169552114602704522356652769947041607822219725780640550022962086936576010p 0.9
+ \]
V_wl_bar_321 (WordLine_bar\\<321\\> gnd!) vsource type=pwl wave=\[
+ 0    0.9
+ 4271974071841820164790043412339104229205409044713305539894083215644439451561281100045924173873151500p 0.9
+ 4271974071841820164790043412339104229205409044713305539894083215644439451561281100045924173873151510p -0.3
+ 4271974071841820164790043412339104229205409044713305539894083215644439451561281100045924173873152000p -0.3
+ 4271974071841820164790043412339104229205409044713305539894083215644439451561281100045924173873152010p 0.9
+ \]
V_wl_bar_322 (WordLine_bar\\<322\\> gnd!) vsource type=pwl wave=\[
+ 0    0.9
+ 8543948143683640329580086824678208458410818089426611079788166431288878903122562200091848347746303500p 0.9
+ 8543948143683640329580086824678208458410818089426611079788166431288878903122562200091848347746303510p -0.3
+ 8543948143683640329580086824678208458410818089426611079788166431288878903122562200091848347746304000p -0.3
+ 8543948143683640329580086824678208458410818089426611079788166431288878903122562200091848347746304010p 0.9
+ \]
V_wl_bar_323 (WordLine_bar\\<323\\> gnd!) vsource type=pwl wave=\[
+ 0    0.9
+ 17087896287367280659160173649356416916821636178853222159576332862577757806245124400183696695492607500p 0.9
+ 17087896287367280659160173649356416916821636178853222159576332862577757806245124400183696695492607510p -0.3
+ 17087896287367280659160173649356416916821636178853222159576332862577757806245124400183696695492608000p -0.3
+ 17087896287367280659160173649356416916821636178853222159576332862577757806245124400183696695492608010p 0.9
+ \]
V_wl_bar_324 (WordLine_bar\\<324\\> gnd!) vsource type=pwl wave=\[
+ 0    0.9
+ 34175792574734561318320347298712833833643272357706444319152665725155515612490248800367393390985215500p 0.9
+ 34175792574734561318320347298712833833643272357706444319152665725155515612490248800367393390985215510p -0.3
+ 34175792574734561318320347298712833833643272357706444319152665725155515612490248800367393390985216000p -0.3
+ 34175792574734561318320347298712833833643272357706444319152665725155515612490248800367393390985216010p 0.9
+ \]
V_wl_bar_325 (WordLine_bar\\<325\\> gnd!) vsource type=pwl wave=\[
+ 0    0.9
+ 68351585149469122636640694597425667667286544715412888638305331450311031224980497600734786781970431500p 0.9
+ 68351585149469122636640694597425667667286544715412888638305331450311031224980497600734786781970431510p -0.3
+ 68351585149469122636640694597425667667286544715412888638305331450311031224980497600734786781970432000p -0.3
+ 68351585149469122636640694597425667667286544715412888638305331450311031224980497600734786781970432010p 0.9
+ \]
V_wl_bar_326 (WordLine_bar\\<326\\> gnd!) vsource type=pwl wave=\[
+ 0    0.9
+ 136703170298938245273281389194851335334573089430825777276610662900622062449960995201469573563940863500p 0.9
+ 136703170298938245273281389194851335334573089430825777276610662900622062449960995201469573563940863510p -0.3
+ 136703170298938245273281389194851335334573089430825777276610662900622062449960995201469573563940864000p -0.3
+ 136703170298938245273281389194851335334573089430825777276610662900622062449960995201469573563940864010p 0.9
+ \]
V_wl_bar_327 (WordLine_bar\\<327\\> gnd!) vsource type=pwl wave=\[
+ 0    0.9
+ 273406340597876490546562778389702670669146178861651554553221325801244124899921990402939147127881727500p 0.9
+ 273406340597876490546562778389702670669146178861651554553221325801244124899921990402939147127881727510p -0.3
+ 273406340597876490546562778389702670669146178861651554553221325801244124899921990402939147127881728000p -0.3
+ 273406340597876490546562778389702670669146178861651554553221325801244124899921990402939147127881728010p 0.9
+ \]
V_wl_bar_328 (WordLine_bar\\<328\\> gnd!) vsource type=pwl wave=\[
+ 0    0.9
+ 546812681195752981093125556779405341338292357723303109106442651602488249799843980805878294255763455500p 0.9
+ 546812681195752981093125556779405341338292357723303109106442651602488249799843980805878294255763455510p -0.3
+ 546812681195752981093125556779405341338292357723303109106442651602488249799843980805878294255763456000p -0.3
+ 546812681195752981093125556779405341338292357723303109106442651602488249799843980805878294255763456010p 0.9
+ \]
V_wl_bar_329 (WordLine_bar\\<329\\> gnd!) vsource type=pwl wave=\[
+ 0    0.9
+ 1093625362391505962186251113558810682676584715446606218212885303204976499599687961611756588511526911500p 0.9
+ 1093625362391505962186251113558810682676584715446606218212885303204976499599687961611756588511526911510p -0.3
+ 1093625362391505962186251113558810682676584715446606218212885303204976499599687961611756588511526912000p -0.3
+ 1093625362391505962186251113558810682676584715446606218212885303204976499599687961611756588511526912010p 0.9
+ \]
V_wl_bar_330 (WordLine_bar\\<330\\> gnd!) vsource type=pwl wave=\[
+ 0    0.9
+ 2187250724783011924372502227117621365353169430893212436425770606409952999199375923223513177023053823500p 0.9
+ 2187250724783011924372502227117621365353169430893212436425770606409952999199375923223513177023053823510p -0.3
+ 2187250724783011924372502227117621365353169430893212436425770606409952999199375923223513177023053824000p -0.3
+ 2187250724783011924372502227117621365353169430893212436425770606409952999199375923223513177023053824010p 0.9
+ \]
V_wl_bar_331 (WordLine_bar\\<331\\> gnd!) vsource type=pwl wave=\[
+ 0    0.9
+ 4374501449566023848745004454235242730706338861786424872851541212819905998398751846447026354046107647500p 0.9
+ 4374501449566023848745004454235242730706338861786424872851541212819905998398751846447026354046107647510p -0.3
+ 4374501449566023848745004454235242730706338861786424872851541212819905998398751846447026354046107648000p -0.3
+ 4374501449566023848745004454235242730706338861786424872851541212819905998398751846447026354046107648010p 0.9
+ \]
V_wl_bar_332 (WordLine_bar\\<332\\> gnd!) vsource type=pwl wave=\[
+ 0    0.9
+ 8749002899132047697490008908470485461412677723572849745703082425639811996797503692894052708092215295500p 0.9
+ 8749002899132047697490008908470485461412677723572849745703082425639811996797503692894052708092215295510p -0.3
+ 8749002899132047697490008908470485461412677723572849745703082425639811996797503692894052708092215296000p -0.3
+ 8749002899132047697490008908470485461412677723572849745703082425639811996797503692894052708092215296010p 0.9
+ \]
V_wl_bar_333 (WordLine_bar\\<333\\> gnd!) vsource type=pwl wave=\[
+ 0    0.9
+ 17498005798264095394980017816940970922825355447145699491406164851279623993595007385788105416184430591500p 0.9
+ 17498005798264095394980017816940970922825355447145699491406164851279623993595007385788105416184430591510p -0.3
+ 17498005798264095394980017816940970922825355447145699491406164851279623993595007385788105416184430592000p -0.3
+ 17498005798264095394980017816940970922825355447145699491406164851279623993595007385788105416184430592010p 0.9
+ \]
V_wl_bar_334 (WordLine_bar\\<334\\> gnd!) vsource type=pwl wave=\[
+ 0    0.9
+ 34996011596528190789960035633881941845650710894291398982812329702559247987190014771576210832368861183500p 0.9
+ 34996011596528190789960035633881941845650710894291398982812329702559247987190014771576210832368861183510p -0.3
+ 34996011596528190789960035633881941845650710894291398982812329702559247987190014771576210832368861184000p -0.3
+ 34996011596528190789960035633881941845650710894291398982812329702559247987190014771576210832368861184010p 0.9
+ \]
V_wl_bar_335 (WordLine_bar\\<335\\> gnd!) vsource type=pwl wave=\[
+ 0    0.9
+ 69992023193056381579920071267763883691301421788582797965624659405118495974380029543152421664737722367500p 0.9
+ 69992023193056381579920071267763883691301421788582797965624659405118495974380029543152421664737722367510p -0.3
+ 69992023193056381579920071267763883691301421788582797965624659405118495974380029543152421664737722368000p -0.3
+ 69992023193056381579920071267763883691301421788582797965624659405118495974380029543152421664737722368010p 0.9
+ \]
V_wl_bar_336 (WordLine_bar\\<336\\> gnd!) vsource type=pwl wave=\[
+ 0    0.9
+ 139984046386112763159840142535527767382602843577165595931249318810236991948760059086304843329475444735500p 0.9
+ 139984046386112763159840142535527767382602843577165595931249318810236991948760059086304843329475444735510p -0.3
+ 139984046386112763159840142535527767382602843577165595931249318810236991948760059086304843329475444736000p -0.3
+ 139984046386112763159840142535527767382602843577165595931249318810236991948760059086304843329475444736010p 0.9
+ \]
V_wl_bar_337 (WordLine_bar\\<337\\> gnd!) vsource type=pwl wave=\[
+ 0    0.9
+ 279968092772225526319680285071055534765205687154331191862498637620473983897520118172609686658950889471500p 0.9
+ 279968092772225526319680285071055534765205687154331191862498637620473983897520118172609686658950889471510p -0.3
+ 279968092772225526319680285071055534765205687154331191862498637620473983897520118172609686658950889472000p -0.3
+ 279968092772225526319680285071055534765205687154331191862498637620473983897520118172609686658950889472010p 0.9
+ \]
V_wl_bar_338 (WordLine_bar\\<338\\> gnd!) vsource type=pwl wave=\[
+ 0    0.9
+ 559936185544451052639360570142111069530411374308662383724997275240947967795040236345219373317901778943500p 0.9
+ 559936185544451052639360570142111069530411374308662383724997275240947967795040236345219373317901778943510p -0.3
+ 559936185544451052639360570142111069530411374308662383724997275240947967795040236345219373317901778944000p -0.3
+ 559936185544451052639360570142111069530411374308662383724997275240947967795040236345219373317901778944010p 0.9
+ \]
V_wl_bar_339 (WordLine_bar\\<339\\> gnd!) vsource type=pwl wave=\[
+ 0    0.9
+ 1119872371088902105278721140284222139060822748617324767449994550481895935590080472690438746635803557887500p 0.9
+ 1119872371088902105278721140284222139060822748617324767449994550481895935590080472690438746635803557887510p -0.3
+ 1119872371088902105278721140284222139060822748617324767449994550481895935590080472690438746635803557888000p -0.3
+ 1119872371088902105278721140284222139060822748617324767449994550481895935590080472690438746635803557888010p 0.9
+ \]
V_wl_bar_340 (WordLine_bar\\<340\\> gnd!) vsource type=pwl wave=\[
+ 0    0.9
+ 2239744742177804210557442280568444278121645497234649534899989100963791871180160945380877493271607115775500p 0.9
+ 2239744742177804210557442280568444278121645497234649534899989100963791871180160945380877493271607115775510p -0.3
+ 2239744742177804210557442280568444278121645497234649534899989100963791871180160945380877493271607115776000p -0.3
+ 2239744742177804210557442280568444278121645497234649534899989100963791871180160945380877493271607115776010p 0.9
+ \]
V_wl_bar_341 (WordLine_bar\\<341\\> gnd!) vsource type=pwl wave=\[
+ 0    0.9
+ 4479489484355608421114884561136888556243290994469299069799978201927583742360321890761754986543214231551500p 0.9
+ 4479489484355608421114884561136888556243290994469299069799978201927583742360321890761754986543214231551510p -0.3
+ 4479489484355608421114884561136888556243290994469299069799978201927583742360321890761754986543214231552000p -0.3
+ 4479489484355608421114884561136888556243290994469299069799978201927583742360321890761754986543214231552010p 0.9
+ \]
V_wl_bar_342 (WordLine_bar\\<342\\> gnd!) vsource type=pwl wave=\[
+ 0    0.9
+ 8958978968711216842229769122273777112486581988938598139599956403855167484720643781523509973086428463103500p 0.9
+ 8958978968711216842229769122273777112486581988938598139599956403855167484720643781523509973086428463103510p -0.3
+ 8958978968711216842229769122273777112486581988938598139599956403855167484720643781523509973086428463104000p -0.3
+ 8958978968711216842229769122273777112486581988938598139599956403855167484720643781523509973086428463104010p 0.9
+ \]
V_wl_bar_343 (WordLine_bar\\<343\\> gnd!) vsource type=pwl wave=\[
+ 0    0.9
+ 17917957937422433684459538244547554224973163977877196279199912807710334969441287563047019946172856926207500p 0.9
+ 17917957937422433684459538244547554224973163977877196279199912807710334969441287563047019946172856926207510p -0.3
+ 17917957937422433684459538244547554224973163977877196279199912807710334969441287563047019946172856926208000p -0.3
+ 17917957937422433684459538244547554224973163977877196279199912807710334969441287563047019946172856926208010p 0.9
+ \]
V_wl_bar_344 (WordLine_bar\\<344\\> gnd!) vsource type=pwl wave=\[
+ 0    0.9
+ 35835915874844867368919076489095108449946327955754392558399825615420669938882575126094039892345713852415500p 0.9
+ 35835915874844867368919076489095108449946327955754392558399825615420669938882575126094039892345713852415510p -0.3
+ 35835915874844867368919076489095108449946327955754392558399825615420669938882575126094039892345713852416000p -0.3
+ 35835915874844867368919076489095108449946327955754392558399825615420669938882575126094039892345713852416010p 0.9
+ \]
V_wl_bar_345 (WordLine_bar\\<345\\> gnd!) vsource type=pwl wave=\[
+ 0    0.9
+ 71671831749689734737838152978190216899892655911508785116799651230841339877765150252188079784691427704831500p 0.9
+ 71671831749689734737838152978190216899892655911508785116799651230841339877765150252188079784691427704831510p -0.3
+ 71671831749689734737838152978190216899892655911508785116799651230841339877765150252188079784691427704832000p -0.3
+ 71671831749689734737838152978190216899892655911508785116799651230841339877765150252188079784691427704832010p 0.9
+ \]
V_wl_bar_346 (WordLine_bar\\<346\\> gnd!) vsource type=pwl wave=\[
+ 0    0.9
+ 143343663499379469475676305956380433799785311823017570233599302461682679755530300504376159569382855409663500p 0.9
+ 143343663499379469475676305956380433799785311823017570233599302461682679755530300504376159569382855409663510p -0.3
+ 143343663499379469475676305956380433799785311823017570233599302461682679755530300504376159569382855409664000p -0.3
+ 143343663499379469475676305956380433799785311823017570233599302461682679755530300504376159569382855409664010p 0.9
+ \]
V_wl_bar_347 (WordLine_bar\\<347\\> gnd!) vsource type=pwl wave=\[
+ 0    0.9
+ 286687326998758938951352611912760867599570623646035140467198604923365359511060601008752319138765710819327500p 0.9
+ 286687326998758938951352611912760867599570623646035140467198604923365359511060601008752319138765710819327510p -0.3
+ 286687326998758938951352611912760867599570623646035140467198604923365359511060601008752319138765710819328000p -0.3
+ 286687326998758938951352611912760867599570623646035140467198604923365359511060601008752319138765710819328010p 0.9
+ \]
V_wl_bar_348 (WordLine_bar\\<348\\> gnd!) vsource type=pwl wave=\[
+ 0    0.9
+ 573374653997517877902705223825521735199141247292070280934397209846730719022121202017504638277531421638655500p 0.9
+ 573374653997517877902705223825521735199141247292070280934397209846730719022121202017504638277531421638655510p -0.3
+ 573374653997517877902705223825521735199141247292070280934397209846730719022121202017504638277531421638656000p -0.3
+ 573374653997517877902705223825521735199141247292070280934397209846730719022121202017504638277531421638656010p 0.9
+ \]
V_wl_bar_349 (WordLine_bar\\<349\\> gnd!) vsource type=pwl wave=\[
+ 0    0.9
+ 1146749307995035755805410447651043470398282494584140561868794419693461438044242404035009276555062843277311500p 0.9
+ 1146749307995035755805410447651043470398282494584140561868794419693461438044242404035009276555062843277311510p -0.3
+ 1146749307995035755805410447651043470398282494584140561868794419693461438044242404035009276555062843277312000p -0.3
+ 1146749307995035755805410447651043470398282494584140561868794419693461438044242404035009276555062843277312010p 0.9
+ \]
V_wl_bar_350 (WordLine_bar\\<350\\> gnd!) vsource type=pwl wave=\[
+ 0    0.9
+ 2293498615990071511610820895302086940796564989168281123737588839386922876088484808070018553110125686554623500p 0.9
+ 2293498615990071511610820895302086940796564989168281123737588839386922876088484808070018553110125686554623510p -0.3
+ 2293498615990071511610820895302086940796564989168281123737588839386922876088484808070018553110125686554624000p -0.3
+ 2293498615990071511610820895302086940796564989168281123737588839386922876088484808070018553110125686554624010p 0.9
+ \]
V_wl_bar_351 (WordLine_bar\\<351\\> gnd!) vsource type=pwl wave=\[
+ 0    0.9
+ 4586997231980143023221641790604173881593129978336562247475177678773845752176969616140037106220251373109247500p 0.9
+ 4586997231980143023221641790604173881593129978336562247475177678773845752176969616140037106220251373109247510p -0.3
+ 4586997231980143023221641790604173881593129978336562247475177678773845752176969616140037106220251373109248000p -0.3
+ 4586997231980143023221641790604173881593129978336562247475177678773845752176969616140037106220251373109248010p 0.9
+ \]
V_wl_bar_352 (WordLine_bar\\<352\\> gnd!) vsource type=pwl wave=\[
+ 0    0.9
+ 9173994463960286046443283581208347763186259956673124494950355357547691504353939232280074212440502746218495500p 0.9
+ 9173994463960286046443283581208347763186259956673124494950355357547691504353939232280074212440502746218495510p -0.3
+ 9173994463960286046443283581208347763186259956673124494950355357547691504353939232280074212440502746218496000p -0.3
+ 9173994463960286046443283581208347763186259956673124494950355357547691504353939232280074212440502746218496010p 0.9
+ \]
V_wl_bar_353 (WordLine_bar\\<353\\> gnd!) vsource type=pwl wave=\[
+ 0    0.9
+ 18347988927920572092886567162416695526372519913346248989900710715095383008707878464560148424881005492436991500p 0.9
+ 18347988927920572092886567162416695526372519913346248989900710715095383008707878464560148424881005492436991510p -0.3
+ 18347988927920572092886567162416695526372519913346248989900710715095383008707878464560148424881005492436992000p -0.3
+ 18347988927920572092886567162416695526372519913346248989900710715095383008707878464560148424881005492436992010p 0.9
+ \]
V_wl_bar_354 (WordLine_bar\\<354\\> gnd!) vsource type=pwl wave=\[
+ 0    0.9
+ 36695977855841144185773134324833391052745039826692497979801421430190766017415756929120296849762010984873983500p 0.9
+ 36695977855841144185773134324833391052745039826692497979801421430190766017415756929120296849762010984873983510p -0.3
+ 36695977855841144185773134324833391052745039826692497979801421430190766017415756929120296849762010984873984000p -0.3
+ 36695977855841144185773134324833391052745039826692497979801421430190766017415756929120296849762010984873984010p 0.9
+ \]
V_wl_bar_355 (WordLine_bar\\<355\\> gnd!) vsource type=pwl wave=\[
+ 0    0.9
+ 73391955711682288371546268649666782105490079653384995959602842860381532034831513858240593699524021969747967500p 0.9
+ 73391955711682288371546268649666782105490079653384995959602842860381532034831513858240593699524021969747967510p -0.3
+ 73391955711682288371546268649666782105490079653384995959602842860381532034831513858240593699524021969747968000p -0.3
+ 73391955711682288371546268649666782105490079653384995959602842860381532034831513858240593699524021969747968010p 0.9
+ \]
V_wl_bar_356 (WordLine_bar\\<356\\> gnd!) vsource type=pwl wave=\[
+ 0    0.9
+ 146783911423364576743092537299333564210980159306769991919205685720763064069663027716481187399048043939495935500p 0.9
+ 146783911423364576743092537299333564210980159306769991919205685720763064069663027716481187399048043939495935510p -0.3
+ 146783911423364576743092537299333564210980159306769991919205685720763064069663027716481187399048043939495936000p -0.3
+ 146783911423364576743092537299333564210980159306769991919205685720763064069663027716481187399048043939495936010p 0.9
+ \]
V_wl_bar_357 (WordLine_bar\\<357\\> gnd!) vsource type=pwl wave=\[
+ 0    0.9
+ 293567822846729153486185074598667128421960318613539983838411371441526128139326055432962374798096087878991871500p 0.9
+ 293567822846729153486185074598667128421960318613539983838411371441526128139326055432962374798096087878991871510p -0.3
+ 293567822846729153486185074598667128421960318613539983838411371441526128139326055432962374798096087878991872000p -0.3
+ 293567822846729153486185074598667128421960318613539983838411371441526128139326055432962374798096087878991872010p 0.9
+ \]
V_wl_bar_358 (WordLine_bar\\<358\\> gnd!) vsource type=pwl wave=\[
+ 0    0.9
+ 587135645693458306972370149197334256843920637227079967676822742883052256278652110865924749596192175757983743500p 0.9
+ 587135645693458306972370149197334256843920637227079967676822742883052256278652110865924749596192175757983743510p -0.3
+ 587135645693458306972370149197334256843920637227079967676822742883052256278652110865924749596192175757983744000p -0.3
+ 587135645693458306972370149197334256843920637227079967676822742883052256278652110865924749596192175757983744010p 0.9
+ \]
V_wl_bar_359 (WordLine_bar\\<359\\> gnd!) vsource type=pwl wave=\[
+ 0    0.9
+ 1174271291386916613944740298394668513687841274454159935353645485766104512557304221731849499192384351515967487500p 0.9
+ 1174271291386916613944740298394668513687841274454159935353645485766104512557304221731849499192384351515967487510p -0.3
+ 1174271291386916613944740298394668513687841274454159935353645485766104512557304221731849499192384351515967488000p -0.3
+ 1174271291386916613944740298394668513687841274454159935353645485766104512557304221731849499192384351515967488010p 0.9
+ \]
V_wl_bar_360 (WordLine_bar\\<360\\> gnd!) vsource type=pwl wave=\[
+ 0    0.9
+ 2348542582773833227889480596789337027375682548908319870707290971532209025114608443463698998384768703031934975500p 0.9
+ 2348542582773833227889480596789337027375682548908319870707290971532209025114608443463698998384768703031934975510p -0.3
+ 2348542582773833227889480596789337027375682548908319870707290971532209025114608443463698998384768703031934976000p -0.3
+ 2348542582773833227889480596789337027375682548908319870707290971532209025114608443463698998384768703031934976010p 0.9
+ \]
V_wl_bar_361 (WordLine_bar\\<361\\> gnd!) vsource type=pwl wave=\[
+ 0    0.9
+ 4697085165547666455778961193578674054751365097816639741414581943064418050229216886927397996769537406063869951500p 0.9
+ 4697085165547666455778961193578674054751365097816639741414581943064418050229216886927397996769537406063869951510p -0.3
+ 4697085165547666455778961193578674054751365097816639741414581943064418050229216886927397996769537406063869952000p -0.3
+ 4697085165547666455778961193578674054751365097816639741414581943064418050229216886927397996769537406063869952010p 0.9
+ \]
V_wl_bar_362 (WordLine_bar\\<362\\> gnd!) vsource type=pwl wave=\[
+ 0    0.9
+ 9394170331095332911557922387157348109502730195633279482829163886128836100458433773854795993539074812127739903500p 0.9
+ 9394170331095332911557922387157348109502730195633279482829163886128836100458433773854795993539074812127739903510p -0.3
+ 9394170331095332911557922387157348109502730195633279482829163886128836100458433773854795993539074812127739904000p -0.3
+ 9394170331095332911557922387157348109502730195633279482829163886128836100458433773854795993539074812127739904010p 0.9
+ \]
V_wl_bar_363 (WordLine_bar\\<363\\> gnd!) vsource type=pwl wave=\[
+ 0    0.9
+ 18788340662190665823115844774314696219005460391266558965658327772257672200916867547709591987078149624255479807500p 0.9
+ 18788340662190665823115844774314696219005460391266558965658327772257672200916867547709591987078149624255479807510p -0.3
+ 18788340662190665823115844774314696219005460391266558965658327772257672200916867547709591987078149624255479808000p -0.3
+ 18788340662190665823115844774314696219005460391266558965658327772257672200916867547709591987078149624255479808010p 0.9
+ \]
V_wl_bar_364 (WordLine_bar\\<364\\> gnd!) vsource type=pwl wave=\[
+ 0    0.9
+ 37576681324381331646231689548629392438010920782533117931316655544515344401833735095419183974156299248510959615500p 0.9
+ 37576681324381331646231689548629392438010920782533117931316655544515344401833735095419183974156299248510959615510p -0.3
+ 37576681324381331646231689548629392438010920782533117931316655544515344401833735095419183974156299248510959616000p -0.3
+ 37576681324381331646231689548629392438010920782533117931316655544515344401833735095419183974156299248510959616010p 0.9
+ \]
V_wl_bar_365 (WordLine_bar\\<365\\> gnd!) vsource type=pwl wave=\[
+ 0    0.9
+ 75153362648762663292463379097258784876021841565066235862633311089030688803667470190838367948312598497021919231500p 0.9
+ 75153362648762663292463379097258784876021841565066235862633311089030688803667470190838367948312598497021919231510p -0.3
+ 75153362648762663292463379097258784876021841565066235862633311089030688803667470190838367948312598497021919232000p -0.3
+ 75153362648762663292463379097258784876021841565066235862633311089030688803667470190838367948312598497021919232010p 0.9
+ \]
V_wl_bar_366 (WordLine_bar\\<366\\> gnd!) vsource type=pwl wave=\[
+ 0    0.9
+ 150306725297525326584926758194517569752043683130132471725266622178061377607334940381676735896625196994043838463500p 0.9
+ 150306725297525326584926758194517569752043683130132471725266622178061377607334940381676735896625196994043838463510p -0.3
+ 150306725297525326584926758194517569752043683130132471725266622178061377607334940381676735896625196994043838464000p -0.3
+ 150306725297525326584926758194517569752043683130132471725266622178061377607334940381676735896625196994043838464010p 0.9
+ \]
V_wl_bar_367 (WordLine_bar\\<367\\> gnd!) vsource type=pwl wave=\[
+ 0    0.9
+ 300613450595050653169853516389035139504087366260264943450533244356122755214669880763353471793250393988087676927500p 0.9
+ 300613450595050653169853516389035139504087366260264943450533244356122755214669880763353471793250393988087676927510p -0.3
+ 300613450595050653169853516389035139504087366260264943450533244356122755214669880763353471793250393988087676928000p -0.3
+ 300613450595050653169853516389035139504087366260264943450533244356122755214669880763353471793250393988087676928010p 0.9
+ \]
V_wl_bar_368 (WordLine_bar\\<368\\> gnd!) vsource type=pwl wave=\[
+ 0    0.9
+ 601226901190101306339707032778070279008174732520529886901066488712245510429339761526706943586500787976175353855500p 0.9
+ 601226901190101306339707032778070279008174732520529886901066488712245510429339761526706943586500787976175353855510p -0.3
+ 601226901190101306339707032778070279008174732520529886901066488712245510429339761526706943586500787976175353856000p -0.3
+ 601226901190101306339707032778070279008174732520529886901066488712245510429339761526706943586500787976175353856010p 0.9
+ \]
V_wl_bar_369 (WordLine_bar\\<369\\> gnd!) vsource type=pwl wave=\[
+ 0    0.9
+ 1202453802380202612679414065556140558016349465041059773802132977424491020858679523053413887173001575952350707711500p 0.9
+ 1202453802380202612679414065556140558016349465041059773802132977424491020858679523053413887173001575952350707711510p -0.3
+ 1202453802380202612679414065556140558016349465041059773802132977424491020858679523053413887173001575952350707712000p -0.3
+ 1202453802380202612679414065556140558016349465041059773802132977424491020858679523053413887173001575952350707712010p 0.9
+ \]
V_wl_bar_370 (WordLine_bar\\<370\\> gnd!) vsource type=pwl wave=\[
+ 0    0.9
+ 2404907604760405225358828131112281116032698930082119547604265954848982041717359046106827774346003151904701415423500p 0.9
+ 2404907604760405225358828131112281116032698930082119547604265954848982041717359046106827774346003151904701415423510p -0.3
+ 2404907604760405225358828131112281116032698930082119547604265954848982041717359046106827774346003151904701415424000p -0.3
+ 2404907604760405225358828131112281116032698930082119547604265954848982041717359046106827774346003151904701415424010p 0.9
+ \]
V_wl_bar_371 (WordLine_bar\\<371\\> gnd!) vsource type=pwl wave=\[
+ 0    0.9
+ 4809815209520810450717656262224562232065397860164239095208531909697964083434718092213655548692006303809402830847500p 0.9
+ 4809815209520810450717656262224562232065397860164239095208531909697964083434718092213655548692006303809402830847510p -0.3
+ 4809815209520810450717656262224562232065397860164239095208531909697964083434718092213655548692006303809402830848000p -0.3
+ 4809815209520810450717656262224562232065397860164239095208531909697964083434718092213655548692006303809402830848010p 0.9
+ \]
V_wl_bar_372 (WordLine_bar\\<372\\> gnd!) vsource type=pwl wave=\[
+ 0    0.9
+ 9619630419041620901435312524449124464130795720328478190417063819395928166869436184427311097384012607618805661695500p 0.9
+ 9619630419041620901435312524449124464130795720328478190417063819395928166869436184427311097384012607618805661695510p -0.3
+ 9619630419041620901435312524449124464130795720328478190417063819395928166869436184427311097384012607618805661696000p -0.3
+ 9619630419041620901435312524449124464130795720328478190417063819395928166869436184427311097384012607618805661696010p 0.9
+ \]
V_wl_bar_373 (WordLine_bar\\<373\\> gnd!) vsource type=pwl wave=\[
+ 0    0.9
+ 19239260838083241802870625048898248928261591440656956380834127638791856333738872368854622194768025215237611323391500p 0.9
+ 19239260838083241802870625048898248928261591440656956380834127638791856333738872368854622194768025215237611323391510p -0.3
+ 19239260838083241802870625048898248928261591440656956380834127638791856333738872368854622194768025215237611323392000p -0.3
+ 19239260838083241802870625048898248928261591440656956380834127638791856333738872368854622194768025215237611323392010p 0.9
+ \]
V_wl_bar_374 (WordLine_bar\\<374\\> gnd!) vsource type=pwl wave=\[
+ 0    0.9
+ 38478521676166483605741250097796497856523182881313912761668255277583712667477744737709244389536050430475222646783500p 0.9
+ 38478521676166483605741250097796497856523182881313912761668255277583712667477744737709244389536050430475222646783510p -0.3
+ 38478521676166483605741250097796497856523182881313912761668255277583712667477744737709244389536050430475222646784000p -0.3
+ 38478521676166483605741250097796497856523182881313912761668255277583712667477744737709244389536050430475222646784010p 0.9
+ \]
V_wl_bar_375 (WordLine_bar\\<375\\> gnd!) vsource type=pwl wave=\[
+ 0    0.9
+ 76957043352332967211482500195592995713046365762627825523336510555167425334955489475418488779072100860950445293567500p 0.9
+ 76957043352332967211482500195592995713046365762627825523336510555167425334955489475418488779072100860950445293567510p -0.3
+ 76957043352332967211482500195592995713046365762627825523336510555167425334955489475418488779072100860950445293568000p -0.3
+ 76957043352332967211482500195592995713046365762627825523336510555167425334955489475418488779072100860950445293568010p 0.9
+ \]
V_wl_bar_376 (WordLine_bar\\<376\\> gnd!) vsource type=pwl wave=\[
+ 0    0.9
+ 153914086704665934422965000391185991426092731525255651046673021110334850669910978950836977558144201721900890587135500p 0.9
+ 153914086704665934422965000391185991426092731525255651046673021110334850669910978950836977558144201721900890587135510p -0.3
+ 153914086704665934422965000391185991426092731525255651046673021110334850669910978950836977558144201721900890587136000p -0.3
+ 153914086704665934422965000391185991426092731525255651046673021110334850669910978950836977558144201721900890587136010p 0.9
+ \]
V_wl_bar_377 (WordLine_bar\\<377\\> gnd!) vsource type=pwl wave=\[
+ 0    0.9
+ 307828173409331868845930000782371982852185463050511302093346042220669701339821957901673955116288403443801781174271500p 0.9
+ 307828173409331868845930000782371982852185463050511302093346042220669701339821957901673955116288403443801781174271510p -0.3
+ 307828173409331868845930000782371982852185463050511302093346042220669701339821957901673955116288403443801781174272000p -0.3
+ 307828173409331868845930000782371982852185463050511302093346042220669701339821957901673955116288403443801781174272010p 0.9
+ \]
V_wl_bar_378 (WordLine_bar\\<378\\> gnd!) vsource type=pwl wave=\[
+ 0    0.9
+ 615656346818663737691860001564743965704370926101022604186692084441339402679643915803347910232576806887603562348543500p 0.9
+ 615656346818663737691860001564743965704370926101022604186692084441339402679643915803347910232576806887603562348543510p -0.3
+ 615656346818663737691860001564743965704370926101022604186692084441339402679643915803347910232576806887603562348544000p -0.3
+ 615656346818663737691860001564743965704370926101022604186692084441339402679643915803347910232576806887603562348544010p 0.9
+ \]
V_wl_bar_379 (WordLine_bar\\<379\\> gnd!) vsource type=pwl wave=\[
+ 0    0.9
+ 1231312693637327475383720003129487931408741852202045208373384168882678805359287831606695820465153613775207124697087500p 0.9
+ 1231312693637327475383720003129487931408741852202045208373384168882678805359287831606695820465153613775207124697087510p -0.3
+ 1231312693637327475383720003129487931408741852202045208373384168882678805359287831606695820465153613775207124697088000p -0.3
+ 1231312693637327475383720003129487931408741852202045208373384168882678805359287831606695820465153613775207124697088010p 0.9
+ \]
V_wl_bar_380 (WordLine_bar\\<380\\> gnd!) vsource type=pwl wave=\[
+ 0    0.9
+ 2462625387274654950767440006258975862817483704404090416746768337765357610718575663213391640930307227550414249394175500p 0.9
+ 2462625387274654950767440006258975862817483704404090416746768337765357610718575663213391640930307227550414249394175510p -0.3
+ 2462625387274654950767440006258975862817483704404090416746768337765357610718575663213391640930307227550414249394176000p -0.3
+ 2462625387274654950767440006258975862817483704404090416746768337765357610718575663213391640930307227550414249394176010p 0.9
+ \]
V_wl_bar_381 (WordLine_bar\\<381\\> gnd!) vsource type=pwl wave=\[
+ 0    0.9
+ 4925250774549309901534880012517951725634967408808180833493536675530715221437151326426783281860614455100828498788351500p 0.9
+ 4925250774549309901534880012517951725634967408808180833493536675530715221437151326426783281860614455100828498788351510p -0.3
+ 4925250774549309901534880012517951725634967408808180833493536675530715221437151326426783281860614455100828498788352000p -0.3
+ 4925250774549309901534880012517951725634967408808180833493536675530715221437151326426783281860614455100828498788352010p 0.9
+ \]
V_wl_bar_382 (WordLine_bar\\<382\\> gnd!) vsource type=pwl wave=\[
+ 0    0.9
+ 9850501549098619803069760025035903451269934817616361666987073351061430442874302652853566563721228910201656997576703500p 0.9
+ 9850501549098619803069760025035903451269934817616361666987073351061430442874302652853566563721228910201656997576703510p -0.3
+ 9850501549098619803069760025035903451269934817616361666987073351061430442874302652853566563721228910201656997576704000p -0.3
+ 9850501549098619803069760025035903451269934817616361666987073351061430442874302652853566563721228910201656997576704010p 0.9
+ \]
V_wl_bar_383 (WordLine_bar\\<383\\> gnd!) vsource type=pwl wave=\[
+ 0    0.9
+ 19701003098197239606139520050071806902539869635232723333974146702122860885748605305707133127442457820403313995153407500p 0.9
+ 19701003098197239606139520050071806902539869635232723333974146702122860885748605305707133127442457820403313995153407510p -0.3
+ 19701003098197239606139520050071806902539869635232723333974146702122860885748605305707133127442457820403313995153408000p -0.3
+ 19701003098197239606139520050071806902539869635232723333974146702122860885748605305707133127442457820403313995153408010p 0.9
+ \]
V_wl_bar_384 (WordLine_bar\\<384\\> gnd!) vsource type=pwl wave=\[
+ 0    0.9
+ 39402006196394479212279040100143613805079739270465446667948293404245721771497210611414266254884915640806627990306815500p 0.9
+ 39402006196394479212279040100143613805079739270465446667948293404245721771497210611414266254884915640806627990306815510p -0.3
+ 39402006196394479212279040100143613805079739270465446667948293404245721771497210611414266254884915640806627990306816000p -0.3
+ 39402006196394479212279040100143613805079739270465446667948293404245721771497210611414266254884915640806627990306816010p 0.9
+ \]
V_wl_bar_385 (WordLine_bar\\<385\\> gnd!) vsource type=pwl wave=\[
+ 0    0.9
+ 78804012392788958424558080200287227610159478540930893335896586808491443542994421222828532509769831281613255980613631500p 0.9
+ 78804012392788958424558080200287227610159478540930893335896586808491443542994421222828532509769831281613255980613631510p -0.3
+ 78804012392788958424558080200287227610159478540930893335896586808491443542994421222828532509769831281613255980613632000p -0.3
+ 78804012392788958424558080200287227610159478540930893335896586808491443542994421222828532509769831281613255980613632010p 0.9
+ \]
V_wl_bar_386 (WordLine_bar\\<386\\> gnd!) vsource type=pwl wave=\[
+ 0    0.9
+ 157608024785577916849116160400574455220318957081861786671793173616982887085988842445657065019539662563226511961227263500p 0.9
+ 157608024785577916849116160400574455220318957081861786671793173616982887085988842445657065019539662563226511961227263510p -0.3
+ 157608024785577916849116160400574455220318957081861786671793173616982887085988842445657065019539662563226511961227264000p -0.3
+ 157608024785577916849116160400574455220318957081861786671793173616982887085988842445657065019539662563226511961227264010p 0.9
+ \]
V_wl_bar_387 (WordLine_bar\\<387\\> gnd!) vsource type=pwl wave=\[
+ 0    0.9
+ 315216049571155833698232320801148910440637914163723573343586347233965774171977684891314130039079325126453023922454527500p 0.9
+ 315216049571155833698232320801148910440637914163723573343586347233965774171977684891314130039079325126453023922454527510p -0.3
+ 315216049571155833698232320801148910440637914163723573343586347233965774171977684891314130039079325126453023922454528000p -0.3
+ 315216049571155833698232320801148910440637914163723573343586347233965774171977684891314130039079325126453023922454528010p 0.9
+ \]
V_wl_bar_388 (WordLine_bar\\<388\\> gnd!) vsource type=pwl wave=\[
+ 0    0.9
+ 630432099142311667396464641602297820881275828327447146687172694467931548343955369782628260078158650252906047844909055500p 0.9
+ 630432099142311667396464641602297820881275828327447146687172694467931548343955369782628260078158650252906047844909055510p -0.3
+ 630432099142311667396464641602297820881275828327447146687172694467931548343955369782628260078158650252906047844909056000p -0.3
+ 630432099142311667396464641602297820881275828327447146687172694467931548343955369782628260078158650252906047844909056010p 0.9
+ \]
V_wl_bar_389 (WordLine_bar\\<389\\> gnd!) vsource type=pwl wave=\[
+ 0    0.9
+ 1260864198284623334792929283204595641762551656654894293374345388935863096687910739565256520156317300505812095689818111500p 0.9
+ 1260864198284623334792929283204595641762551656654894293374345388935863096687910739565256520156317300505812095689818111510p -0.3
+ 1260864198284623334792929283204595641762551656654894293374345388935863096687910739565256520156317300505812095689818112000p -0.3
+ 1260864198284623334792929283204595641762551656654894293374345388935863096687910739565256520156317300505812095689818112010p 0.9
+ \]
V_wl_bar_390 (WordLine_bar\\<390\\> gnd!) vsource type=pwl wave=\[
+ 0    0.9
+ 2521728396569246669585858566409191283525103313309788586748690777871726193375821479130513040312634601011624191379636223500p 0.9
+ 2521728396569246669585858566409191283525103313309788586748690777871726193375821479130513040312634601011624191379636223510p -0.3
+ 2521728396569246669585858566409191283525103313309788586748690777871726193375821479130513040312634601011624191379636224000p -0.3
+ 2521728396569246669585858566409191283525103313309788586748690777871726193375821479130513040312634601011624191379636224010p 0.9
+ \]
V_wl_bar_391 (WordLine_bar\\<391\\> gnd!) vsource type=pwl wave=\[
+ 0    0.9
+ 5043456793138493339171717132818382567050206626619577173497381555743452386751642958261026080625269202023248382759272447500p 0.9
+ 5043456793138493339171717132818382567050206626619577173497381555743452386751642958261026080625269202023248382759272447510p -0.3
+ 5043456793138493339171717132818382567050206626619577173497381555743452386751642958261026080625269202023248382759272448000p -0.3
+ 5043456793138493339171717132818382567050206626619577173497381555743452386751642958261026080625269202023248382759272448010p 0.9
+ \]
V_wl_bar_392 (WordLine_bar\\<392\\> gnd!) vsource type=pwl wave=\[
+ 0    0.9
+ 10086913586276986678343434265636765134100413253239154346994763111486904773503285916522052161250538404046496765518544895500p 0.9
+ 10086913586276986678343434265636765134100413253239154346994763111486904773503285916522052161250538404046496765518544895510p -0.3
+ 10086913586276986678343434265636765134100413253239154346994763111486904773503285916522052161250538404046496765518544896000p -0.3
+ 10086913586276986678343434265636765134100413253239154346994763111486904773503285916522052161250538404046496765518544896010p 0.9
+ \]
V_wl_bar_393 (WordLine_bar\\<393\\> gnd!) vsource type=pwl wave=\[
+ 0    0.9
+ 20173827172553973356686868531273530268200826506478308693989526222973809547006571833044104322501076808092993531037089791500p 0.9
+ 20173827172553973356686868531273530268200826506478308693989526222973809547006571833044104322501076808092993531037089791510p -0.3
+ 20173827172553973356686868531273530268200826506478308693989526222973809547006571833044104322501076808092993531037089792000p -0.3
+ 20173827172553973356686868531273530268200826506478308693989526222973809547006571833044104322501076808092993531037089792010p 0.9
+ \]
V_wl_bar_394 (WordLine_bar\\<394\\> gnd!) vsource type=pwl wave=\[
+ 0    0.9
+ 40347654345107946713373737062547060536401653012956617387979052445947619094013143666088208645002153616185987062074179583500p 0.9
+ 40347654345107946713373737062547060536401653012956617387979052445947619094013143666088208645002153616185987062074179583510p -0.3
+ 40347654345107946713373737062547060536401653012956617387979052445947619094013143666088208645002153616185987062074179584000p -0.3
+ 40347654345107946713373737062547060536401653012956617387979052445947619094013143666088208645002153616185987062074179584010p 0.9
+ \]
V_wl_bar_395 (WordLine_bar\\<395\\> gnd!) vsource type=pwl wave=\[
+ 0    0.9
+ 80695308690215893426747474125094121072803306025913234775958104891895238188026287332176417290004307232371974124148359167500p 0.9
+ 80695308690215893426747474125094121072803306025913234775958104891895238188026287332176417290004307232371974124148359167510p -0.3
+ 80695308690215893426747474125094121072803306025913234775958104891895238188026287332176417290004307232371974124148359168000p -0.3
+ 80695308690215893426747474125094121072803306025913234775958104891895238188026287332176417290004307232371974124148359168010p 0.9
+ \]
V_wl_bar_396 (WordLine_bar\\<396\\> gnd!) vsource type=pwl wave=\[
+ 0    0.9
+ 161390617380431786853494948250188242145606612051826469551916209783790476376052574664352834580008614464743948248296718335500p 0.9
+ 161390617380431786853494948250188242145606612051826469551916209783790476376052574664352834580008614464743948248296718335510p -0.3
+ 161390617380431786853494948250188242145606612051826469551916209783790476376052574664352834580008614464743948248296718336000p -0.3
+ 161390617380431786853494948250188242145606612051826469551916209783790476376052574664352834580008614464743948248296718336010p 0.9
+ \]
V_wl_bar_397 (WordLine_bar\\<397\\> gnd!) vsource type=pwl wave=\[
+ 0    0.9
+ 322781234760863573706989896500376484291213224103652939103832419567580952752105149328705669160017228929487896496593436671500p 0.9
+ 322781234760863573706989896500376484291213224103652939103832419567580952752105149328705669160017228929487896496593436671510p -0.3
+ 322781234760863573706989896500376484291213224103652939103832419567580952752105149328705669160017228929487896496593436672000p -0.3
+ 322781234760863573706989896500376484291213224103652939103832419567580952752105149328705669160017228929487896496593436672010p 0.9
+ \]
V_wl_bar_398 (WordLine_bar\\<398\\> gnd!) vsource type=pwl wave=\[
+ 0    0.9
+ 645562469521727147413979793000752968582426448207305878207664839135161905504210298657411338320034457858975792993186873343500p 0.9
+ 645562469521727147413979793000752968582426448207305878207664839135161905504210298657411338320034457858975792993186873343510p -0.3
+ 645562469521727147413979793000752968582426448207305878207664839135161905504210298657411338320034457858975792993186873344000p -0.3
+ 645562469521727147413979793000752968582426448207305878207664839135161905504210298657411338320034457858975792993186873344010p 0.9
+ \]
V_wl_bar_399 (WordLine_bar\\<399\\> gnd!) vsource type=pwl wave=\[
+ 0    0.9
+ 1291124939043454294827959586001505937164852896414611756415329678270323811008420597314822676640068915717951585986373746687500p 0.9
+ 1291124939043454294827959586001505937164852896414611756415329678270323811008420597314822676640068915717951585986373746687510p -0.3
+ 1291124939043454294827959586001505937164852896414611756415329678270323811008420597314822676640068915717951585986373746688000p -0.3
+ 1291124939043454294827959586001505937164852896414611756415329678270323811008420597314822676640068915717951585986373746688010p 0.9
+ \]
V_wl_bar_400 (WordLine_bar\\<400\\> gnd!) vsource type=pwl wave=\[
+ 0    0.9
+ 2582249878086908589655919172003011874329705792829223512830659356540647622016841194629645353280137831435903171972747493375500p 0.9
+ 2582249878086908589655919172003011874329705792829223512830659356540647622016841194629645353280137831435903171972747493375510p -0.3
+ 2582249878086908589655919172003011874329705792829223512830659356540647622016841194629645353280137831435903171972747493376000p -0.3
+ 2582249878086908589655919172003011874329705792829223512830659356540647622016841194629645353280137831435903171972747493376010p 0.9
+ \]
V_wl_bar_401 (WordLine_bar\\<401\\> gnd!) vsource type=pwl wave=\[
+ 0    0.9
+ 5164499756173817179311838344006023748659411585658447025661318713081295244033682389259290706560275662871806343945494986751500p 0.9
+ 5164499756173817179311838344006023748659411585658447025661318713081295244033682389259290706560275662871806343945494986751510p -0.3
+ 5164499756173817179311838344006023748659411585658447025661318713081295244033682389259290706560275662871806343945494986752000p -0.3
+ 5164499756173817179311838344006023748659411585658447025661318713081295244033682389259290706560275662871806343945494986752010p 0.9
+ \]
V_wl_bar_402 (WordLine_bar\\<402\\> gnd!) vsource type=pwl wave=\[
+ 0    0.9
+ 10328999512347634358623676688012047497318823171316894051322637426162590488067364778518581413120551325743612687890989973503500p 0.9
+ 10328999512347634358623676688012047497318823171316894051322637426162590488067364778518581413120551325743612687890989973503510p -0.3
+ 10328999512347634358623676688012047497318823171316894051322637426162590488067364778518581413120551325743612687890989973504000p -0.3
+ 10328999512347634358623676688012047497318823171316894051322637426162590488067364778518581413120551325743612687890989973504010p 0.9
+ \]
V_wl_bar_403 (WordLine_bar\\<403\\> gnd!) vsource type=pwl wave=\[
+ 0    0.9
+ 20657999024695268717247353376024094994637646342633788102645274852325180976134729557037162826241102651487225375781979947007500p 0.9
+ 20657999024695268717247353376024094994637646342633788102645274852325180976134729557037162826241102651487225375781979947007510p -0.3
+ 20657999024695268717247353376024094994637646342633788102645274852325180976134729557037162826241102651487225375781979947008000p -0.3
+ 20657999024695268717247353376024094994637646342633788102645274852325180976134729557037162826241102651487225375781979947008010p 0.9
+ \]
V_wl_bar_404 (WordLine_bar\\<404\\> gnd!) vsource type=pwl wave=\[
+ 0    0.9
+ 41315998049390537434494706752048189989275292685267576205290549704650361952269459114074325652482205302974450751563959894015500p 0.9
+ 41315998049390537434494706752048189989275292685267576205290549704650361952269459114074325652482205302974450751563959894015510p -0.3
+ 41315998049390537434494706752048189989275292685267576205290549704650361952269459114074325652482205302974450751563959894016000p -0.3
+ 41315998049390537434494706752048189989275292685267576205290549704650361952269459114074325652482205302974450751563959894016010p 0.9
+ \]
V_wl_bar_405 (WordLine_bar\\<405\\> gnd!) vsource type=pwl wave=\[
+ 0    0.9
+ 82631996098781074868989413504096379978550585370535152410581099409300723904538918228148651304964410605948901503127919788031500p 0.9
+ 82631996098781074868989413504096379978550585370535152410581099409300723904538918228148651304964410605948901503127919788031510p -0.3
+ 82631996098781074868989413504096379978550585370535152410581099409300723904538918228148651304964410605948901503127919788032000p -0.3
+ 82631996098781074868989413504096379978550585370535152410581099409300723904538918228148651304964410605948901503127919788032010p 0.9
+ \]
V_wl_bar_406 (WordLine_bar\\<406\\> gnd!) vsource type=pwl wave=\[
+ 0    0.9
+ 165263992197562149737978827008192759957101170741070304821162198818601447809077836456297302609928821211897803006255839576063500p 0.9
+ 165263992197562149737978827008192759957101170741070304821162198818601447809077836456297302609928821211897803006255839576063510p -0.3
+ 165263992197562149737978827008192759957101170741070304821162198818601447809077836456297302609928821211897803006255839576064000p -0.3
+ 165263992197562149737978827008192759957101170741070304821162198818601447809077836456297302609928821211897803006255839576064010p 0.9
+ \]
V_wl_bar_407 (WordLine_bar\\<407\\> gnd!) vsource type=pwl wave=\[
+ 0    0.9
+ 330527984395124299475957654016385519914202341482140609642324397637202895618155672912594605219857642423795606012511679152127500p 0.9
+ 330527984395124299475957654016385519914202341482140609642324397637202895618155672912594605219857642423795606012511679152127510p -0.3
+ 330527984395124299475957654016385519914202341482140609642324397637202895618155672912594605219857642423795606012511679152128000p -0.3
+ 330527984395124299475957654016385519914202341482140609642324397637202895618155672912594605219857642423795606012511679152128010p 0.9
+ \]
V_wl_bar_408 (WordLine_bar\\<408\\> gnd!) vsource type=pwl wave=\[
+ 0    0.9
+ 661055968790248598951915308032771039828404682964281219284648795274405791236311345825189210439715284847591212025023358304255500p 0.9
+ 661055968790248598951915308032771039828404682964281219284648795274405791236311345825189210439715284847591212025023358304255510p -0.3
+ 661055968790248598951915308032771039828404682964281219284648795274405791236311345825189210439715284847591212025023358304256000p -0.3
+ 661055968790248598951915308032771039828404682964281219284648795274405791236311345825189210439715284847591212025023358304256010p 0.9
+ \]
V_wl_bar_409 (WordLine_bar\\<409\\> gnd!) vsource type=pwl wave=\[
+ 0    0.9
+ 1322111937580497197903830616065542079656809365928562438569297590548811582472622691650378420879430569695182424050046716608511500p 0.9
+ 1322111937580497197903830616065542079656809365928562438569297590548811582472622691650378420879430569695182424050046716608511510p -0.3
+ 1322111937580497197903830616065542079656809365928562438569297590548811582472622691650378420879430569695182424050046716608512000p -0.3
+ 1322111937580497197903830616065542079656809365928562438569297590548811582472622691650378420879430569695182424050046716608512010p 0.9
+ \]
V_wl_bar_410 (WordLine_bar\\<410\\> gnd!) vsource type=pwl wave=\[
+ 0    0.9
+ 2644223875160994395807661232131084159313618731857124877138595181097623164945245383300756841758861139390364848100093433217023500p 0.9
+ 2644223875160994395807661232131084159313618731857124877138595181097623164945245383300756841758861139390364848100093433217023510p -0.3
+ 2644223875160994395807661232131084159313618731857124877138595181097623164945245383300756841758861139390364848100093433217024000p -0.3
+ 2644223875160994395807661232131084159313618731857124877138595181097623164945245383300756841758861139390364848100093433217024010p 0.9
+ \]
V_wl_bar_411 (WordLine_bar\\<411\\> gnd!) vsource type=pwl wave=\[
+ 0    0.9
+ 5288447750321988791615322464262168318627237463714249754277190362195246329890490766601513683517722278780729696200186866434047500p 0.9
+ 5288447750321988791615322464262168318627237463714249754277190362195246329890490766601513683517722278780729696200186866434047510p -0.3
+ 5288447750321988791615322464262168318627237463714249754277190362195246329890490766601513683517722278780729696200186866434048000p -0.3
+ 5288447750321988791615322464262168318627237463714249754277190362195246329890490766601513683517722278780729696200186866434048010p 0.9
+ \]
V_wl_bar_412 (WordLine_bar\\<412\\> gnd!) vsource type=pwl wave=\[
+ 0    0.9
+ 10576895500643977583230644928524336637254474927428499508554380724390492659780981533203027367035444557561459392400373732868095500p 0.9
+ 10576895500643977583230644928524336637254474927428499508554380724390492659780981533203027367035444557561459392400373732868095510p -0.3
+ 10576895500643977583230644928524336637254474927428499508554380724390492659780981533203027367035444557561459392400373732868096000p -0.3
+ 10576895500643977583230644928524336637254474927428499508554380724390492659780981533203027367035444557561459392400373732868096010p 0.9
+ \]
V_wl_bar_413 (WordLine_bar\\<413\\> gnd!) vsource type=pwl wave=\[
+ 0    0.9
+ 21153791001287955166461289857048673274508949854856999017108761448780985319561963066406054734070889115122918784800747465736191500p 0.9
+ 21153791001287955166461289857048673274508949854856999017108761448780985319561963066406054734070889115122918784800747465736191510p -0.3
+ 21153791001287955166461289857048673274508949854856999017108761448780985319561963066406054734070889115122918784800747465736192000p -0.3
+ 21153791001287955166461289857048673274508949854856999017108761448780985319561963066406054734070889115122918784800747465736192010p 0.9
+ \]
V_wl_bar_414 (WordLine_bar\\<414\\> gnd!) vsource type=pwl wave=\[
+ 0    0.9
+ 42307582002575910332922579714097346549017899709713998034217522897561970639123926132812109468141778230245837569601494931472383500p 0.9
+ 42307582002575910332922579714097346549017899709713998034217522897561970639123926132812109468141778230245837569601494931472383510p -0.3
+ 42307582002575910332922579714097346549017899709713998034217522897561970639123926132812109468141778230245837569601494931472384000p -0.3
+ 42307582002575910332922579714097346549017899709713998034217522897561970639123926132812109468141778230245837569601494931472384010p 0.9
+ \]
V_wl_bar_415 (WordLine_bar\\<415\\> gnd!) vsource type=pwl wave=\[
+ 0    0.9
+ 84615164005151820665845159428194693098035799419427996068435045795123941278247852265624218936283556460491675139202989862944767500p 0.9
+ 84615164005151820665845159428194693098035799419427996068435045795123941278247852265624218936283556460491675139202989862944767510p -0.3
+ 84615164005151820665845159428194693098035799419427996068435045795123941278247852265624218936283556460491675139202989862944768000p -0.3
+ 84615164005151820665845159428194693098035799419427996068435045795123941278247852265624218936283556460491675139202989862944768010p 0.9
+ \]
V_wl_bar_416 (WordLine_bar\\<416\\> gnd!) vsource type=pwl wave=\[
+ 0    0.9
+ 169230328010303641331690318856389386196071598838855992136870091590247882556495704531248437872567112920983350278405979725889535500p 0.9
+ 169230328010303641331690318856389386196071598838855992136870091590247882556495704531248437872567112920983350278405979725889535510p -0.3
+ 169230328010303641331690318856389386196071598838855992136870091590247882556495704531248437872567112920983350278405979725889536000p -0.3
+ 169230328010303641331690318856389386196071598838855992136870091590247882556495704531248437872567112920983350278405979725889536010p 0.9
+ \]
V_wl_bar_417 (WordLine_bar\\<417\\> gnd!) vsource type=pwl wave=\[
+ 0    0.9
+ 338460656020607282663380637712778772392143197677711984273740183180495765112991409062496875745134225841966700556811959451779071500p 0.9
+ 338460656020607282663380637712778772392143197677711984273740183180495765112991409062496875745134225841966700556811959451779071510p -0.3
+ 338460656020607282663380637712778772392143197677711984273740183180495765112991409062496875745134225841966700556811959451779072000p -0.3
+ 338460656020607282663380637712778772392143197677711984273740183180495765112991409062496875745134225841966700556811959451779072010p 0.9
+ \]
V_wl_bar_418 (WordLine_bar\\<418\\> gnd!) vsource type=pwl wave=\[
+ 0    0.9
+ 676921312041214565326761275425557544784286395355423968547480366360991530225982818124993751490268451683933401113623918903558143500p 0.9
+ 676921312041214565326761275425557544784286395355423968547480366360991530225982818124993751490268451683933401113623918903558143510p -0.3
+ 676921312041214565326761275425557544784286395355423968547480366360991530225982818124993751490268451683933401113623918903558144000p -0.3
+ 676921312041214565326761275425557544784286395355423968547480366360991530225982818124993751490268451683933401113623918903558144010p 0.9
+ \]
V_wl_bar_419 (WordLine_bar\\<419\\> gnd!) vsource type=pwl wave=\[
+ 0    0.9
+ 1353842624082429130653522550851115089568572790710847937094960732721983060451965636249987502980536903367866802227247837807116287500p 0.9
+ 1353842624082429130653522550851115089568572790710847937094960732721983060451965636249987502980536903367866802227247837807116287510p -0.3
+ 1353842624082429130653522550851115089568572790710847937094960732721983060451965636249987502980536903367866802227247837807116288000p -0.3
+ 1353842624082429130653522550851115089568572790710847937094960732721983060451965636249987502980536903367866802227247837807116288010p 0.9
+ \]
V_wl_bar_420 (WordLine_bar\\<420\\> gnd!) vsource type=pwl wave=\[
+ 0    0.9
+ 2707685248164858261307045101702230179137145581421695874189921465443966120903931272499975005961073806735733604454495675614232575500p 0.9
+ 2707685248164858261307045101702230179137145581421695874189921465443966120903931272499975005961073806735733604454495675614232575510p -0.3
+ 2707685248164858261307045101702230179137145581421695874189921465443966120903931272499975005961073806735733604454495675614232576000p -0.3
+ 2707685248164858261307045101702230179137145581421695874189921465443966120903931272499975005961073806735733604454495675614232576010p 0.9
+ \]
V_wl_bar_421 (WordLine_bar\\<421\\> gnd!) vsource type=pwl wave=\[
+ 0    0.9
+ 5415370496329716522614090203404460358274291162843391748379842930887932241807862544999950011922147613471467208908991351228465151500p 0.9
+ 5415370496329716522614090203404460358274291162843391748379842930887932241807862544999950011922147613471467208908991351228465151510p -0.3
+ 5415370496329716522614090203404460358274291162843391748379842930887932241807862544999950011922147613471467208908991351228465152000p -0.3
+ 5415370496329716522614090203404460358274291162843391748379842930887932241807862544999950011922147613471467208908991351228465152010p 0.9
+ \]
V_wl_bar_422 (WordLine_bar\\<422\\> gnd!) vsource type=pwl wave=\[
+ 0    0.9
+ 10830740992659433045228180406808920716548582325686783496759685861775864483615725089999900023844295226942934417817982702456930303500p 0.9
+ 10830740992659433045228180406808920716548582325686783496759685861775864483615725089999900023844295226942934417817982702456930303510p -0.3
+ 10830740992659433045228180406808920716548582325686783496759685861775864483615725089999900023844295226942934417817982702456930304000p -0.3
+ 10830740992659433045228180406808920716548582325686783496759685861775864483615725089999900023844295226942934417817982702456930304010p 0.9
+ \]
V_wl_bar_423 (WordLine_bar\\<423\\> gnd!) vsource type=pwl wave=\[
+ 0    0.9
+ 21661481985318866090456360813617841433097164651373566993519371723551728967231450179999800047688590453885868835635965404913860607500p 0.9
+ 21661481985318866090456360813617841433097164651373566993519371723551728967231450179999800047688590453885868835635965404913860607510p -0.3
+ 21661481985318866090456360813617841433097164651373566993519371723551728967231450179999800047688590453885868835635965404913860608000p -0.3
+ 21661481985318866090456360813617841433097164651373566993519371723551728967231450179999800047688590453885868835635965404913860608010p 0.9
+ \]
V_wl_bar_424 (WordLine_bar\\<424\\> gnd!) vsource type=pwl wave=\[
+ 0    0.9
+ 43322963970637732180912721627235682866194329302747133987038743447103457934462900359999600095377180907771737671271930809827721215500p 0.9
+ 43322963970637732180912721627235682866194329302747133987038743447103457934462900359999600095377180907771737671271930809827721215510p -0.3
+ 43322963970637732180912721627235682866194329302747133987038743447103457934462900359999600095377180907771737671271930809827721216000p -0.3
+ 43322963970637732180912721627235682866194329302747133987038743447103457934462900359999600095377180907771737671271930809827721216010p 0.9
+ \]
V_wl_bar_425 (WordLine_bar\\<425\\> gnd!) vsource type=pwl wave=\[
+ 0    0.9
+ 86645927941275464361825443254471365732388658605494267974077486894206915868925800719999200190754361815543475342543861619655442431500p 0.9
+ 86645927941275464361825443254471365732388658605494267974077486894206915868925800719999200190754361815543475342543861619655442431510p -0.3
+ 86645927941275464361825443254471365732388658605494267974077486894206915868925800719999200190754361815543475342543861619655442432000p -0.3
+ 86645927941275464361825443254471365732388658605494267974077486894206915868925800719999200190754361815543475342543861619655442432010p 0.9
+ \]
V_wl_bar_426 (WordLine_bar\\<426\\> gnd!) vsource type=pwl wave=\[
+ 0    0.9
+ 173291855882550928723650886508942731464777317210988535948154973788413831737851601439998400381508723631086950685087723239310884863500p 0.9
+ 173291855882550928723650886508942731464777317210988535948154973788413831737851601439998400381508723631086950685087723239310884863510p -0.3
+ 173291855882550928723650886508942731464777317210988535948154973788413831737851601439998400381508723631086950685087723239310884864000p -0.3
+ 173291855882550928723650886508942731464777317210988535948154973788413831737851601439998400381508723631086950685087723239310884864010p 0.9
+ \]
V_wl_bar_427 (WordLine_bar\\<427\\> gnd!) vsource type=pwl wave=\[
+ 0    0.9
+ 346583711765101857447301773017885462929554634421977071896309947576827663475703202879996800763017447262173901370175446478621769727500p 0.9
+ 346583711765101857447301773017885462929554634421977071896309947576827663475703202879996800763017447262173901370175446478621769727510p -0.3
+ 346583711765101857447301773017885462929554634421977071896309947576827663475703202879996800763017447262173901370175446478621769728000p -0.3
+ 346583711765101857447301773017885462929554634421977071896309947576827663475703202879996800763017447262173901370175446478621769728010p 0.9
+ \]
V_wl_bar_428 (WordLine_bar\\<428\\> gnd!) vsource type=pwl wave=\[
+ 0    0.9
+ 693167423530203714894603546035770925859109268843954143792619895153655326951406405759993601526034894524347802740350892957243539455500p 0.9
+ 693167423530203714894603546035770925859109268843954143792619895153655326951406405759993601526034894524347802740350892957243539455510p -0.3
+ 693167423530203714894603546035770925859109268843954143792619895153655326951406405759993601526034894524347802740350892957243539456000p -0.3
+ 693167423530203714894603546035770925859109268843954143792619895153655326951406405759993601526034894524347802740350892957243539456010p 0.9
+ \]
V_wl_bar_429 (WordLine_bar\\<429\\> gnd!) vsource type=pwl wave=\[
+ 0    0.9
+ 1386334847060407429789207092071541851718218537687908287585239790307310653902812811519987203052069789048695605480701785914487078911500p 0.9
+ 1386334847060407429789207092071541851718218537687908287585239790307310653902812811519987203052069789048695605480701785914487078911510p -0.3
+ 1386334847060407429789207092071541851718218537687908287585239790307310653902812811519987203052069789048695605480701785914487078912000p -0.3
+ 1386334847060407429789207092071541851718218537687908287585239790307310653902812811519987203052069789048695605480701785914487078912010p 0.9
+ \]
V_wl_bar_430 (WordLine_bar\\<430\\> gnd!) vsource type=pwl wave=\[
+ 0    0.9
+ 2772669694120814859578414184143083703436437075375816575170479580614621307805625623039974406104139578097391210961403571828974157823500p 0.9
+ 2772669694120814859578414184143083703436437075375816575170479580614621307805625623039974406104139578097391210961403571828974157823510p -0.3
+ 2772669694120814859578414184143083703436437075375816575170479580614621307805625623039974406104139578097391210961403571828974157824000p -0.3
+ 2772669694120814859578414184143083703436437075375816575170479580614621307805625623039974406104139578097391210961403571828974157824010p 0.9
+ \]
V_wl_bar_431 (WordLine_bar\\<431\\> gnd!) vsource type=pwl wave=\[
+ 0    0.9
+ 5545339388241629719156828368286167406872874150751633150340959161229242615611251246079948812208279156194782421922807143657948315647500p 0.9
+ 5545339388241629719156828368286167406872874150751633150340959161229242615611251246079948812208279156194782421922807143657948315647510p -0.3
+ 5545339388241629719156828368286167406872874150751633150340959161229242615611251246079948812208279156194782421922807143657948315648000p -0.3
+ 5545339388241629719156828368286167406872874150751633150340959161229242615611251246079948812208279156194782421922807143657948315648010p 0.9
+ \]
V_wl_bar_432 (WordLine_bar\\<432\\> gnd!) vsource type=pwl wave=\[
+ 0    0.9
+ 11090678776483259438313656736572334813745748301503266300681918322458485231222502492159897624416558312389564843845614287315896631295500p 0.9
+ 11090678776483259438313656736572334813745748301503266300681918322458485231222502492159897624416558312389564843845614287315896631295510p -0.3
+ 11090678776483259438313656736572334813745748301503266300681918322458485231222502492159897624416558312389564843845614287315896631296000p -0.3
+ 11090678776483259438313656736572334813745748301503266300681918322458485231222502492159897624416558312389564843845614287315896631296010p 0.9
+ \]
V_wl_bar_433 (WordLine_bar\\<433\\> gnd!) vsource type=pwl wave=\[
+ 0    0.9
+ 22181357552966518876627313473144669627491496603006532601363836644916970462445004984319795248833116624779129687691228574631793262591500p 0.9
+ 22181357552966518876627313473144669627491496603006532601363836644916970462445004984319795248833116624779129687691228574631793262591510p -0.3
+ 22181357552966518876627313473144669627491496603006532601363836644916970462445004984319795248833116624779129687691228574631793262592000p -0.3
+ 22181357552966518876627313473144669627491496603006532601363836644916970462445004984319795248833116624779129687691228574631793262592010p 0.9
+ \]
V_wl_bar_434 (WordLine_bar\\<434\\> gnd!) vsource type=pwl wave=\[
+ 0    0.9
+ 44362715105933037753254626946289339254982993206013065202727673289833940924890009968639590497666233249558259375382457149263586525183500p 0.9
+ 44362715105933037753254626946289339254982993206013065202727673289833940924890009968639590497666233249558259375382457149263586525183510p -0.3
+ 44362715105933037753254626946289339254982993206013065202727673289833940924890009968639590497666233249558259375382457149263586525184000p -0.3
+ 44362715105933037753254626946289339254982993206013065202727673289833940924890009968639590497666233249558259375382457149263586525184010p 0.9
+ \]
V_wl_bar_435 (WordLine_bar\\<435\\> gnd!) vsource type=pwl wave=\[
+ 0    0.9
+ 88725430211866075506509253892578678509965986412026130405455346579667881849780019937279180995332466499116518750764914298527173050367500p 0.9
+ 88725430211866075506509253892578678509965986412026130405455346579667881849780019937279180995332466499116518750764914298527173050367510p -0.3
+ 88725430211866075506509253892578678509965986412026130405455346579667881849780019937279180995332466499116518750764914298527173050368000p -0.3
+ 88725430211866075506509253892578678509965986412026130405455346579667881849780019937279180995332466499116518750764914298527173050368010p 0.9
+ \]
V_wl_bar_436 (WordLine_bar\\<436\\> gnd!) vsource type=pwl wave=\[
+ 0    0.9
+ 177450860423732151013018507785157357019931972824052260810910693159335763699560039874558361990664932998233037501529828597054346100735500p 0.9
+ 177450860423732151013018507785157357019931972824052260810910693159335763699560039874558361990664932998233037501529828597054346100735510p -0.3
+ 177450860423732151013018507785157357019931972824052260810910693159335763699560039874558361990664932998233037501529828597054346100736000p -0.3
+ 177450860423732151013018507785157357019931972824052260810910693159335763699560039874558361990664932998233037501529828597054346100736010p 0.9
+ \]
V_wl_bar_437 (WordLine_bar\\<437\\> gnd!) vsource type=pwl wave=\[
+ 0    0.9
+ 354901720847464302026037015570314714039863945648104521621821386318671527399120079749116723981329865996466075003059657194108692201471500p 0.9
+ 354901720847464302026037015570314714039863945648104521621821386318671527399120079749116723981329865996466075003059657194108692201471510p -0.3
+ 354901720847464302026037015570314714039863945648104521621821386318671527399120079749116723981329865996466075003059657194108692201472000p -0.3
+ 354901720847464302026037015570314714039863945648104521621821386318671527399120079749116723981329865996466075003059657194108692201472010p 0.9
+ \]
V_wl_bar_438 (WordLine_bar\\<438\\> gnd!) vsource type=pwl wave=\[
+ 0    0.9
+ 709803441694928604052074031140629428079727891296209043243642772637343054798240159498233447962659731992932150006119314388217384402943500p 0.9
+ 709803441694928604052074031140629428079727891296209043243642772637343054798240159498233447962659731992932150006119314388217384402943510p -0.3
+ 709803441694928604052074031140629428079727891296209043243642772637343054798240159498233447962659731992932150006119314388217384402944000p -0.3
+ 709803441694928604052074031140629428079727891296209043243642772637343054798240159498233447962659731992932150006119314388217384402944010p 0.9
+ \]
V_wl_bar_439 (WordLine_bar\\<439\\> gnd!) vsource type=pwl wave=\[
+ 0    0.9
+ 1419606883389857208104148062281258856159455782592418086487285545274686109596480318996466895925319463985864300012238628776434768805887500p 0.9
+ 1419606883389857208104148062281258856159455782592418086487285545274686109596480318996466895925319463985864300012238628776434768805887510p -0.3
+ 1419606883389857208104148062281258856159455782592418086487285545274686109596480318996466895925319463985864300012238628776434768805888000p -0.3
+ 1419606883389857208104148062281258856159455782592418086487285545274686109596480318996466895925319463985864300012238628776434768805888010p 0.9
+ \]
V_wl_bar_440 (WordLine_bar\\<440\\> gnd!) vsource type=pwl wave=\[
+ 0    0.9
+ 2839213766779714416208296124562517712318911565184836172974571090549372219192960637992933791850638927971728600024477257552869537611775500p 0.9
+ 2839213766779714416208296124562517712318911565184836172974571090549372219192960637992933791850638927971728600024477257552869537611775510p -0.3
+ 2839213766779714416208296124562517712318911565184836172974571090549372219192960637992933791850638927971728600024477257552869537611776000p -0.3
+ 2839213766779714416208296124562517712318911565184836172974571090549372219192960637992933791850638927971728600024477257552869537611776010p 0.9
+ \]
V_wl_bar_441 (WordLine_bar\\<441\\> gnd!) vsource type=pwl wave=\[
+ 0    0.9
+ 5678427533559428832416592249125035424637823130369672345949142181098744438385921275985867583701277855943457200048954515105739075223551500p 0.9
+ 5678427533559428832416592249125035424637823130369672345949142181098744438385921275985867583701277855943457200048954515105739075223551510p -0.3
+ 5678427533559428832416592249125035424637823130369672345949142181098744438385921275985867583701277855943457200048954515105739075223552000p -0.3
+ 5678427533559428832416592249125035424637823130369672345949142181098744438385921275985867583701277855943457200048954515105739075223552010p 0.9
+ \]
V_wl_bar_442 (WordLine_bar\\<442\\> gnd!) vsource type=pwl wave=\[
+ 0    0.9
+ 11356855067118857664833184498250070849275646260739344691898284362197488876771842551971735167402555711886914400097909030211478150447103500p 0.9
+ 11356855067118857664833184498250070849275646260739344691898284362197488876771842551971735167402555711886914400097909030211478150447103510p -0.3
+ 11356855067118857664833184498250070849275646260739344691898284362197488876771842551971735167402555711886914400097909030211478150447104000p -0.3
+ 11356855067118857664833184498250070849275646260739344691898284362197488876771842551971735167402555711886914400097909030211478150447104010p 0.9
+ \]
V_wl_bar_443 (WordLine_bar\\<443\\> gnd!) vsource type=pwl wave=\[
+ 0    0.9
+ 22713710134237715329666368996500141698551292521478689383796568724394977753543685103943470334805111423773828800195818060422956300894207500p 0.9
+ 22713710134237715329666368996500141698551292521478689383796568724394977753543685103943470334805111423773828800195818060422956300894207510p -0.3
+ 22713710134237715329666368996500141698551292521478689383796568724394977753543685103943470334805111423773828800195818060422956300894208000p -0.3
+ 22713710134237715329666368996500141698551292521478689383796568724394977753543685103943470334805111423773828800195818060422956300894208010p 0.9
+ \]
V_wl_bar_444 (WordLine_bar\\<444\\> gnd!) vsource type=pwl wave=\[
+ 0    0.9
+ 45427420268475430659332737993000283397102585042957378767593137448789955507087370207886940669610222847547657600391636120845912601788415500p 0.9
+ 45427420268475430659332737993000283397102585042957378767593137448789955507087370207886940669610222847547657600391636120845912601788415510p -0.3
+ 45427420268475430659332737993000283397102585042957378767593137448789955507087370207886940669610222847547657600391636120845912601788416000p -0.3
+ 45427420268475430659332737993000283397102585042957378767593137448789955507087370207886940669610222847547657600391636120845912601788416010p 0.9
+ \]
V_wl_bar_445 (WordLine_bar\\<445\\> gnd!) vsource type=pwl wave=\[
+ 0    0.9
+ 90854840536950861318665475986000566794205170085914757535186274897579911014174740415773881339220445695095315200783272241691825203576831500p 0.9
+ 90854840536950861318665475986000566794205170085914757535186274897579911014174740415773881339220445695095315200783272241691825203576831510p -0.3
+ 90854840536950861318665475986000566794205170085914757535186274897579911014174740415773881339220445695095315200783272241691825203576832000p -0.3
+ 90854840536950861318665475986000566794205170085914757535186274897579911014174740415773881339220445695095315200783272241691825203576832010p 0.9
+ \]
V_wl_bar_446 (WordLine_bar\\<446\\> gnd!) vsource type=pwl wave=\[
+ 0    0.9
+ 181709681073901722637330951972001133588410340171829515070372549795159822028349480831547762678440891390190630401566544483383650407153663500p 0.9
+ 181709681073901722637330951972001133588410340171829515070372549795159822028349480831547762678440891390190630401566544483383650407153663510p -0.3
+ 181709681073901722637330951972001133588410340171829515070372549795159822028349480831547762678440891390190630401566544483383650407153664000p -0.3
+ 181709681073901722637330951972001133588410340171829515070372549795159822028349480831547762678440891390190630401566544483383650407153664010p 0.9
+ \]
V_wl_bar_447 (WordLine_bar\\<447\\> gnd!) vsource type=pwl wave=\[
+ 0    0.9
+ 363419362147803445274661903944002267176820680343659030140745099590319644056698961663095525356881782780381260803133088966767300814307327500p 0.9
+ 363419362147803445274661903944002267176820680343659030140745099590319644056698961663095525356881782780381260803133088966767300814307327510p -0.3
+ 363419362147803445274661903944002267176820680343659030140745099590319644056698961663095525356881782780381260803133088966767300814307328000p -0.3
+ 363419362147803445274661903944002267176820680343659030140745099590319644056698961663095525356881782780381260803133088966767300814307328010p 0.9
+ \]
V_wl_bar_448 (WordLine_bar\\<448\\> gnd!) vsource type=pwl wave=\[
+ 0    0.9
+ 726838724295606890549323807888004534353641360687318060281490199180639288113397923326191050713763565560762521606266177933534601628614655500p 0.9
+ 726838724295606890549323807888004534353641360687318060281490199180639288113397923326191050713763565560762521606266177933534601628614655510p -0.3
+ 726838724295606890549323807888004534353641360687318060281490199180639288113397923326191050713763565560762521606266177933534601628614656000p -0.3
+ 726838724295606890549323807888004534353641360687318060281490199180639288113397923326191050713763565560762521606266177933534601628614656010p 0.9
+ \]
V_wl_bar_449 (WordLine_bar\\<449\\> gnd!) vsource type=pwl wave=\[
+ 0    0.9
+ 1453677448591213781098647615776009068707282721374636120562980398361278576226795846652382101427527131121525043212532355867069203257229311500p 0.9
+ 1453677448591213781098647615776009068707282721374636120562980398361278576226795846652382101427527131121525043212532355867069203257229311510p -0.3
+ 1453677448591213781098647615776009068707282721374636120562980398361278576226795846652382101427527131121525043212532355867069203257229312000p -0.3
+ 1453677448591213781098647615776009068707282721374636120562980398361278576226795846652382101427527131121525043212532355867069203257229312010p 0.9
+ \]
V_wl_bar_450 (WordLine_bar\\<450\\> gnd!) vsource type=pwl wave=\[
+ 0    0.9
+ 2907354897182427562197295231552018137414565442749272241125960796722557152453591693304764202855054262243050086425064711734138406514458623500p 0.9
+ 2907354897182427562197295231552018137414565442749272241125960796722557152453591693304764202855054262243050086425064711734138406514458623510p -0.3
+ 2907354897182427562197295231552018137414565442749272241125960796722557152453591693304764202855054262243050086425064711734138406514458624000p -0.3
+ 2907354897182427562197295231552018137414565442749272241125960796722557152453591693304764202855054262243050086425064711734138406514458624010p 0.9
+ \]
V_wl_bar_451 (WordLine_bar\\<451\\> gnd!) vsource type=pwl wave=\[
+ 0    0.9
+ 5814709794364855124394590463104036274829130885498544482251921593445114304907183386609528405710108524486100172850129423468276813028917247500p 0.9
+ 5814709794364855124394590463104036274829130885498544482251921593445114304907183386609528405710108524486100172850129423468276813028917247510p -0.3
+ 5814709794364855124394590463104036274829130885498544482251921593445114304907183386609528405710108524486100172850129423468276813028917248000p -0.3
+ 5814709794364855124394590463104036274829130885498544482251921593445114304907183386609528405710108524486100172850129423468276813028917248010p 0.9
+ \]
V_wl_bar_452 (WordLine_bar\\<452\\> gnd!) vsource type=pwl wave=\[
+ 0    0.9
+ 11629419588729710248789180926208072549658261770997088964503843186890228609814366773219056811420217048972200345700258846936553626057834495500p 0.9
+ 11629419588729710248789180926208072549658261770997088964503843186890228609814366773219056811420217048972200345700258846936553626057834495510p -0.3
+ 11629419588729710248789180926208072549658261770997088964503843186890228609814366773219056811420217048972200345700258846936553626057834496000p -0.3
+ 11629419588729710248789180926208072549658261770997088964503843186890228609814366773219056811420217048972200345700258846936553626057834496010p 0.9
+ \]
V_wl_bar_453 (WordLine_bar\\<453\\> gnd!) vsource type=pwl wave=\[
+ 0    0.9
+ 23258839177459420497578361852416145099316523541994177929007686373780457219628733546438113622840434097944400691400517693873107252115668991500p 0.9
+ 23258839177459420497578361852416145099316523541994177929007686373780457219628733546438113622840434097944400691400517693873107252115668991510p -0.3
+ 23258839177459420497578361852416145099316523541994177929007686373780457219628733546438113622840434097944400691400517693873107252115668992000p -0.3
+ 23258839177459420497578361852416145099316523541994177929007686373780457219628733546438113622840434097944400691400517693873107252115668992010p 0.9
+ \]
V_wl_bar_454 (WordLine_bar\\<454\\> gnd!) vsource type=pwl wave=\[
+ 0    0.9
+ 46517678354918840995156723704832290198633047083988355858015372747560914439257467092876227245680868195888801382801035387746214504231337983500p 0.9
+ 46517678354918840995156723704832290198633047083988355858015372747560914439257467092876227245680868195888801382801035387746214504231337983510p -0.3
+ 46517678354918840995156723704832290198633047083988355858015372747560914439257467092876227245680868195888801382801035387746214504231337984000p -0.3
+ 46517678354918840995156723704832290198633047083988355858015372747560914439257467092876227245680868195888801382801035387746214504231337984010p 0.9
+ \]
V_wl_bar_455 (WordLine_bar\\<455\\> gnd!) vsource type=pwl wave=\[
+ 0    0.9
+ 93035356709837681990313447409664580397266094167976711716030745495121828878514934185752454491361736391777602765602070775492429008462675967500p 0.9
+ 93035356709837681990313447409664580397266094167976711716030745495121828878514934185752454491361736391777602765602070775492429008462675967510p -0.3
+ 93035356709837681990313447409664580397266094167976711716030745495121828878514934185752454491361736391777602765602070775492429008462675968000p -0.3
+ 93035356709837681990313447409664580397266094167976711716030745495121828878514934185752454491361736391777602765602070775492429008462675968010p 0.9
+ \]
V_wl_bar_456 (WordLine_bar\\<456\\> gnd!) vsource type=pwl wave=\[
+ 0    0.9
+ 186070713419675363980626894819329160794532188335953423432061490990243657757029868371504908982723472783555205531204141550984858016925351935500p 0.9
+ 186070713419675363980626894819329160794532188335953423432061490990243657757029868371504908982723472783555205531204141550984858016925351935510p -0.3
+ 186070713419675363980626894819329160794532188335953423432061490990243657757029868371504908982723472783555205531204141550984858016925351936000p -0.3
+ 186070713419675363980626894819329160794532188335953423432061490990243657757029868371504908982723472783555205531204141550984858016925351936010p 0.9
+ \]
V_wl_bar_457 (WordLine_bar\\<457\\> gnd!) vsource type=pwl wave=\[
+ 0    0.9
+ 372141426839350727961253789638658321589064376671906846864122981980487315514059736743009817965446945567110411062408283101969716033850703871500p 0.9
+ 372141426839350727961253789638658321589064376671906846864122981980487315514059736743009817965446945567110411062408283101969716033850703871510p -0.3
+ 372141426839350727961253789638658321589064376671906846864122981980487315514059736743009817965446945567110411062408283101969716033850703872000p -0.3
+ 372141426839350727961253789638658321589064376671906846864122981980487315514059736743009817965446945567110411062408283101969716033850703872010p 0.9
+ \]
V_wl_bar_458 (WordLine_bar\\<458\\> gnd!) vsource type=pwl wave=\[
+ 0    0.9
+ 744282853678701455922507579277316643178128753343813693728245963960974631028119473486019635930893891134220822124816566203939432067701407743500p 0.9
+ 744282853678701455922507579277316643178128753343813693728245963960974631028119473486019635930893891134220822124816566203939432067701407743510p -0.3
+ 744282853678701455922507579277316643178128753343813693728245963960974631028119473486019635930893891134220822124816566203939432067701407744000p -0.3
+ 744282853678701455922507579277316643178128753343813693728245963960974631028119473486019635930893891134220822124816566203939432067701407744010p 0.9
+ \]
V_wl_bar_459 (WordLine_bar\\<459\\> gnd!) vsource type=pwl wave=\[
+ 0    0.9
+ 1488565707357402911845015158554633286356257506687627387456491927921949262056238946972039271861787782268441644249633132407878864135402815487500p 0.9
+ 1488565707357402911845015158554633286356257506687627387456491927921949262056238946972039271861787782268441644249633132407878864135402815487510p -0.3
+ 1488565707357402911845015158554633286356257506687627387456491927921949262056238946972039271861787782268441644249633132407878864135402815488000p -0.3
+ 1488565707357402911845015158554633286356257506687627387456491927921949262056238946972039271861787782268441644249633132407878864135402815488010p 0.9
+ \]
V_wl_bar_460 (WordLine_bar\\<460\\> gnd!) vsource type=pwl wave=\[
+ 0    0.9
+ 2977131414714805823690030317109266572712515013375254774912983855843898524112477893944078543723575564536883288499266264815757728270805630975500p 0.9
+ 2977131414714805823690030317109266572712515013375254774912983855843898524112477893944078543723575564536883288499266264815757728270805630975510p -0.3
+ 2977131414714805823690030317109266572712515013375254774912983855843898524112477893944078543723575564536883288499266264815757728270805630976000p -0.3
+ 2977131414714805823690030317109266572712515013375254774912983855843898524112477893944078543723575564536883288499266264815757728270805630976010p 0.9
+ \]
V_wl_bar_461 (WordLine_bar\\<461\\> gnd!) vsource type=pwl wave=\[
+ 0    0.9
+ 5954262829429611647380060634218533145425030026750509549825967711687797048224955787888157087447151129073766576998532529631515456541611261951500p 0.9
+ 5954262829429611647380060634218533145425030026750509549825967711687797048224955787888157087447151129073766576998532529631515456541611261951510p -0.3
+ 5954262829429611647380060634218533145425030026750509549825967711687797048224955787888157087447151129073766576998532529631515456541611261952000p -0.3
+ 5954262829429611647380060634218533145425030026750509549825967711687797048224955787888157087447151129073766576998532529631515456541611261952010p 0.9
+ \]
V_wl_bar_462 (WordLine_bar\\<462\\> gnd!) vsource type=pwl wave=\[
+ 0    0.9
+ 11908525658859223294760121268437066290850060053501019099651935423375594096449911575776314174894302258147533153997065059263030913083222523903500p 0.9
+ 11908525658859223294760121268437066290850060053501019099651935423375594096449911575776314174894302258147533153997065059263030913083222523903510p -0.3
+ 11908525658859223294760121268437066290850060053501019099651935423375594096449911575776314174894302258147533153997065059263030913083222523904000p -0.3
+ 11908525658859223294760121268437066290850060053501019099651935423375594096449911575776314174894302258147533153997065059263030913083222523904010p 0.9
+ \]
V_wl_bar_463 (WordLine_bar\\<463\\> gnd!) vsource type=pwl wave=\[
+ 0    0.9
+ 23817051317718446589520242536874132581700120107002038199303870846751188192899823151552628349788604516295066307994130118526061826166445047807500p 0.9
+ 23817051317718446589520242536874132581700120107002038199303870846751188192899823151552628349788604516295066307994130118526061826166445047807510p -0.3
+ 23817051317718446589520242536874132581700120107002038199303870846751188192899823151552628349788604516295066307994130118526061826166445047808000p -0.3
+ 23817051317718446589520242536874132581700120107002038199303870846751188192899823151552628349788604516295066307994130118526061826166445047808010p 0.9
+ \]
V_wl_bar_464 (WordLine_bar\\<464\\> gnd!) vsource type=pwl wave=\[
+ 0    0.9
+ 47634102635436893179040485073748265163400240214004076398607741693502376385799646303105256699577209032590132615988260237052123652332890095615500p 0.9
+ 47634102635436893179040485073748265163400240214004076398607741693502376385799646303105256699577209032590132615988260237052123652332890095615510p -0.3
+ 47634102635436893179040485073748265163400240214004076398607741693502376385799646303105256699577209032590132615988260237052123652332890095616000p -0.3
+ 47634102635436893179040485073748265163400240214004076398607741693502376385799646303105256699577209032590132615988260237052123652332890095616010p 0.9
+ \]
V_wl_bar_465 (WordLine_bar\\<465\\> gnd!) vsource type=pwl wave=\[
+ 0    0.9
+ 95268205270873786358080970147496530326800480428008152797215483387004752771599292606210513399154418065180265231976520474104247304665780191231500p 0.9
+ 95268205270873786358080970147496530326800480428008152797215483387004752771599292606210513399154418065180265231976520474104247304665780191231510p -0.3
+ 95268205270873786358080970147496530326800480428008152797215483387004752771599292606210513399154418065180265231976520474104247304665780191232000p -0.3
+ 95268205270873786358080970147496530326800480428008152797215483387004752771599292606210513399154418065180265231976520474104247304665780191232010p 0.9
+ \]
V_wl_bar_466 (WordLine_bar\\<466\\> gnd!) vsource type=pwl wave=\[
+ 0    0.9
+ 190536410541747572716161940294993060653600960856016305594430966774009505543198585212421026798308836130360530463953040948208494609331560382463500p 0.9
+ 190536410541747572716161940294993060653600960856016305594430966774009505543198585212421026798308836130360530463953040948208494609331560382463510p -0.3
+ 190536410541747572716161940294993060653600960856016305594430966774009505543198585212421026798308836130360530463953040948208494609331560382464000p -0.3
+ 190536410541747572716161940294993060653600960856016305594430966774009505543198585212421026798308836130360530463953040948208494609331560382464010p 0.9
+ \]
V_wl_bar_467 (WordLine_bar\\<467\\> gnd!) vsource type=pwl wave=\[
+ 0    0.9
+ 381072821083495145432323880589986121307201921712032611188861933548019011086397170424842053596617672260721060927906081896416989218663120764927500p 0.9
+ 381072821083495145432323880589986121307201921712032611188861933548019011086397170424842053596617672260721060927906081896416989218663120764927510p -0.3
+ 381072821083495145432323880589986121307201921712032611188861933548019011086397170424842053596617672260721060927906081896416989218663120764928000p -0.3
+ 381072821083495145432323880589986121307201921712032611188861933548019011086397170424842053596617672260721060927906081896416989218663120764928010p 0.9
+ \]
V_wl_bar_468 (WordLine_bar\\<468\\> gnd!) vsource type=pwl wave=\[
+ 0    0.9
+ 762145642166990290864647761179972242614403843424065222377723867096038022172794340849684107193235344521442121855812163792833978437326241529855500p 0.9
+ 762145642166990290864647761179972242614403843424065222377723867096038022172794340849684107193235344521442121855812163792833978437326241529855510p -0.3
+ 762145642166990290864647761179972242614403843424065222377723867096038022172794340849684107193235344521442121855812163792833978437326241529856000p -0.3
+ 762145642166990290864647761179972242614403843424065222377723867096038022172794340849684107193235344521442121855812163792833978437326241529856010p 0.9
+ \]
V_wl_bar_469 (WordLine_bar\\<469\\> gnd!) vsource type=pwl wave=\[
+ 0    0.9
+ 1524291284333980581729295522359944485228807686848130444755447734192076044345588681699368214386470689042884243711624327585667956874652483059711500p 0.9
+ 1524291284333980581729295522359944485228807686848130444755447734192076044345588681699368214386470689042884243711624327585667956874652483059711510p -0.3
+ 1524291284333980581729295522359944485228807686848130444755447734192076044345588681699368214386470689042884243711624327585667956874652483059712000p -0.3
+ 1524291284333980581729295522359944485228807686848130444755447734192076044345588681699368214386470689042884243711624327585667956874652483059712010p 0.9
+ \]
V_wl_bar_470 (WordLine_bar\\<470\\> gnd!) vsource type=pwl wave=\[
+ 0    0.9
+ 3048582568667961163458591044719888970457615373696260889510895468384152088691177363398736428772941378085768487423248655171335913749304966119423500p 0.9
+ 3048582568667961163458591044719888970457615373696260889510895468384152088691177363398736428772941378085768487423248655171335913749304966119423510p -0.3
+ 3048582568667961163458591044719888970457615373696260889510895468384152088691177363398736428772941378085768487423248655171335913749304966119424000p -0.3
+ 3048582568667961163458591044719888970457615373696260889510895468384152088691177363398736428772941378085768487423248655171335913749304966119424010p 0.9
+ \]
V_wl_bar_471 (WordLine_bar\\<471\\> gnd!) vsource type=pwl wave=\[
+ 0    0.9
+ 6097165137335922326917182089439777940915230747392521779021790936768304177382354726797472857545882756171536974846497310342671827498609932238847500p 0.9
+ 6097165137335922326917182089439777940915230747392521779021790936768304177382354726797472857545882756171536974846497310342671827498609932238847510p -0.3
+ 6097165137335922326917182089439777940915230747392521779021790936768304177382354726797472857545882756171536974846497310342671827498609932238848000p -0.3
+ 6097165137335922326917182089439777940915230747392521779021790936768304177382354726797472857545882756171536974846497310342671827498609932238848010p 0.9
+ \]
V_wl_bar_472 (WordLine_bar\\<472\\> gnd!) vsource type=pwl wave=\[
+ 0    0.9
+ 12194330274671844653834364178879555881830461494785043558043581873536608354764709453594945715091765512343073949692994620685343654997219864477695500p 0.9
+ 12194330274671844653834364178879555881830461494785043558043581873536608354764709453594945715091765512343073949692994620685343654997219864477695510p -0.3
+ 12194330274671844653834364178879555881830461494785043558043581873536608354764709453594945715091765512343073949692994620685343654997219864477696000p -0.3
+ 12194330274671844653834364178879555881830461494785043558043581873536608354764709453594945715091765512343073949692994620685343654997219864477696010p 0.9
+ \]
V_wl_bar_473 (WordLine_bar\\<473\\> gnd!) vsource type=pwl wave=\[
+ 0    0.9
+ 24388660549343689307668728357759111763660922989570087116087163747073216709529418907189891430183531024686147899385989241370687309994439728955391500p 0.9
+ 24388660549343689307668728357759111763660922989570087116087163747073216709529418907189891430183531024686147899385989241370687309994439728955391510p -0.3
+ 24388660549343689307668728357759111763660922989570087116087163747073216709529418907189891430183531024686147899385989241370687309994439728955392000p -0.3
+ 24388660549343689307668728357759111763660922989570087116087163747073216709529418907189891430183531024686147899385989241370687309994439728955392010p 0.9
+ \]
V_wl_bar_474 (WordLine_bar\\<474\\> gnd!) vsource type=pwl wave=\[
+ 0    0.9
+ 48777321098687378615337456715518223527321845979140174232174327494146433419058837814379782860367062049372295798771978482741374619988879457910783500p 0.9
+ 48777321098687378615337456715518223527321845979140174232174327494146433419058837814379782860367062049372295798771978482741374619988879457910783510p -0.3
+ 48777321098687378615337456715518223527321845979140174232174327494146433419058837814379782860367062049372295798771978482741374619988879457910784000p -0.3
+ 48777321098687378615337456715518223527321845979140174232174327494146433419058837814379782860367062049372295798771978482741374619988879457910784010p 0.9
+ \]
V_wl_bar_475 (WordLine_bar\\<475\\> gnd!) vsource type=pwl wave=\[
+ 0    0.9
+ 97554642197374757230674913431036447054643691958280348464348654988292866838117675628759565720734124098744591597543956965482749239977758915821567500p 0.9
+ 97554642197374757230674913431036447054643691958280348464348654988292866838117675628759565720734124098744591597543956965482749239977758915821567510p -0.3
+ 97554642197374757230674913431036447054643691958280348464348654988292866838117675628759565720734124098744591597543956965482749239977758915821568000p -0.3
+ 97554642197374757230674913431036447054643691958280348464348654988292866838117675628759565720734124098744591597543956965482749239977758915821568010p 0.9
+ \]
V_wl_bar_476 (WordLine_bar\\<476\\> gnd!) vsource type=pwl wave=\[
+ 0    0.9
+ 195109284394749514461349826862072894109287383916560696928697309976585733676235351257519131441468248197489183195087913930965498479955517831643135500p 0.9
+ 195109284394749514461349826862072894109287383916560696928697309976585733676235351257519131441468248197489183195087913930965498479955517831643135510p -0.3
+ 195109284394749514461349826862072894109287383916560696928697309976585733676235351257519131441468248197489183195087913930965498479955517831643136000p -0.3
+ 195109284394749514461349826862072894109287383916560696928697309976585733676235351257519131441468248197489183195087913930965498479955517831643136010p 0.9
+ \]
V_wl_bar_477 (WordLine_bar\\<477\\> gnd!) vsource type=pwl wave=\[
+ 0    0.9
+ 390218568789499028922699653724145788218574767833121393857394619953171467352470702515038262882936496394978366390175827861930996959911035663286271500p 0.9
+ 390218568789499028922699653724145788218574767833121393857394619953171467352470702515038262882936496394978366390175827861930996959911035663286271510p -0.3
+ 390218568789499028922699653724145788218574767833121393857394619953171467352470702515038262882936496394978366390175827861930996959911035663286272000p -0.3
+ 390218568789499028922699653724145788218574767833121393857394619953171467352470702515038262882936496394978366390175827861930996959911035663286272010p 0.9
+ \]
V_wl_bar_478 (WordLine_bar\\<478\\> gnd!) vsource type=pwl wave=\[
+ 0    0.9
+ 780437137578998057845399307448291576437149535666242787714789239906342934704941405030076525765872992789956732780351655723861993919822071326572543500p 0.9
+ 780437137578998057845399307448291576437149535666242787714789239906342934704941405030076525765872992789956732780351655723861993919822071326572543510p -0.3
+ 780437137578998057845399307448291576437149535666242787714789239906342934704941405030076525765872992789956732780351655723861993919822071326572544000p -0.3
+ 780437137578998057845399307448291576437149535666242787714789239906342934704941405030076525765872992789956732780351655723861993919822071326572544010p 0.9
+ \]
V_wl_bar_479 (WordLine_bar\\<479\\> gnd!) vsource type=pwl wave=\[
+ 0    0.9
+ 1560874275157996115690798614896583152874299071332485575429578479812685869409882810060153051531745985579913465560703311447723987839644142653145087500p 0.9
+ 1560874275157996115690798614896583152874299071332485575429578479812685869409882810060153051531745985579913465560703311447723987839644142653145087510p -0.3
+ 1560874275157996115690798614896583152874299071332485575429578479812685869409882810060153051531745985579913465560703311447723987839644142653145088000p -0.3
+ 1560874275157996115690798614896583152874299071332485575429578479812685869409882810060153051531745985579913465560703311447723987839644142653145088010p 0.9
+ \]
V_wl_bar_480 (WordLine_bar\\<480\\> gnd!) vsource type=pwl wave=\[
+ 0    0.9
+ 3121748550315992231381597229793166305748598142664971150859156959625371738819765620120306103063491971159826931121406622895447975679288285306290175500p 0.9
+ 3121748550315992231381597229793166305748598142664971150859156959625371738819765620120306103063491971159826931121406622895447975679288285306290175510p -0.3
+ 3121748550315992231381597229793166305748598142664971150859156959625371738819765620120306103063491971159826931121406622895447975679288285306290176000p -0.3
+ 3121748550315992231381597229793166305748598142664971150859156959625371738819765620120306103063491971159826931121406622895447975679288285306290176010p 0.9
+ \]
V_wl_bar_481 (WordLine_bar\\<481\\> gnd!) vsource type=pwl wave=\[
+ 0    0.9
+ 6243497100631984462763194459586332611497196285329942301718313919250743477639531240240612206126983942319653862242813245790895951358576570612580351500p 0.9
+ 6243497100631984462763194459586332611497196285329942301718313919250743477639531240240612206126983942319653862242813245790895951358576570612580351510p -0.3
+ 6243497100631984462763194459586332611497196285329942301718313919250743477639531240240612206126983942319653862242813245790895951358576570612580352000p -0.3
+ 6243497100631984462763194459586332611497196285329942301718313919250743477639531240240612206126983942319653862242813245790895951358576570612580352010p 0.9
+ \]
V_wl_bar_482 (WordLine_bar\\<482\\> gnd!) vsource type=pwl wave=\[
+ 0    0.9
+ 12486994201263968925526388919172665222994392570659884603436627838501486955279062480481224412253967884639307724485626491581791902717153141225160703500p 0.9
+ 12486994201263968925526388919172665222994392570659884603436627838501486955279062480481224412253967884639307724485626491581791902717153141225160703510p -0.3
+ 12486994201263968925526388919172665222994392570659884603436627838501486955279062480481224412253967884639307724485626491581791902717153141225160704000p -0.3
+ 12486994201263968925526388919172665222994392570659884603436627838501486955279062480481224412253967884639307724485626491581791902717153141225160704010p 0.9
+ \]
V_wl_bar_483 (WordLine_bar\\<483\\> gnd!) vsource type=pwl wave=\[
+ 0    0.9
+ 24973988402527937851052777838345330445988785141319769206873255677002973910558124960962448824507935769278615448971252983163583805434306282450321407500p 0.9
+ 24973988402527937851052777838345330445988785141319769206873255677002973910558124960962448824507935769278615448971252983163583805434306282450321407510p -0.3
+ 24973988402527937851052777838345330445988785141319769206873255677002973910558124960962448824507935769278615448971252983163583805434306282450321408000p -0.3
+ 24973988402527937851052777838345330445988785141319769206873255677002973910558124960962448824507935769278615448971252983163583805434306282450321408010p 0.9
+ \]
V_wl_bar_484 (WordLine_bar\\<484\\> gnd!) vsource type=pwl wave=\[
+ 0    0.9
+ 49947976805055875702105555676690660891977570282639538413746511354005947821116249921924897649015871538557230897942505966327167610868612564900642815500p 0.9
+ 49947976805055875702105555676690660891977570282639538413746511354005947821116249921924897649015871538557230897942505966327167610868612564900642815510p -0.3
+ 49947976805055875702105555676690660891977570282639538413746511354005947821116249921924897649015871538557230897942505966327167610868612564900642816000p -0.3
+ 49947976805055875702105555676690660891977570282639538413746511354005947821116249921924897649015871538557230897942505966327167610868612564900642816010p 0.9
+ \]
V_wl_bar_485 (WordLine_bar\\<485\\> gnd!) vsource type=pwl wave=\[
+ 0    0.9
+ 99895953610111751404211111353381321783955140565279076827493022708011895642232499843849795298031743077114461795885011932654335221737225129801285631500p 0.9
+ 99895953610111751404211111353381321783955140565279076827493022708011895642232499843849795298031743077114461795885011932654335221737225129801285631510p -0.3
+ 99895953610111751404211111353381321783955140565279076827493022708011895642232499843849795298031743077114461795885011932654335221737225129801285632000p -0.3
+ 99895953610111751404211111353381321783955140565279076827493022708011895642232499843849795298031743077114461795885011932654335221737225129801285632010p 0.9
+ \]
V_wl_bar_486 (WordLine_bar\\<486\\> gnd!) vsource type=pwl wave=\[
+ 0    0.9
+ 199791907220223502808422222706762643567910281130558153654986045416023791284464999687699590596063486154228923591770023865308670443474450259602571263500p 0.9
+ 199791907220223502808422222706762643567910281130558153654986045416023791284464999687699590596063486154228923591770023865308670443474450259602571263510p -0.3
+ 199791907220223502808422222706762643567910281130558153654986045416023791284464999687699590596063486154228923591770023865308670443474450259602571264000p -0.3
+ 199791907220223502808422222706762643567910281130558153654986045416023791284464999687699590596063486154228923591770023865308670443474450259602571264010p 0.9
+ \]
V_wl_bar_487 (WordLine_bar\\<487\\> gnd!) vsource type=pwl wave=\[
+ 0    0.9
+ 399583814440447005616844445413525287135820562261116307309972090832047582568929999375399181192126972308457847183540047730617340886948900519205142527500p 0.9
+ 399583814440447005616844445413525287135820562261116307309972090832047582568929999375399181192126972308457847183540047730617340886948900519205142527510p -0.3
+ 399583814440447005616844445413525287135820562261116307309972090832047582568929999375399181192126972308457847183540047730617340886948900519205142528000p -0.3
+ 399583814440447005616844445413525287135820562261116307309972090832047582568929999375399181192126972308457847183540047730617340886948900519205142528010p 0.9
+ \]
V_wl_bar_488 (WordLine_bar\\<488\\> gnd!) vsource type=pwl wave=\[
+ 0    0.9
+ 799167628880894011233688890827050574271641124522232614619944181664095165137859998750798362384253944616915694367080095461234681773897801038410285055500p 0.9
+ 799167628880894011233688890827050574271641124522232614619944181664095165137859998750798362384253944616915694367080095461234681773897801038410285055510p -0.3
+ 799167628880894011233688890827050574271641124522232614619944181664095165137859998750798362384253944616915694367080095461234681773897801038410285056000p -0.3
+ 799167628880894011233688890827050574271641124522232614619944181664095165137859998750798362384253944616915694367080095461234681773897801038410285056010p 0.9
+ \]
V_wl_bar_489 (WordLine_bar\\<489\\> gnd!) vsource type=pwl wave=\[
+ 0    0.9
+ 1598335257761788022467377781654101148543282249044465229239888363328190330275719997501596724768507889233831388734160190922469363547795602076820570111500p 0.9
+ 1598335257761788022467377781654101148543282249044465229239888363328190330275719997501596724768507889233831388734160190922469363547795602076820570111510p -0.3
+ 1598335257761788022467377781654101148543282249044465229239888363328190330275719997501596724768507889233831388734160190922469363547795602076820570112000p -0.3
+ 1598335257761788022467377781654101148543282249044465229239888363328190330275719997501596724768507889233831388734160190922469363547795602076820570112010p 0.9
+ \]
V_wl_bar_490 (WordLine_bar\\<490\\> gnd!) vsource type=pwl wave=\[
+ 0    0.9
+ 3196670515523576044934755563308202297086564498088930458479776726656380660551439995003193449537015778467662777468320381844938727095591204153641140223500p 0.9
+ 3196670515523576044934755563308202297086564498088930458479776726656380660551439995003193449537015778467662777468320381844938727095591204153641140223510p -0.3
+ 3196670515523576044934755563308202297086564498088930458479776726656380660551439995003193449537015778467662777468320381844938727095591204153641140224000p -0.3
+ 3196670515523576044934755563308202297086564498088930458479776726656380660551439995003193449537015778467662777468320381844938727095591204153641140224010p 0.9
+ \]
V_wl_bar_491 (WordLine_bar\\<491\\> gnd!) vsource type=pwl wave=\[
+ 0    0.9
+ 6393341031047152089869511126616404594173128996177860916959553453312761321102879990006386899074031556935325554936640763689877454191182408307282280447500p 0.9
+ 6393341031047152089869511126616404594173128996177860916959553453312761321102879990006386899074031556935325554936640763689877454191182408307282280447510p -0.3
+ 6393341031047152089869511126616404594173128996177860916959553453312761321102879990006386899074031556935325554936640763689877454191182408307282280448000p -0.3
+ 6393341031047152089869511126616404594173128996177860916959553453312761321102879990006386899074031556935325554936640763689877454191182408307282280448010p 0.9
+ \]
V_wl_bar_492 (WordLine_bar\\<492\\> gnd!) vsource type=pwl wave=\[
+ 0    0.9
+ 12786682062094304179739022253232809188346257992355721833919106906625522642205759980012773798148063113870651109873281527379754908382364816614564560895500p 0.9
+ 12786682062094304179739022253232809188346257992355721833919106906625522642205759980012773798148063113870651109873281527379754908382364816614564560895510p -0.3
+ 12786682062094304179739022253232809188346257992355721833919106906625522642205759980012773798148063113870651109873281527379754908382364816614564560896000p -0.3
+ 12786682062094304179739022253232809188346257992355721833919106906625522642205759980012773798148063113870651109873281527379754908382364816614564560896010p 0.9
+ \]
V_wl_bar_493 (WordLine_bar\\<493\\> gnd!) vsource type=pwl wave=\[
+ 0    0.9
+ 25573364124188608359478044506465618376692515984711443667838213813251045284411519960025547596296126227741302219746563054759509816764729633229129121791500p 0.9
+ 25573364124188608359478044506465618376692515984711443667838213813251045284411519960025547596296126227741302219746563054759509816764729633229129121791510p -0.3
+ 25573364124188608359478044506465618376692515984711443667838213813251045284411519960025547596296126227741302219746563054759509816764729633229129121792000p -0.3
+ 25573364124188608359478044506465618376692515984711443667838213813251045284411519960025547596296126227741302219746563054759509816764729633229129121792010p 0.9
+ \]
V_wl_bar_494 (WordLine_bar\\<494\\> gnd!) vsource type=pwl wave=\[
+ 0    0.9
+ 51146728248377216718956089012931236753385031969422887335676427626502090568823039920051095192592252455482604439493126109519019633529459266458258243583500p 0.9
+ 51146728248377216718956089012931236753385031969422887335676427626502090568823039920051095192592252455482604439493126109519019633529459266458258243583510p -0.3
+ 51146728248377216718956089012931236753385031969422887335676427626502090568823039920051095192592252455482604439493126109519019633529459266458258243584000p -0.3
+ 51146728248377216718956089012931236753385031969422887335676427626502090568823039920051095192592252455482604439493126109519019633529459266458258243584010p 0.9
+ \]
V_wl_bar_495 (WordLine_bar\\<495\\> gnd!) vsource type=pwl wave=\[
+ 0    0.9
+ 102293456496754433437912178025862473506770063938845774671352855253004181137646079840102190385184504910965208878986252219038039267058918532916516487167500p 0.9
+ 102293456496754433437912178025862473506770063938845774671352855253004181137646079840102190385184504910965208878986252219038039267058918532916516487167510p -0.3
+ 102293456496754433437912178025862473506770063938845774671352855253004181137646079840102190385184504910965208878986252219038039267058918532916516487168000p -0.3
+ 102293456496754433437912178025862473506770063938845774671352855253004181137646079840102190385184504910965208878986252219038039267058918532916516487168010p 0.9
+ \]
V_wl_bar_496 (WordLine_bar\\<496\\> gnd!) vsource type=pwl wave=\[
+ 0    0.9
+ 204586912993508866875824356051724947013540127877691549342705710506008362275292159680204380770369009821930417757972504438076078534117837065833032974335500p 0.9
+ 204586912993508866875824356051724947013540127877691549342705710506008362275292159680204380770369009821930417757972504438076078534117837065833032974335510p -0.3
+ 204586912993508866875824356051724947013540127877691549342705710506008362275292159680204380770369009821930417757972504438076078534117837065833032974336000p -0.3
+ 204586912993508866875824356051724947013540127877691549342705710506008362275292159680204380770369009821930417757972504438076078534117837065833032974336010p 0.9
+ \]
V_wl_bar_497 (WordLine_bar\\<497\\> gnd!) vsource type=pwl wave=\[
+ 0    0.9
+ 409173825987017733751648712103449894027080255755383098685411421012016724550584319360408761540738019643860835515945008876152157068235674131666065948671500p 0.9
+ 409173825987017733751648712103449894027080255755383098685411421012016724550584319360408761540738019643860835515945008876152157068235674131666065948671510p -0.3
+ 409173825987017733751648712103449894027080255755383098685411421012016724550584319360408761540738019643860835515945008876152157068235674131666065948672000p -0.3
+ 409173825987017733751648712103449894027080255755383098685411421012016724550584319360408761540738019643860835515945008876152157068235674131666065948672010p 0.9
+ \]
V_wl_bar_498 (WordLine_bar\\<498\\> gnd!) vsource type=pwl wave=\[
+ 0    0.9
+ 818347651974035467503297424206899788054160511510766197370822842024033449101168638720817523081476039287721671031890017752304314136471348263332131897343500p 0.9
+ 818347651974035467503297424206899788054160511510766197370822842024033449101168638720817523081476039287721671031890017752304314136471348263332131897343510p -0.3
+ 818347651974035467503297424206899788054160511510766197370822842024033449101168638720817523081476039287721671031890017752304314136471348263332131897344000p -0.3
+ 818347651974035467503297424206899788054160511510766197370822842024033449101168638720817523081476039287721671031890017752304314136471348263332131897344010p 0.9
+ \]
V_wl_bar_499 (WordLine_bar\\<499\\> gnd!) vsource type=pwl wave=\[
+ 0    0.9
+ 1636695303948070935006594848413799576108321023021532394741645684048066898202337277441635046162952078575443342063780035504608628272942696526664263794687500p 0.9
+ 1636695303948070935006594848413799576108321023021532394741645684048066898202337277441635046162952078575443342063780035504608628272942696526664263794687510p -0.3
+ 1636695303948070935006594848413799576108321023021532394741645684048066898202337277441635046162952078575443342063780035504608628272942696526664263794688000p -0.3
+ 1636695303948070935006594848413799576108321023021532394741645684048066898202337277441635046162952078575443342063780035504608628272942696526664263794688010p 0.9
+ \]
V_wl_bar_500 (WordLine_bar\\<500\\> gnd!) vsource type=pwl wave=\[
+ 0    0.9
+ 3273390607896141870013189696827599152216642046043064789483291368096133796404674554883270092325904157150886684127560071009217256545885393053328527589375500p 0.9
+ 3273390607896141870013189696827599152216642046043064789483291368096133796404674554883270092325904157150886684127560071009217256545885393053328527589375510p -0.3
+ 3273390607896141870013189696827599152216642046043064789483291368096133796404674554883270092325904157150886684127560071009217256545885393053328527589376000p -0.3
+ 3273390607896141870013189696827599152216642046043064789483291368096133796404674554883270092325904157150886684127560071009217256545885393053328527589376010p 0.9
+ \]
V_wl_bar_501 (WordLine_bar\\<501\\> gnd!) vsource type=pwl wave=\[
+ 0    0.9
+ 6546781215792283740026379393655198304433284092086129578966582736192267592809349109766540184651808314301773368255120142018434513091770786106657055178751500p 0.9
+ 6546781215792283740026379393655198304433284092086129578966582736192267592809349109766540184651808314301773368255120142018434513091770786106657055178751510p -0.3
+ 6546781215792283740026379393655198304433284092086129578966582736192267592809349109766540184651808314301773368255120142018434513091770786106657055178752000p -0.3
+ 6546781215792283740026379393655198304433284092086129578966582736192267592809349109766540184651808314301773368255120142018434513091770786106657055178752010p 0.9
+ \]
V_wl_bar_502 (WordLine_bar\\<502\\> gnd!) vsource type=pwl wave=\[
+ 0    0.9
+ 13093562431584567480052758787310396608866568184172259157933165472384535185618698219533080369303616628603546736510240284036869026183541572213314110357503500p 0.9
+ 13093562431584567480052758787310396608866568184172259157933165472384535185618698219533080369303616628603546736510240284036869026183541572213314110357503510p -0.3
+ 13093562431584567480052758787310396608866568184172259157933165472384535185618698219533080369303616628603546736510240284036869026183541572213314110357504000p -0.3
+ 13093562431584567480052758787310396608866568184172259157933165472384535185618698219533080369303616628603546736510240284036869026183541572213314110357504010p 0.9
+ \]
V_wl_bar_503 (WordLine_bar\\<503\\> gnd!) vsource type=pwl wave=\[
+ 0    0.9
+ 26187124863169134960105517574620793217733136368344518315866330944769070371237396439066160738607233257207093473020480568073738052367083144426628220715007500p 0.9
+ 26187124863169134960105517574620793217733136368344518315866330944769070371237396439066160738607233257207093473020480568073738052367083144426628220715007510p -0.3
+ 26187124863169134960105517574620793217733136368344518315866330944769070371237396439066160738607233257207093473020480568073738052367083144426628220715008000p -0.3
+ 26187124863169134960105517574620793217733136368344518315866330944769070371237396439066160738607233257207093473020480568073738052367083144426628220715008010p 0.9
+ \]
V_wl_bar_504 (WordLine_bar\\<504\\> gnd!) vsource type=pwl wave=\[
+ 0    0.9
+ 52374249726338269920211035149241586435466272736689036631732661889538140742474792878132321477214466514414186946040961136147476104734166288853256441430015500p 0.9
+ 52374249726338269920211035149241586435466272736689036631732661889538140742474792878132321477214466514414186946040961136147476104734166288853256441430015510p -0.3
+ 52374249726338269920211035149241586435466272736689036631732661889538140742474792878132321477214466514414186946040961136147476104734166288853256441430016000p -0.3
+ 52374249726338269920211035149241586435466272736689036631732661889538140742474792878132321477214466514414186946040961136147476104734166288853256441430016010p 0.9
+ \]
V_wl_bar_505 (WordLine_bar\\<505\\> gnd!) vsource type=pwl wave=\[
+ 0    0.9
+ 104748499452676539840422070298483172870932545473378073263465323779076281484949585756264642954428933028828373892081922272294952209468332577706512882860031500p 0.9
+ 104748499452676539840422070298483172870932545473378073263465323779076281484949585756264642954428933028828373892081922272294952209468332577706512882860031510p -0.3
+ 104748499452676539840422070298483172870932545473378073263465323779076281484949585756264642954428933028828373892081922272294952209468332577706512882860032000p -0.3
+ 104748499452676539840422070298483172870932545473378073263465323779076281484949585756264642954428933028828373892081922272294952209468332577706512882860032010p 0.9
+ \]
V_wl_bar_506 (WordLine_bar\\<506\\> gnd!) vsource type=pwl wave=\[
+ 0    0.9
+ 209496998905353079680844140596966345741865090946756146526930647558152562969899171512529285908857866057656747784163844544589904418936665155413025765720063500p 0.9
+ 209496998905353079680844140596966345741865090946756146526930647558152562969899171512529285908857866057656747784163844544589904418936665155413025765720063510p -0.3
+ 209496998905353079680844140596966345741865090946756146526930647558152562969899171512529285908857866057656747784163844544589904418936665155413025765720064000p -0.3
+ 209496998905353079680844140596966345741865090946756146526930647558152562969899171512529285908857866057656747784163844544589904418936665155413025765720064010p 0.9
+ \]
V_wl_bar_507 (WordLine_bar\\<507\\> gnd!) vsource type=pwl wave=\[
+ 0    0.9
+ 418993997810706159361688281193932691483730181893512293053861295116305125939798343025058571817715732115313495568327689089179808837873330310826051531440127500p 0.9
+ 418993997810706159361688281193932691483730181893512293053861295116305125939798343025058571817715732115313495568327689089179808837873330310826051531440127510p -0.3
+ 418993997810706159361688281193932691483730181893512293053861295116305125939798343025058571817715732115313495568327689089179808837873330310826051531440128000p -0.3
+ 418993997810706159361688281193932691483730181893512293053861295116305125939798343025058571817715732115313495568327689089179808837873330310826051531440128010p 0.9
+ \]
V_wl_bar_508 (WordLine_bar\\<508\\> gnd!) vsource type=pwl wave=\[
+ 0    0.9
+ 837987995621412318723376562387865382967460363787024586107722590232610251879596686050117143635431464230626991136655378178359617675746660621652103062880255500p 0.9
+ 837987995621412318723376562387865382967460363787024586107722590232610251879596686050117143635431464230626991136655378178359617675746660621652103062880255510p -0.3
+ 837987995621412318723376562387865382967460363787024586107722590232610251879596686050117143635431464230626991136655378178359617675746660621652103062880256000p -0.3
+ 837987995621412318723376562387865382967460363787024586107722590232610251879596686050117143635431464230626991136655378178359617675746660621652103062880256010p 0.9
+ \]
V_wl_bar_509 (WordLine_bar\\<509\\> gnd!) vsource type=pwl wave=\[
+ 0    0.9
+ 1675975991242824637446753124775730765934920727574049172215445180465220503759193372100234287270862928461253982273310756356719235351493321243304206125760511500p 0.9
+ 1675975991242824637446753124775730765934920727574049172215445180465220503759193372100234287270862928461253982273310756356719235351493321243304206125760511510p -0.3
+ 1675975991242824637446753124775730765934920727574049172215445180465220503759193372100234287270862928461253982273310756356719235351493321243304206125760512000p -0.3
+ 1675975991242824637446753124775730765934920727574049172215445180465220503759193372100234287270862928461253982273310756356719235351493321243304206125760512010p 0.9
+ \]
V_wl_bar_510 (WordLine_bar\\<510\\> gnd!) vsource type=pwl wave=\[
+ 0    0.9
+ 3351951982485649274893506249551461531869841455148098344430890360930441007518386744200468574541725856922507964546621512713438470702986642486608412251521023500p 0.9
+ 3351951982485649274893506249551461531869841455148098344430890360930441007518386744200468574541725856922507964546621512713438470702986642486608412251521023510p -0.3
+ 3351951982485649274893506249551461531869841455148098344430890360930441007518386744200468574541725856922507964546621512713438470702986642486608412251521024000p -0.3
+ 3351951982485649274893506249551461531869841455148098344430890360930441007518386744200468574541725856922507964546621512713438470702986642486608412251521024010p 0.9
+ \]
V_wl_bar_511 (WordLine_bar\\<511\\> gnd!) vsource type=pwl wave=\[
+ 0    0.9
+ 6703903964971298549787012499102923063739682910296196688861780721860882015036773488400937149083451713845015929093243025426876941405973284973216824503042047500p 0.9
+ 6703903964971298549787012499102923063739682910296196688861780721860882015036773488400937149083451713845015929093243025426876941405973284973216824503042047510p -0.3
+ 6703903964971298549787012499102923063739682910296196688861780721860882015036773488400937149083451713845015929093243025426876941405973284973216824503042048000p -0.3
+ 6703903964971298549787012499102923063739682910296196688861780721860882015036773488400937149083451713845015929093243025426876941405973284973216824503042048010p 0.9
+ \]
V_wl_bar_512 (WordLine_bar\\<512\\> gnd!) vsource type=pwl wave=\[
+ 0    0.9
+ 13407807929942597099574024998205846127479365820592393377723561443721764030073546976801874298166903427690031858186486050853753882811946569946433649006084095500p 0.9
+ 13407807929942597099574024998205846127479365820592393377723561443721764030073546976801874298166903427690031858186486050853753882811946569946433649006084095510p -0.3
+ 13407807929942597099574024998205846127479365820592393377723561443721764030073546976801874298166903427690031858186486050853753882811946569946433649006084096000p -0.3
+ 13407807929942597099574024998205846127479365820592393377723561443721764030073546976801874298166903427690031858186486050853753882811946569946433649006084096010p 0.9
+ \]
V_wl_bar_513 (WordLine_bar\\<513\\> gnd!) vsource type=pwl wave=\[
+ 0    0.9
+ 26815615859885194199148049996411692254958731641184786755447122887443528060147093953603748596333806855380063716372972101707507765623893139892867298012168191500p 0.9
+ 26815615859885194199148049996411692254958731641184786755447122887443528060147093953603748596333806855380063716372972101707507765623893139892867298012168191510p -0.3
+ 26815615859885194199148049996411692254958731641184786755447122887443528060147093953603748596333806855380063716372972101707507765623893139892867298012168192000p -0.3
+ 26815615859885194199148049996411692254958731641184786755447122887443528060147093953603748596333806855380063716372972101707507765623893139892867298012168192010p 0.9
+ \]
V_wl_bar_514 (WordLine_bar\\<514\\> gnd!) vsource type=pwl wave=\[
+ 0    0.9
+ 53631231719770388398296099992823384509917463282369573510894245774887056120294187907207497192667613710760127432745944203415015531247786279785734596024336383500p 0.9
+ 53631231719770388398296099992823384509917463282369573510894245774887056120294187907207497192667613710760127432745944203415015531247786279785734596024336383510p -0.3
+ 53631231719770388398296099992823384509917463282369573510894245774887056120294187907207497192667613710760127432745944203415015531247786279785734596024336384000p -0.3
+ 53631231719770388398296099992823384509917463282369573510894245774887056120294187907207497192667613710760127432745944203415015531247786279785734596024336384010p 0.9
+ \]
V_wl_bar_515 (WordLine_bar\\<515\\> gnd!) vsource type=pwl wave=\[
+ 0    0.9
+ 107262463439540776796592199985646769019834926564739147021788491549774112240588375814414994385335227421520254865491888406830031062495572559571469192048672767500p 0.9
+ 107262463439540776796592199985646769019834926564739147021788491549774112240588375814414994385335227421520254865491888406830031062495572559571469192048672767510p -0.3
+ 107262463439540776796592199985646769019834926564739147021788491549774112240588375814414994385335227421520254865491888406830031062495572559571469192048672768000p -0.3
+ 107262463439540776796592199985646769019834926564739147021788491549774112240588375814414994385335227421520254865491888406830031062495572559571469192048672768010p 0.9
+ \]
V_wl_bar_516 (WordLine_bar\\<516\\> gnd!) vsource type=pwl wave=\[
+ 0    0.9
+ 214524926879081553593184399971293538039669853129478294043576983099548224481176751628829988770670454843040509730983776813660062124991145119142938384097345535500p 0.9
+ 214524926879081553593184399971293538039669853129478294043576983099548224481176751628829988770670454843040509730983776813660062124991145119142938384097345535510p -0.3
+ 214524926879081553593184399971293538039669853129478294043576983099548224481176751628829988770670454843040509730983776813660062124991145119142938384097345536000p -0.3
+ 214524926879081553593184399971293538039669853129478294043576983099548224481176751628829988770670454843040509730983776813660062124991145119142938384097345536010p 0.9
+ \]
V_wl_bar_517 (WordLine_bar\\<517\\> gnd!) vsource type=pwl wave=\[
+ 0    0.9
+ 429049853758163107186368799942587076079339706258956588087153966199096448962353503257659977541340909686081019461967553627320124249982290238285876768194691071500p 0.9
+ 429049853758163107186368799942587076079339706258956588087153966199096448962353503257659977541340909686081019461967553627320124249982290238285876768194691071510p -0.3
+ 429049853758163107186368799942587076079339706258956588087153966199096448962353503257659977541340909686081019461967553627320124249982290238285876768194691072000p -0.3
+ 429049853758163107186368799942587076079339706258956588087153966199096448962353503257659977541340909686081019461967553627320124249982290238285876768194691072010p 0.9
+ \]
V_wl_bar_518 (WordLine_bar\\<518\\> gnd!) vsource type=pwl wave=\[
+ 0    0.9
+ 858099707516326214372737599885174152158679412517913176174307932398192897924707006515319955082681819372162038923935107254640248499964580476571753536389382143500p 0.9
+ 858099707516326214372737599885174152158679412517913176174307932398192897924707006515319955082681819372162038923935107254640248499964580476571753536389382143510p -0.3
+ 858099707516326214372737599885174152158679412517913176174307932398192897924707006515319955082681819372162038923935107254640248499964580476571753536389382144000p -0.3
+ 858099707516326214372737599885174152158679412517913176174307932398192897924707006515319955082681819372162038923935107254640248499964580476571753536389382144010p 0.9
+ \]
V_wl_bar_519 (WordLine_bar\\<519\\> gnd!) vsource type=pwl wave=\[
+ 0    0.9
+ 1716199415032652428745475199770348304317358825035826352348615864796385795849414013030639910165363638744324077847870214509280496999929160953143507072778764287500p 0.9
+ 1716199415032652428745475199770348304317358825035826352348615864796385795849414013030639910165363638744324077847870214509280496999929160953143507072778764287510p -0.3
+ 1716199415032652428745475199770348304317358825035826352348615864796385795849414013030639910165363638744324077847870214509280496999929160953143507072778764288000p -0.3
+ 1716199415032652428745475199770348304317358825035826352348615864796385795849414013030639910165363638744324077847870214509280496999929160953143507072778764288010p 0.9
+ \]
V_wl_bar_520 (WordLine_bar\\<520\\> gnd!) vsource type=pwl wave=\[
+ 0    0.9
+ 3432398830065304857490950399540696608634717650071652704697231729592771591698828026061279820330727277488648155695740429018560993999858321906287014145557528575500p 0.9
+ 3432398830065304857490950399540696608634717650071652704697231729592771591698828026061279820330727277488648155695740429018560993999858321906287014145557528575510p -0.3
+ 3432398830065304857490950399540696608634717650071652704697231729592771591698828026061279820330727277488648155695740429018560993999858321906287014145557528576000p -0.3
+ 3432398830065304857490950399540696608634717650071652704697231729592771591698828026061279820330727277488648155695740429018560993999858321906287014145557528576010p 0.9
+ \]
V_wl_bar_521 (WordLine_bar\\<521\\> gnd!) vsource type=pwl wave=\[
+ 0    0.9
+ 6864797660130609714981900799081393217269435300143305409394463459185543183397656052122559640661454554977296311391480858037121987999716643812574028291115057151500p 0.9
+ 6864797660130609714981900799081393217269435300143305409394463459185543183397656052122559640661454554977296311391480858037121987999716643812574028291115057151510p -0.3
+ 6864797660130609714981900799081393217269435300143305409394463459185543183397656052122559640661454554977296311391480858037121987999716643812574028291115057152000p -0.3
+ 6864797660130609714981900799081393217269435300143305409394463459185543183397656052122559640661454554977296311391480858037121987999716643812574028291115057152010p 0.9
+ \]
V_wl_bar_522 (WordLine_bar\\<522\\> gnd!) vsource type=pwl wave=\[
+ 0    0.9
+ 13729595320261219429963801598162786434538870600286610818788926918371086366795312104245119281322909109954592622782961716074243975999433287625148056582230114303500p 0.9
+ 13729595320261219429963801598162786434538870600286610818788926918371086366795312104245119281322909109954592622782961716074243975999433287625148056582230114303510p -0.3
+ 13729595320261219429963801598162786434538870600286610818788926918371086366795312104245119281322909109954592622782961716074243975999433287625148056582230114304000p -0.3
+ 13729595320261219429963801598162786434538870600286610818788926918371086366795312104245119281322909109954592622782961716074243975999433287625148056582230114304010p 0.9
+ \]
V_wl_bar_523 (WordLine_bar\\<523\\> gnd!) vsource type=pwl wave=\[
+ 0    0.9
+ 27459190640522438859927603196325572869077741200573221637577853836742172733590624208490238562645818219909185245565923432148487951998866575250296113164460228607500p 0.9
+ 27459190640522438859927603196325572869077741200573221637577853836742172733590624208490238562645818219909185245565923432148487951998866575250296113164460228607510p -0.3
+ 27459190640522438859927603196325572869077741200573221637577853836742172733590624208490238562645818219909185245565923432148487951998866575250296113164460228608000p -0.3
+ 27459190640522438859927603196325572869077741200573221637577853836742172733590624208490238562645818219909185245565923432148487951998866575250296113164460228608010p 0.9
+ \]
V_wl_bar_524 (WordLine_bar\\<524\\> gnd!) vsource type=pwl wave=\[
+ 0    0.9
+ 54918381281044877719855206392651145738155482401146443275155707673484345467181248416980477125291636439818370491131846864296975903997733150500592226328920457215500p 0.9
+ 54918381281044877719855206392651145738155482401146443275155707673484345467181248416980477125291636439818370491131846864296975903997733150500592226328920457215510p -0.3
+ 54918381281044877719855206392651145738155482401146443275155707673484345467181248416980477125291636439818370491131846864296975903997733150500592226328920457216000p -0.3
+ 54918381281044877719855206392651145738155482401146443275155707673484345467181248416980477125291636439818370491131846864296975903997733150500592226328920457216010p 0.9
+ \]
V_wl_bar_525 (WordLine_bar\\<525\\> gnd!) vsource type=pwl wave=\[
+ 0    0.9
+ 109836762562089755439710412785302291476310964802292886550311415346968690934362496833960954250583272879636740982263693728593951807995466301001184452657840914431500p 0.9
+ 109836762562089755439710412785302291476310964802292886550311415346968690934362496833960954250583272879636740982263693728593951807995466301001184452657840914431510p -0.3
+ 109836762562089755439710412785302291476310964802292886550311415346968690934362496833960954250583272879636740982263693728593951807995466301001184452657840914432000p -0.3
+ 109836762562089755439710412785302291476310964802292886550311415346968690934362496833960954250583272879636740982263693728593951807995466301001184452657840914432010p 0.9
+ \]
V_wl_bar_526 (WordLine_bar\\<526\\> gnd!) vsource type=pwl wave=\[
+ 0    0.9
+ 219673525124179510879420825570604582952621929604585773100622830693937381868724993667921908501166545759273481964527387457187903615990932602002368905315681828863500p 0.9
+ 219673525124179510879420825570604582952621929604585773100622830693937381868724993667921908501166545759273481964527387457187903615990932602002368905315681828863510p -0.3
+ 219673525124179510879420825570604582952621929604585773100622830693937381868724993667921908501166545759273481964527387457187903615990932602002368905315681828864000p -0.3
+ 219673525124179510879420825570604582952621929604585773100622830693937381868724993667921908501166545759273481964527387457187903615990932602002368905315681828864010p 0.9
+ \]
V_wl_bar_527 (WordLine_bar\\<527\\> gnd!) vsource type=pwl wave=\[
+ 0    0.9
+ 439347050248359021758841651141209165905243859209171546201245661387874763737449987335843817002333091518546963929054774914375807231981865204004737810631363657727500p 0.9
+ 439347050248359021758841651141209165905243859209171546201245661387874763737449987335843817002333091518546963929054774914375807231981865204004737810631363657727510p -0.3
+ 439347050248359021758841651141209165905243859209171546201245661387874763737449987335843817002333091518546963929054774914375807231981865204004737810631363657728000p -0.3
+ 439347050248359021758841651141209165905243859209171546201245661387874763737449987335843817002333091518546963929054774914375807231981865204004737810631363657728010p 0.9
+ \]
V_wl_bar_528 (WordLine_bar\\<528\\> gnd!) vsource type=pwl wave=\[
+ 0    0.9
+ 878694100496718043517683302282418331810487718418343092402491322775749527474899974671687634004666183037093927858109549828751614463963730408009475621262727315455500p 0.9
+ 878694100496718043517683302282418331810487718418343092402491322775749527474899974671687634004666183037093927858109549828751614463963730408009475621262727315455510p -0.3
+ 878694100496718043517683302282418331810487718418343092402491322775749527474899974671687634004666183037093927858109549828751614463963730408009475621262727315456000p -0.3
+ 878694100496718043517683302282418331810487718418343092402491322775749527474899974671687634004666183037093927858109549828751614463963730408009475621262727315456010p 0.9
+ \]
V_wl_bar_529 (WordLine_bar\\<529\\> gnd!) vsource type=pwl wave=\[
+ 0    0.9
+ 1757388200993436087035366604564836663620975436836686184804982645551499054949799949343375268009332366074187855716219099657503228927927460816018951242525454630911500p 0.9
+ 1757388200993436087035366604564836663620975436836686184804982645551499054949799949343375268009332366074187855716219099657503228927927460816018951242525454630911510p -0.3
+ 1757388200993436087035366604564836663620975436836686184804982645551499054949799949343375268009332366074187855716219099657503228927927460816018951242525454630912000p -0.3
+ 1757388200993436087035366604564836663620975436836686184804982645551499054949799949343375268009332366074187855716219099657503228927927460816018951242525454630912010p 0.9
+ \]
V_wl_bar_530 (WordLine_bar\\<530\\> gnd!) vsource type=pwl wave=\[
+ 0    0.9
+ 3514776401986872174070733209129673327241950873673372369609965291102998109899599898686750536018664732148375711432438199315006457855854921632037902485050909261823500p 0.9
+ 3514776401986872174070733209129673327241950873673372369609965291102998109899599898686750536018664732148375711432438199315006457855854921632037902485050909261823510p -0.3
+ 3514776401986872174070733209129673327241950873673372369609965291102998109899599898686750536018664732148375711432438199315006457855854921632037902485050909261824000p -0.3
+ 3514776401986872174070733209129673327241950873673372369609965291102998109899599898686750536018664732148375711432438199315006457855854921632037902485050909261824010p 0.9
+ \]
V_wl_bar_531 (WordLine_bar\\<531\\> gnd!) vsource type=pwl wave=\[
+ 0    0.9
+ 7029552803973744348141466418259346654483901747346744739219930582205996219799199797373501072037329464296751422864876398630012915711709843264075804970101818523647500p 0.9
+ 7029552803973744348141466418259346654483901747346744739219930582205996219799199797373501072037329464296751422864876398630012915711709843264075804970101818523647510p -0.3
+ 7029552803973744348141466418259346654483901747346744739219930582205996219799199797373501072037329464296751422864876398630012915711709843264075804970101818523648000p -0.3
+ 7029552803973744348141466418259346654483901747346744739219930582205996219799199797373501072037329464296751422864876398630012915711709843264075804970101818523648010p 0.9
+ \]
V_wl_bar_532 (WordLine_bar\\<532\\> gnd!) vsource type=pwl wave=\[
+ 0    0.9
+ 14059105607947488696282932836518693308967803494693489478439861164411992439598399594747002144074658928593502845729752797260025831423419686528151609940203637047295500p 0.9
+ 14059105607947488696282932836518693308967803494693489478439861164411992439598399594747002144074658928593502845729752797260025831423419686528151609940203637047295510p -0.3
+ 14059105607947488696282932836518693308967803494693489478439861164411992439598399594747002144074658928593502845729752797260025831423419686528151609940203637047296000p -0.3
+ 14059105607947488696282932836518693308967803494693489478439861164411992439598399594747002144074658928593502845729752797260025831423419686528151609940203637047296010p 0.9
+ \]
V_wl_bar_533 (WordLine_bar\\<533\\> gnd!) vsource type=pwl wave=\[
+ 0    0.9
+ 28118211215894977392565865673037386617935606989386978956879722328823984879196799189494004288149317857187005691459505594520051662846839373056303219880407274094591500p 0.9
+ 28118211215894977392565865673037386617935606989386978956879722328823984879196799189494004288149317857187005691459505594520051662846839373056303219880407274094591510p -0.3
+ 28118211215894977392565865673037386617935606989386978956879722328823984879196799189494004288149317857187005691459505594520051662846839373056303219880407274094592000p -0.3
+ 28118211215894977392565865673037386617935606989386978956879722328823984879196799189494004288149317857187005691459505594520051662846839373056303219880407274094592010p 0.9
+ \]
V_wl_bar_534 (WordLine_bar\\<534\\> gnd!) vsource type=pwl wave=\[
+ 0    0.9
+ 56236422431789954785131731346074773235871213978773957913759444657647969758393598378988008576298635714374011382919011189040103325693678746112606439760814548189183500p 0.9
+ 56236422431789954785131731346074773235871213978773957913759444657647969758393598378988008576298635714374011382919011189040103325693678746112606439760814548189183510p -0.3
+ 56236422431789954785131731346074773235871213978773957913759444657647969758393598378988008576298635714374011382919011189040103325693678746112606439760814548189184000p -0.3
+ 56236422431789954785131731346074773235871213978773957913759444657647969758393598378988008576298635714374011382919011189040103325693678746112606439760814548189184010p 0.9
+ \]
V_wl_bar_535 (WordLine_bar\\<535\\> gnd!) vsource type=pwl wave=\[
+ 0    0.9
+ 112472844863579909570263462692149546471742427957547915827518889315295939516787196757976017152597271428748022765838022378080206651387357492225212879521629096378367500p 0.9
+ 112472844863579909570263462692149546471742427957547915827518889315295939516787196757976017152597271428748022765838022378080206651387357492225212879521629096378367510p -0.3
+ 112472844863579909570263462692149546471742427957547915827518889315295939516787196757976017152597271428748022765838022378080206651387357492225212879521629096378368000p -0.3
+ 112472844863579909570263462692149546471742427957547915827518889315295939516787196757976017152597271428748022765838022378080206651387357492225212879521629096378368010p 0.9
+ \]
V_wl_bar_536 (WordLine_bar\\<536\\> gnd!) vsource type=pwl wave=\[
+ 0    0.9
+ 224945689727159819140526925384299092943484855915095831655037778630591879033574393515952034305194542857496045531676044756160413302774714984450425759043258192756735500p 0.9
+ 224945689727159819140526925384299092943484855915095831655037778630591879033574393515952034305194542857496045531676044756160413302774714984450425759043258192756735510p -0.3
+ 224945689727159819140526925384299092943484855915095831655037778630591879033574393515952034305194542857496045531676044756160413302774714984450425759043258192756736000p -0.3
+ 224945689727159819140526925384299092943484855915095831655037778630591879033574393515952034305194542857496045531676044756160413302774714984450425759043258192756736010p 0.9
+ \]
V_wl_bar_537 (WordLine_bar\\<537\\> gnd!) vsource type=pwl wave=\[
+ 0    0.9
+ 449891379454319638281053850768598185886969711830191663310075557261183758067148787031904068610389085714992091063352089512320826605549429968900851518086516385513471500p 0.9
+ 449891379454319638281053850768598185886969711830191663310075557261183758067148787031904068610389085714992091063352089512320826605549429968900851518086516385513471510p -0.3
+ 449891379454319638281053850768598185886969711830191663310075557261183758067148787031904068610389085714992091063352089512320826605549429968900851518086516385513472000p -0.3
+ 449891379454319638281053850768598185886969711830191663310075557261183758067148787031904068610389085714992091063352089512320826605549429968900851518086516385513472010p 0.9
+ \]
V_wl_bar_538 (WordLine_bar\\<538\\> gnd!) vsource type=pwl wave=\[
+ 0    0.9
+ 899782758908639276562107701537196371773939423660383326620151114522367516134297574063808137220778171429984182126704179024641653211098859937801703036173032771026943500p 0.9
+ 899782758908639276562107701537196371773939423660383326620151114522367516134297574063808137220778171429984182126704179024641653211098859937801703036173032771026943510p -0.3
+ 899782758908639276562107701537196371773939423660383326620151114522367516134297574063808137220778171429984182126704179024641653211098859937801703036173032771026944000p -0.3
+ 899782758908639276562107701537196371773939423660383326620151114522367516134297574063808137220778171429984182126704179024641653211098859937801703036173032771026944010p 0.9
+ \]
V_wl_bar_539 (WordLine_bar\\<539\\> gnd!) vsource type=pwl wave=\[
+ 0    0.9
+ 1799565517817278553124215403074392743547878847320766653240302229044735032268595148127616274441556342859968364253408358049283306422197719875603406072346065542053887500p 0.9
+ 1799565517817278553124215403074392743547878847320766653240302229044735032268595148127616274441556342859968364253408358049283306422197719875603406072346065542053887510p -0.3
+ 1799565517817278553124215403074392743547878847320766653240302229044735032268595148127616274441556342859968364253408358049283306422197719875603406072346065542053888000p -0.3
+ 1799565517817278553124215403074392743547878847320766653240302229044735032268595148127616274441556342859968364253408358049283306422197719875603406072346065542053888010p 0.9
+ \]
V_wl_bar_540 (WordLine_bar\\<540\\> gnd!) vsource type=pwl wave=\[
+ 0    0.9
+ 3599131035634557106248430806148785487095757694641533306480604458089470064537190296255232548883112685719936728506816716098566612844395439751206812144692131084107775500p 0.9
+ 3599131035634557106248430806148785487095757694641533306480604458089470064537190296255232548883112685719936728506816716098566612844395439751206812144692131084107775510p -0.3
+ 3599131035634557106248430806148785487095757694641533306480604458089470064537190296255232548883112685719936728506816716098566612844395439751206812144692131084107776000p -0.3
+ 3599131035634557106248430806148785487095757694641533306480604458089470064537190296255232548883112685719936728506816716098566612844395439751206812144692131084107776010p 0.9
+ \]
V_wl_bar_541 (WordLine_bar\\<541\\> gnd!) vsource type=pwl wave=\[
+ 0    0.9
+ 7198262071269114212496861612297570974191515389283066612961208916178940129074380592510465097766225371439873457013633432197133225688790879502413624289384262168215551500p 0.9
+ 7198262071269114212496861612297570974191515389283066612961208916178940129074380592510465097766225371439873457013633432197133225688790879502413624289384262168215551510p -0.3
+ 7198262071269114212496861612297570974191515389283066612961208916178940129074380592510465097766225371439873457013633432197133225688790879502413624289384262168215552000p -0.3
+ 7198262071269114212496861612297570974191515389283066612961208916178940129074380592510465097766225371439873457013633432197133225688790879502413624289384262168215552010p 0.9
+ \]
V_wl_bar_542 (WordLine_bar\\<542\\> gnd!) vsource type=pwl wave=\[
+ 0    0.9
+ 14396524142538228424993723224595141948383030778566133225922417832357880258148761185020930195532450742879746914027266864394266451377581759004827248578768524336431103500p 0.9
+ 14396524142538228424993723224595141948383030778566133225922417832357880258148761185020930195532450742879746914027266864394266451377581759004827248578768524336431103510p -0.3
+ 14396524142538228424993723224595141948383030778566133225922417832357880258148761185020930195532450742879746914027266864394266451377581759004827248578768524336431104000p -0.3
+ 14396524142538228424993723224595141948383030778566133225922417832357880258148761185020930195532450742879746914027266864394266451377581759004827248578768524336431104010p 0.9
+ \]
V_wl_bar_543 (WordLine_bar\\<543\\> gnd!) vsource type=pwl wave=\[
+ 0    0.9
+ 28793048285076456849987446449190283896766061557132266451844835664715760516297522370041860391064901485759493828054533728788532902755163518009654497157537048672862207500p 0.9
+ 28793048285076456849987446449190283896766061557132266451844835664715760516297522370041860391064901485759493828054533728788532902755163518009654497157537048672862207510p -0.3
+ 28793048285076456849987446449190283896766061557132266451844835664715760516297522370041860391064901485759493828054533728788532902755163518009654497157537048672862208000p -0.3
+ 28793048285076456849987446449190283896766061557132266451844835664715760516297522370041860391064901485759493828054533728788532902755163518009654497157537048672862208010p 0.9
+ \]
V_wl_bar_544 (WordLine_bar\\<544\\> gnd!) vsource type=pwl wave=\[
+ 0    0.9
+ 57586096570152913699974892898380567793532123114264532903689671329431521032595044740083720782129802971518987656109067457577065805510327036019308994315074097345724415500p 0.9
+ 57586096570152913699974892898380567793532123114264532903689671329431521032595044740083720782129802971518987656109067457577065805510327036019308994315074097345724415510p -0.3
+ 57586096570152913699974892898380567793532123114264532903689671329431521032595044740083720782129802971518987656109067457577065805510327036019308994315074097345724416000p -0.3
+ 57586096570152913699974892898380567793532123114264532903689671329431521032595044740083720782129802971518987656109067457577065805510327036019308994315074097345724416010p 0.9
+ \]
V_wl_bar_545 (WordLine_bar\\<545\\> gnd!) vsource type=pwl wave=\[
+ 0    0.9
+ 115172193140305827399949785796761135587064246228529065807379342658863042065190089480167441564259605943037975312218134915154131611020654072038617988630148194691448831500p 0.9
+ 115172193140305827399949785796761135587064246228529065807379342658863042065190089480167441564259605943037975312218134915154131611020654072038617988630148194691448831510p -0.3
+ 115172193140305827399949785796761135587064246228529065807379342658863042065190089480167441564259605943037975312218134915154131611020654072038617988630148194691448832000p -0.3
+ 115172193140305827399949785796761135587064246228529065807379342658863042065190089480167441564259605943037975312218134915154131611020654072038617988630148194691448832010p 0.9
+ \]
V_wl_bar_546 (WordLine_bar\\<546\\> gnd!) vsource type=pwl wave=\[
+ 0    0.9
+ 230344386280611654799899571593522271174128492457058131614758685317726084130380178960334883128519211886075950624436269830308263222041308144077235977260296389382897663500p 0.9
+ 230344386280611654799899571593522271174128492457058131614758685317726084130380178960334883128519211886075950624436269830308263222041308144077235977260296389382897663510p -0.3
+ 230344386280611654799899571593522271174128492457058131614758685317726084130380178960334883128519211886075950624436269830308263222041308144077235977260296389382897664000p -0.3
+ 230344386280611654799899571593522271174128492457058131614758685317726084130380178960334883128519211886075950624436269830308263222041308144077235977260296389382897664010p 0.9
+ \]
V_wl_bar_547 (WordLine_bar\\<547\\> gnd!) vsource type=pwl wave=\[
+ 0    0.9
+ 460688772561223309599799143187044542348256984914116263229517370635452168260760357920669766257038423772151901248872539660616526444082616288154471954520592778765795327500p 0.9
+ 460688772561223309599799143187044542348256984914116263229517370635452168260760357920669766257038423772151901248872539660616526444082616288154471954520592778765795327510p -0.3
+ 460688772561223309599799143187044542348256984914116263229517370635452168260760357920669766257038423772151901248872539660616526444082616288154471954520592778765795328000p -0.3
+ 460688772561223309599799143187044542348256984914116263229517370635452168260760357920669766257038423772151901248872539660616526444082616288154471954520592778765795328010p 0.9
+ \]
V_wl_bar_548 (WordLine_bar\\<548\\> gnd!) vsource type=pwl wave=\[
+ 0    0.9
+ 921377545122446619199598286374089084696513969828232526459034741270904336521520715841339532514076847544303802497745079321233052888165232576308943909041185557531590655500p 0.9
+ 921377545122446619199598286374089084696513969828232526459034741270904336521520715841339532514076847544303802497745079321233052888165232576308943909041185557531590655510p -0.3
+ 921377545122446619199598286374089084696513969828232526459034741270904336521520715841339532514076847544303802497745079321233052888165232576308943909041185557531590656000p -0.3
+ 921377545122446619199598286374089084696513969828232526459034741270904336521520715841339532514076847544303802497745079321233052888165232576308943909041185557531590656010p 0.9
+ \]
V_wl_bar_549 (WordLine_bar\\<549\\> gnd!) vsource type=pwl wave=\[
+ 0    0.9
+ 1842755090244893238399196572748178169393027939656465052918069482541808673043041431682679065028153695088607604995490158642466105776330465152617887818082371115063181311500p 0.9
+ 1842755090244893238399196572748178169393027939656465052918069482541808673043041431682679065028153695088607604995490158642466105776330465152617887818082371115063181311510p -0.3
+ 1842755090244893238399196572748178169393027939656465052918069482541808673043041431682679065028153695088607604995490158642466105776330465152617887818082371115063181312000p -0.3
+ 1842755090244893238399196572748178169393027939656465052918069482541808673043041431682679065028153695088607604995490158642466105776330465152617887818082371115063181312010p 0.9
+ \]
V_wl_bar_550 (WordLine_bar\\<550\\> gnd!) vsource type=pwl wave=\[
+ 0    0.9
+ 3685510180489786476798393145496356338786055879312930105836138965083617346086082863365358130056307390177215209990980317284932211552660930305235775636164742230126362623500p 0.9
+ 3685510180489786476798393145496356338786055879312930105836138965083617346086082863365358130056307390177215209990980317284932211552660930305235775636164742230126362623510p -0.3
+ 3685510180489786476798393145496356338786055879312930105836138965083617346086082863365358130056307390177215209990980317284932211552660930305235775636164742230126362624000p -0.3
+ 3685510180489786476798393145496356338786055879312930105836138965083617346086082863365358130056307390177215209990980317284932211552660930305235775636164742230126362624010p 0.9
+ \]
V_wl_bar_551 (WordLine_bar\\<551\\> gnd!) vsource type=pwl wave=\[
+ 0    0.9
+ 7371020360979572953596786290992712677572111758625860211672277930167234692172165726730716260112614780354430419981960634569864423105321860610471551272329484460252725247500p 0.9
+ 7371020360979572953596786290992712677572111758625860211672277930167234692172165726730716260112614780354430419981960634569864423105321860610471551272329484460252725247510p -0.3
+ 7371020360979572953596786290992712677572111758625860211672277930167234692172165726730716260112614780354430419981960634569864423105321860610471551272329484460252725248000p -0.3
+ 7371020360979572953596786290992712677572111758625860211672277930167234692172165726730716260112614780354430419981960634569864423105321860610471551272329484460252725248010p 0.9
+ \]
V_wl_bar_552 (WordLine_bar\\<552\\> gnd!) vsource type=pwl wave=\[
+ 0    0.9
+ 14742040721959145907193572581985425355144223517251720423344555860334469384344331453461432520225229560708860839963921269139728846210643721220943102544658968920505450495500p 0.9
+ 14742040721959145907193572581985425355144223517251720423344555860334469384344331453461432520225229560708860839963921269139728846210643721220943102544658968920505450495510p -0.3
+ 14742040721959145907193572581985425355144223517251720423344555860334469384344331453461432520225229560708860839963921269139728846210643721220943102544658968920505450496000p -0.3
+ 14742040721959145907193572581985425355144223517251720423344555860334469384344331453461432520225229560708860839963921269139728846210643721220943102544658968920505450496010p 0.9
+ \]
V_wl_bar_553 (WordLine_bar\\<553\\> gnd!) vsource type=pwl wave=\[
+ 0    0.9
+ 29484081443918291814387145163970850710288447034503440846689111720668938768688662906922865040450459121417721679927842538279457692421287442441886205089317937841010900991500p 0.9
+ 29484081443918291814387145163970850710288447034503440846689111720668938768688662906922865040450459121417721679927842538279457692421287442441886205089317937841010900991510p -0.3
+ 29484081443918291814387145163970850710288447034503440846689111720668938768688662906922865040450459121417721679927842538279457692421287442441886205089317937841010900992000p -0.3
+ 29484081443918291814387145163970850710288447034503440846689111720668938768688662906922865040450459121417721679927842538279457692421287442441886205089317937841010900992010p 0.9
+ \]
V_wl_bar_554 (WordLine_bar\\<554\\> gnd!) vsource type=pwl wave=\[
+ 0    0.9
+ 58968162887836583628774290327941701420576894069006881693378223441337877537377325813845730080900918242835443359855685076558915384842574884883772410178635875682021801983500p 0.9
+ 58968162887836583628774290327941701420576894069006881693378223441337877537377325813845730080900918242835443359855685076558915384842574884883772410178635875682021801983510p -0.3
+ 58968162887836583628774290327941701420576894069006881693378223441337877537377325813845730080900918242835443359855685076558915384842574884883772410178635875682021801984000p -0.3
+ 58968162887836583628774290327941701420576894069006881693378223441337877537377325813845730080900918242835443359855685076558915384842574884883772410178635875682021801984010p 0.9
+ \]
V_wl_bar_555 (WordLine_bar\\<555\\> gnd!) vsource type=pwl wave=\[
+ 0    0.9
+ 117936325775673167257548580655883402841153788138013763386756446882675755074754651627691460161801836485670886719711370153117830769685149769767544820357271751364043603967500p 0.9
+ 117936325775673167257548580655883402841153788138013763386756446882675755074754651627691460161801836485670886719711370153117830769685149769767544820357271751364043603967510p -0.3
+ 117936325775673167257548580655883402841153788138013763386756446882675755074754651627691460161801836485670886719711370153117830769685149769767544820357271751364043603968000p -0.3
+ 117936325775673167257548580655883402841153788138013763386756446882675755074754651627691460161801836485670886719711370153117830769685149769767544820357271751364043603968010p 0.9
+ \]
V_wl_bar_556 (WordLine_bar\\<556\\> gnd!) vsource type=pwl wave=\[
+ 0    0.9
+ 235872651551346334515097161311766805682307576276027526773512893765351510149509303255382920323603672971341773439422740306235661539370299539535089640714543502728087207935500p 0.9
+ 235872651551346334515097161311766805682307576276027526773512893765351510149509303255382920323603672971341773439422740306235661539370299539535089640714543502728087207935510p -0.3
+ 235872651551346334515097161311766805682307576276027526773512893765351510149509303255382920323603672971341773439422740306235661539370299539535089640714543502728087207936000p -0.3
+ 235872651551346334515097161311766805682307576276027526773512893765351510149509303255382920323603672971341773439422740306235661539370299539535089640714543502728087207936010p 0.9
+ \]
V_wl_bar_557 (WordLine_bar\\<557\\> gnd!) vsource type=pwl wave=\[
+ 0    0.9
+ 471745303102692669030194322623533611364615152552055053547025787530703020299018606510765840647207345942683546878845480612471323078740599079070179281429087005456174415871500p 0.9
+ 471745303102692669030194322623533611364615152552055053547025787530703020299018606510765840647207345942683546878845480612471323078740599079070179281429087005456174415871510p -0.3
+ 471745303102692669030194322623533611364615152552055053547025787530703020299018606510765840647207345942683546878845480612471323078740599079070179281429087005456174415872000p -0.3
+ 471745303102692669030194322623533611364615152552055053547025787530703020299018606510765840647207345942683546878845480612471323078740599079070179281429087005456174415872010p 0.9
+ \]
V_wl_bar_558 (WordLine_bar\\<558\\> gnd!) vsource type=pwl wave=\[
+ 0    0.9
+ 943490606205385338060388645247067222729230305104110107094051575061406040598037213021531681294414691885367093757690961224942646157481198158140358562858174010912348831743500p 0.9
+ 943490606205385338060388645247067222729230305104110107094051575061406040598037213021531681294414691885367093757690961224942646157481198158140358562858174010912348831743510p -0.3
+ 943490606205385338060388645247067222729230305104110107094051575061406040598037213021531681294414691885367093757690961224942646157481198158140358562858174010912348831744000p -0.3
+ 943490606205385338060388645247067222729230305104110107094051575061406040598037213021531681294414691885367093757690961224942646157481198158140358562858174010912348831744010p 0.9
+ \]
V_wl_bar_559 (WordLine_bar\\<559\\> gnd!) vsource type=pwl wave=\[
+ 0    0.9
+ 1886981212410770676120777290494134445458460610208220214188103150122812081196074426043063362588829383770734187515381922449885292314962396316280717125716348021824697663487500p 0.9
+ 1886981212410770676120777290494134445458460610208220214188103150122812081196074426043063362588829383770734187515381922449885292314962396316280717125716348021824697663487510p -0.3
+ 1886981212410770676120777290494134445458460610208220214188103150122812081196074426043063362588829383770734187515381922449885292314962396316280717125716348021824697663488000p -0.3
+ 1886981212410770676120777290494134445458460610208220214188103150122812081196074426043063362588829383770734187515381922449885292314962396316280717125716348021824697663488010p 0.9
+ \]
V_wl_bar_560 (WordLine_bar\\<560\\> gnd!) vsource type=pwl wave=\[
+ 0    0.9
+ 3773962424821541352241554580988268890916921220416440428376206300245624162392148852086126725177658767541468375030763844899770584629924792632561434251432696043649395326975500p 0.9
+ 3773962424821541352241554580988268890916921220416440428376206300245624162392148852086126725177658767541468375030763844899770584629924792632561434251432696043649395326975510p -0.3
+ 3773962424821541352241554580988268890916921220416440428376206300245624162392148852086126725177658767541468375030763844899770584629924792632561434251432696043649395326976000p -0.3
+ 3773962424821541352241554580988268890916921220416440428376206300245624162392148852086126725177658767541468375030763844899770584629924792632561434251432696043649395326976010p 0.9
+ \]
V_wl_bar_561 (WordLine_bar\\<561\\> gnd!) vsource type=pwl wave=\[
+ 0    0.9
+ 7547924849643082704483109161976537781833842440832880856752412600491248324784297704172253450355317535082936750061527689799541169259849585265122868502865392087298790653951500p 0.9
+ 7547924849643082704483109161976537781833842440832880856752412600491248324784297704172253450355317535082936750061527689799541169259849585265122868502865392087298790653951510p -0.3
+ 7547924849643082704483109161976537781833842440832880856752412600491248324784297704172253450355317535082936750061527689799541169259849585265122868502865392087298790653952000p -0.3
+ 7547924849643082704483109161976537781833842440832880856752412600491248324784297704172253450355317535082936750061527689799541169259849585265122868502865392087298790653952010p 0.9
+ \]
V_wl_bar_562 (WordLine_bar\\<562\\> gnd!) vsource type=pwl wave=\[
+ 0    0.9
+ 15095849699286165408966218323953075563667684881665761713504825200982496649568595408344506900710635070165873500123055379599082338519699170530245737005730784174597581307903500p 0.9
+ 15095849699286165408966218323953075563667684881665761713504825200982496649568595408344506900710635070165873500123055379599082338519699170530245737005730784174597581307903510p -0.3
+ 15095849699286165408966218323953075563667684881665761713504825200982496649568595408344506900710635070165873500123055379599082338519699170530245737005730784174597581307904000p -0.3
+ 15095849699286165408966218323953075563667684881665761713504825200982496649568595408344506900710635070165873500123055379599082338519699170530245737005730784174597581307904010p 0.9
+ \]
V_wl_bar_563 (WordLine_bar\\<563\\> gnd!) vsource type=pwl wave=\[
+ 0    0.9
+ 30191699398572330817932436647906151127335369763331523427009650401964993299137190816689013801421270140331747000246110759198164677039398341060491474011461568349195162615807500p 0.9
+ 30191699398572330817932436647906151127335369763331523427009650401964993299137190816689013801421270140331747000246110759198164677039398341060491474011461568349195162615807510p -0.3
+ 30191699398572330817932436647906151127335369763331523427009650401964993299137190816689013801421270140331747000246110759198164677039398341060491474011461568349195162615808000p -0.3
+ 30191699398572330817932436647906151127335369763331523427009650401964993299137190816689013801421270140331747000246110759198164677039398341060491474011461568349195162615808010p 0.9
+ \]
V_wl_bar_564 (WordLine_bar\\<564\\> gnd!) vsource type=pwl wave=\[
+ 0    0.9
+ 60383398797144661635864873295812302254670739526663046854019300803929986598274381633378027602842540280663494000492221518396329354078796682120982948022923136698390325231615500p 0.9
+ 60383398797144661635864873295812302254670739526663046854019300803929986598274381633378027602842540280663494000492221518396329354078796682120982948022923136698390325231615510p -0.3
+ 60383398797144661635864873295812302254670739526663046854019300803929986598274381633378027602842540280663494000492221518396329354078796682120982948022923136698390325231616000p -0.3
+ 60383398797144661635864873295812302254670739526663046854019300803929986598274381633378027602842540280663494000492221518396329354078796682120982948022923136698390325231616010p 0.9
+ \]
V_wl_bar_565 (WordLine_bar\\<565\\> gnd!) vsource type=pwl wave=\[
+ 0    0.9
+ 120766797594289323271729746591624604509341479053326093708038601607859973196548763266756055205685080561326988000984443036792658708157593364241965896045846273396780650463231500p 0.9
+ 120766797594289323271729746591624604509341479053326093708038601607859973196548763266756055205685080561326988000984443036792658708157593364241965896045846273396780650463231510p -0.3
+ 120766797594289323271729746591624604509341479053326093708038601607859973196548763266756055205685080561326988000984443036792658708157593364241965896045846273396780650463232000p -0.3
+ 120766797594289323271729746591624604509341479053326093708038601607859973196548763266756055205685080561326988000984443036792658708157593364241965896045846273396780650463232010p 0.9
+ \]
V_wl_bar_566 (WordLine_bar\\<566\\> gnd!) vsource type=pwl wave=\[
+ 0    0.9
+ 241533595188578646543459493183249209018682958106652187416077203215719946393097526533512110411370161122653976001968886073585317416315186728483931792091692546793561300926463500p 0.9
+ 241533595188578646543459493183249209018682958106652187416077203215719946393097526533512110411370161122653976001968886073585317416315186728483931792091692546793561300926463510p -0.3
+ 241533595188578646543459493183249209018682958106652187416077203215719946393097526533512110411370161122653976001968886073585317416315186728483931792091692546793561300926464000p -0.3
+ 241533595188578646543459493183249209018682958106652187416077203215719946393097526533512110411370161122653976001968886073585317416315186728483931792091692546793561300926464010p 0.9
+ \]
V_wl_bar_567 (WordLine_bar\\<567\\> gnd!) vsource type=pwl wave=\[
+ 0    0.9
+ 483067190377157293086918986366498418037365916213304374832154406431439892786195053067024220822740322245307952003937772147170634832630373456967863584183385093587122601852927500p 0.9
+ 483067190377157293086918986366498418037365916213304374832154406431439892786195053067024220822740322245307952003937772147170634832630373456967863584183385093587122601852927510p -0.3
+ 483067190377157293086918986366498418037365916213304374832154406431439892786195053067024220822740322245307952003937772147170634832630373456967863584183385093587122601852928000p -0.3
+ 483067190377157293086918986366498418037365916213304374832154406431439892786195053067024220822740322245307952003937772147170634832630373456967863584183385093587122601852928010p 0.9
+ \]
V_wl_bar_568 (WordLine_bar\\<568\\> gnd!) vsource type=pwl wave=\[
+ 0    0.9
+ 966134380754314586173837972732996836074731832426608749664308812862879785572390106134048441645480644490615904007875544294341269665260746913935727168366770187174245203705855500p 0.9
+ 966134380754314586173837972732996836074731832426608749664308812862879785572390106134048441645480644490615904007875544294341269665260746913935727168366770187174245203705855510p -0.3
+ 966134380754314586173837972732996836074731832426608749664308812862879785572390106134048441645480644490615904007875544294341269665260746913935727168366770187174245203705856000p -0.3
+ 966134380754314586173837972732996836074731832426608749664308812862879785572390106134048441645480644490615904007875544294341269665260746913935727168366770187174245203705856010p 0.9
+ \]
V_wl_bar_569 (WordLine_bar\\<569\\> gnd!) vsource type=pwl wave=\[
+ 0    0.9
+ 1932268761508629172347675945465993672149463664853217499328617625725759571144780212268096883290961288981231808015751088588682539330521493827871454336733540374348490407411711500p 0.9
+ 1932268761508629172347675945465993672149463664853217499328617625725759571144780212268096883290961288981231808015751088588682539330521493827871454336733540374348490407411711510p -0.3
+ 1932268761508629172347675945465993672149463664853217499328617625725759571144780212268096883290961288981231808015751088588682539330521493827871454336733540374348490407411712000p -0.3
+ 1932268761508629172347675945465993672149463664853217499328617625725759571144780212268096883290961288981231808015751088588682539330521493827871454336733540374348490407411712010p 0.9
+ \]
V_wl_bar_570 (WordLine_bar\\<570\\> gnd!) vsource type=pwl wave=\[
+ 0    0.9
+ 3864537523017258344695351890931987344298927329706434998657235251451519142289560424536193766581922577962463616031502177177365078661042987655742908673467080748696980814823423500p 0.9
+ 3864537523017258344695351890931987344298927329706434998657235251451519142289560424536193766581922577962463616031502177177365078661042987655742908673467080748696980814823423510p -0.3
+ 3864537523017258344695351890931987344298927329706434998657235251451519142289560424536193766581922577962463616031502177177365078661042987655742908673467080748696980814823424000p -0.3
+ 3864537523017258344695351890931987344298927329706434998657235251451519142289560424536193766581922577962463616031502177177365078661042987655742908673467080748696980814823424010p 0.9
+ \]
V_wl_bar_571 (WordLine_bar\\<571\\> gnd!) vsource type=pwl wave=\[
+ 0    0.9
+ 7729075046034516689390703781863974688597854659412869997314470502903038284579120849072387533163845155924927232063004354354730157322085975311485817346934161497393961629646847500p 0.9
+ 7729075046034516689390703781863974688597854659412869997314470502903038284579120849072387533163845155924927232063004354354730157322085975311485817346934161497393961629646847510p -0.3
+ 7729075046034516689390703781863974688597854659412869997314470502903038284579120849072387533163845155924927232063004354354730157322085975311485817346934161497393961629646848000p -0.3
+ 7729075046034516689390703781863974688597854659412869997314470502903038284579120849072387533163845155924927232063004354354730157322085975311485817346934161497393961629646848010p 0.9
+ \]
V_wl_bar_572 (WordLine_bar\\<572\\> gnd!) vsource type=pwl wave=\[
+ 0    0.9
+ 15458150092069033378781407563727949377195709318825739994628941005806076569158241698144775066327690311849854464126008708709460314644171950622971634693868322994787923259293695500p 0.9
+ 15458150092069033378781407563727949377195709318825739994628941005806076569158241698144775066327690311849854464126008708709460314644171950622971634693868322994787923259293695510p -0.3
+ 15458150092069033378781407563727949377195709318825739994628941005806076569158241698144775066327690311849854464126008708709460314644171950622971634693868322994787923259293696000p -0.3
+ 15458150092069033378781407563727949377195709318825739994628941005806076569158241698144775066327690311849854464126008708709460314644171950622971634693868322994787923259293696010p 0.9
+ \]
V_wl_bar_573 (WordLine_bar\\<573\\> gnd!) vsource type=pwl wave=\[
+ 0    0.9
+ 30916300184138066757562815127455898754391418637651479989257882011612153138316483396289550132655380623699708928252017417418920629288343901245943269387736645989575846518587391500p 0.9
+ 30916300184138066757562815127455898754391418637651479989257882011612153138316483396289550132655380623699708928252017417418920629288343901245943269387736645989575846518587391510p -0.3
+ 30916300184138066757562815127455898754391418637651479989257882011612153138316483396289550132655380623699708928252017417418920629288343901245943269387736645989575846518587392000p -0.3
+ 30916300184138066757562815127455898754391418637651479989257882011612153138316483396289550132655380623699708928252017417418920629288343901245943269387736645989575846518587392010p 0.9
+ \]
V_wl_bar_574 (WordLine_bar\\<574\\> gnd!) vsource type=pwl wave=\[
+ 0    0.9
+ 61832600368276133515125630254911797508782837275302959978515764023224306276632966792579100265310761247399417856504034834837841258576687802491886538775473291979151693037174783500p 0.9
+ 61832600368276133515125630254911797508782837275302959978515764023224306276632966792579100265310761247399417856504034834837841258576687802491886538775473291979151693037174783510p -0.3
+ 61832600368276133515125630254911797508782837275302959978515764023224306276632966792579100265310761247399417856504034834837841258576687802491886538775473291979151693037174784000p -0.3
+ 61832600368276133515125630254911797508782837275302959978515764023224306276632966792579100265310761247399417856504034834837841258576687802491886538775473291979151693037174784010p 0.9
+ \]
V_wl_bar_575 (WordLine_bar\\<575\\> gnd!) vsource type=pwl wave=\[
+ 0    0.9
+ 123665200736552267030251260509823595017565674550605919957031528046448612553265933585158200530621522494798835713008069669675682517153375604983773077550946583958303386074349567500p 0.9
+ 123665200736552267030251260509823595017565674550605919957031528046448612553265933585158200530621522494798835713008069669675682517153375604983773077550946583958303386074349567510p -0.3
+ 123665200736552267030251260509823595017565674550605919957031528046448612553265933585158200530621522494798835713008069669675682517153375604983773077550946583958303386074349568000p -0.3
+ 123665200736552267030251260509823595017565674550605919957031528046448612553265933585158200530621522494798835713008069669675682517153375604983773077550946583958303386074349568010p 0.9
+ \]
V_wl_bar_576 (WordLine_bar\\<576\\> gnd!) vsource type=pwl wave=\[
+ 0    0.9
+ 247330401473104534060502521019647190035131349101211839914063056092897225106531867170316401061243044989597671426016139339351365034306751209967546155101893167916606772148699135500p 0.9
+ 247330401473104534060502521019647190035131349101211839914063056092897225106531867170316401061243044989597671426016139339351365034306751209967546155101893167916606772148699135510p -0.3
+ 247330401473104534060502521019647190035131349101211839914063056092897225106531867170316401061243044989597671426016139339351365034306751209967546155101893167916606772148699136000p -0.3
+ 247330401473104534060502521019647190035131349101211839914063056092897225106531867170316401061243044989597671426016139339351365034306751209967546155101893167916606772148699136010p 0.9
+ \]
V_wl_bar_577 (WordLine_bar\\<577\\> gnd!) vsource type=pwl wave=\[
+ 0    0.9
+ 494660802946209068121005042039294380070262698202423679828126112185794450213063734340632802122486089979195342852032278678702730068613502419935092310203786335833213544297398271500p 0.9
+ 494660802946209068121005042039294380070262698202423679828126112185794450213063734340632802122486089979195342852032278678702730068613502419935092310203786335833213544297398271510p -0.3
+ 494660802946209068121005042039294380070262698202423679828126112185794450213063734340632802122486089979195342852032278678702730068613502419935092310203786335833213544297398272000p -0.3
+ 494660802946209068121005042039294380070262698202423679828126112185794450213063734340632802122486089979195342852032278678702730068613502419935092310203786335833213544297398272010p 0.9
+ \]
V_wl_bar_578 (WordLine_bar\\<578\\> gnd!) vsource type=pwl wave=\[
+ 0    0.9
+ 989321605892418136242010084078588760140525396404847359656252224371588900426127468681265604244972179958390685704064557357405460137227004839870184620407572671666427088594796543500p 0.9
+ 989321605892418136242010084078588760140525396404847359656252224371588900426127468681265604244972179958390685704064557357405460137227004839870184620407572671666427088594796543510p -0.3
+ 989321605892418136242010084078588760140525396404847359656252224371588900426127468681265604244972179958390685704064557357405460137227004839870184620407572671666427088594796544000p -0.3
+ 989321605892418136242010084078588760140525396404847359656252224371588900426127468681265604244972179958390685704064557357405460137227004839870184620407572671666427088594796544010p 0.9
+ \]
V_wl_bar_579 (WordLine_bar\\<579\\> gnd!) vsource type=pwl wave=\[
+ 0    0.9
+ 1978643211784836272484020168157177520281050792809694719312504448743177800852254937362531208489944359916781371408129114714810920274454009679740369240815145343332854177189593087500p 0.9
+ 1978643211784836272484020168157177520281050792809694719312504448743177800852254937362531208489944359916781371408129114714810920274454009679740369240815145343332854177189593087510p -0.3
+ 1978643211784836272484020168157177520281050792809694719312504448743177800852254937362531208489944359916781371408129114714810920274454009679740369240815145343332854177189593088000p -0.3
+ 1978643211784836272484020168157177520281050792809694719312504448743177800852254937362531208489944359916781371408129114714810920274454009679740369240815145343332854177189593088010p 0.9
+ \]
V_wl_bar_580 (WordLine_bar\\<580\\> gnd!) vsource type=pwl wave=\[
+ 0    0.9
+ 3957286423569672544968040336314355040562101585619389438625008897486355601704509874725062416979888719833562742816258229429621840548908019359480738481630290686665708354379186175500p 0.9
+ 3957286423569672544968040336314355040562101585619389438625008897486355601704509874725062416979888719833562742816258229429621840548908019359480738481630290686665708354379186175510p -0.3
+ 3957286423569672544968040336314355040562101585619389438625008897486355601704509874725062416979888719833562742816258229429621840548908019359480738481630290686665708354379186176000p -0.3
+ 3957286423569672544968040336314355040562101585619389438625008897486355601704509874725062416979888719833562742816258229429621840548908019359480738481630290686665708354379186176010p 0.9
+ \]
V_wl_bar_581 (WordLine_bar\\<581\\> gnd!) vsource type=pwl wave=\[
+ 0    0.9
+ 7914572847139345089936080672628710081124203171238778877250017794972711203409019749450124833959777439667125485632516458859243681097816038718961476963260581373331416708758372351500p 0.9
+ 7914572847139345089936080672628710081124203171238778877250017794972711203409019749450124833959777439667125485632516458859243681097816038718961476963260581373331416708758372351510p -0.3
+ 7914572847139345089936080672628710081124203171238778877250017794972711203409019749450124833959777439667125485632516458859243681097816038718961476963260581373331416708758372352000p -0.3
+ 7914572847139345089936080672628710081124203171238778877250017794972711203409019749450124833959777439667125485632516458859243681097816038718961476963260581373331416708758372352010p 0.9
+ \]
V_wl_bar_582 (WordLine_bar\\<582\\> gnd!) vsource type=pwl wave=\[
+ 0    0.9
+ 15829145694278690179872161345257420162248406342477557754500035589945422406818039498900249667919554879334250971265032917718487362195632077437922953926521162746662833417516744703500p 0.9
+ 15829145694278690179872161345257420162248406342477557754500035589945422406818039498900249667919554879334250971265032917718487362195632077437922953926521162746662833417516744703510p -0.3
+ 15829145694278690179872161345257420162248406342477557754500035589945422406818039498900249667919554879334250971265032917718487362195632077437922953926521162746662833417516744704000p -0.3
+ 15829145694278690179872161345257420162248406342477557754500035589945422406818039498900249667919554879334250971265032917718487362195632077437922953926521162746662833417516744704010p 0.9
+ \]
V_wl_bar_583 (WordLine_bar\\<583\\> gnd!) vsource type=pwl wave=\[
+ 0    0.9
+ 31658291388557380359744322690514840324496812684955115509000071179890844813636078997800499335839109758668501942530065835436974724391264154875845907853042325493325666835033489407500p 0.9
+ 31658291388557380359744322690514840324496812684955115509000071179890844813636078997800499335839109758668501942530065835436974724391264154875845907853042325493325666835033489407510p -0.3
+ 31658291388557380359744322690514840324496812684955115509000071179890844813636078997800499335839109758668501942530065835436974724391264154875845907853042325493325666835033489408000p -0.3
+ 31658291388557380359744322690514840324496812684955115509000071179890844813636078997800499335839109758668501942530065835436974724391264154875845907853042325493325666835033489408010p 0.9
+ \]
V_wl_bar_584 (WordLine_bar\\<584\\> gnd!) vsource type=pwl wave=\[
+ 0    0.9
+ 63316582777114760719488645381029680648993625369910231018000142359781689627272157995600998671678219517337003885060131670873949448782528309751691815706084650986651333670066978815500p 0.9
+ 63316582777114760719488645381029680648993625369910231018000142359781689627272157995600998671678219517337003885060131670873949448782528309751691815706084650986651333670066978815510p -0.3
+ 63316582777114760719488645381029680648993625369910231018000142359781689627272157995600998671678219517337003885060131670873949448782528309751691815706084650986651333670066978816000p -0.3
+ 63316582777114760719488645381029680648993625369910231018000142359781689627272157995600998671678219517337003885060131670873949448782528309751691815706084650986651333670066978816010p 0.9
+ \]
V_wl_bar_585 (WordLine_bar\\<585\\> gnd!) vsource type=pwl wave=\[
+ 0    0.9
+ 126633165554229521438977290762059361297987250739820462036000284719563379254544315991201997343356439034674007770120263341747898897565056619503383631412169301973302667340133957631500p 0.9
+ 126633165554229521438977290762059361297987250739820462036000284719563379254544315991201997343356439034674007770120263341747898897565056619503383631412169301973302667340133957631510p -0.3
+ 126633165554229521438977290762059361297987250739820462036000284719563379254544315991201997343356439034674007770120263341747898897565056619503383631412169301973302667340133957632000p -0.3
+ 126633165554229521438977290762059361297987250739820462036000284719563379254544315991201997343356439034674007770120263341747898897565056619503383631412169301973302667340133957632010p 0.9
+ \]
V_wl_bar_586 (WordLine_bar\\<586\\> gnd!) vsource type=pwl wave=\[
+ 0    0.9
+ 253266331108459042877954581524118722595974501479640924072000569439126758509088631982403994686712878069348015540240526683495797795130113239006767262824338603946605334680267915263500p 0.9
+ 253266331108459042877954581524118722595974501479640924072000569439126758509088631982403994686712878069348015540240526683495797795130113239006767262824338603946605334680267915263510p -0.3
+ 253266331108459042877954581524118722595974501479640924072000569439126758509088631982403994686712878069348015540240526683495797795130113239006767262824338603946605334680267915264000p -0.3
+ 253266331108459042877954581524118722595974501479640924072000569439126758509088631982403994686712878069348015540240526683495797795130113239006767262824338603946605334680267915264010p 0.9
+ \]
V_wl_bar_587 (WordLine_bar\\<587\\> gnd!) vsource type=pwl wave=\[
+ 0    0.9
+ 506532662216918085755909163048237445191949002959281848144001138878253517018177263964807989373425756138696031080481053366991595590260226478013534525648677207893210669360535830527500p 0.9
+ 506532662216918085755909163048237445191949002959281848144001138878253517018177263964807989373425756138696031080481053366991595590260226478013534525648677207893210669360535830527510p -0.3
+ 506532662216918085755909163048237445191949002959281848144001138878253517018177263964807989373425756138696031080481053366991595590260226478013534525648677207893210669360535830528000p -0.3
+ 506532662216918085755909163048237445191949002959281848144001138878253517018177263964807989373425756138696031080481053366991595590260226478013534525648677207893210669360535830528010p 0.9
+ \]
V_wl_bar_588 (WordLine_bar\\<588\\> gnd!) vsource type=pwl wave=\[
+ 0    0.9
+ 1013065324433836171511818326096474890383898005918563696288002277756507034036354527929615978746851512277392062160962106733983191180520452956027069051297354415786421338721071661055500p 0.9
+ 1013065324433836171511818326096474890383898005918563696288002277756507034036354527929615978746851512277392062160962106733983191180520452956027069051297354415786421338721071661055510p -0.3
+ 1013065324433836171511818326096474890383898005918563696288002277756507034036354527929615978746851512277392062160962106733983191180520452956027069051297354415786421338721071661056000p -0.3
+ 1013065324433836171511818326096474890383898005918563696288002277756507034036354527929615978746851512277392062160962106733983191180520452956027069051297354415786421338721071661056010p 0.9
+ \]
V_wl_bar_589 (WordLine_bar\\<589\\> gnd!) vsource type=pwl wave=\[
+ 0    0.9
+ 2026130648867672343023636652192949780767796011837127392576004555513014068072709055859231957493703024554784124321924213467966382361040905912054138102594708831572842677442143322111500p 0.9
+ 2026130648867672343023636652192949780767796011837127392576004555513014068072709055859231957493703024554784124321924213467966382361040905912054138102594708831572842677442143322111510p -0.3
+ 2026130648867672343023636652192949780767796011837127392576004555513014068072709055859231957493703024554784124321924213467966382361040905912054138102594708831572842677442143322112000p -0.3
+ 2026130648867672343023636652192949780767796011837127392576004555513014068072709055859231957493703024554784124321924213467966382361040905912054138102594708831572842677442143322112010p 0.9
+ \]
V_wl_bar_590 (WordLine_bar\\<590\\> gnd!) vsource type=pwl wave=\[
+ 0    0.9
+ 4052261297735344686047273304385899561535592023674254785152009111026028136145418111718463914987406049109568248643848426935932764722081811824108276205189417663145685354884286644223500p 0.9
+ 4052261297735344686047273304385899561535592023674254785152009111026028136145418111718463914987406049109568248643848426935932764722081811824108276205189417663145685354884286644223510p -0.3
+ 4052261297735344686047273304385899561535592023674254785152009111026028136145418111718463914987406049109568248643848426935932764722081811824108276205189417663145685354884286644224000p -0.3
+ 4052261297735344686047273304385899561535592023674254785152009111026028136145418111718463914987406049109568248643848426935932764722081811824108276205189417663145685354884286644224010p 0.9
+ \]
V_wl_bar_591 (WordLine_bar\\<591\\> gnd!) vsource type=pwl wave=\[
+ 0    0.9
+ 8104522595470689372094546608771799123071184047348509570304018222052056272290836223436927829974812098219136497287696853871865529444163623648216552410378835326291370709768573288447500p 0.9
+ 8104522595470689372094546608771799123071184047348509570304018222052056272290836223436927829974812098219136497287696853871865529444163623648216552410378835326291370709768573288447510p -0.3
+ 8104522595470689372094546608771799123071184047348509570304018222052056272290836223436927829974812098219136497287696853871865529444163623648216552410378835326291370709768573288448000p -0.3
+ 8104522595470689372094546608771799123071184047348509570304018222052056272290836223436927829974812098219136497287696853871865529444163623648216552410378835326291370709768573288448010p 0.9
+ \]
V_wl_bar_592 (WordLine_bar\\<592\\> gnd!) vsource type=pwl wave=\[
+ 0    0.9
+ 16209045190941378744189093217543598246142368094697019140608036444104112544581672446873855659949624196438272994575393707743731058888327247296433104820757670652582741419537146576895500p 0.9
+ 16209045190941378744189093217543598246142368094697019140608036444104112544581672446873855659949624196438272994575393707743731058888327247296433104820757670652582741419537146576895510p -0.3
+ 16209045190941378744189093217543598246142368094697019140608036444104112544581672446873855659949624196438272994575393707743731058888327247296433104820757670652582741419537146576896000p -0.3
+ 16209045190941378744189093217543598246142368094697019140608036444104112544581672446873855659949624196438272994575393707743731058888327247296433104820757670652582741419537146576896010p 0.9
+ \]
V_wl_bar_593 (WordLine_bar\\<593\\> gnd!) vsource type=pwl wave=\[
+ 0    0.9
+ 32418090381882757488378186435087196492284736189394038281216072888208225089163344893747711319899248392876545989150787415487462117776654494592866209641515341305165482839074293153791500p 0.9
+ 32418090381882757488378186435087196492284736189394038281216072888208225089163344893747711319899248392876545989150787415487462117776654494592866209641515341305165482839074293153791510p -0.3
+ 32418090381882757488378186435087196492284736189394038281216072888208225089163344893747711319899248392876545989150787415487462117776654494592866209641515341305165482839074293153792000p -0.3
+ 32418090381882757488378186435087196492284736189394038281216072888208225089163344893747711319899248392876545989150787415487462117776654494592866209641515341305165482839074293153792010p 0.9
+ \]
V_wl_bar_594 (WordLine_bar\\<594\\> gnd!) vsource type=pwl wave=\[
+ 0    0.9
+ 64836180763765514976756372870174392984569472378788076562432145776416450178326689787495422639798496785753091978301574830974924235553308989185732419283030682610330965678148586307583500p 0.9
+ 64836180763765514976756372870174392984569472378788076562432145776416450178326689787495422639798496785753091978301574830974924235553308989185732419283030682610330965678148586307583510p -0.3
+ 64836180763765514976756372870174392984569472378788076562432145776416450178326689787495422639798496785753091978301574830974924235553308989185732419283030682610330965678148586307584000p -0.3
+ 64836180763765514976756372870174392984569472378788076562432145776416450178326689787495422639798496785753091978301574830974924235553308989185732419283030682610330965678148586307584010p 0.9
+ \]
V_wl_bar_595 (WordLine_bar\\<595\\> gnd!) vsource type=pwl wave=\[
+ 0    0.9
+ 129672361527531029953512745740348785969138944757576153124864291552832900356653379574990845279596993571506183956603149661949848471106617978371464838566061365220661931356297172615167500p 0.9
+ 129672361527531029953512745740348785969138944757576153124864291552832900356653379574990845279596993571506183956603149661949848471106617978371464838566061365220661931356297172615167510p -0.3
+ 129672361527531029953512745740348785969138944757576153124864291552832900356653379574990845279596993571506183956603149661949848471106617978371464838566061365220661931356297172615168000p -0.3
+ 129672361527531029953512745740348785969138944757576153124864291552832900356653379574990845279596993571506183956603149661949848471106617978371464838566061365220661931356297172615168010p 0.9
+ \]
V_wl_bar_596 (WordLine_bar\\<596\\> gnd!) vsource type=pwl wave=\[
+ 0    0.9
+ 259344723055062059907025491480697571938277889515152306249728583105665800713306759149981690559193987143012367913206299323899696942213235956742929677132122730441323862712594345230335500p 0.9
+ 259344723055062059907025491480697571938277889515152306249728583105665800713306759149981690559193987143012367913206299323899696942213235956742929677132122730441323862712594345230335510p -0.3
+ 259344723055062059907025491480697571938277889515152306249728583105665800713306759149981690559193987143012367913206299323899696942213235956742929677132122730441323862712594345230336000p -0.3
+ 259344723055062059907025491480697571938277889515152306249728583105665800713306759149981690559193987143012367913206299323899696942213235956742929677132122730441323862712594345230336010p 0.9
+ \]
V_wl_bar_597 (WordLine_bar\\<597\\> gnd!) vsource type=pwl wave=\[
+ 0    0.9
+ 518689446110124119814050982961395143876555779030304612499457166211331601426613518299963381118387974286024735826412598647799393884426471913485859354264245460882647725425188690460671500p 0.9
+ 518689446110124119814050982961395143876555779030304612499457166211331601426613518299963381118387974286024735826412598647799393884426471913485859354264245460882647725425188690460671510p -0.3
+ 518689446110124119814050982961395143876555779030304612499457166211331601426613518299963381118387974286024735826412598647799393884426471913485859354264245460882647725425188690460672000p -0.3
+ 518689446110124119814050982961395143876555779030304612499457166211331601426613518299963381118387974286024735826412598647799393884426471913485859354264245460882647725425188690460672010p 0.9
+ \]
V_wl_bar_598 (WordLine_bar\\<598\\> gnd!) vsource type=pwl wave=\[
+ 0    0.9
+ 1037378892220248239628101965922790287753111558060609224998914332422663202853227036599926762236775948572049471652825197295598787768852943826971718708528490921765295450850377380921343500p 0.9
+ 1037378892220248239628101965922790287753111558060609224998914332422663202853227036599926762236775948572049471652825197295598787768852943826971718708528490921765295450850377380921343510p -0.3
+ 1037378892220248239628101965922790287753111558060609224998914332422663202853227036599926762236775948572049471652825197295598787768852943826971718708528490921765295450850377380921344000p -0.3
+ 1037378892220248239628101965922790287753111558060609224998914332422663202853227036599926762236775948572049471652825197295598787768852943826971718708528490921765295450850377380921344010p 0.9
+ \]
V_wl_bar_599 (WordLine_bar\\<599\\> gnd!) vsource type=pwl wave=\[
+ 0    0.9
+ 2074757784440496479256203931845580575506223116121218449997828664845326405706454073199853524473551897144098943305650394591197575537705887653943437417056981843530590901700754761842687500p 0.9
+ 2074757784440496479256203931845580575506223116121218449997828664845326405706454073199853524473551897144098943305650394591197575537705887653943437417056981843530590901700754761842687510p -0.3
+ 2074757784440496479256203931845580575506223116121218449997828664845326405706454073199853524473551897144098943305650394591197575537705887653943437417056981843530590901700754761842688000p -0.3
+ 2074757784440496479256203931845580575506223116121218449997828664845326405706454073199853524473551897144098943305650394591197575537705887653943437417056981843530590901700754761842688010p 0.9
+ \]
V_wl_bar_600 (WordLine_bar\\<600\\> gnd!) vsource type=pwl wave=\[
+ 0    0.9
+ 4149515568880992958512407863691161151012446232242436899995657329690652811412908146399707048947103794288197886611300789182395151075411775307886874834113963687061181803401509523685375500p 0.9
+ 4149515568880992958512407863691161151012446232242436899995657329690652811412908146399707048947103794288197886611300789182395151075411775307886874834113963687061181803401509523685375510p -0.3
+ 4149515568880992958512407863691161151012446232242436899995657329690652811412908146399707048947103794288197886611300789182395151075411775307886874834113963687061181803401509523685376000p -0.3
+ 4149515568880992958512407863691161151012446232242436899995657329690652811412908146399707048947103794288197886611300789182395151075411775307886874834113963687061181803401509523685376010p 0.9
+ \]
V_wl_bar_601 (WordLine_bar\\<601\\> gnd!) vsource type=pwl wave=\[
+ 0    0.9
+ 8299031137761985917024815727382322302024892464484873799991314659381305622825816292799414097894207588576395773222601578364790302150823550615773749668227927374122363606803019047370751500p 0.9
+ 8299031137761985917024815727382322302024892464484873799991314659381305622825816292799414097894207588576395773222601578364790302150823550615773749668227927374122363606803019047370751510p -0.3
+ 8299031137761985917024815727382322302024892464484873799991314659381305622825816292799414097894207588576395773222601578364790302150823550615773749668227927374122363606803019047370752000p -0.3
+ 8299031137761985917024815727382322302024892464484873799991314659381305622825816292799414097894207588576395773222601578364790302150823550615773749668227927374122363606803019047370752010p 0.9
+ \]
V_wl_bar_602 (WordLine_bar\\<602\\> gnd!) vsource type=pwl wave=\[
+ 0    0.9
+ 16598062275523971834049631454764644604049784928969747599982629318762611245651632585598828195788415177152791546445203156729580604301647101231547499336455854748244727213606038094741503500p 0.9
+ 16598062275523971834049631454764644604049784928969747599982629318762611245651632585598828195788415177152791546445203156729580604301647101231547499336455854748244727213606038094741503510p -0.3
+ 16598062275523971834049631454764644604049784928969747599982629318762611245651632585598828195788415177152791546445203156729580604301647101231547499336455854748244727213606038094741504000p -0.3
+ 16598062275523971834049631454764644604049784928969747599982629318762611245651632585598828195788415177152791546445203156729580604301647101231547499336455854748244727213606038094741504010p 0.9
+ \]
V_wl_bar_603 (WordLine_bar\\<603\\> gnd!) vsource type=pwl wave=\[
+ 0    0.9
+ 33196124551047943668099262909529289208099569857939495199965258637525222491303265171197656391576830354305583092890406313459161208603294202463094998672911709496489454427212076189483007500p 0.9
+ 33196124551047943668099262909529289208099569857939495199965258637525222491303265171197656391576830354305583092890406313459161208603294202463094998672911709496489454427212076189483007510p -0.3
+ 33196124551047943668099262909529289208099569857939495199965258637525222491303265171197656391576830354305583092890406313459161208603294202463094998672911709496489454427212076189483008000p -0.3
+ 33196124551047943668099262909529289208099569857939495199965258637525222491303265171197656391576830354305583092890406313459161208603294202463094998672911709496489454427212076189483008010p 0.9
+ \]
V_wl_bar_604 (WordLine_bar\\<604\\> gnd!) vsource type=pwl wave=\[
+ 0    0.9
+ 66392249102095887336198525819058578416199139715878990399930517275050444982606530342395312783153660708611166185780812626918322417206588404926189997345823418992978908854424152378966015500p 0.9
+ 66392249102095887336198525819058578416199139715878990399930517275050444982606530342395312783153660708611166185780812626918322417206588404926189997345823418992978908854424152378966015510p -0.3
+ 66392249102095887336198525819058578416199139715878990399930517275050444982606530342395312783153660708611166185780812626918322417206588404926189997345823418992978908854424152378966016000p -0.3
+ 66392249102095887336198525819058578416199139715878990399930517275050444982606530342395312783153660708611166185780812626918322417206588404926189997345823418992978908854424152378966016010p 0.9
+ \]
V_wl_bar_605 (WordLine_bar\\<605\\> gnd!) vsource type=pwl wave=\[
+ 0    0.9
+ 132784498204191774672397051638117156832398279431757980799861034550100889965213060684790625566307321417222332371561625253836644834413176809852379994691646837985957817708848304757932031500p 0.9
+ 132784498204191774672397051638117156832398279431757980799861034550100889965213060684790625566307321417222332371561625253836644834413176809852379994691646837985957817708848304757932031510p -0.3
+ 132784498204191774672397051638117156832398279431757980799861034550100889965213060684790625566307321417222332371561625253836644834413176809852379994691646837985957817708848304757932032000p -0.3
+ 132784498204191774672397051638117156832398279431757980799861034550100889965213060684790625566307321417222332371561625253836644834413176809852379994691646837985957817708848304757932032010p 0.9
+ \]
V_wl_bar_606 (WordLine_bar\\<606\\> gnd!) vsource type=pwl wave=\[
+ 0    0.9
+ 265568996408383549344794103276234313664796558863515961599722069100201779930426121369581251132614642834444664743123250507673289668826353619704759989383293675971915635417696609515864063500p 0.9
+ 265568996408383549344794103276234313664796558863515961599722069100201779930426121369581251132614642834444664743123250507673289668826353619704759989383293675971915635417696609515864063510p -0.3
+ 265568996408383549344794103276234313664796558863515961599722069100201779930426121369581251132614642834444664743123250507673289668826353619704759989383293675971915635417696609515864064000p -0.3
+ 265568996408383549344794103276234313664796558863515961599722069100201779930426121369581251132614642834444664743123250507673289668826353619704759989383293675971915635417696609515864064010p 0.9
+ \]
V_wl_bar_607 (WordLine_bar\\<607\\> gnd!) vsource type=pwl wave=\[
+ 0    0.9
+ 531137992816767098689588206552468627329593117727031923199444138200403559860852242739162502265229285668889329486246501015346579337652707239409519978766587351943831270835393219031728127500p 0.9
+ 531137992816767098689588206552468627329593117727031923199444138200403559860852242739162502265229285668889329486246501015346579337652707239409519978766587351943831270835393219031728127510p -0.3
+ 531137992816767098689588206552468627329593117727031923199444138200403559860852242739162502265229285668889329486246501015346579337652707239409519978766587351943831270835393219031728128000p -0.3
+ 531137992816767098689588206552468627329593117727031923199444138200403559860852242739162502265229285668889329486246501015346579337652707239409519978766587351943831270835393219031728128010p 0.9
+ \]
V_wl_bar_608 (WordLine_bar\\<608\\> gnd!) vsource type=pwl wave=\[
+ 0    0.9
+ 1062275985633534197379176413104937254659186235454063846398888276400807119721704485478325004530458571337778658972493002030693158675305414478819039957533174703887662541670786438063456255500p 0.9
+ 1062275985633534197379176413104937254659186235454063846398888276400807119721704485478325004530458571337778658972493002030693158675305414478819039957533174703887662541670786438063456255510p -0.3
+ 1062275985633534197379176413104937254659186235454063846398888276400807119721704485478325004530458571337778658972493002030693158675305414478819039957533174703887662541670786438063456256000p -0.3
+ 1062275985633534197379176413104937254659186235454063846398888276400807119721704485478325004530458571337778658972493002030693158675305414478819039957533174703887662541670786438063456256010p 0.9
+ \]
V_wl_bar_609 (WordLine_bar\\<609\\> gnd!) vsource type=pwl wave=\[
+ 0    0.9
+ 2124551971267068394758352826209874509318372470908127692797776552801614239443408970956650009060917142675557317944986004061386317350610828957638079915066349407775325083341572876126912511500p 0.9
+ 2124551971267068394758352826209874509318372470908127692797776552801614239443408970956650009060917142675557317944986004061386317350610828957638079915066349407775325083341572876126912511510p -0.3
+ 2124551971267068394758352826209874509318372470908127692797776552801614239443408970956650009060917142675557317944986004061386317350610828957638079915066349407775325083341572876126912512000p -0.3
+ 2124551971267068394758352826209874509318372470908127692797776552801614239443408970956650009060917142675557317944986004061386317350610828957638079915066349407775325083341572876126912512010p 0.9
+ \]
V_wl_bar_610 (WordLine_bar\\<610\\> gnd!) vsource type=pwl wave=\[
+ 0    0.9
+ 4249103942534136789516705652419749018636744941816255385595553105603228478886817941913300018121834285351114635889972008122772634701221657915276159830132698815550650166683145752253825023500p 0.9
+ 4249103942534136789516705652419749018636744941816255385595553105603228478886817941913300018121834285351114635889972008122772634701221657915276159830132698815550650166683145752253825023510p -0.3
+ 4249103942534136789516705652419749018636744941816255385595553105603228478886817941913300018121834285351114635889972008122772634701221657915276159830132698815550650166683145752253825024000p -0.3
+ 4249103942534136789516705652419749018636744941816255385595553105603228478886817941913300018121834285351114635889972008122772634701221657915276159830132698815550650166683145752253825024010p 0.9
+ \]
V_wl_bar_611 (WordLine_bar\\<611\\> gnd!) vsource type=pwl wave=\[
+ 0    0.9
+ 8498207885068273579033411304839498037273489883632510771191106211206456957773635883826600036243668570702229271779944016245545269402443315830552319660265397631101300333366291504507650047500p 0.9
+ 8498207885068273579033411304839498037273489883632510771191106211206456957773635883826600036243668570702229271779944016245545269402443315830552319660265397631101300333366291504507650047510p -0.3
+ 8498207885068273579033411304839498037273489883632510771191106211206456957773635883826600036243668570702229271779944016245545269402443315830552319660265397631101300333366291504507650048000p -0.3
+ 8498207885068273579033411304839498037273489883632510771191106211206456957773635883826600036243668570702229271779944016245545269402443315830552319660265397631101300333366291504507650048010p 0.9
+ \]
V_wl_bar_612 (WordLine_bar\\<612\\> gnd!) vsource type=pwl wave=\[
+ 0    0.9
+ 16996415770136547158066822609678996074546979767265021542382212422412913915547271767653200072487337141404458543559888032491090538804886631661104639320530795262202600666732583009015300095500p 0.9
+ 16996415770136547158066822609678996074546979767265021542382212422412913915547271767653200072487337141404458543559888032491090538804886631661104639320530795262202600666732583009015300095510p -0.3
+ 16996415770136547158066822609678996074546979767265021542382212422412913915547271767653200072487337141404458543559888032491090538804886631661104639320530795262202600666732583009015300096000p -0.3
+ 16996415770136547158066822609678996074546979767265021542382212422412913915547271767653200072487337141404458543559888032491090538804886631661104639320530795262202600666732583009015300096010p 0.9
+ \]
V_wl_bar_613 (WordLine_bar\\<613\\> gnd!) vsource type=pwl wave=\[
+ 0    0.9
+ 33992831540273094316133645219357992149093959534530043084764424844825827831094543535306400144974674282808917087119776064982181077609773263322209278641061590524405201333465166018030600191500p 0.9
+ 33992831540273094316133645219357992149093959534530043084764424844825827831094543535306400144974674282808917087119776064982181077609773263322209278641061590524405201333465166018030600191510p -0.3
+ 33992831540273094316133645219357992149093959534530043084764424844825827831094543535306400144974674282808917087119776064982181077609773263322209278641061590524405201333465166018030600192000p -0.3
+ 33992831540273094316133645219357992149093959534530043084764424844825827831094543535306400144974674282808917087119776064982181077609773263322209278641061590524405201333465166018030600192010p 0.9
+ \]
V_wl_bar_614 (WordLine_bar\\<614\\> gnd!) vsource type=pwl wave=\[
+ 0    0.9
+ 67985663080546188632267290438715984298187919069060086169528849689651655662189087070612800289949348565617834174239552129964362155219546526644418557282123181048810402666930332036061200383500p 0.9
+ 67985663080546188632267290438715984298187919069060086169528849689651655662189087070612800289949348565617834174239552129964362155219546526644418557282123181048810402666930332036061200383510p -0.3
+ 67985663080546188632267290438715984298187919069060086169528849689651655662189087070612800289949348565617834174239552129964362155219546526644418557282123181048810402666930332036061200384000p -0.3
+ 67985663080546188632267290438715984298187919069060086169528849689651655662189087070612800289949348565617834174239552129964362155219546526644418557282123181048810402666930332036061200384010p 0.9
+ \]
V_wl_bar_615 (WordLine_bar\\<615\\> gnd!) vsource type=pwl wave=\[
+ 0    0.9
+ 135971326161092377264534580877431968596375838138120172339057699379303311324378174141225600579898697131235668348479104259928724310439093053288837114564246362097620805333860664072122400767500p 0.9
+ 135971326161092377264534580877431968596375838138120172339057699379303311324378174141225600579898697131235668348479104259928724310439093053288837114564246362097620805333860664072122400767510p -0.3
+ 135971326161092377264534580877431968596375838138120172339057699379303311324378174141225600579898697131235668348479104259928724310439093053288837114564246362097620805333860664072122400768000p -0.3
+ 135971326161092377264534580877431968596375838138120172339057699379303311324378174141225600579898697131235668348479104259928724310439093053288837114564246362097620805333860664072122400768010p 0.9
+ \]
V_wl_bar_616 (WordLine_bar\\<616\\> gnd!) vsource type=pwl wave=\[
+ 0    0.9
+ 271942652322184754529069161754863937192751676276240344678115398758606622648756348282451201159797394262471336696958208519857448620878186106577674229128492724195241610667721328144244801535500p 0.9
+ 271942652322184754529069161754863937192751676276240344678115398758606622648756348282451201159797394262471336696958208519857448620878186106577674229128492724195241610667721328144244801535510p -0.3
+ 271942652322184754529069161754863937192751676276240344678115398758606622648756348282451201159797394262471336696958208519857448620878186106577674229128492724195241610667721328144244801536000p -0.3
+ 271942652322184754529069161754863937192751676276240344678115398758606622648756348282451201159797394262471336696958208519857448620878186106577674229128492724195241610667721328144244801536010p 0.9
+ \]
V_wl_bar_617 (WordLine_bar\\<617\\> gnd!) vsource type=pwl wave=\[
+ 0    0.9
+ 543885304644369509058138323509727874385503352552480689356230797517213245297512696564902402319594788524942673393916417039714897241756372213155348458256985448390483221335442656288489603071500p 0.9
+ 543885304644369509058138323509727874385503352552480689356230797517213245297512696564902402319594788524942673393916417039714897241756372213155348458256985448390483221335442656288489603071510p -0.3
+ 543885304644369509058138323509727874385503352552480689356230797517213245297512696564902402319594788524942673393916417039714897241756372213155348458256985448390483221335442656288489603072000p -0.3
+ 543885304644369509058138323509727874385503352552480689356230797517213245297512696564902402319594788524942673393916417039714897241756372213155348458256985448390483221335442656288489603072010p 0.9
+ \]
V_wl_bar_618 (WordLine_bar\\<618\\> gnd!) vsource type=pwl wave=\[
+ 0    0.9
+ 1087770609288739018116276647019455748771006705104961378712461595034426490595025393129804804639189577049885346787832834079429794483512744426310696916513970896780966442670885312576979206143500p 0.9
+ 1087770609288739018116276647019455748771006705104961378712461595034426490595025393129804804639189577049885346787832834079429794483512744426310696916513970896780966442670885312576979206143510p -0.3
+ 1087770609288739018116276647019455748771006705104961378712461595034426490595025393129804804639189577049885346787832834079429794483512744426310696916513970896780966442670885312576979206144000p -0.3
+ 1087770609288739018116276647019455748771006705104961378712461595034426490595025393129804804639189577049885346787832834079429794483512744426310696916513970896780966442670885312576979206144010p 0.9
+ \]
V_wl_bar_619 (WordLine_bar\\<619\\> gnd!) vsource type=pwl wave=\[
+ 0    0.9
+ 2175541218577478036232553294038911497542013410209922757424923190068852981190050786259609609278379154099770693575665668158859588967025488852621393833027941793561932885341770625153958412287500p 0.9
+ 2175541218577478036232553294038911497542013410209922757424923190068852981190050786259609609278379154099770693575665668158859588967025488852621393833027941793561932885341770625153958412287510p -0.3
+ 2175541218577478036232553294038911497542013410209922757424923190068852981190050786259609609278379154099770693575665668158859588967025488852621393833027941793561932885341770625153958412288000p -0.3
+ 2175541218577478036232553294038911497542013410209922757424923190068852981190050786259609609278379154099770693575665668158859588967025488852621393833027941793561932885341770625153958412288010p 0.9
+ \]
V_wl_bar_620 (WordLine_bar\\<620\\> gnd!) vsource type=pwl wave=\[
+ 0    0.9
+ 4351082437154956072465106588077822995084026820419845514849846380137705962380101572519219218556758308199541387151331336317719177934050977705242787666055883587123865770683541250307916824575500p 0.9
+ 4351082437154956072465106588077822995084026820419845514849846380137705962380101572519219218556758308199541387151331336317719177934050977705242787666055883587123865770683541250307916824575510p -0.3
+ 4351082437154956072465106588077822995084026820419845514849846380137705962380101572519219218556758308199541387151331336317719177934050977705242787666055883587123865770683541250307916824576000p -0.3
+ 4351082437154956072465106588077822995084026820419845514849846380137705962380101572519219218556758308199541387151331336317719177934050977705242787666055883587123865770683541250307916824576010p 0.9
+ \]
V_wl_bar_621 (WordLine_bar\\<621\\> gnd!) vsource type=pwl wave=\[
+ 0    0.9
+ 8702164874309912144930213176155645990168053640839691029699692760275411924760203145038438437113516616399082774302662672635438355868101955410485575332111767174247731541367082500615833649151500p 0.9
+ 8702164874309912144930213176155645990168053640839691029699692760275411924760203145038438437113516616399082774302662672635438355868101955410485575332111767174247731541367082500615833649151510p -0.3
+ 8702164874309912144930213176155645990168053640839691029699692760275411924760203145038438437113516616399082774302662672635438355868101955410485575332111767174247731541367082500615833649152000p -0.3
+ 8702164874309912144930213176155645990168053640839691029699692760275411924760203145038438437113516616399082774302662672635438355868101955410485575332111767174247731541367082500615833649152010p 0.9
+ \]
V_wl_bar_622 (WordLine_bar\\<622\\> gnd!) vsource type=pwl wave=\[
+ 0    0.9
+ 17404329748619824289860426352311291980336107281679382059399385520550823849520406290076876874227033232798165548605325345270876711736203910820971150664223534348495463082734165001231667298303500p 0.9
+ 17404329748619824289860426352311291980336107281679382059399385520550823849520406290076876874227033232798165548605325345270876711736203910820971150664223534348495463082734165001231667298303510p -0.3
+ 17404329748619824289860426352311291980336107281679382059399385520550823849520406290076876874227033232798165548605325345270876711736203910820971150664223534348495463082734165001231667298304000p -0.3
+ 17404329748619824289860426352311291980336107281679382059399385520550823849520406290076876874227033232798165548605325345270876711736203910820971150664223534348495463082734165001231667298304010p 0.9
+ \]
V_wl_bar_623 (WordLine_bar\\<623\\> gnd!) vsource type=pwl wave=\[
+ 0    0.9
+ 34808659497239648579720852704622583960672214563358764118798771041101647699040812580153753748454066465596331097210650690541753423472407821641942301328447068696990926165468330002463334596607500p 0.9
+ 34808659497239648579720852704622583960672214563358764118798771041101647699040812580153753748454066465596331097210650690541753423472407821641942301328447068696990926165468330002463334596607510p -0.3
+ 34808659497239648579720852704622583960672214563358764118798771041101647699040812580153753748454066465596331097210650690541753423472407821641942301328447068696990926165468330002463334596608000p -0.3
+ 34808659497239648579720852704622583960672214563358764118798771041101647699040812580153753748454066465596331097210650690541753423472407821641942301328447068696990926165468330002463334596608010p 0.9
+ \]
V_wl_bar_624 (WordLine_bar\\<624\\> gnd!) vsource type=pwl wave=\[
+ 0    0.9
+ 69617318994479297159441705409245167921344429126717528237597542082203295398081625160307507496908132931192662194421301381083506846944815643283884602656894137393981852330936660004926669193215500p 0.9
+ 69617318994479297159441705409245167921344429126717528237597542082203295398081625160307507496908132931192662194421301381083506846944815643283884602656894137393981852330936660004926669193215510p -0.3
+ 69617318994479297159441705409245167921344429126717528237597542082203295398081625160307507496908132931192662194421301381083506846944815643283884602656894137393981852330936660004926669193216000p -0.3
+ 69617318994479297159441705409245167921344429126717528237597542082203295398081625160307507496908132931192662194421301381083506846944815643283884602656894137393981852330936660004926669193216010p 0.9
+ \]
V_wl_bar_625 (WordLine_bar\\<625\\> gnd!) vsource type=pwl wave=\[
+ 0    0.9
+ 139234637988958594318883410818490335842688858253435056475195084164406590796163250320615014993816265862385324388842602762167013693889631286567769205313788274787963704661873320009853338386431500p 0.9
+ 139234637988958594318883410818490335842688858253435056475195084164406590796163250320615014993816265862385324388842602762167013693889631286567769205313788274787963704661873320009853338386431510p -0.3
+ 139234637988958594318883410818490335842688858253435056475195084164406590796163250320615014993816265862385324388842602762167013693889631286567769205313788274787963704661873320009853338386432000p -0.3
+ 139234637988958594318883410818490335842688858253435056475195084164406590796163250320615014993816265862385324388842602762167013693889631286567769205313788274787963704661873320009853338386432010p 0.9
+ \]
V_wl_bar_626 (WordLine_bar\\<626\\> gnd!) vsource type=pwl wave=\[
+ 0    0.9
+ 278469275977917188637766821636980671685377716506870112950390168328813181592326500641230029987632531724770648777685205524334027387779262573135538410627576549575927409323746640019706676772863500p 0.9
+ 278469275977917188637766821636980671685377716506870112950390168328813181592326500641230029987632531724770648777685205524334027387779262573135538410627576549575927409323746640019706676772863510p -0.3
+ 278469275977917188637766821636980671685377716506870112950390168328813181592326500641230029987632531724770648777685205524334027387779262573135538410627576549575927409323746640019706676772864000p -0.3
+ 278469275977917188637766821636980671685377716506870112950390168328813181592326500641230029987632531724770648777685205524334027387779262573135538410627576549575927409323746640019706676772864010p 0.9
+ \]
V_wl_bar_627 (WordLine_bar\\<627\\> gnd!) vsource type=pwl wave=\[
+ 0    0.9
+ 556938551955834377275533643273961343370755433013740225900780336657626363184653001282460059975265063449541297555370411048668054775558525146271076821255153099151854818647493280039413353545727500p 0.9
+ 556938551955834377275533643273961343370755433013740225900780336657626363184653001282460059975265063449541297555370411048668054775558525146271076821255153099151854818647493280039413353545727510p -0.3
+ 556938551955834377275533643273961343370755433013740225900780336657626363184653001282460059975265063449541297555370411048668054775558525146271076821255153099151854818647493280039413353545728000p -0.3
+ 556938551955834377275533643273961343370755433013740225900780336657626363184653001282460059975265063449541297555370411048668054775558525146271076821255153099151854818647493280039413353545728010p 0.9
+ \]
V_wl_bar_628 (WordLine_bar\\<628\\> gnd!) vsource type=pwl wave=\[
+ 0    0.9
+ 1113877103911668754551067286547922686741510866027480451801560673315252726369306002564920119950530126899082595110740822097336109551117050292542153642510306198303709637294986560078826707091455500p 0.9
+ 1113877103911668754551067286547922686741510866027480451801560673315252726369306002564920119950530126899082595110740822097336109551117050292542153642510306198303709637294986560078826707091455510p -0.3
+ 1113877103911668754551067286547922686741510866027480451801560673315252726369306002564920119950530126899082595110740822097336109551117050292542153642510306198303709637294986560078826707091456000p -0.3
+ 1113877103911668754551067286547922686741510866027480451801560673315252726369306002564920119950530126899082595110740822097336109551117050292542153642510306198303709637294986560078826707091456010p 0.9
+ \]
V_wl_bar_629 (WordLine_bar\\<629\\> gnd!) vsource type=pwl wave=\[
+ 0    0.9
+ 2227754207823337509102134573095845373483021732054960903603121346630505452738612005129840239901060253798165190221481644194672219102234100585084307285020612396607419274589973120157653414182911500p 0.9
+ 2227754207823337509102134573095845373483021732054960903603121346630505452738612005129840239901060253798165190221481644194672219102234100585084307285020612396607419274589973120157653414182911510p -0.3
+ 2227754207823337509102134573095845373483021732054960903603121346630505452738612005129840239901060253798165190221481644194672219102234100585084307285020612396607419274589973120157653414182912000p -0.3
+ 2227754207823337509102134573095845373483021732054960903603121346630505452738612005129840239901060253798165190221481644194672219102234100585084307285020612396607419274589973120157653414182912010p 0.9
+ \]
V_wl_bar_630 (WordLine_bar\\<630\\> gnd!) vsource type=pwl wave=\[
+ 0    0.9
+ 4455508415646675018204269146191690746966043464109921807206242693261010905477224010259680479802120507596330380442963288389344438204468201170168614570041224793214838549179946240315306828365823500p 0.9
+ 4455508415646675018204269146191690746966043464109921807206242693261010905477224010259680479802120507596330380442963288389344438204468201170168614570041224793214838549179946240315306828365823510p -0.3
+ 4455508415646675018204269146191690746966043464109921807206242693261010905477224010259680479802120507596330380442963288389344438204468201170168614570041224793214838549179946240315306828365824000p -0.3
+ 4455508415646675018204269146191690746966043464109921807206242693261010905477224010259680479802120507596330380442963288389344438204468201170168614570041224793214838549179946240315306828365824010p 0.9
+ \]
V_wl_bar_631 (WordLine_bar\\<631\\> gnd!) vsource type=pwl wave=\[
+ 0    0.9
+ 8911016831293350036408538292383381493932086928219843614412485386522021810954448020519360959604241015192660760885926576778688876408936402340337229140082449586429677098359892480630613656731647500p 0.9
+ 8911016831293350036408538292383381493932086928219843614412485386522021810954448020519360959604241015192660760885926576778688876408936402340337229140082449586429677098359892480630613656731647510p -0.3
+ 8911016831293350036408538292383381493932086928219843614412485386522021810954448020519360959604241015192660760885926576778688876408936402340337229140082449586429677098359892480630613656731648000p -0.3
+ 8911016831293350036408538292383381493932086928219843614412485386522021810954448020519360959604241015192660760885926576778688876408936402340337229140082449586429677098359892480630613656731648010p 0.9
+ \]
V_wl_bar_632 (WordLine_bar\\<632\\> gnd!) vsource type=pwl wave=\[
+ 0    0.9
+ 17822033662586700072817076584766762987864173856439687228824970773044043621908896041038721919208482030385321521771853153557377752817872804680674458280164899172859354196719784961261227313463295500p 0.9
+ 17822033662586700072817076584766762987864173856439687228824970773044043621908896041038721919208482030385321521771853153557377752817872804680674458280164899172859354196719784961261227313463295510p -0.3
+ 17822033662586700072817076584766762987864173856439687228824970773044043621908896041038721919208482030385321521771853153557377752817872804680674458280164899172859354196719784961261227313463296000p -0.3
+ 17822033662586700072817076584766762987864173856439687228824970773044043621908896041038721919208482030385321521771853153557377752817872804680674458280164899172859354196719784961261227313463296010p 0.9
+ \]
V_wl_bar_633 (WordLine_bar\\<633\\> gnd!) vsource type=pwl wave=\[
+ 0    0.9
+ 35644067325173400145634153169533525975728347712879374457649941546088087243817792082077443838416964060770643043543706307114755505635745609361348916560329798345718708393439569922522454626926591500p 0.9
+ 35644067325173400145634153169533525975728347712879374457649941546088087243817792082077443838416964060770643043543706307114755505635745609361348916560329798345718708393439569922522454626926591510p -0.3
+ 35644067325173400145634153169533525975728347712879374457649941546088087243817792082077443838416964060770643043543706307114755505635745609361348916560329798345718708393439569922522454626926592000p -0.3
+ 35644067325173400145634153169533525975728347712879374457649941546088087243817792082077443838416964060770643043543706307114755505635745609361348916560329798345718708393439569922522454626926592010p 0.9
+ \]
V_wl_bar_634 (WordLine_bar\\<634\\> gnd!) vsource type=pwl wave=\[
+ 0    0.9
+ 71288134650346800291268306339067051951456695425758748915299883092176174487635584164154887676833928121541286087087412614229511011271491218722697833120659596691437416786879139845044909253853183500p 0.9
+ 71288134650346800291268306339067051951456695425758748915299883092176174487635584164154887676833928121541286087087412614229511011271491218722697833120659596691437416786879139845044909253853183510p -0.3
+ 71288134650346800291268306339067051951456695425758748915299883092176174487635584164154887676833928121541286087087412614229511011271491218722697833120659596691437416786879139845044909253853184000p -0.3
+ 71288134650346800291268306339067051951456695425758748915299883092176174487635584164154887676833928121541286087087412614229511011271491218722697833120659596691437416786879139845044909253853184010p 0.9
+ \]
V_wl_bar_635 (WordLine_bar\\<635\\> gnd!) vsource type=pwl wave=\[
+ 0    0.9
+ 142576269300693600582536612678134103902913390851517497830599766184352348975271168328309775353667856243082572174174825228459022022542982437445395666241319193382874833573758279690089818507706367500p 0.9
+ 142576269300693600582536612678134103902913390851517497830599766184352348975271168328309775353667856243082572174174825228459022022542982437445395666241319193382874833573758279690089818507706367510p -0.3
+ 142576269300693600582536612678134103902913390851517497830599766184352348975271168328309775353667856243082572174174825228459022022542982437445395666241319193382874833573758279690089818507706368000p -0.3
+ 142576269300693600582536612678134103902913390851517497830599766184352348975271168328309775353667856243082572174174825228459022022542982437445395666241319193382874833573758279690089818507706368010p 0.9
+ \]
V_wl_bar_636 (WordLine_bar\\<636\\> gnd!) vsource type=pwl wave=\[
+ 0    0.9
+ 285152538601387201165073225356268207805826781703034995661199532368704697950542336656619550707335712486165144348349650456918044045085964874890791332482638386765749667147516559380179637015412735500p 0.9
+ 285152538601387201165073225356268207805826781703034995661199532368704697950542336656619550707335712486165144348349650456918044045085964874890791332482638386765749667147516559380179637015412735510p -0.3
+ 285152538601387201165073225356268207805826781703034995661199532368704697950542336656619550707335712486165144348349650456918044045085964874890791332482638386765749667147516559380179637015412736000p -0.3
+ 285152538601387201165073225356268207805826781703034995661199532368704697950542336656619550707335712486165144348349650456918044045085964874890791332482638386765749667147516559380179637015412736010p 0.9
+ \]
V_wl_bar_637 (WordLine_bar\\<637\\> gnd!) vsource type=pwl wave=\[
+ 0    0.9
+ 570305077202774402330146450712536415611653563406069991322399064737409395901084673313239101414671424972330288696699300913836088090171929749781582664965276773531499334295033118760359274030825471500p 0.9
+ 570305077202774402330146450712536415611653563406069991322399064737409395901084673313239101414671424972330288696699300913836088090171929749781582664965276773531499334295033118760359274030825471510p -0.3
+ 570305077202774402330146450712536415611653563406069991322399064737409395901084673313239101414671424972330288696699300913836088090171929749781582664965276773531499334295033118760359274030825472000p -0.3
+ 570305077202774402330146450712536415611653563406069991322399064737409395901084673313239101414671424972330288696699300913836088090171929749781582664965276773531499334295033118760359274030825472010p 0.9
+ \]
V_wl_bar_638 (WordLine_bar\\<638\\> gnd!) vsource type=pwl wave=\[
+ 0    0.9
+ 1140610154405548804660292901425072831223307126812139982644798129474818791802169346626478202829342849944660577393398601827672176180343859499563165329930553547062998668590066237520718548061650943500p 0.9
+ 1140610154405548804660292901425072831223307126812139982644798129474818791802169346626478202829342849944660577393398601827672176180343859499563165329930553547062998668590066237520718548061650943510p -0.3
+ 1140610154405548804660292901425072831223307126812139982644798129474818791802169346626478202829342849944660577393398601827672176180343859499563165329930553547062998668590066237520718548061650944000p -0.3
+ 1140610154405548804660292901425072831223307126812139982644798129474818791802169346626478202829342849944660577393398601827672176180343859499563165329930553547062998668590066237520718548061650944010p 0.9
+ \]
V_wl_bar_639 (WordLine_bar\\<639\\> gnd!) vsource type=pwl wave=\[
+ 0    0.9
+ 2281220308811097609320585802850145662446614253624279965289596258949637583604338693252956405658685699889321154786797203655344352360687718999126330659861107094125997337180132475041437096123301887500p 0.9
+ 2281220308811097609320585802850145662446614253624279965289596258949637583604338693252956405658685699889321154786797203655344352360687718999126330659861107094125997337180132475041437096123301887510p -0.3
+ 2281220308811097609320585802850145662446614253624279965289596258949637583604338693252956405658685699889321154786797203655344352360687718999126330659861107094125997337180132475041437096123301888000p -0.3
+ 2281220308811097609320585802850145662446614253624279965289596258949637583604338693252956405658685699889321154786797203655344352360687718999126330659861107094125997337180132475041437096123301888010p 0.9
+ \]
V_wl_bar_640 (WordLine_bar\\<640\\> gnd!) vsource type=pwl wave=\[
+ 0    0.9
+ 4562440617622195218641171605700291324893228507248559930579192517899275167208677386505912811317371399778642309573594407310688704721375437998252661319722214188251994674360264950082874192246603775500p 0.9
+ 4562440617622195218641171605700291324893228507248559930579192517899275167208677386505912811317371399778642309573594407310688704721375437998252661319722214188251994674360264950082874192246603775510p -0.3
+ 4562440617622195218641171605700291324893228507248559930579192517899275167208677386505912811317371399778642309573594407310688704721375437998252661319722214188251994674360264950082874192246603776000p -0.3
+ 4562440617622195218641171605700291324893228507248559930579192517899275167208677386505912811317371399778642309573594407310688704721375437998252661319722214188251994674360264950082874192246603776010p 0.9
+ \]
V_wl_bar_641 (WordLine_bar\\<641\\> gnd!) vsource type=pwl wave=\[
+ 0    0.9
+ 9124881235244390437282343211400582649786457014497119861158385035798550334417354773011825622634742799557284619147188814621377409442750875996505322639444428376503989348720529900165748384493207551500p 0.9
+ 9124881235244390437282343211400582649786457014497119861158385035798550334417354773011825622634742799557284619147188814621377409442750875996505322639444428376503989348720529900165748384493207551510p -0.3
+ 9124881235244390437282343211400582649786457014497119861158385035798550334417354773011825622634742799557284619147188814621377409442750875996505322639444428376503989348720529900165748384493207552000p -0.3
+ 9124881235244390437282343211400582649786457014497119861158385035798550334417354773011825622634742799557284619147188814621377409442750875996505322639444428376503989348720529900165748384493207552010p 0.9
+ \]
V_wl_bar_642 (WordLine_bar\\<642\\> gnd!) vsource type=pwl wave=\[
+ 0    0.9
+ 18249762470488780874564686422801165299572914028994239722316770071597100668834709546023651245269485599114569238294377629242754818885501751993010645278888856753007978697441059800331496768986415103500p 0.9
+ 18249762470488780874564686422801165299572914028994239722316770071597100668834709546023651245269485599114569238294377629242754818885501751993010645278888856753007978697441059800331496768986415103510p -0.3
+ 18249762470488780874564686422801165299572914028994239722316770071597100668834709546023651245269485599114569238294377629242754818885501751993010645278888856753007978697441059800331496768986415104000p -0.3
+ 18249762470488780874564686422801165299572914028994239722316770071597100668834709546023651245269485599114569238294377629242754818885501751993010645278888856753007978697441059800331496768986415104010p 0.9
+ \]
V_wl_bar_643 (WordLine_bar\\<643\\> gnd!) vsource type=pwl wave=\[
+ 0    0.9
+ 36499524940977561749129372845602330599145828057988479444633540143194201337669419092047302490538971198229138476588755258485509637771003503986021290557777713506015957394882119600662993537972830207500p 0.9
+ 36499524940977561749129372845602330599145828057988479444633540143194201337669419092047302490538971198229138476588755258485509637771003503986021290557777713506015957394882119600662993537972830207510p -0.3
+ 36499524940977561749129372845602330599145828057988479444633540143194201337669419092047302490538971198229138476588755258485509637771003503986021290557777713506015957394882119600662993537972830208000p -0.3
+ 36499524940977561749129372845602330599145828057988479444633540143194201337669419092047302490538971198229138476588755258485509637771003503986021290557777713506015957394882119600662993537972830208010p 0.9
+ \]
V_wl_bar_644 (WordLine_bar\\<644\\> gnd!) vsource type=pwl wave=\[
+ 0    0.9
+ 72999049881955123498258745691204661198291656115976958889267080286388402675338838184094604981077942396458276953177510516971019275542007007972042581115555427012031914789764239201325987075945660415500p 0.9
+ 72999049881955123498258745691204661198291656115976958889267080286388402675338838184094604981077942396458276953177510516971019275542007007972042581115555427012031914789764239201325987075945660415510p -0.3
+ 72999049881955123498258745691204661198291656115976958889267080286388402675338838184094604981077942396458276953177510516971019275542007007972042581115555427012031914789764239201325987075945660416000p -0.3
+ 72999049881955123498258745691204661198291656115976958889267080286388402675338838184094604981077942396458276953177510516971019275542007007972042581115555427012031914789764239201325987075945660416010p 0.9
+ \]
V_wl_bar_645 (WordLine_bar\\<645\\> gnd!) vsource type=pwl wave=\[
+ 0    0.9
+ 145998099763910246996517491382409322396583312231953917778534160572776805350677676368189209962155884792916553906355021033942038551084014015944085162231110854024063829579528478402651974151891320831500p 0.9
+ 145998099763910246996517491382409322396583312231953917778534160572776805350677676368189209962155884792916553906355021033942038551084014015944085162231110854024063829579528478402651974151891320831510p -0.3
+ 145998099763910246996517491382409322396583312231953917778534160572776805350677676368189209962155884792916553906355021033942038551084014015944085162231110854024063829579528478402651974151891320832000p -0.3
+ 145998099763910246996517491382409322396583312231953917778534160572776805350677676368189209962155884792916553906355021033942038551084014015944085162231110854024063829579528478402651974151891320832010p 0.9
+ \]
V_wl_bar_646 (WordLine_bar\\<646\\> gnd!) vsource type=pwl wave=\[
+ 0    0.9
+ 291996199527820493993034982764818644793166624463907835557068321145553610701355352736378419924311769585833107812710042067884077102168028031888170324462221708048127659159056956805303948303782641663500p 0.9
+ 291996199527820493993034982764818644793166624463907835557068321145553610701355352736378419924311769585833107812710042067884077102168028031888170324462221708048127659159056956805303948303782641663510p -0.3
+ 291996199527820493993034982764818644793166624463907835557068321145553610701355352736378419924311769585833107812710042067884077102168028031888170324462221708048127659159056956805303948303782641664000p -0.3
+ 291996199527820493993034982764818644793166624463907835557068321145553610701355352736378419924311769585833107812710042067884077102168028031888170324462221708048127659159056956805303948303782641664010p 0.9
+ \]
V_wl_bar_647 (WordLine_bar\\<647\\> gnd!) vsource type=pwl wave=\[
+ 0    0.9
+ 583992399055640987986069965529637289586333248927815671114136642291107221402710705472756839848623539171666215625420084135768154204336056063776340648924443416096255318318113913610607896607565283327500p 0.9
+ 583992399055640987986069965529637289586333248927815671114136642291107221402710705472756839848623539171666215625420084135768154204336056063776340648924443416096255318318113913610607896607565283327510p -0.3
+ 583992399055640987986069965529637289586333248927815671114136642291107221402710705472756839848623539171666215625420084135768154204336056063776340648924443416096255318318113913610607896607565283328000p -0.3
+ 583992399055640987986069965529637289586333248927815671114136642291107221402710705472756839848623539171666215625420084135768154204336056063776340648924443416096255318318113913610607896607565283328010p 0.9
+ \]
V_wl_bar_648 (WordLine_bar\\<648\\> gnd!) vsource type=pwl wave=\[
+ 0    0.9
+ 1167984798111281975972139931059274579172666497855631342228273284582214442805421410945513679697247078343332431250840168271536308408672112127552681297848886832192510636636227827221215793215130566655500p 0.9
+ 1167984798111281975972139931059274579172666497855631342228273284582214442805421410945513679697247078343332431250840168271536308408672112127552681297848886832192510636636227827221215793215130566655510p -0.3
+ 1167984798111281975972139931059274579172666497855631342228273284582214442805421410945513679697247078343332431250840168271536308408672112127552681297848886832192510636636227827221215793215130566656000p -0.3
+ 1167984798111281975972139931059274579172666497855631342228273284582214442805421410945513679697247078343332431250840168271536308408672112127552681297848886832192510636636227827221215793215130566656010p 0.9
+ \]
V_wl_bar_649 (WordLine_bar\\<649\\> gnd!) vsource type=pwl wave=\[
+ 0    0.9
+ 2335969596222563951944279862118549158345332995711262684456546569164428885610842821891027359394494156686664862501680336543072616817344224255105362595697773664385021273272455654442431586430261133311500p 0.9
+ 2335969596222563951944279862118549158345332995711262684456546569164428885610842821891027359394494156686664862501680336543072616817344224255105362595697773664385021273272455654442431586430261133311510p -0.3
+ 2335969596222563951944279862118549158345332995711262684456546569164428885610842821891027359394494156686664862501680336543072616817344224255105362595697773664385021273272455654442431586430261133312000p -0.3
+ 2335969596222563951944279862118549158345332995711262684456546569164428885610842821891027359394494156686664862501680336543072616817344224255105362595697773664385021273272455654442431586430261133312010p 0.9
+ \]
V_wl_bar_650 (WordLine_bar\\<650\\> gnd!) vsource type=pwl wave=\[
+ 0    0.9
+ 4671939192445127903888559724237098316690665991422525368913093138328857771221685643782054718788988313373329725003360673086145233634688448510210725191395547328770042546544911308884863172860522266623500p 0.9
+ 4671939192445127903888559724237098316690665991422525368913093138328857771221685643782054718788988313373329725003360673086145233634688448510210725191395547328770042546544911308884863172860522266623510p -0.3
+ 4671939192445127903888559724237098316690665991422525368913093138328857771221685643782054718788988313373329725003360673086145233634688448510210725191395547328770042546544911308884863172860522266624000p -0.3
+ 4671939192445127903888559724237098316690665991422525368913093138328857771221685643782054718788988313373329725003360673086145233634688448510210725191395547328770042546544911308884863172860522266624010p 0.9
+ \]
V_wl_bar_651 (WordLine_bar\\<651\\> gnd!) vsource type=pwl wave=\[
+ 0    0.9
+ 9343878384890255807777119448474196633381331982845050737826186276657715542443371287564109437577976626746659450006721346172290467269376897020421450382791094657540085093089822617769726345721044533247500p 0.9
+ 9343878384890255807777119448474196633381331982845050737826186276657715542443371287564109437577976626746659450006721346172290467269376897020421450382791094657540085093089822617769726345721044533247510p -0.3
+ 9343878384890255807777119448474196633381331982845050737826186276657715542443371287564109437577976626746659450006721346172290467269376897020421450382791094657540085093089822617769726345721044533248000p -0.3
+ 9343878384890255807777119448474196633381331982845050737826186276657715542443371287564109437577976626746659450006721346172290467269376897020421450382791094657540085093089822617769726345721044533248010p 0.9
+ \]
V_wl_bar_652 (WordLine_bar\\<652\\> gnd!) vsource type=pwl wave=\[
+ 0    0.9
+ 18687756769780511615554238896948393266762663965690101475652372553315431084886742575128218875155953253493318900013442692344580934538753794040842900765582189315080170186179645235539452691442089066495500p 0.9
+ 18687756769780511615554238896948393266762663965690101475652372553315431084886742575128218875155953253493318900013442692344580934538753794040842900765582189315080170186179645235539452691442089066495510p -0.3
+ 18687756769780511615554238896948393266762663965690101475652372553315431084886742575128218875155953253493318900013442692344580934538753794040842900765582189315080170186179645235539452691442089066496000p -0.3
+ 18687756769780511615554238896948393266762663965690101475652372553315431084886742575128218875155953253493318900013442692344580934538753794040842900765582189315080170186179645235539452691442089066496010p 0.9
+ \]
V_wl_bar_653 (WordLine_bar\\<653\\> gnd!) vsource type=pwl wave=\[
+ 0    0.9
+ 37375513539561023231108477793896786533525327931380202951304745106630862169773485150256437750311906506986637800026885384689161869077507588081685801531164378630160340372359290471078905382884178132991500p 0.9
+ 37375513539561023231108477793896786533525327931380202951304745106630862169773485150256437750311906506986637800026885384689161869077507588081685801531164378630160340372359290471078905382884178132991510p -0.3
+ 37375513539561023231108477793896786533525327931380202951304745106630862169773485150256437750311906506986637800026885384689161869077507588081685801531164378630160340372359290471078905382884178132992000p -0.3
+ 37375513539561023231108477793896786533525327931380202951304745106630862169773485150256437750311906506986637800026885384689161869077507588081685801531164378630160340372359290471078905382884178132992010p 0.9
+ \]
V_wl_bar_654 (WordLine_bar\\<654\\> gnd!) vsource type=pwl wave=\[
+ 0    0.9
+ 74751027079122046462216955587793573067050655862760405902609490213261724339546970300512875500623813013973275600053770769378323738155015176163371603062328757260320680744718580942157810765768356265983500p 0.9
+ 74751027079122046462216955587793573067050655862760405902609490213261724339546970300512875500623813013973275600053770769378323738155015176163371603062328757260320680744718580942157810765768356265983510p -0.3
+ 74751027079122046462216955587793573067050655862760405902609490213261724339546970300512875500623813013973275600053770769378323738155015176163371603062328757260320680744718580942157810765768356265984000p -0.3
+ 74751027079122046462216955587793573067050655862760405902609490213261724339546970300512875500623813013973275600053770769378323738155015176163371603062328757260320680744718580942157810765768356265984010p 0.9
+ \]
V_wl_bar_655 (WordLine_bar\\<655\\> gnd!) vsource type=pwl wave=\[
+ 0    0.9
+ 149502054158244092924433911175587146134101311725520811805218980426523448679093940601025751001247626027946551200107541538756647476310030352326743206124657514520641361489437161884315621531536712531967500p 0.9
+ 149502054158244092924433911175587146134101311725520811805218980426523448679093940601025751001247626027946551200107541538756647476310030352326743206124657514520641361489437161884315621531536712531967510p -0.3
+ 149502054158244092924433911175587146134101311725520811805218980426523448679093940601025751001247626027946551200107541538756647476310030352326743206124657514520641361489437161884315621531536712531968000p -0.3
+ 149502054158244092924433911175587146134101311725520811805218980426523448679093940601025751001247626027946551200107541538756647476310030352326743206124657514520641361489437161884315621531536712531968010p 0.9
+ \]
V_wl_bar_656 (WordLine_bar\\<656\\> gnd!) vsource type=pwl wave=\[
+ 0    0.9
+ 299004108316488185848867822351174292268202623451041623610437960853046897358187881202051502002495252055893102400215083077513294952620060704653486412249315029041282722978874323768631243063073425063935500p 0.9
+ 299004108316488185848867822351174292268202623451041623610437960853046897358187881202051502002495252055893102400215083077513294952620060704653486412249315029041282722978874323768631243063073425063935510p -0.3
+ 299004108316488185848867822351174292268202623451041623610437960853046897358187881202051502002495252055893102400215083077513294952620060704653486412249315029041282722978874323768631243063073425063936000p -0.3
+ 299004108316488185848867822351174292268202623451041623610437960853046897358187881202051502002495252055893102400215083077513294952620060704653486412249315029041282722978874323768631243063073425063936010p 0.9
+ \]
V_wl_bar_657 (WordLine_bar\\<657\\> gnd!) vsource type=pwl wave=\[
+ 0    0.9
+ 598008216632976371697735644702348584536405246902083247220875921706093794716375762404103004004990504111786204800430166155026589905240121409306972824498630058082565445957748647537262486126146850127871500p 0.9
+ 598008216632976371697735644702348584536405246902083247220875921706093794716375762404103004004990504111786204800430166155026589905240121409306972824498630058082565445957748647537262486126146850127871510p -0.3
+ 598008216632976371697735644702348584536405246902083247220875921706093794716375762404103004004990504111786204800430166155026589905240121409306972824498630058082565445957748647537262486126146850127872000p -0.3
+ 598008216632976371697735644702348584536405246902083247220875921706093794716375762404103004004990504111786204800430166155026589905240121409306972824498630058082565445957748647537262486126146850127872010p 0.9
+ \]
V_wl_bar_658 (WordLine_bar\\<658\\> gnd!) vsource type=pwl wave=\[
+ 0    0.9
+ 1196016433265952743395471289404697169072810493804166494441751843412187589432751524808206008009981008223572409600860332310053179810480242818613945648997260116165130891915497295074524972252293700255743500p 0.9
+ 1196016433265952743395471289404697169072810493804166494441751843412187589432751524808206008009981008223572409600860332310053179810480242818613945648997260116165130891915497295074524972252293700255743510p -0.3
+ 1196016433265952743395471289404697169072810493804166494441751843412187589432751524808206008009981008223572409600860332310053179810480242818613945648997260116165130891915497295074524972252293700255744000p -0.3
+ 1196016433265952743395471289404697169072810493804166494441751843412187589432751524808206008009981008223572409600860332310053179810480242818613945648997260116165130891915497295074524972252293700255744010p 0.9
+ \]
V_wl_bar_659 (WordLine_bar\\<659\\> gnd!) vsource type=pwl wave=\[
+ 0    0.9
+ 2392032866531905486790942578809394338145620987608332988883503686824375178865503049616412016019962016447144819201720664620106359620960485637227891297994520232330261783830994590149049944504587400511487500p 0.9
+ 2392032866531905486790942578809394338145620987608332988883503686824375178865503049616412016019962016447144819201720664620106359620960485637227891297994520232330261783830994590149049944504587400511487510p -0.3
+ 2392032866531905486790942578809394338145620987608332988883503686824375178865503049616412016019962016447144819201720664620106359620960485637227891297994520232330261783830994590149049944504587400511488000p -0.3
+ 2392032866531905486790942578809394338145620987608332988883503686824375178865503049616412016019962016447144819201720664620106359620960485637227891297994520232330261783830994590149049944504587400511488010p 0.9
+ \]
V_wl_bar_660 (WordLine_bar\\<660\\> gnd!) vsource type=pwl wave=\[
+ 0    0.9
+ 4784065733063810973581885157618788676291241975216665977767007373648750357731006099232824032039924032894289638403441329240212719241920971274455782595989040464660523567661989180298099889009174801022975500p 0.9
+ 4784065733063810973581885157618788676291241975216665977767007373648750357731006099232824032039924032894289638403441329240212719241920971274455782595989040464660523567661989180298099889009174801022975510p -0.3
+ 4784065733063810973581885157618788676291241975216665977767007373648750357731006099232824032039924032894289638403441329240212719241920971274455782595989040464660523567661989180298099889009174801022976000p -0.3
+ 4784065733063810973581885157618788676291241975216665977767007373648750357731006099232824032039924032894289638403441329240212719241920971274455782595989040464660523567661989180298099889009174801022976010p 0.9
+ \]
V_wl_bar_661 (WordLine_bar\\<661\\> gnd!) vsource type=pwl wave=\[
+ 0    0.9
+ 9568131466127621947163770315237577352582483950433331955534014747297500715462012198465648064079848065788579276806882658480425438483841942548911565191978080929321047135323978360596199778018349602045951500p 0.9
+ 9568131466127621947163770315237577352582483950433331955534014747297500715462012198465648064079848065788579276806882658480425438483841942548911565191978080929321047135323978360596199778018349602045951510p -0.3
+ 9568131466127621947163770315237577352582483950433331955534014747297500715462012198465648064079848065788579276806882658480425438483841942548911565191978080929321047135323978360596199778018349602045952000p -0.3
+ 9568131466127621947163770315237577352582483950433331955534014747297500715462012198465648064079848065788579276806882658480425438483841942548911565191978080929321047135323978360596199778018349602045952010p 0.9
+ \]
V_wl_bar_662 (WordLine_bar\\<662\\> gnd!) vsource type=pwl wave=\[
+ 0    0.9
+ 19136262932255243894327540630475154705164967900866663911068029494595001430924024396931296128159696131577158553613765316960850876967683885097823130383956161858642094270647956721192399556036699204091903500p 0.9
+ 19136262932255243894327540630475154705164967900866663911068029494595001430924024396931296128159696131577158553613765316960850876967683885097823130383956161858642094270647956721192399556036699204091903510p -0.3
+ 19136262932255243894327540630475154705164967900866663911068029494595001430924024396931296128159696131577158553613765316960850876967683885097823130383956161858642094270647956721192399556036699204091904000p -0.3
+ 19136262932255243894327540630475154705164967900866663911068029494595001430924024396931296128159696131577158553613765316960850876967683885097823130383956161858642094270647956721192399556036699204091904010p 0.9
+ \]
V_wl_bar_663 (WordLine_bar\\<663\\> gnd!) vsource type=pwl wave=\[
+ 0    0.9
+ 38272525864510487788655081260950309410329935801733327822136058989190002861848048793862592256319392263154317107227530633921701753935367770195646260767912323717284188541295913442384799112073398408183807500p 0.9
+ 38272525864510487788655081260950309410329935801733327822136058989190002861848048793862592256319392263154317107227530633921701753935367770195646260767912323717284188541295913442384799112073398408183807510p -0.3
+ 38272525864510487788655081260950309410329935801733327822136058989190002861848048793862592256319392263154317107227530633921701753935367770195646260767912323717284188541295913442384799112073398408183808000p -0.3
+ 38272525864510487788655081260950309410329935801733327822136058989190002861848048793862592256319392263154317107227530633921701753935367770195646260767912323717284188541295913442384799112073398408183808010p 0.9
+ \]
V_wl_bar_664 (WordLine_bar\\<664\\> gnd!) vsource type=pwl wave=\[
+ 0    0.9
+ 76545051729020975577310162521900618820659871603466655644272117978380005723696097587725184512638784526308634214455061267843403507870735540391292521535824647434568377082591826884769598224146796816367615500p 0.9
+ 76545051729020975577310162521900618820659871603466655644272117978380005723696097587725184512638784526308634214455061267843403507870735540391292521535824647434568377082591826884769598224146796816367615510p -0.3
+ 76545051729020975577310162521900618820659871603466655644272117978380005723696097587725184512638784526308634214455061267843403507870735540391292521535824647434568377082591826884769598224146796816367616000p -0.3
+ 76545051729020975577310162521900618820659871603466655644272117978380005723696097587725184512638784526308634214455061267843403507870735540391292521535824647434568377082591826884769598224146796816367616010p 0.9
+ \]
V_wl_bar_665 (WordLine_bar\\<665\\> gnd!) vsource type=pwl wave=\[
+ 0    0.9
+ 153090103458041951154620325043801237641319743206933311288544235956760011447392195175450369025277569052617268428910122535686807015741471080782585043071649294869136754165183653769539196448293593632735231500p 0.9
+ 153090103458041951154620325043801237641319743206933311288544235956760011447392195175450369025277569052617268428910122535686807015741471080782585043071649294869136754165183653769539196448293593632735231510p -0.3
+ 153090103458041951154620325043801237641319743206933311288544235956760011447392195175450369025277569052617268428910122535686807015741471080782585043071649294869136754165183653769539196448293593632735232000p -0.3
+ 153090103458041951154620325043801237641319743206933311288544235956760011447392195175450369025277569052617268428910122535686807015741471080782585043071649294869136754165183653769539196448293593632735232010p 0.9
+ \]
V_wl_bar_666 (WordLine_bar\\<666\\> gnd!) vsource type=pwl wave=\[
+ 0    0.9
+ 306180206916083902309240650087602475282639486413866622577088471913520022894784390350900738050555138105234536857820245071373614031482942161565170086143298589738273508330367307539078392896587187265470463500p 0.9
+ 306180206916083902309240650087602475282639486413866622577088471913520022894784390350900738050555138105234536857820245071373614031482942161565170086143298589738273508330367307539078392896587187265470463510p -0.3
+ 306180206916083902309240650087602475282639486413866622577088471913520022894784390350900738050555138105234536857820245071373614031482942161565170086143298589738273508330367307539078392896587187265470464000p -0.3
+ 306180206916083902309240650087602475282639486413866622577088471913520022894784390350900738050555138105234536857820245071373614031482942161565170086143298589738273508330367307539078392896587187265470464010p 0.9
+ \]
V_wl_bar_667 (WordLine_bar\\<667\\> gnd!) vsource type=pwl wave=\[
+ 0    0.9
+ 612360413832167804618481300175204950565278972827733245154176943827040045789568780701801476101110276210469073715640490142747228062965884323130340172286597179476547016660734615078156785793174374530940927500p 0.9
+ 612360413832167804618481300175204950565278972827733245154176943827040045789568780701801476101110276210469073715640490142747228062965884323130340172286597179476547016660734615078156785793174374530940927510p -0.3
+ 612360413832167804618481300175204950565278972827733245154176943827040045789568780701801476101110276210469073715640490142747228062965884323130340172286597179476547016660734615078156785793174374530940928000p -0.3
+ 612360413832167804618481300175204950565278972827733245154176943827040045789568780701801476101110276210469073715640490142747228062965884323130340172286597179476547016660734615078156785793174374530940928010p 0.9
+ \]
V_wl_bar_668 (WordLine_bar\\<668\\> gnd!) vsource type=pwl wave=\[
+ 0    0.9
+ 1224720827664335609236962600350409901130557945655466490308353887654080091579137561403602952202220552420938147431280980285494456125931768646260680344573194358953094033321469230156313571586348749061881855500p 0.9
+ 1224720827664335609236962600350409901130557945655466490308353887654080091579137561403602952202220552420938147431280980285494456125931768646260680344573194358953094033321469230156313571586348749061881855510p -0.3
+ 1224720827664335609236962600350409901130557945655466490308353887654080091579137561403602952202220552420938147431280980285494456125931768646260680344573194358953094033321469230156313571586348749061881856000p -0.3
+ 1224720827664335609236962600350409901130557945655466490308353887654080091579137561403602952202220552420938147431280980285494456125931768646260680344573194358953094033321469230156313571586348749061881856010p 0.9
+ \]
V_wl_bar_669 (WordLine_bar\\<669\\> gnd!) vsource type=pwl wave=\[
+ 0    0.9
+ 2449441655328671218473925200700819802261115891310932980616707775308160183158275122807205904404441104841876294862561960570988912251863537292521360689146388717906188066642938460312627143172697498123763711500p 0.9
+ 2449441655328671218473925200700819802261115891310932980616707775308160183158275122807205904404441104841876294862561960570988912251863537292521360689146388717906188066642938460312627143172697498123763711510p -0.3
+ 2449441655328671218473925200700819802261115891310932980616707775308160183158275122807205904404441104841876294862561960570988912251863537292521360689146388717906188066642938460312627143172697498123763712000p -0.3
+ 2449441655328671218473925200700819802261115891310932980616707775308160183158275122807205904404441104841876294862561960570988912251863537292521360689146388717906188066642938460312627143172697498123763712010p 0.9
+ \]
V_wl_bar_670 (WordLine_bar\\<670\\> gnd!) vsource type=pwl wave=\[
+ 0    0.9
+ 4898883310657342436947850401401639604522231782621865961233415550616320366316550245614411808808882209683752589725123921141977824503727074585042721378292777435812376133285876920625254286345394996247527423500p 0.9
+ 4898883310657342436947850401401639604522231782621865961233415550616320366316550245614411808808882209683752589725123921141977824503727074585042721378292777435812376133285876920625254286345394996247527423510p -0.3
+ 4898883310657342436947850401401639604522231782621865961233415550616320366316550245614411808808882209683752589725123921141977824503727074585042721378292777435812376133285876920625254286345394996247527424000p -0.3
+ 4898883310657342436947850401401639604522231782621865961233415550616320366316550245614411808808882209683752589725123921141977824503727074585042721378292777435812376133285876920625254286345394996247527424010p 0.9
+ \]
V_wl_bar_671 (WordLine_bar\\<671\\> gnd!) vsource type=pwl wave=\[
+ 0    0.9
+ 9797766621314684873895700802803279209044463565243731922466831101232640732633100491228823617617764419367505179450247842283955649007454149170085442756585554871624752266571753841250508572690789992495054847500p 0.9
+ 9797766621314684873895700802803279209044463565243731922466831101232640732633100491228823617617764419367505179450247842283955649007454149170085442756585554871624752266571753841250508572690789992495054847510p -0.3
+ 9797766621314684873895700802803279209044463565243731922466831101232640732633100491228823617617764419367505179450247842283955649007454149170085442756585554871624752266571753841250508572690789992495054848000p -0.3
+ 9797766621314684873895700802803279209044463565243731922466831101232640732633100491228823617617764419367505179450247842283955649007454149170085442756585554871624752266571753841250508572690789992495054848010p 0.9
+ \]
V_wl_bar_672 (WordLine_bar\\<672\\> gnd!) vsource type=pwl wave=\[
+ 0    0.9
+ 19595533242629369747791401605606558418088927130487463844933662202465281465266200982457647235235528838735010358900495684567911298014908298340170885513171109743249504533143507682501017145381579984990109695500p 0.9
+ 19595533242629369747791401605606558418088927130487463844933662202465281465266200982457647235235528838735010358900495684567911298014908298340170885513171109743249504533143507682501017145381579984990109695510p -0.3
+ 19595533242629369747791401605606558418088927130487463844933662202465281465266200982457647235235528838735010358900495684567911298014908298340170885513171109743249504533143507682501017145381579984990109696000p -0.3
+ 19595533242629369747791401605606558418088927130487463844933662202465281465266200982457647235235528838735010358900495684567911298014908298340170885513171109743249504533143507682501017145381579984990109696010p 0.9
+ \]
V_wl_bar_673 (WordLine_bar\\<673\\> gnd!) vsource type=pwl wave=\[
+ 0    0.9
+ 39191066485258739495582803211213116836177854260974927689867324404930562930532401964915294470471057677470020717800991369135822596029816596680341771026342219486499009066287015365002034290763159969980219391500p 0.9
+ 39191066485258739495582803211213116836177854260974927689867324404930562930532401964915294470471057677470020717800991369135822596029816596680341771026342219486499009066287015365002034290763159969980219391510p -0.3
+ 39191066485258739495582803211213116836177854260974927689867324404930562930532401964915294470471057677470020717800991369135822596029816596680341771026342219486499009066287015365002034290763159969980219392000p -0.3
+ 39191066485258739495582803211213116836177854260974927689867324404930562930532401964915294470471057677470020717800991369135822596029816596680341771026342219486499009066287015365002034290763159969980219392010p 0.9
+ \]
V_wl_bar_674 (WordLine_bar\\<674\\> gnd!) vsource type=pwl wave=\[
+ 0    0.9
+ 78382132970517478991165606422426233672355708521949855379734648809861125861064803929830588940942115354940041435601982738271645192059633193360683542052684438972998018132574030730004068581526319939960438783500p 0.9
+ 78382132970517478991165606422426233672355708521949855379734648809861125861064803929830588940942115354940041435601982738271645192059633193360683542052684438972998018132574030730004068581526319939960438783510p -0.3
+ 78382132970517478991165606422426233672355708521949855379734648809861125861064803929830588940942115354940041435601982738271645192059633193360683542052684438972998018132574030730004068581526319939960438784000p -0.3
+ 78382132970517478991165606422426233672355708521949855379734648809861125861064803929830588940942115354940041435601982738271645192059633193360683542052684438972998018132574030730004068581526319939960438784010p 0.9
+ \]
V_wl_bar_675 (WordLine_bar\\<675\\> gnd!) vsource type=pwl wave=\[
+ 0    0.9
+ 156764265941034957982331212844852467344711417043899710759469297619722251722129607859661177881884230709880082871203965476543290384119266386721367084105368877945996036265148061460008137163052639879920877567500p 0.9
+ 156764265941034957982331212844852467344711417043899710759469297619722251722129607859661177881884230709880082871203965476543290384119266386721367084105368877945996036265148061460008137163052639879920877567510p -0.3
+ 156764265941034957982331212844852467344711417043899710759469297619722251722129607859661177881884230709880082871203965476543290384119266386721367084105368877945996036265148061460008137163052639879920877568000p -0.3
+ 156764265941034957982331212844852467344711417043899710759469297619722251722129607859661177881884230709880082871203965476543290384119266386721367084105368877945996036265148061460008137163052639879920877568010p 0.9
+ \]
V_wl_bar_676 (WordLine_bar\\<676\\> gnd!) vsource type=pwl wave=\[
+ 0    0.9
+ 313528531882069915964662425689704934689422834087799421518938595239444503444259215719322355763768461419760165742407930953086580768238532773442734168210737755891992072530296122920016274326105279759841755135500p 0.9
+ 313528531882069915964662425689704934689422834087799421518938595239444503444259215719322355763768461419760165742407930953086580768238532773442734168210737755891992072530296122920016274326105279759841755135510p -0.3
+ 313528531882069915964662425689704934689422834087799421518938595239444503444259215719322355763768461419760165742407930953086580768238532773442734168210737755891992072530296122920016274326105279759841755136000p -0.3
+ 313528531882069915964662425689704934689422834087799421518938595239444503444259215719322355763768461419760165742407930953086580768238532773442734168210737755891992072530296122920016274326105279759841755136010p 0.9
+ \]
V_wl_bar_677 (WordLine_bar\\<677\\> gnd!) vsource type=pwl wave=\[
+ 0    0.9
+ 627057063764139831929324851379409869378845668175598843037877190478889006888518431438644711527536922839520331484815861906173161536477065546885468336421475511783984145060592245840032548652210559519683510271500p 0.9
+ 627057063764139831929324851379409869378845668175598843037877190478889006888518431438644711527536922839520331484815861906173161536477065546885468336421475511783984145060592245840032548652210559519683510271510p -0.3
+ 627057063764139831929324851379409869378845668175598843037877190478889006888518431438644711527536922839520331484815861906173161536477065546885468336421475511783984145060592245840032548652210559519683510272000p -0.3
+ 627057063764139831929324851379409869378845668175598843037877190478889006888518431438644711527536922839520331484815861906173161536477065546885468336421475511783984145060592245840032548652210559519683510272010p 0.9
+ \]
V_wl_bar_678 (WordLine_bar\\<678\\> gnd!) vsource type=pwl wave=\[
+ 0    0.9
+ 1254114127528279663858649702758819738757691336351197686075754380957778013777036862877289423055073845679040662969631723812346323072954131093770936672842951023567968290121184491680065097304421119039367020543500p 0.9
+ 1254114127528279663858649702758819738757691336351197686075754380957778013777036862877289423055073845679040662969631723812346323072954131093770936672842951023567968290121184491680065097304421119039367020543510p -0.3
+ 1254114127528279663858649702758819738757691336351197686075754380957778013777036862877289423055073845679040662969631723812346323072954131093770936672842951023567968290121184491680065097304421119039367020544000p -0.3
+ 1254114127528279663858649702758819738757691336351197686075754380957778013777036862877289423055073845679040662969631723812346323072954131093770936672842951023567968290121184491680065097304421119039367020544010p 0.9
+ \]
V_wl_bar_679 (WordLine_bar\\<679\\> gnd!) vsource type=pwl wave=\[
+ 0    0.9
+ 2508228255056559327717299405517639477515382672702395372151508761915556027554073725754578846110147691358081325939263447624692646145908262187541873345685902047135936580242368983360130194608842238078734041087500p 0.9
+ 2508228255056559327717299405517639477515382672702395372151508761915556027554073725754578846110147691358081325939263447624692646145908262187541873345685902047135936580242368983360130194608842238078734041087510p -0.3
+ 2508228255056559327717299405517639477515382672702395372151508761915556027554073725754578846110147691358081325939263447624692646145908262187541873345685902047135936580242368983360130194608842238078734041088000p -0.3
+ 2508228255056559327717299405517639477515382672702395372151508761915556027554073725754578846110147691358081325939263447624692646145908262187541873345685902047135936580242368983360130194608842238078734041088010p 0.9
+ \]
V_wl_bar_680 (WordLine_bar\\<680\\> gnd!) vsource type=pwl wave=\[
+ 0    0.9
+ 5016456510113118655434598811035278955030765345404790744303017523831112055108147451509157692220295382716162651878526895249385292291816524375083746691371804094271873160484737966720260389217684476157468082175500p 0.9
+ 5016456510113118655434598811035278955030765345404790744303017523831112055108147451509157692220295382716162651878526895249385292291816524375083746691371804094271873160484737966720260389217684476157468082175510p -0.3
+ 5016456510113118655434598811035278955030765345404790744303017523831112055108147451509157692220295382716162651878526895249385292291816524375083746691371804094271873160484737966720260389217684476157468082176000p -0.3
+ 5016456510113118655434598811035278955030765345404790744303017523831112055108147451509157692220295382716162651878526895249385292291816524375083746691371804094271873160484737966720260389217684476157468082176010p 0.9
+ \]
V_wl_bar_681 (WordLine_bar\\<681\\> gnd!) vsource type=pwl wave=\[
+ 0    0.9
+ 10032913020226237310869197622070557910061530690809581488606035047662224110216294903018315384440590765432325303757053790498770584583633048750167493382743608188543746320969475933440520778435368952314936164351500p 0.9
+ 10032913020226237310869197622070557910061530690809581488606035047662224110216294903018315384440590765432325303757053790498770584583633048750167493382743608188543746320969475933440520778435368952314936164351510p -0.3
+ 10032913020226237310869197622070557910061530690809581488606035047662224110216294903018315384440590765432325303757053790498770584583633048750167493382743608188543746320969475933440520778435368952314936164352000p -0.3
+ 10032913020226237310869197622070557910061530690809581488606035047662224110216294903018315384440590765432325303757053790498770584583633048750167493382743608188543746320969475933440520778435368952314936164352010p 0.9
+ \]
V_wl_bar_682 (WordLine_bar\\<682\\> gnd!) vsource type=pwl wave=\[
+ 0    0.9
+ 20065826040452474621738395244141115820123061381619162977212070095324448220432589806036630768881181530864650607514107580997541169167266097500334986765487216377087492641938951866881041556870737904629872328703500p 0.9
+ 20065826040452474621738395244141115820123061381619162977212070095324448220432589806036630768881181530864650607514107580997541169167266097500334986765487216377087492641938951866881041556870737904629872328703510p -0.3
+ 20065826040452474621738395244141115820123061381619162977212070095324448220432589806036630768881181530864650607514107580997541169167266097500334986765487216377087492641938951866881041556870737904629872328704000p -0.3
+ 20065826040452474621738395244141115820123061381619162977212070095324448220432589806036630768881181530864650607514107580997541169167266097500334986765487216377087492641938951866881041556870737904629872328704010p 0.9
+ \]
V_wl_bar_683 (WordLine_bar\\<683\\> gnd!) vsource type=pwl wave=\[
+ 0    0.9
+ 40131652080904949243476790488282231640246122763238325954424140190648896440865179612073261537762363061729301215028215161995082338334532195000669973530974432754174985283877903733762083113741475809259744657407500p 0.9
+ 40131652080904949243476790488282231640246122763238325954424140190648896440865179612073261537762363061729301215028215161995082338334532195000669973530974432754174985283877903733762083113741475809259744657407510p -0.3
+ 40131652080904949243476790488282231640246122763238325954424140190648896440865179612073261537762363061729301215028215161995082338334532195000669973530974432754174985283877903733762083113741475809259744657408000p -0.3
+ 40131652080904949243476790488282231640246122763238325954424140190648896440865179612073261537762363061729301215028215161995082338334532195000669973530974432754174985283877903733762083113741475809259744657408010p 0.9
+ \]
V_wl_bar_684 (WordLine_bar\\<684\\> gnd!) vsource type=pwl wave=\[
+ 0    0.9
+ 80263304161809898486953580976564463280492245526476651908848280381297792881730359224146523075524726123458602430056430323990164676669064390001339947061948865508349970567755807467524166227482951618519489314815500p 0.9
+ 80263304161809898486953580976564463280492245526476651908848280381297792881730359224146523075524726123458602430056430323990164676669064390001339947061948865508349970567755807467524166227482951618519489314815510p -0.3
+ 80263304161809898486953580976564463280492245526476651908848280381297792881730359224146523075524726123458602430056430323990164676669064390001339947061948865508349970567755807467524166227482951618519489314816000p -0.3
+ 80263304161809898486953580976564463280492245526476651908848280381297792881730359224146523075524726123458602430056430323990164676669064390001339947061948865508349970567755807467524166227482951618519489314816010p 0.9
+ \]
V_wl_bar_685 (WordLine_bar\\<685\\> gnd!) vsource type=pwl wave=\[
+ 0    0.9
+ 160526608323619796973907161953128926560984491052953303817696560762595585763460718448293046151049452246917204860112860647980329353338128780002679894123897731016699941135511614935048332454965903237038978629631500p 0.9
+ 160526608323619796973907161953128926560984491052953303817696560762595585763460718448293046151049452246917204860112860647980329353338128780002679894123897731016699941135511614935048332454965903237038978629631510p -0.3
+ 160526608323619796973907161953128926560984491052953303817696560762595585763460718448293046151049452246917204860112860647980329353338128780002679894123897731016699941135511614935048332454965903237038978629632000p -0.3
+ 160526608323619796973907161953128926560984491052953303817696560762595585763460718448293046151049452246917204860112860647980329353338128780002679894123897731016699941135511614935048332454965903237038978629632010p 0.9
+ \]
V_wl_bar_686 (WordLine_bar\\<686\\> gnd!) vsource type=pwl wave=\[
+ 0    0.9
+ 321053216647239593947814323906257853121968982105906607635393121525191171526921436896586092302098904493834409720225721295960658706676257560005359788247795462033399882271023229870096664909931806474077957259263500p 0.9
+ 321053216647239593947814323906257853121968982105906607635393121525191171526921436896586092302098904493834409720225721295960658706676257560005359788247795462033399882271023229870096664909931806474077957259263510p -0.3
+ 321053216647239593947814323906257853121968982105906607635393121525191171526921436896586092302098904493834409720225721295960658706676257560005359788247795462033399882271023229870096664909931806474077957259264000p -0.3
+ 321053216647239593947814323906257853121968982105906607635393121525191171526921436896586092302098904493834409720225721295960658706676257560005359788247795462033399882271023229870096664909931806474077957259264010p 0.9
+ \]
V_wl_bar_687 (WordLine_bar\\<687\\> gnd!) vsource type=pwl wave=\[
+ 0    0.9
+ 642106433294479187895628647812515706243937964211813215270786243050382343053842873793172184604197808987668819440451442591921317413352515120010719576495590924066799764542046459740193329819863612948155914518527500p 0.9
+ 642106433294479187895628647812515706243937964211813215270786243050382343053842873793172184604197808987668819440451442591921317413352515120010719576495590924066799764542046459740193329819863612948155914518527510p -0.3
+ 642106433294479187895628647812515706243937964211813215270786243050382343053842873793172184604197808987668819440451442591921317413352515120010719576495590924066799764542046459740193329819863612948155914518528000p -0.3
+ 642106433294479187895628647812515706243937964211813215270786243050382343053842873793172184604197808987668819440451442591921317413352515120010719576495590924066799764542046459740193329819863612948155914518528010p 0.9
+ \]
V_wl_bar_688 (WordLine_bar\\<688\\> gnd!) vsource type=pwl wave=\[
+ 0    0.9
+ 1284212866588958375791257295625031412487875928423626430541572486100764686107685747586344369208395617975337638880902885183842634826705030240021439152991181848133599529084092919480386659639727225896311829037055500p 0.9
+ 1284212866588958375791257295625031412487875928423626430541572486100764686107685747586344369208395617975337638880902885183842634826705030240021439152991181848133599529084092919480386659639727225896311829037055510p -0.3
+ 1284212866588958375791257295625031412487875928423626430541572486100764686107685747586344369208395617975337638880902885183842634826705030240021439152991181848133599529084092919480386659639727225896311829037056000p -0.3
+ 1284212866588958375791257295625031412487875928423626430541572486100764686107685747586344369208395617975337638880902885183842634826705030240021439152991181848133599529084092919480386659639727225896311829037056010p 0.9
+ \]
V_wl_bar_689 (WordLine_bar\\<689\\> gnd!) vsource type=pwl wave=\[
+ 0    0.9
+ 2568425733177916751582514591250062824975751856847252861083144972201529372215371495172688738416791235950675277761805770367685269653410060480042878305982363696267199058168185838960773319279454451792623658074111500p 0.9
+ 2568425733177916751582514591250062824975751856847252861083144972201529372215371495172688738416791235950675277761805770367685269653410060480042878305982363696267199058168185838960773319279454451792623658074111510p -0.3
+ 2568425733177916751582514591250062824975751856847252861083144972201529372215371495172688738416791235950675277761805770367685269653410060480042878305982363696267199058168185838960773319279454451792623658074112000p -0.3
+ 2568425733177916751582514591250062824975751856847252861083144972201529372215371495172688738416791235950675277761805770367685269653410060480042878305982363696267199058168185838960773319279454451792623658074112010p 0.9
+ \]
V_wl_bar_690 (WordLine_bar\\<690\\> gnd!) vsource type=pwl wave=\[
+ 0    0.9
+ 5136851466355833503165029182500125649951503713694505722166289944403058744430742990345377476833582471901350555523611540735370539306820120960085756611964727392534398116336371677921546638558908903585247316148223500p 0.9
+ 5136851466355833503165029182500125649951503713694505722166289944403058744430742990345377476833582471901350555523611540735370539306820120960085756611964727392534398116336371677921546638558908903585247316148223510p -0.3
+ 5136851466355833503165029182500125649951503713694505722166289944403058744430742990345377476833582471901350555523611540735370539306820120960085756611964727392534398116336371677921546638558908903585247316148224000p -0.3
+ 5136851466355833503165029182500125649951503713694505722166289944403058744430742990345377476833582471901350555523611540735370539306820120960085756611964727392534398116336371677921546638558908903585247316148224010p 0.9
+ \]
V_wl_bar_691 (WordLine_bar\\<691\\> gnd!) vsource type=pwl wave=\[
+ 0    0.9
+ 10273702932711667006330058365000251299903007427389011444332579888806117488861485980690754953667164943802701111047223081470741078613640241920171513223929454785068796232672743355843093277117817807170494632296447500p 0.9
+ 10273702932711667006330058365000251299903007427389011444332579888806117488861485980690754953667164943802701111047223081470741078613640241920171513223929454785068796232672743355843093277117817807170494632296447510p -0.3
+ 10273702932711667006330058365000251299903007427389011444332579888806117488861485980690754953667164943802701111047223081470741078613640241920171513223929454785068796232672743355843093277117817807170494632296448000p -0.3
+ 10273702932711667006330058365000251299903007427389011444332579888806117488861485980690754953667164943802701111047223081470741078613640241920171513223929454785068796232672743355843093277117817807170494632296448010p 0.9
+ \]
V_wl_bar_692 (WordLine_bar\\<692\\> gnd!) vsource type=pwl wave=\[
+ 0    0.9
+ 20547405865423334012660116730000502599806014854778022888665159777612234977722971961381509907334329887605402222094446162941482157227280483840343026447858909570137592465345486711686186554235635614340989264592895500p 0.9
+ 20547405865423334012660116730000502599806014854778022888665159777612234977722971961381509907334329887605402222094446162941482157227280483840343026447858909570137592465345486711686186554235635614340989264592895510p -0.3
+ 20547405865423334012660116730000502599806014854778022888665159777612234977722971961381509907334329887605402222094446162941482157227280483840343026447858909570137592465345486711686186554235635614340989264592896000p -0.3
+ 20547405865423334012660116730000502599806014854778022888665159777612234977722971961381509907334329887605402222094446162941482157227280483840343026447858909570137592465345486711686186554235635614340989264592896010p 0.9
+ \]
V_wl_bar_693 (WordLine_bar\\<693\\> gnd!) vsource type=pwl wave=\[
+ 0    0.9
+ 41094811730846668025320233460001005199612029709556045777330319555224469955445943922763019814668659775210804444188892325882964314454560967680686052895717819140275184930690973423372373108471271228681978529185791500p 0.9
+ 41094811730846668025320233460001005199612029709556045777330319555224469955445943922763019814668659775210804444188892325882964314454560967680686052895717819140275184930690973423372373108471271228681978529185791510p -0.3
+ 41094811730846668025320233460001005199612029709556045777330319555224469955445943922763019814668659775210804444188892325882964314454560967680686052895717819140275184930690973423372373108471271228681978529185792000p -0.3
+ 41094811730846668025320233460001005199612029709556045777330319555224469955445943922763019814668659775210804444188892325882964314454560967680686052895717819140275184930690973423372373108471271228681978529185792010p 0.9
+ \]
V_wl_bar_694 (WordLine_bar\\<694\\> gnd!) vsource type=pwl wave=\[
+ 0    0.9
+ 82189623461693336050640466920002010399224059419112091554660639110448939910891887845526039629337319550421608888377784651765928628909121935361372105791435638280550369861381946846744746216942542457363957058371583500p 0.9
+ 82189623461693336050640466920002010399224059419112091554660639110448939910891887845526039629337319550421608888377784651765928628909121935361372105791435638280550369861381946846744746216942542457363957058371583510p -0.3
+ 82189623461693336050640466920002010399224059419112091554660639110448939910891887845526039629337319550421608888377784651765928628909121935361372105791435638280550369861381946846744746216942542457363957058371584000p -0.3
+ 82189623461693336050640466920002010399224059419112091554660639110448939910891887845526039629337319550421608888377784651765928628909121935361372105791435638280550369861381946846744746216942542457363957058371584010p 0.9
+ \]
V_wl_bar_695 (WordLine_bar\\<695\\> gnd!) vsource type=pwl wave=\[
+ 0    0.9
+ 164379246923386672101280933840004020798448118838224183109321278220897879821783775691052079258674639100843217776755569303531857257818243870722744211582871276561100739722763893693489492433885084914727914116743167500p 0.9
+ 164379246923386672101280933840004020798448118838224183109321278220897879821783775691052079258674639100843217776755569303531857257818243870722744211582871276561100739722763893693489492433885084914727914116743167510p -0.3
+ 164379246923386672101280933840004020798448118838224183109321278220897879821783775691052079258674639100843217776755569303531857257818243870722744211582871276561100739722763893693489492433885084914727914116743168000p -0.3
+ 164379246923386672101280933840004020798448118838224183109321278220897879821783775691052079258674639100843217776755569303531857257818243870722744211582871276561100739722763893693489492433885084914727914116743168010p 0.9
+ \]
V_wl_bar_696 (WordLine_bar\\<696\\> gnd!) vsource type=pwl wave=\[
+ 0    0.9
+ 328758493846773344202561867680008041596896237676448366218642556441795759643567551382104158517349278201686435553511138607063714515636487741445488423165742553122201479445527787386978984867770169829455828233486335500p 0.9
+ 328758493846773344202561867680008041596896237676448366218642556441795759643567551382104158517349278201686435553511138607063714515636487741445488423165742553122201479445527787386978984867770169829455828233486335510p -0.3
+ 328758493846773344202561867680008041596896237676448366218642556441795759643567551382104158517349278201686435553511138607063714515636487741445488423165742553122201479445527787386978984867770169829455828233486336000p -0.3
+ 328758493846773344202561867680008041596896237676448366218642556441795759643567551382104158517349278201686435553511138607063714515636487741445488423165742553122201479445527787386978984867770169829455828233486336010p 0.9
+ \]
V_wl_bar_697 (WordLine_bar\\<697\\> gnd!) vsource type=pwl wave=\[
+ 0    0.9
+ 657516987693546688405123735360016083193792475352896732437285112883591519287135102764208317034698556403372871107022277214127429031272975482890976846331485106244402958891055574773957969735540339658911656466972671500p 0.9
+ 657516987693546688405123735360016083193792475352896732437285112883591519287135102764208317034698556403372871107022277214127429031272975482890976846331485106244402958891055574773957969735540339658911656466972671510p -0.3
+ 657516987693546688405123735360016083193792475352896732437285112883591519287135102764208317034698556403372871107022277214127429031272975482890976846331485106244402958891055574773957969735540339658911656466972672000p -0.3
+ 657516987693546688405123735360016083193792475352896732437285112883591519287135102764208317034698556403372871107022277214127429031272975482890976846331485106244402958891055574773957969735540339658911656466972672010p 0.9
+ \]
V_wl_bar_698 (WordLine_bar\\<698\\> gnd!) vsource type=pwl wave=\[
+ 0    0.9
+ 1315033975387093376810247470720032166387584950705793464874570225767183038574270205528416634069397112806745742214044554428254858062545950965781953692662970212488805917782111149547915939471080679317823312933945343500p 0.9
+ 1315033975387093376810247470720032166387584950705793464874570225767183038574270205528416634069397112806745742214044554428254858062545950965781953692662970212488805917782111149547915939471080679317823312933945343510p -0.3
+ 1315033975387093376810247470720032166387584950705793464874570225767183038574270205528416634069397112806745742214044554428254858062545950965781953692662970212488805917782111149547915939471080679317823312933945344000p -0.3
+ 1315033975387093376810247470720032166387584950705793464874570225767183038574270205528416634069397112806745742214044554428254858062545950965781953692662970212488805917782111149547915939471080679317823312933945344010p 0.9
+ \]
V_wl_bar_699 (WordLine_bar\\<699\\> gnd!) vsource type=pwl wave=\[
+ 0    0.9
+ 2630067950774186753620494941440064332775169901411586929749140451534366077148540411056833268138794225613491484428089108856509716125091901931563907385325940424977611835564222299095831878942161358635646625867890687500p 0.9
+ 2630067950774186753620494941440064332775169901411586929749140451534366077148540411056833268138794225613491484428089108856509716125091901931563907385325940424977611835564222299095831878942161358635646625867890687510p -0.3
+ 2630067950774186753620494941440064332775169901411586929749140451534366077148540411056833268138794225613491484428089108856509716125091901931563907385325940424977611835564222299095831878942161358635646625867890688000p -0.3
+ 2630067950774186753620494941440064332775169901411586929749140451534366077148540411056833268138794225613491484428089108856509716125091901931563907385325940424977611835564222299095831878942161358635646625867890688010p 0.9
+ \]
V_wl_bar_700 (WordLine_bar\\<700\\> gnd!) vsource type=pwl wave=\[
+ 0    0.9
+ 5260135901548373507240989882880128665550339802823173859498280903068732154297080822113666536277588451226982968856178217713019432250183803863127814770651880849955223671128444598191663757884322717271293251735781375500p 0.9
+ 5260135901548373507240989882880128665550339802823173859498280903068732154297080822113666536277588451226982968856178217713019432250183803863127814770651880849955223671128444598191663757884322717271293251735781375510p -0.3
+ 5260135901548373507240989882880128665550339802823173859498280903068732154297080822113666536277588451226982968856178217713019432250183803863127814770651880849955223671128444598191663757884322717271293251735781376000p -0.3
+ 5260135901548373507240989882880128665550339802823173859498280903068732154297080822113666536277588451226982968856178217713019432250183803863127814770651880849955223671128444598191663757884322717271293251735781376010p 0.9
+ \]
V_wl_bar_701 (WordLine_bar\\<701\\> gnd!) vsource type=pwl wave=\[
+ 0    0.9
+ 10520271803096747014481979765760257331100679605646347718996561806137464308594161644227333072555176902453965937712356435426038864500367607726255629541303761699910447342256889196383327515768645434542586503471562751500p 0.9
+ 10520271803096747014481979765760257331100679605646347718996561806137464308594161644227333072555176902453965937712356435426038864500367607726255629541303761699910447342256889196383327515768645434542586503471562751510p -0.3
+ 10520271803096747014481979765760257331100679605646347718996561806137464308594161644227333072555176902453965937712356435426038864500367607726255629541303761699910447342256889196383327515768645434542586503471562752000p -0.3
+ 10520271803096747014481979765760257331100679605646347718996561806137464308594161644227333072555176902453965937712356435426038864500367607726255629541303761699910447342256889196383327515768645434542586503471562752010p 0.9
+ \]
V_wl_bar_702 (WordLine_bar\\<702\\> gnd!) vsource type=pwl wave=\[
+ 0    0.9
+ 21040543606193494028963959531520514662201359211292695437993123612274928617188323288454666145110353804907931875424712870852077729000735215452511259082607523399820894684513778392766655031537290869085173006943125503500p 0.9
+ 21040543606193494028963959531520514662201359211292695437993123612274928617188323288454666145110353804907931875424712870852077729000735215452511259082607523399820894684513778392766655031537290869085173006943125503510p -0.3
+ 21040543606193494028963959531520514662201359211292695437993123612274928617188323288454666145110353804907931875424712870852077729000735215452511259082607523399820894684513778392766655031537290869085173006943125504000p -0.3
+ 21040543606193494028963959531520514662201359211292695437993123612274928617188323288454666145110353804907931875424712870852077729000735215452511259082607523399820894684513778392766655031537290869085173006943125504010p 0.9
+ \]
V_wl_bar_703 (WordLine_bar\\<703\\> gnd!) vsource type=pwl wave=\[
+ 0    0.9
+ 42081087212386988057927919063041029324402718422585390875986247224549857234376646576909332290220707609815863750849425741704155458001470430905022518165215046799641789369027556785533310063074581738170346013886251007500p 0.9
+ 42081087212386988057927919063041029324402718422585390875986247224549857234376646576909332290220707609815863750849425741704155458001470430905022518165215046799641789369027556785533310063074581738170346013886251007510p -0.3
+ 42081087212386988057927919063041029324402718422585390875986247224549857234376646576909332290220707609815863750849425741704155458001470430905022518165215046799641789369027556785533310063074581738170346013886251008000p -0.3
+ 42081087212386988057927919063041029324402718422585390875986247224549857234376646576909332290220707609815863750849425741704155458001470430905022518165215046799641789369027556785533310063074581738170346013886251008010p 0.9
+ \]
V_wl_bar_704 (WordLine_bar\\<704\\> gnd!) vsource type=pwl wave=\[
+ 0    0.9
+ 84162174424773976115855838126082058648805436845170781751972494449099714468753293153818664580441415219631727501698851483408310916002940861810045036330430093599283578738055113571066620126149163476340692027772502015500p 0.9
+ 84162174424773976115855838126082058648805436845170781751972494449099714468753293153818664580441415219631727501698851483408310916002940861810045036330430093599283578738055113571066620126149163476340692027772502015510p -0.3
+ 84162174424773976115855838126082058648805436845170781751972494449099714468753293153818664580441415219631727501698851483408310916002940861810045036330430093599283578738055113571066620126149163476340692027772502016000p -0.3
+ 84162174424773976115855838126082058648805436845170781751972494449099714468753293153818664580441415219631727501698851483408310916002940861810045036330430093599283578738055113571066620126149163476340692027772502016010p 0.9
+ \]
V_wl_bar_705 (WordLine_bar\\<705\\> gnd!) vsource type=pwl wave=\[
+ 0    0.9
+ 168324348849547952231711676252164117297610873690341563503944988898199428937506586307637329160882830439263455003397702966816621832005881723620090072660860187198567157476110227142133240252298326952681384055545004031500p 0.9
+ 168324348849547952231711676252164117297610873690341563503944988898199428937506586307637329160882830439263455003397702966816621832005881723620090072660860187198567157476110227142133240252298326952681384055545004031510p -0.3
+ 168324348849547952231711676252164117297610873690341563503944988898199428937506586307637329160882830439263455003397702966816621832005881723620090072660860187198567157476110227142133240252298326952681384055545004032000p -0.3
+ 168324348849547952231711676252164117297610873690341563503944988898199428937506586307637329160882830439263455003397702966816621832005881723620090072660860187198567157476110227142133240252298326952681384055545004032010p 0.9
+ \]
V_wl_bar_706 (WordLine_bar\\<706\\> gnd!) vsource type=pwl wave=\[
+ 0    0.9
+ 336648697699095904463423352504328234595221747380683127007889977796398857875013172615274658321765660878526910006795405933633243664011763447240180145321720374397134314952220454284266480504596653905362768111090008063500p 0.9
+ 336648697699095904463423352504328234595221747380683127007889977796398857875013172615274658321765660878526910006795405933633243664011763447240180145321720374397134314952220454284266480504596653905362768111090008063510p -0.3
+ 336648697699095904463423352504328234595221747380683127007889977796398857875013172615274658321765660878526910006795405933633243664011763447240180145321720374397134314952220454284266480504596653905362768111090008064000p -0.3
+ 336648697699095904463423352504328234595221747380683127007889977796398857875013172615274658321765660878526910006795405933633243664011763447240180145321720374397134314952220454284266480504596653905362768111090008064010p 0.9
+ \]
V_wl_bar_707 (WordLine_bar\\<707\\> gnd!) vsource type=pwl wave=\[
+ 0    0.9
+ 673297395398191808926846705008656469190443494761366254015779955592797715750026345230549316643531321757053820013590811867266487328023526894480360290643440748794268629904440908568532961009193307810725536222180016127500p 0.9
+ 673297395398191808926846705008656469190443494761366254015779955592797715750026345230549316643531321757053820013590811867266487328023526894480360290643440748794268629904440908568532961009193307810725536222180016127510p -0.3
+ 673297395398191808926846705008656469190443494761366254015779955592797715750026345230549316643531321757053820013590811867266487328023526894480360290643440748794268629904440908568532961009193307810725536222180016128000p -0.3
+ 673297395398191808926846705008656469190443494761366254015779955592797715750026345230549316643531321757053820013590811867266487328023526894480360290643440748794268629904440908568532961009193307810725536222180016128010p 0.9
+ \]
V_wl_bar_708 (WordLine_bar\\<708\\> gnd!) vsource type=pwl wave=\[
+ 0    0.9
+ 1346594790796383617853693410017312938380886989522732508031559911185595431500052690461098633287062643514107640027181623734532974656047053788960720581286881497588537259808881817137065922018386615621451072444360032255500p 0.9
+ 1346594790796383617853693410017312938380886989522732508031559911185595431500052690461098633287062643514107640027181623734532974656047053788960720581286881497588537259808881817137065922018386615621451072444360032255510p -0.3
+ 1346594790796383617853693410017312938380886989522732508031559911185595431500052690461098633287062643514107640027181623734532974656047053788960720581286881497588537259808881817137065922018386615621451072444360032256000p -0.3
+ 1346594790796383617853693410017312938380886989522732508031559911185595431500052690461098633287062643514107640027181623734532974656047053788960720581286881497588537259808881817137065922018386615621451072444360032256010p 0.9
+ \]
V_wl_bar_709 (WordLine_bar\\<709\\> gnd!) vsource type=pwl wave=\[
+ 0    0.9
+ 2693189581592767235707386820034625876761773979045465016063119822371190863000105380922197266574125287028215280054363247469065949312094107577921441162573762995177074519617763634274131844036773231242902144888720064511500p 0.9
+ 2693189581592767235707386820034625876761773979045465016063119822371190863000105380922197266574125287028215280054363247469065949312094107577921441162573762995177074519617763634274131844036773231242902144888720064511510p -0.3
+ 2693189581592767235707386820034625876761773979045465016063119822371190863000105380922197266574125287028215280054363247469065949312094107577921441162573762995177074519617763634274131844036773231242902144888720064512000p -0.3
+ 2693189581592767235707386820034625876761773979045465016063119822371190863000105380922197266574125287028215280054363247469065949312094107577921441162573762995177074519617763634274131844036773231242902144888720064512010p 0.9
+ \]
V_wl_bar_710 (WordLine_bar\\<710\\> gnd!) vsource type=pwl wave=\[
+ 0    0.9
+ 5386379163185534471414773640069251753523547958090930032126239644742381726000210761844394533148250574056430560108726494938131898624188215155842882325147525990354149039235527268548263688073546462485804289777440129023500p 0.9
+ 5386379163185534471414773640069251753523547958090930032126239644742381726000210761844394533148250574056430560108726494938131898624188215155842882325147525990354149039235527268548263688073546462485804289777440129023510p -0.3
+ 5386379163185534471414773640069251753523547958090930032126239644742381726000210761844394533148250574056430560108726494938131898624188215155842882325147525990354149039235527268548263688073546462485804289777440129024000p -0.3
+ 5386379163185534471414773640069251753523547958090930032126239644742381726000210761844394533148250574056430560108726494938131898624188215155842882325147525990354149039235527268548263688073546462485804289777440129024010p 0.9
+ \]
V_wl_bar_711 (WordLine_bar\\<711\\> gnd!) vsource type=pwl wave=\[
+ 0    0.9
+ 10772758326371068942829547280138503507047095916181860064252479289484763452000421523688789066296501148112861120217452989876263797248376430311685764650295051980708298078471054537096527376147092924971608579554880258047500p 0.9
+ 10772758326371068942829547280138503507047095916181860064252479289484763452000421523688789066296501148112861120217452989876263797248376430311685764650295051980708298078471054537096527376147092924971608579554880258047510p -0.3
+ 10772758326371068942829547280138503507047095916181860064252479289484763452000421523688789066296501148112861120217452989876263797248376430311685764650295051980708298078471054537096527376147092924971608579554880258048000p -0.3
+ 10772758326371068942829547280138503507047095916181860064252479289484763452000421523688789066296501148112861120217452989876263797248376430311685764650295051980708298078471054537096527376147092924971608579554880258048010p 0.9
+ \]
V_wl_bar_712 (WordLine_bar\\<712\\> gnd!) vsource type=pwl wave=\[
+ 0    0.9
+ 21545516652742137885659094560277007014094191832363720128504958578969526904000843047377578132593002296225722240434905979752527594496752860623371529300590103961416596156942109074193054752294185849943217159109760516095500p 0.9
+ 21545516652742137885659094560277007014094191832363720128504958578969526904000843047377578132593002296225722240434905979752527594496752860623371529300590103961416596156942109074193054752294185849943217159109760516095510p -0.3
+ 21545516652742137885659094560277007014094191832363720128504958578969526904000843047377578132593002296225722240434905979752527594496752860623371529300590103961416596156942109074193054752294185849943217159109760516096000p -0.3
+ 21545516652742137885659094560277007014094191832363720128504958578969526904000843047377578132593002296225722240434905979752527594496752860623371529300590103961416596156942109074193054752294185849943217159109760516096010p 0.9
+ \]
V_wl_bar_713 (WordLine_bar\\<713\\> gnd!) vsource type=pwl wave=\[
+ 0    0.9
+ 43091033305484275771318189120554014028188383664727440257009917157939053808001686094755156265186004592451444480869811959505055188993505721246743058601180207922833192313884218148386109504588371699886434318219521032191500p 0.9
+ 43091033305484275771318189120554014028188383664727440257009917157939053808001686094755156265186004592451444480869811959505055188993505721246743058601180207922833192313884218148386109504588371699886434318219521032191510p -0.3
+ 43091033305484275771318189120554014028188383664727440257009917157939053808001686094755156265186004592451444480869811959505055188993505721246743058601180207922833192313884218148386109504588371699886434318219521032192000p -0.3
+ 43091033305484275771318189120554014028188383664727440257009917157939053808001686094755156265186004592451444480869811959505055188993505721246743058601180207922833192313884218148386109504588371699886434318219521032192010p 0.9
+ \]
V_wl_bar_714 (WordLine_bar\\<714\\> gnd!) vsource type=pwl wave=\[
+ 0    0.9
+ 86182066610968551542636378241108028056376767329454880514019834315878107616003372189510312530372009184902888961739623919010110377987011442493486117202360415845666384627768436296772219009176743399772868636439042064383500p 0.9
+ 86182066610968551542636378241108028056376767329454880514019834315878107616003372189510312530372009184902888961739623919010110377987011442493486117202360415845666384627768436296772219009176743399772868636439042064383510p -0.3
+ 86182066610968551542636378241108028056376767329454880514019834315878107616003372189510312530372009184902888961739623919010110377987011442493486117202360415845666384627768436296772219009176743399772868636439042064384000p -0.3
+ 86182066610968551542636378241108028056376767329454880514019834315878107616003372189510312530372009184902888961739623919010110377987011442493486117202360415845666384627768436296772219009176743399772868636439042064384010p 0.9
+ \]
V_wl_bar_715 (WordLine_bar\\<715\\> gnd!) vsource type=pwl wave=\[
+ 0    0.9
+ 172364133221937103085272756482216056112753534658909761028039668631756215232006744379020625060744018369805777923479247838020220755974022884986972234404720831691332769255536872593544438018353486799545737272878084128767500p 0.9
+ 172364133221937103085272756482216056112753534658909761028039668631756215232006744379020625060744018369805777923479247838020220755974022884986972234404720831691332769255536872593544438018353486799545737272878084128767510p -0.3
+ 172364133221937103085272756482216056112753534658909761028039668631756215232006744379020625060744018369805777923479247838020220755974022884986972234404720831691332769255536872593544438018353486799545737272878084128768000p -0.3
+ 172364133221937103085272756482216056112753534658909761028039668631756215232006744379020625060744018369805777923479247838020220755974022884986972234404720831691332769255536872593544438018353486799545737272878084128768010p 0.9
+ \]
V_wl_bar_716 (WordLine_bar\\<716\\> gnd!) vsource type=pwl wave=\[
+ 0    0.9
+ 344728266443874206170545512964432112225507069317819522056079337263512430464013488758041250121488036739611555846958495676040441511948045769973944468809441663382665538511073745187088876036706973599091474545756168257535500p 0.9
+ 344728266443874206170545512964432112225507069317819522056079337263512430464013488758041250121488036739611555846958495676040441511948045769973944468809441663382665538511073745187088876036706973599091474545756168257535510p -0.3
+ 344728266443874206170545512964432112225507069317819522056079337263512430464013488758041250121488036739611555846958495676040441511948045769973944468809441663382665538511073745187088876036706973599091474545756168257536000p -0.3
+ 344728266443874206170545512964432112225507069317819522056079337263512430464013488758041250121488036739611555846958495676040441511948045769973944468809441663382665538511073745187088876036706973599091474545756168257536010p 0.9
+ \]
V_wl_bar_717 (WordLine_bar\\<717\\> gnd!) vsource type=pwl wave=\[
+ 0    0.9
+ 689456532887748412341091025928864224451014138635639044112158674527024860928026977516082500242976073479223111693916991352080883023896091539947888937618883326765331077022147490374177752073413947198182949091512336515071500p 0.9
+ 689456532887748412341091025928864224451014138635639044112158674527024860928026977516082500242976073479223111693916991352080883023896091539947888937618883326765331077022147490374177752073413947198182949091512336515071510p -0.3
+ 689456532887748412341091025928864224451014138635639044112158674527024860928026977516082500242976073479223111693916991352080883023896091539947888937618883326765331077022147490374177752073413947198182949091512336515072000p -0.3
+ 689456532887748412341091025928864224451014138635639044112158674527024860928026977516082500242976073479223111693916991352080883023896091539947888937618883326765331077022147490374177752073413947198182949091512336515072010p 0.9
+ \]
V_wl_bar_718 (WordLine_bar\\<718\\> gnd!) vsource type=pwl wave=\[
+ 0    0.9
+ 1378913065775496824682182051857728448902028277271278088224317349054049721856053955032165000485952146958446223387833982704161766047792183079895777875237766653530662154044294980748355504146827894396365898183024673030143500p 0.9
+ 1378913065775496824682182051857728448902028277271278088224317349054049721856053955032165000485952146958446223387833982704161766047792183079895777875237766653530662154044294980748355504146827894396365898183024673030143510p -0.3
+ 1378913065775496824682182051857728448902028277271278088224317349054049721856053955032165000485952146958446223387833982704161766047792183079895777875237766653530662154044294980748355504146827894396365898183024673030144000p -0.3
+ 1378913065775496824682182051857728448902028277271278088224317349054049721856053955032165000485952146958446223387833982704161766047792183079895777875237766653530662154044294980748355504146827894396365898183024673030144010p 0.9
+ \]
V_wl_bar_719 (WordLine_bar\\<719\\> gnd!) vsource type=pwl wave=\[
+ 0    0.9
+ 2757826131550993649364364103715456897804056554542556176448634698108099443712107910064330000971904293916892446775667965408323532095584366159791555750475533307061324308088589961496711008293655788792731796366049346060287500p 0.9
+ 2757826131550993649364364103715456897804056554542556176448634698108099443712107910064330000971904293916892446775667965408323532095584366159791555750475533307061324308088589961496711008293655788792731796366049346060287510p -0.3
+ 2757826131550993649364364103715456897804056554542556176448634698108099443712107910064330000971904293916892446775667965408323532095584366159791555750475533307061324308088589961496711008293655788792731796366049346060288000p -0.3
+ 2757826131550993649364364103715456897804056554542556176448634698108099443712107910064330000971904293916892446775667965408323532095584366159791555750475533307061324308088589961496711008293655788792731796366049346060288010p 0.9
+ \]
V_wl_bar_720 (WordLine_bar\\<720\\> gnd!) vsource type=pwl wave=\[
+ 0    0.9
+ 5515652263101987298728728207430913795608113109085112352897269396216198887424215820128660001943808587833784893551335930816647064191168732319583111500951066614122648616177179922993422016587311577585463592732098692120575500p 0.9
+ 5515652263101987298728728207430913795608113109085112352897269396216198887424215820128660001943808587833784893551335930816647064191168732319583111500951066614122648616177179922993422016587311577585463592732098692120575510p -0.3
+ 5515652263101987298728728207430913795608113109085112352897269396216198887424215820128660001943808587833784893551335930816647064191168732319583111500951066614122648616177179922993422016587311577585463592732098692120576000p -0.3
+ 5515652263101987298728728207430913795608113109085112352897269396216198887424215820128660001943808587833784893551335930816647064191168732319583111500951066614122648616177179922993422016587311577585463592732098692120576010p 0.9
+ \]
V_wl_bar_721 (WordLine_bar\\<721\\> gnd!) vsource type=pwl wave=\[
+ 0    0.9
+ 11031304526203974597457456414861827591216226218170224705794538792432397774848431640257320003887617175667569787102671861633294128382337464639166223001902133228245297232354359845986844033174623155170927185464197384241151500p 0.9
+ 11031304526203974597457456414861827591216226218170224705794538792432397774848431640257320003887617175667569787102671861633294128382337464639166223001902133228245297232354359845986844033174623155170927185464197384241151510p -0.3
+ 11031304526203974597457456414861827591216226218170224705794538792432397774848431640257320003887617175667569787102671861633294128382337464639166223001902133228245297232354359845986844033174623155170927185464197384241152000p -0.3
+ 11031304526203974597457456414861827591216226218170224705794538792432397774848431640257320003887617175667569787102671861633294128382337464639166223001902133228245297232354359845986844033174623155170927185464197384241152010p 0.9
+ \]
V_wl_bar_722 (WordLine_bar\\<722\\> gnd!) vsource type=pwl wave=\[
+ 0    0.9
+ 22062609052407949194914912829723655182432452436340449411589077584864795549696863280514640007775234351335139574205343723266588256764674929278332446003804266456490594464708719691973688066349246310341854370928394768482303500p 0.9
+ 22062609052407949194914912829723655182432452436340449411589077584864795549696863280514640007775234351335139574205343723266588256764674929278332446003804266456490594464708719691973688066349246310341854370928394768482303510p -0.3
+ 22062609052407949194914912829723655182432452436340449411589077584864795549696863280514640007775234351335139574205343723266588256764674929278332446003804266456490594464708719691973688066349246310341854370928394768482304000p -0.3
+ 22062609052407949194914912829723655182432452436340449411589077584864795549696863280514640007775234351335139574205343723266588256764674929278332446003804266456490594464708719691973688066349246310341854370928394768482304010p 0.9
+ \]
V_wl_bar_723 (WordLine_bar\\<723\\> gnd!) vsource type=pwl wave=\[
+ 0    0.9
+ 44125218104815898389829825659447310364864904872680898823178155169729591099393726561029280015550468702670279148410687446533176513529349858556664892007608532912981188929417439383947376132698492620683708741856789536964607500p 0.9
+ 44125218104815898389829825659447310364864904872680898823178155169729591099393726561029280015550468702670279148410687446533176513529349858556664892007608532912981188929417439383947376132698492620683708741856789536964607510p -0.3
+ 44125218104815898389829825659447310364864904872680898823178155169729591099393726561029280015550468702670279148410687446533176513529349858556664892007608532912981188929417439383947376132698492620683708741856789536964608000p -0.3
+ 44125218104815898389829825659447310364864904872680898823178155169729591099393726561029280015550468702670279148410687446533176513529349858556664892007608532912981188929417439383947376132698492620683708741856789536964608010p 0.9
+ \]
V_wl_bar_724 (WordLine_bar\\<724\\> gnd!) vsource type=pwl wave=\[
+ 0    0.9
+ 88250436209631796779659651318894620729729809745361797646356310339459182198787453122058560031100937405340558296821374893066353027058699717113329784015217065825962377858834878767894752265396985241367417483713579073929215500p 0.9
+ 88250436209631796779659651318894620729729809745361797646356310339459182198787453122058560031100937405340558296821374893066353027058699717113329784015217065825962377858834878767894752265396985241367417483713579073929215510p -0.3
+ 88250436209631796779659651318894620729729809745361797646356310339459182198787453122058560031100937405340558296821374893066353027058699717113329784015217065825962377858834878767894752265396985241367417483713579073929216000p -0.3
+ 88250436209631796779659651318894620729729809745361797646356310339459182198787453122058560031100937405340558296821374893066353027058699717113329784015217065825962377858834878767894752265396985241367417483713579073929216010p 0.9
+ \]
V_wl_bar_725 (WordLine_bar\\<725\\> gnd!) vsource type=pwl wave=\[
+ 0    0.9
+ 176500872419263593559319302637789241459459619490723595292712620678918364397574906244117120062201874810681116593642749786132706054117399434226659568030434131651924755717669757535789504530793970482734834967427158147858431500p 0.9
+ 176500872419263593559319302637789241459459619490723595292712620678918364397574906244117120062201874810681116593642749786132706054117399434226659568030434131651924755717669757535789504530793970482734834967427158147858431510p -0.3
+ 176500872419263593559319302637789241459459619490723595292712620678918364397574906244117120062201874810681116593642749786132706054117399434226659568030434131651924755717669757535789504530793970482734834967427158147858432000p -0.3
+ 176500872419263593559319302637789241459459619490723595292712620678918364397574906244117120062201874810681116593642749786132706054117399434226659568030434131651924755717669757535789504530793970482734834967427158147858432010p 0.9
+ \]
V_wl_bar_726 (WordLine_bar\\<726\\> gnd!) vsource type=pwl wave=\[
+ 0    0.9
+ 353001744838527187118638605275578482918919238981447190585425241357836728795149812488234240124403749621362233187285499572265412108234798868453319136060868263303849511435339515071579009061587940965469669934854316295716863500p 0.9
+ 353001744838527187118638605275578482918919238981447190585425241357836728795149812488234240124403749621362233187285499572265412108234798868453319136060868263303849511435339515071579009061587940965469669934854316295716863510p -0.3
+ 353001744838527187118638605275578482918919238981447190585425241357836728795149812488234240124403749621362233187285499572265412108234798868453319136060868263303849511435339515071579009061587940965469669934854316295716864000p -0.3
+ 353001744838527187118638605275578482918919238981447190585425241357836728795149812488234240124403749621362233187285499572265412108234798868453319136060868263303849511435339515071579009061587940965469669934854316295716864010p 0.9
+ \]
V_wl_bar_727 (WordLine_bar\\<727\\> gnd!) vsource type=pwl wave=\[
+ 0    0.9
+ 706003489677054374237277210551156965837838477962894381170850482715673457590299624976468480248807499242724466374570999144530824216469597736906638272121736526607699022870679030143158018123175881930939339869708632591433727500p 0.9
+ 706003489677054374237277210551156965837838477962894381170850482715673457590299624976468480248807499242724466374570999144530824216469597736906638272121736526607699022870679030143158018123175881930939339869708632591433727510p -0.3
+ 706003489677054374237277210551156965837838477962894381170850482715673457590299624976468480248807499242724466374570999144530824216469597736906638272121736526607699022870679030143158018123175881930939339869708632591433728000p -0.3
+ 706003489677054374237277210551156965837838477962894381170850482715673457590299624976468480248807499242724466374570999144530824216469597736906638272121736526607699022870679030143158018123175881930939339869708632591433728010p 0.9
+ \]
V_wl_bar_728 (WordLine_bar\\<728\\> gnd!) vsource type=pwl wave=\[
+ 0    0.9
+ 1412006979354108748474554421102313931675676955925788762341700965431346915180599249952936960497614998485448932749141998289061648432939195473813276544243473053215398045741358060286316036246351763861878679739417265182867455500p 0.9
+ 1412006979354108748474554421102313931675676955925788762341700965431346915180599249952936960497614998485448932749141998289061648432939195473813276544243473053215398045741358060286316036246351763861878679739417265182867455510p -0.3
+ 1412006979354108748474554421102313931675676955925788762341700965431346915180599249952936960497614998485448932749141998289061648432939195473813276544243473053215398045741358060286316036246351763861878679739417265182867456000p -0.3
+ 1412006979354108748474554421102313931675676955925788762341700965431346915180599249952936960497614998485448932749141998289061648432939195473813276544243473053215398045741358060286316036246351763861878679739417265182867456010p 0.9
+ \]
V_wl_bar_729 (WordLine_bar\\<729\\> gnd!) vsource type=pwl wave=\[
+ 0    0.9
+ 2824013958708217496949108842204627863351353911851577524683401930862693830361198499905873920995229996970897865498283996578123296865878390947626553088486946106430796091482716120572632072492703527723757359478834530365734911500p 0.9
+ 2824013958708217496949108842204627863351353911851577524683401930862693830361198499905873920995229996970897865498283996578123296865878390947626553088486946106430796091482716120572632072492703527723757359478834530365734911510p -0.3
+ 2824013958708217496949108842204627863351353911851577524683401930862693830361198499905873920995229996970897865498283996578123296865878390947626553088486946106430796091482716120572632072492703527723757359478834530365734912000p -0.3
+ 2824013958708217496949108842204627863351353911851577524683401930862693830361198499905873920995229996970897865498283996578123296865878390947626553088486946106430796091482716120572632072492703527723757359478834530365734912010p 0.9
+ \]
V_wl_bar_730 (WordLine_bar\\<730\\> gnd!) vsource type=pwl wave=\[
+ 0    0.9
+ 5648027917416434993898217684409255726702707823703155049366803861725387660722396999811747841990459993941795730996567993156246593731756781895253106176973892212861592182965432241145264144985407055447514718957669060731469823500p 0.9
+ 5648027917416434993898217684409255726702707823703155049366803861725387660722396999811747841990459993941795730996567993156246593731756781895253106176973892212861592182965432241145264144985407055447514718957669060731469823510p -0.3
+ 5648027917416434993898217684409255726702707823703155049366803861725387660722396999811747841990459993941795730996567993156246593731756781895253106176973892212861592182965432241145264144985407055447514718957669060731469824000p -0.3
+ 5648027917416434993898217684409255726702707823703155049366803861725387660722396999811747841990459993941795730996567993156246593731756781895253106176973892212861592182965432241145264144985407055447514718957669060731469824010p 0.9
+ \]
V_wl_bar_731 (WordLine_bar\\<731\\> gnd!) vsource type=pwl wave=\[
+ 0    0.9
+ 11296055834832869987796435368818511453405415647406310098733607723450775321444793999623495683980919987883591461993135986312493187463513563790506212353947784425723184365930864482290528289970814110895029437915338121462939647500p 0.9
+ 11296055834832869987796435368818511453405415647406310098733607723450775321444793999623495683980919987883591461993135986312493187463513563790506212353947784425723184365930864482290528289970814110895029437915338121462939647510p -0.3
+ 11296055834832869987796435368818511453405415647406310098733607723450775321444793999623495683980919987883591461993135986312493187463513563790506212353947784425723184365930864482290528289970814110895029437915338121462939648000p -0.3
+ 11296055834832869987796435368818511453405415647406310098733607723450775321444793999623495683980919987883591461993135986312493187463513563790506212353947784425723184365930864482290528289970814110895029437915338121462939648010p 0.9
+ \]
V_wl_bar_732 (WordLine_bar\\<732\\> gnd!) vsource type=pwl wave=\[
+ 0    0.9
+ 22592111669665739975592870737637022906810831294812620197467215446901550642889587999246991367961839975767182923986271972624986374927027127581012424707895568851446368731861728964581056579941628221790058875830676242925879295500p 0.9
+ 22592111669665739975592870737637022906810831294812620197467215446901550642889587999246991367961839975767182923986271972624986374927027127581012424707895568851446368731861728964581056579941628221790058875830676242925879295510p -0.3
+ 22592111669665739975592870737637022906810831294812620197467215446901550642889587999246991367961839975767182923986271972624986374927027127581012424707895568851446368731861728964581056579941628221790058875830676242925879296000p -0.3
+ 22592111669665739975592870737637022906810831294812620197467215446901550642889587999246991367961839975767182923986271972624986374927027127581012424707895568851446368731861728964581056579941628221790058875830676242925879296010p 0.9
+ \]
V_wl_bar_733 (WordLine_bar\\<733\\> gnd!) vsource type=pwl wave=\[
+ 0    0.9
+ 45184223339331479951185741475274045813621662589625240394934430893803101285779175998493982735923679951534365847972543945249972749854054255162024849415791137702892737463723457929162113159883256443580117751661352485851758591500p 0.9
+ 45184223339331479951185741475274045813621662589625240394934430893803101285779175998493982735923679951534365847972543945249972749854054255162024849415791137702892737463723457929162113159883256443580117751661352485851758591510p -0.3
+ 45184223339331479951185741475274045813621662589625240394934430893803101285779175998493982735923679951534365847972543945249972749854054255162024849415791137702892737463723457929162113159883256443580117751661352485851758592000p -0.3
+ 45184223339331479951185741475274045813621662589625240394934430893803101285779175998493982735923679951534365847972543945249972749854054255162024849415791137702892737463723457929162113159883256443580117751661352485851758592010p 0.9
+ \]
V_wl_bar_734 (WordLine_bar\\<734\\> gnd!) vsource type=pwl wave=\[
+ 0    0.9
+ 90368446678662959902371482950548091627243325179250480789868861787606202571558351996987965471847359903068731695945087890499945499708108510324049698831582275405785474927446915858324226319766512887160235503322704971703517183500p 0.9
+ 90368446678662959902371482950548091627243325179250480789868861787606202571558351996987965471847359903068731695945087890499945499708108510324049698831582275405785474927446915858324226319766512887160235503322704971703517183510p -0.3
+ 90368446678662959902371482950548091627243325179250480789868861787606202571558351996987965471847359903068731695945087890499945499708108510324049698831582275405785474927446915858324226319766512887160235503322704971703517184000p -0.3
+ 90368446678662959902371482950548091627243325179250480789868861787606202571558351996987965471847359903068731695945087890499945499708108510324049698831582275405785474927446915858324226319766512887160235503322704971703517184010p 0.9
+ \]
V_wl_bar_735 (WordLine_bar\\<735\\> gnd!) vsource type=pwl wave=\[
+ 0    0.9
+ 180736893357325919804742965901096183254486650358500961579737723575212405143116703993975930943694719806137463391890175780999890999416217020648099397663164550811570949854893831716648452639533025774320471006645409943407034367500p 0.9
+ 180736893357325919804742965901096183254486650358500961579737723575212405143116703993975930943694719806137463391890175780999890999416217020648099397663164550811570949854893831716648452639533025774320471006645409943407034367510p -0.3
+ 180736893357325919804742965901096183254486650358500961579737723575212405143116703993975930943694719806137463391890175780999890999416217020648099397663164550811570949854893831716648452639533025774320471006645409943407034368000p -0.3
+ 180736893357325919804742965901096183254486650358500961579737723575212405143116703993975930943694719806137463391890175780999890999416217020648099397663164550811570949854893831716648452639533025774320471006645409943407034368010p 0.9
+ \]
V_wl_bar_736 (WordLine_bar\\<736\\> gnd!) vsource type=pwl wave=\[
+ 0    0.9
+ 361473786714651839609485931802192366508973300717001923159475447150424810286233407987951861887389439612274926783780351561999781998832434041296198795326329101623141899709787663433296905279066051548640942013290819886814068735500p 0.9
+ 361473786714651839609485931802192366508973300717001923159475447150424810286233407987951861887389439612274926783780351561999781998832434041296198795326329101623141899709787663433296905279066051548640942013290819886814068735510p -0.3
+ 361473786714651839609485931802192366508973300717001923159475447150424810286233407987951861887389439612274926783780351561999781998832434041296198795326329101623141899709787663433296905279066051548640942013290819886814068736000p -0.3
+ 361473786714651839609485931802192366508973300717001923159475447150424810286233407987951861887389439612274926783780351561999781998832434041296198795326329101623141899709787663433296905279066051548640942013290819886814068736010p 0.9
+ \]
V_wl_bar_737 (WordLine_bar\\<737\\> gnd!) vsource type=pwl wave=\[
+ 0    0.9
+ 722947573429303679218971863604384733017946601434003846318950894300849620572466815975903723774778879224549853567560703123999563997664868082592397590652658203246283799419575326866593810558132103097281884026581639773628137471500p 0.9
+ 722947573429303679218971863604384733017946601434003846318950894300849620572466815975903723774778879224549853567560703123999563997664868082592397590652658203246283799419575326866593810558132103097281884026581639773628137471510p -0.3
+ 722947573429303679218971863604384733017946601434003846318950894300849620572466815975903723774778879224549853567560703123999563997664868082592397590652658203246283799419575326866593810558132103097281884026581639773628137472000p -0.3
+ 722947573429303679218971863604384733017946601434003846318950894300849620572466815975903723774778879224549853567560703123999563997664868082592397590652658203246283799419575326866593810558132103097281884026581639773628137472010p 0.9
+ \]
V_wl_bar_738 (WordLine_bar\\<738\\> gnd!) vsource type=pwl wave=\[
+ 0    0.9
+ 1445895146858607358437943727208769466035893202868007692637901788601699241144933631951807447549557758449099707135121406247999127995329736165184795181305316406492567598839150653733187621116264206194563768053163279547256274943500p 0.9
+ 1445895146858607358437943727208769466035893202868007692637901788601699241144933631951807447549557758449099707135121406247999127995329736165184795181305316406492567598839150653733187621116264206194563768053163279547256274943510p -0.3
+ 1445895146858607358437943727208769466035893202868007692637901788601699241144933631951807447549557758449099707135121406247999127995329736165184795181305316406492567598839150653733187621116264206194563768053163279547256274944000p -0.3
+ 1445895146858607358437943727208769466035893202868007692637901788601699241144933631951807447549557758449099707135121406247999127995329736165184795181305316406492567598839150653733187621116264206194563768053163279547256274944010p 0.9
+ \]
V_wl_bar_739 (WordLine_bar\\<739\\> gnd!) vsource type=pwl wave=\[
+ 0    0.9
+ 2891790293717214716875887454417538932071786405736015385275803577203398482289867263903614895099115516898199414270242812495998255990659472330369590362610632812985135197678301307466375242232528412389127536106326559094512549887500p 0.9
+ 2891790293717214716875887454417538932071786405736015385275803577203398482289867263903614895099115516898199414270242812495998255990659472330369590362610632812985135197678301307466375242232528412389127536106326559094512549887510p -0.3
+ 2891790293717214716875887454417538932071786405736015385275803577203398482289867263903614895099115516898199414270242812495998255990659472330369590362610632812985135197678301307466375242232528412389127536106326559094512549888000p -0.3
+ 2891790293717214716875887454417538932071786405736015385275803577203398482289867263903614895099115516898199414270242812495998255990659472330369590362610632812985135197678301307466375242232528412389127536106326559094512549888010p 0.9
+ \]
V_wl_bar_740 (WordLine_bar\\<740\\> gnd!) vsource type=pwl wave=\[
+ 0    0.9
+ 5783580587434429433751774908835077864143572811472030770551607154406796964579734527807229790198231033796398828540485624991996511981318944660739180725221265625970270395356602614932750484465056824778255072212653118189025099775500p 0.9
+ 5783580587434429433751774908835077864143572811472030770551607154406796964579734527807229790198231033796398828540485624991996511981318944660739180725221265625970270395356602614932750484465056824778255072212653118189025099775510p -0.3
+ 5783580587434429433751774908835077864143572811472030770551607154406796964579734527807229790198231033796398828540485624991996511981318944660739180725221265625970270395356602614932750484465056824778255072212653118189025099776000p -0.3
+ 5783580587434429433751774908835077864143572811472030770551607154406796964579734527807229790198231033796398828540485624991996511981318944660739180725221265625970270395356602614932750484465056824778255072212653118189025099776010p 0.9
+ \]
V_wl_bar_741 (WordLine_bar\\<741\\> gnd!) vsource type=pwl wave=\[
+ 0    0.9
+ 11567161174868858867503549817670155728287145622944061541103214308813593929159469055614459580396462067592797657080971249983993023962637889321478361450442531251940540790713205229865500968930113649556510144425306236378050199551500p 0.9
+ 11567161174868858867503549817670155728287145622944061541103214308813593929159469055614459580396462067592797657080971249983993023962637889321478361450442531251940540790713205229865500968930113649556510144425306236378050199551510p -0.3
+ 11567161174868858867503549817670155728287145622944061541103214308813593929159469055614459580396462067592797657080971249983993023962637889321478361450442531251940540790713205229865500968930113649556510144425306236378050199552000p -0.3
+ 11567161174868858867503549817670155728287145622944061541103214308813593929159469055614459580396462067592797657080971249983993023962637889321478361450442531251940540790713205229865500968930113649556510144425306236378050199552010p 0.9
+ \]
V_wl_bar_742 (WordLine_bar\\<742\\> gnd!) vsource type=pwl wave=\[
+ 0    0.9
+ 23134322349737717735007099635340311456574291245888123082206428617627187858318938111228919160792924135185595314161942499967986047925275778642956722900885062503881081581426410459731001937860227299113020288850612472756100399103500p 0.9
+ 23134322349737717735007099635340311456574291245888123082206428617627187858318938111228919160792924135185595314161942499967986047925275778642956722900885062503881081581426410459731001937860227299113020288850612472756100399103510p -0.3
+ 23134322349737717735007099635340311456574291245888123082206428617627187858318938111228919160792924135185595314161942499967986047925275778642956722900885062503881081581426410459731001937860227299113020288850612472756100399104000p -0.3
+ 23134322349737717735007099635340311456574291245888123082206428617627187858318938111228919160792924135185595314161942499967986047925275778642956722900885062503881081581426410459731001937860227299113020288850612472756100399104010p 0.9
+ \]
V_wl_bar_743 (WordLine_bar\\<743\\> gnd!) vsource type=pwl wave=\[
+ 0    0.9
+ 46268644699475435470014199270680622913148582491776246164412857235254375716637876222457838321585848270371190628323884999935972095850551557285913445801770125007762163162852820919462003875720454598226040577701224945512200798207500p 0.9
+ 46268644699475435470014199270680622913148582491776246164412857235254375716637876222457838321585848270371190628323884999935972095850551557285913445801770125007762163162852820919462003875720454598226040577701224945512200798207510p -0.3
+ 46268644699475435470014199270680622913148582491776246164412857235254375716637876222457838321585848270371190628323884999935972095850551557285913445801770125007762163162852820919462003875720454598226040577701224945512200798208000p -0.3
+ 46268644699475435470014199270680622913148582491776246164412857235254375716637876222457838321585848270371190628323884999935972095850551557285913445801770125007762163162852820919462003875720454598226040577701224945512200798208010p 0.9
+ \]
V_wl_bar_744 (WordLine_bar\\<744\\> gnd!) vsource type=pwl wave=\[
+ 0    0.9
+ 92537289398950870940028398541361245826297164983552492328825714470508751433275752444915676643171696540742381256647769999871944191701103114571826891603540250015524326325705641838924007751440909196452081155402449891024401596415500p 0.9
+ 92537289398950870940028398541361245826297164983552492328825714470508751433275752444915676643171696540742381256647769999871944191701103114571826891603540250015524326325705641838924007751440909196452081155402449891024401596415510p -0.3
+ 92537289398950870940028398541361245826297164983552492328825714470508751433275752444915676643171696540742381256647769999871944191701103114571826891603540250015524326325705641838924007751440909196452081155402449891024401596416000p -0.3
+ 92537289398950870940028398541361245826297164983552492328825714470508751433275752444915676643171696540742381256647769999871944191701103114571826891603540250015524326325705641838924007751440909196452081155402449891024401596416010p 0.9
+ \]
V_wl_bar_745 (WordLine_bar\\<745\\> gnd!) vsource type=pwl wave=\[
+ 0    0.9
+ 185074578797901741880056797082722491652594329967104984657651428941017502866551504889831353286343393081484762513295539999743888383402206229143653783207080500031048652651411283677848015502881818392904162310804899782048803192831500p 0.9
+ 185074578797901741880056797082722491652594329967104984657651428941017502866551504889831353286343393081484762513295539999743888383402206229143653783207080500031048652651411283677848015502881818392904162310804899782048803192831510p -0.3
+ 185074578797901741880056797082722491652594329967104984657651428941017502866551504889831353286343393081484762513295539999743888383402206229143653783207080500031048652651411283677848015502881818392904162310804899782048803192832000p -0.3
+ 185074578797901741880056797082722491652594329967104984657651428941017502866551504889831353286343393081484762513295539999743888383402206229143653783207080500031048652651411283677848015502881818392904162310804899782048803192832010p 0.9
+ \]
V_wl_bar_746 (WordLine_bar\\<746\\> gnd!) vsource type=pwl wave=\[
+ 0    0.9
+ 370149157595803483760113594165444983305188659934209969315302857882035005733103009779662706572686786162969525026591079999487776766804412458287307566414161000062097305302822567355696031005763636785808324621609799564097606385663500p 0.9
+ 370149157595803483760113594165444983305188659934209969315302857882035005733103009779662706572686786162969525026591079999487776766804412458287307566414161000062097305302822567355696031005763636785808324621609799564097606385663510p -0.3
+ 370149157595803483760113594165444983305188659934209969315302857882035005733103009779662706572686786162969525026591079999487776766804412458287307566414161000062097305302822567355696031005763636785808324621609799564097606385664000p -0.3
+ 370149157595803483760113594165444983305188659934209969315302857882035005733103009779662706572686786162969525026591079999487776766804412458287307566414161000062097305302822567355696031005763636785808324621609799564097606385664010p 0.9
+ \]
V_wl_bar_747 (WordLine_bar\\<747\\> gnd!) vsource type=pwl wave=\[
+ 0    0.9
+ 740298315191606967520227188330889966610377319868419938630605715764070011466206019559325413145373572325939050053182159998975553533608824916574615132828322000124194610605645134711392062011527273571616649243219599128195212771327500p 0.9
+ 740298315191606967520227188330889966610377319868419938630605715764070011466206019559325413145373572325939050053182159998975553533608824916574615132828322000124194610605645134711392062011527273571616649243219599128195212771327510p -0.3
+ 740298315191606967520227188330889966610377319868419938630605715764070011466206019559325413145373572325939050053182159998975553533608824916574615132828322000124194610605645134711392062011527273571616649243219599128195212771328000p -0.3
+ 740298315191606967520227188330889966610377319868419938630605715764070011466206019559325413145373572325939050053182159998975553533608824916574615132828322000124194610605645134711392062011527273571616649243219599128195212771328010p 0.9
+ \]
V_wl_bar_748 (WordLine_bar\\<748\\> gnd!) vsource type=pwl wave=\[
+ 0    0.9
+ 1480596630383213935040454376661779933220754639736839877261211431528140022932412039118650826290747144651878100106364319997951107067217649833149230265656644000248389221211290269422784124023054547143233298486439198256390425542655500p 0.9
+ 1480596630383213935040454376661779933220754639736839877261211431528140022932412039118650826290747144651878100106364319997951107067217649833149230265656644000248389221211290269422784124023054547143233298486439198256390425542655510p -0.3
+ 1480596630383213935040454376661779933220754639736839877261211431528140022932412039118650826290747144651878100106364319997951107067217649833149230265656644000248389221211290269422784124023054547143233298486439198256390425542656000p -0.3
+ 1480596630383213935040454376661779933220754639736839877261211431528140022932412039118650826290747144651878100106364319997951107067217649833149230265656644000248389221211290269422784124023054547143233298486439198256390425542656010p 0.9
+ \]
V_wl_bar_749 (WordLine_bar\\<749\\> gnd!) vsource type=pwl wave=\[
+ 0    0.9
+ 2961193260766427870080908753323559866441509279473679754522422863056280045864824078237301652581494289303756200212728639995902214134435299666298460531313288000496778442422580538845568248046109094286466596972878396512780851085311500p 0.9
+ 2961193260766427870080908753323559866441509279473679754522422863056280045864824078237301652581494289303756200212728639995902214134435299666298460531313288000496778442422580538845568248046109094286466596972878396512780851085311510p -0.3
+ 2961193260766427870080908753323559866441509279473679754522422863056280045864824078237301652581494289303756200212728639995902214134435299666298460531313288000496778442422580538845568248046109094286466596972878396512780851085312000p -0.3
+ 2961193260766427870080908753323559866441509279473679754522422863056280045864824078237301652581494289303756200212728639995902214134435299666298460531313288000496778442422580538845568248046109094286466596972878396512780851085312010p 0.9
+ \]
V_wl_bar_750 (WordLine_bar\\<750\\> gnd!) vsource type=pwl wave=\[
+ 0    0.9
+ 5922386521532855740161817506647119732883018558947359509044845726112560091729648156474603305162988578607512400425457279991804428268870599332596921062626576000993556884845161077691136496092218188572933193945756793025561702170623500p 0.9
+ 5922386521532855740161817506647119732883018558947359509044845726112560091729648156474603305162988578607512400425457279991804428268870599332596921062626576000993556884845161077691136496092218188572933193945756793025561702170623510p -0.3
+ 5922386521532855740161817506647119732883018558947359509044845726112560091729648156474603305162988578607512400425457279991804428268870599332596921062626576000993556884845161077691136496092218188572933193945756793025561702170624000p -0.3
+ 5922386521532855740161817506647119732883018558947359509044845726112560091729648156474603305162988578607512400425457279991804428268870599332596921062626576000993556884845161077691136496092218188572933193945756793025561702170624010p 0.9
+ \]
V_wl_bar_751 (WordLine_bar\\<751\\> gnd!) vsource type=pwl wave=\[
+ 0    0.9
+ 11844773043065711480323635013294239465766037117894719018089691452225120183459296312949206610325977157215024800850914559983608856537741198665193842125253152001987113769690322155382272992184436377145866387891513586051123404341247500p 0.9
+ 11844773043065711480323635013294239465766037117894719018089691452225120183459296312949206610325977157215024800850914559983608856537741198665193842125253152001987113769690322155382272992184436377145866387891513586051123404341247510p -0.3
+ 11844773043065711480323635013294239465766037117894719018089691452225120183459296312949206610325977157215024800850914559983608856537741198665193842125253152001987113769690322155382272992184436377145866387891513586051123404341248000p -0.3
+ 11844773043065711480323635013294239465766037117894719018089691452225120183459296312949206610325977157215024800850914559983608856537741198665193842125253152001987113769690322155382272992184436377145866387891513586051123404341248010p 0.9
+ \]
V_wl_bar_752 (WordLine_bar\\<752\\> gnd!) vsource type=pwl wave=\[
+ 0    0.9
+ 23689546086131422960647270026588478931532074235789438036179382904450240366918592625898413220651954314430049601701829119967217713075482397330387684250506304003974227539380644310764545984368872754291732775783027172102246808682495500p 0.9
+ 23689546086131422960647270026588478931532074235789438036179382904450240366918592625898413220651954314430049601701829119967217713075482397330387684250506304003974227539380644310764545984368872754291732775783027172102246808682495510p -0.3
+ 23689546086131422960647270026588478931532074235789438036179382904450240366918592625898413220651954314430049601701829119967217713075482397330387684250506304003974227539380644310764545984368872754291732775783027172102246808682496000p -0.3
+ 23689546086131422960647270026588478931532074235789438036179382904450240366918592625898413220651954314430049601701829119967217713075482397330387684250506304003974227539380644310764545984368872754291732775783027172102246808682496010p 0.9
+ \]
V_wl_bar_753 (WordLine_bar\\<753\\> gnd!) vsource type=pwl wave=\[
+ 0    0.9
+ 47379092172262845921294540053176957863064148471578876072358765808900480733837185251796826441303908628860099203403658239934435426150964794660775368501012608007948455078761288621529091968737745508583465551566054344204493617364991500p 0.9
+ 47379092172262845921294540053176957863064148471578876072358765808900480733837185251796826441303908628860099203403658239934435426150964794660775368501012608007948455078761288621529091968737745508583465551566054344204493617364991510p -0.3
+ 47379092172262845921294540053176957863064148471578876072358765808900480733837185251796826441303908628860099203403658239934435426150964794660775368501012608007948455078761288621529091968737745508583465551566054344204493617364992000p -0.3
+ 47379092172262845921294540053176957863064148471578876072358765808900480733837185251796826441303908628860099203403658239934435426150964794660775368501012608007948455078761288621529091968737745508583465551566054344204493617364992010p 0.9
+ \]
V_wl_bar_754 (WordLine_bar\\<754\\> gnd!) vsource type=pwl wave=\[
+ 0    0.9
+ 94758184344525691842589080106353915726128296943157752144717531617800961467674370503593652882607817257720198406807316479868870852301929589321550737002025216015896910157522577243058183937475491017166931103132108688408987234729983500p 0.9
+ 94758184344525691842589080106353915726128296943157752144717531617800961467674370503593652882607817257720198406807316479868870852301929589321550737002025216015896910157522577243058183937475491017166931103132108688408987234729983510p -0.3
+ 94758184344525691842589080106353915726128296943157752144717531617800961467674370503593652882607817257720198406807316479868870852301929589321550737002025216015896910157522577243058183937475491017166931103132108688408987234729984000p -0.3
+ 94758184344525691842589080106353915726128296943157752144717531617800961467674370503593652882607817257720198406807316479868870852301929589321550737002025216015896910157522577243058183937475491017166931103132108688408987234729984010p 0.9
+ \]
V_wl_bar_755 (WordLine_bar\\<755\\> gnd!) vsource type=pwl wave=\[
+ 0    0.9
+ 189516368689051383685178160212707831452256593886315504289435063235601922935348741007187305765215634515440396813614632959737741704603859178643101474004050432031793820315045154486116367874950982034333862206264217376817974469459967500p 0.9
+ 189516368689051383685178160212707831452256593886315504289435063235601922935348741007187305765215634515440396813614632959737741704603859178643101474004050432031793820315045154486116367874950982034333862206264217376817974469459967510p -0.3
+ 189516368689051383685178160212707831452256593886315504289435063235601922935348741007187305765215634515440396813614632959737741704603859178643101474004050432031793820315045154486116367874950982034333862206264217376817974469459968000p -0.3
+ 189516368689051383685178160212707831452256593886315504289435063235601922935348741007187305765215634515440396813614632959737741704603859178643101474004050432031793820315045154486116367874950982034333862206264217376817974469459968010p 0.9
+ \]
V_wl_bar_756 (WordLine_bar\\<756\\> gnd!) vsource type=pwl wave=\[
+ 0    0.9
+ 379032737378102767370356320425415662904513187772631008578870126471203845870697482014374611530431269030880793627229265919475483409207718357286202948008100864063587640630090308972232735749901964068667724412528434753635948938919935500p 0.9
+ 379032737378102767370356320425415662904513187772631008578870126471203845870697482014374611530431269030880793627229265919475483409207718357286202948008100864063587640630090308972232735749901964068667724412528434753635948938919935510p -0.3
+ 379032737378102767370356320425415662904513187772631008578870126471203845870697482014374611530431269030880793627229265919475483409207718357286202948008100864063587640630090308972232735749901964068667724412528434753635948938919936000p -0.3
+ 379032737378102767370356320425415662904513187772631008578870126471203845870697482014374611530431269030880793627229265919475483409207718357286202948008100864063587640630090308972232735749901964068667724412528434753635948938919936010p 0.9
+ \]
V_wl_bar_757 (WordLine_bar\\<757\\> gnd!) vsource type=pwl wave=\[
+ 0    0.9
+ 758065474756205534740712640850831325809026375545262017157740252942407691741394964028749223060862538061761587254458531838950966818415436714572405896016201728127175281260180617944465471499803928137335448825056869507271897877839871500p 0.9
+ 758065474756205534740712640850831325809026375545262017157740252942407691741394964028749223060862538061761587254458531838950966818415436714572405896016201728127175281260180617944465471499803928137335448825056869507271897877839871510p -0.3
+ 758065474756205534740712640850831325809026375545262017157740252942407691741394964028749223060862538061761587254458531838950966818415436714572405896016201728127175281260180617944465471499803928137335448825056869507271897877839872000p -0.3
+ 758065474756205534740712640850831325809026375545262017157740252942407691741394964028749223060862538061761587254458531838950966818415436714572405896016201728127175281260180617944465471499803928137335448825056869507271897877839872010p 0.9
+ \]
V_wl_bar_758 (WordLine_bar\\<758\\> gnd!) vsource type=pwl wave=\[
+ 0    0.9
+ 1516130949512411069481425281701662651618052751090524034315480505884815383482789928057498446121725076123523174508917063677901933636830873429144811792032403456254350562520361235888930942999607856274670897650113739014543795755679743500p 0.9
+ 1516130949512411069481425281701662651618052751090524034315480505884815383482789928057498446121725076123523174508917063677901933636830873429144811792032403456254350562520361235888930942999607856274670897650113739014543795755679743510p -0.3
+ 1516130949512411069481425281701662651618052751090524034315480505884815383482789928057498446121725076123523174508917063677901933636830873429144811792032403456254350562520361235888930942999607856274670897650113739014543795755679744000p -0.3
+ 1516130949512411069481425281701662651618052751090524034315480505884815383482789928057498446121725076123523174508917063677901933636830873429144811792032403456254350562520361235888930942999607856274670897650113739014543795755679744010p 0.9
+ \]
V_wl_bar_759 (WordLine_bar\\<759\\> gnd!) vsource type=pwl wave=\[
+ 0    0.9
+ 3032261899024822138962850563403325303236105502181048068630961011769630766965579856114996892243450152247046349017834127355803867273661746858289623584064806912508701125040722471777861885999215712549341795300227478029087591511359487500p 0.9
+ 3032261899024822138962850563403325303236105502181048068630961011769630766965579856114996892243450152247046349017834127355803867273661746858289623584064806912508701125040722471777861885999215712549341795300227478029087591511359487510p -0.3
+ 3032261899024822138962850563403325303236105502181048068630961011769630766965579856114996892243450152247046349017834127355803867273661746858289623584064806912508701125040722471777861885999215712549341795300227478029087591511359488000p -0.3
+ 3032261899024822138962850563403325303236105502181048068630961011769630766965579856114996892243450152247046349017834127355803867273661746858289623584064806912508701125040722471777861885999215712549341795300227478029087591511359488010p 0.9
+ \]
V_wl_bar_760 (WordLine_bar\\<760\\> gnd!) vsource type=pwl wave=\[
+ 0    0.9
+ 6064523798049644277925701126806650606472211004362096137261922023539261533931159712229993784486900304494092698035668254711607734547323493716579247168129613825017402250081444943555723771998431425098683590600454956058175183022718975500p 0.9
+ 6064523798049644277925701126806650606472211004362096137261922023539261533931159712229993784486900304494092698035668254711607734547323493716579247168129613825017402250081444943555723771998431425098683590600454956058175183022718975510p -0.3
+ 6064523798049644277925701126806650606472211004362096137261922023539261533931159712229993784486900304494092698035668254711607734547323493716579247168129613825017402250081444943555723771998431425098683590600454956058175183022718976000p -0.3
+ 6064523798049644277925701126806650606472211004362096137261922023539261533931159712229993784486900304494092698035668254711607734547323493716579247168129613825017402250081444943555723771998431425098683590600454956058175183022718976010p 0.9
+ \]
V_wl_bar_761 (WordLine_bar\\<761\\> gnd!) vsource type=pwl wave=\[
+ 0    0.9
+ 12129047596099288555851402253613301212944422008724192274523844047078523067862319424459987568973800608988185396071336509423215469094646987433158494336259227650034804500162889887111447543996862850197367181200909912116350366045437951500p 0.9
+ 12129047596099288555851402253613301212944422008724192274523844047078523067862319424459987568973800608988185396071336509423215469094646987433158494336259227650034804500162889887111447543996862850197367181200909912116350366045437951510p -0.3
+ 12129047596099288555851402253613301212944422008724192274523844047078523067862319424459987568973800608988185396071336509423215469094646987433158494336259227650034804500162889887111447543996862850197367181200909912116350366045437952000p -0.3
+ 12129047596099288555851402253613301212944422008724192274523844047078523067862319424459987568973800608988185396071336509423215469094646987433158494336259227650034804500162889887111447543996862850197367181200909912116350366045437952010p 0.9
+ \]
V_wl_bar_762 (WordLine_bar\\<762\\> gnd!) vsource type=pwl wave=\[
+ 0    0.9
+ 24258095192198577111702804507226602425888844017448384549047688094157046135724638848919975137947601217976370792142673018846430938189293974866316988672518455300069609000325779774222895087993725700394734362401819824232700732090875903500p 0.9
+ 24258095192198577111702804507226602425888844017448384549047688094157046135724638848919975137947601217976370792142673018846430938189293974866316988672518455300069609000325779774222895087993725700394734362401819824232700732090875903510p -0.3
+ 24258095192198577111702804507226602425888844017448384549047688094157046135724638848919975137947601217976370792142673018846430938189293974866316988672518455300069609000325779774222895087993725700394734362401819824232700732090875904000p -0.3
+ 24258095192198577111702804507226602425888844017448384549047688094157046135724638848919975137947601217976370792142673018846430938189293974866316988672518455300069609000325779774222895087993725700394734362401819824232700732090875904010p 0.9
+ \]
V_wl_bar_763 (WordLine_bar\\<763\\> gnd!) vsource type=pwl wave=\[
+ 0    0.9
+ 48516190384397154223405609014453204851777688034896769098095376188314092271449277697839950275895202435952741584285346037692861876378587949732633977345036910600139218000651559548445790175987451400789468724803639648465401464181751807500p 0.9
+ 48516190384397154223405609014453204851777688034896769098095376188314092271449277697839950275895202435952741584285346037692861876378587949732633977345036910600139218000651559548445790175987451400789468724803639648465401464181751807510p -0.3
+ 48516190384397154223405609014453204851777688034896769098095376188314092271449277697839950275895202435952741584285346037692861876378587949732633977345036910600139218000651559548445790175987451400789468724803639648465401464181751808000p -0.3
+ 48516190384397154223405609014453204851777688034896769098095376188314092271449277697839950275895202435952741584285346037692861876378587949732633977345036910600139218000651559548445790175987451400789468724803639648465401464181751808010p 0.9
+ \]
V_wl_bar_764 (WordLine_bar\\<764\\> gnd!) vsource type=pwl wave=\[
+ 0    0.9
+ 97032380768794308446811218028906409703555376069793538196190752376628184542898555395679900551790404871905483168570692075385723752757175899465267954690073821200278436001303119096891580351974902801578937449607279296930802928363503615500p 0.9
+ 97032380768794308446811218028906409703555376069793538196190752376628184542898555395679900551790404871905483168570692075385723752757175899465267954690073821200278436001303119096891580351974902801578937449607279296930802928363503615510p -0.3
+ 97032380768794308446811218028906409703555376069793538196190752376628184542898555395679900551790404871905483168570692075385723752757175899465267954690073821200278436001303119096891580351974902801578937449607279296930802928363503616000p -0.3
+ 97032380768794308446811218028906409703555376069793538196190752376628184542898555395679900551790404871905483168570692075385723752757175899465267954690073821200278436001303119096891580351974902801578937449607279296930802928363503616010p 0.9
+ \]
V_wl_bar_765 (WordLine_bar\\<765\\> gnd!) vsource type=pwl wave=\[
+ 0    0.9
+ 194064761537588616893622436057812819407110752139587076392381504753256369085797110791359801103580809743810966337141384150771447505514351798930535909380147642400556872002606238193783160703949805603157874899214558593861605856727007231500p 0.9
+ 194064761537588616893622436057812819407110752139587076392381504753256369085797110791359801103580809743810966337141384150771447505514351798930535909380147642400556872002606238193783160703949805603157874899214558593861605856727007231510p -0.3
+ 194064761537588616893622436057812819407110752139587076392381504753256369085797110791359801103580809743810966337141384150771447505514351798930535909380147642400556872002606238193783160703949805603157874899214558593861605856727007232000p -0.3
+ 194064761537588616893622436057812819407110752139587076392381504753256369085797110791359801103580809743810966337141384150771447505514351798930535909380147642400556872002606238193783160703949805603157874899214558593861605856727007232010p 0.9
+ \]
V_wl_bar_766 (WordLine_bar\\<766\\> gnd!) vsource type=pwl wave=\[
+ 0    0.9
+ 388129523075177233787244872115625638814221504279174152784763009506512738171594221582719602207161619487621932674282768301542895011028703597861071818760295284801113744005212476387566321407899611206315749798429117187723211713454014463500p 0.9
+ 388129523075177233787244872115625638814221504279174152784763009506512738171594221582719602207161619487621932674282768301542895011028703597861071818760295284801113744005212476387566321407899611206315749798429117187723211713454014463510p -0.3
+ 388129523075177233787244872115625638814221504279174152784763009506512738171594221582719602207161619487621932674282768301542895011028703597861071818760295284801113744005212476387566321407899611206315749798429117187723211713454014464000p -0.3
+ 388129523075177233787244872115625638814221504279174152784763009506512738171594221582719602207161619487621932674282768301542895011028703597861071818760295284801113744005212476387566321407899611206315749798429117187723211713454014464010p 0.9
+ \]
V_wl_bar_767 (WordLine_bar\\<767\\> gnd!) vsource type=pwl wave=\[
+ 0    0.9
+ 776259046150354467574489744231251277628443008558348305569526019013025476343188443165439204414323238975243865348565536603085790022057407195722143637520590569602227488010424952775132642815799222412631499596858234375446423426908028927500p 0.9
+ 776259046150354467574489744231251277628443008558348305569526019013025476343188443165439204414323238975243865348565536603085790022057407195722143637520590569602227488010424952775132642815799222412631499596858234375446423426908028927510p -0.3
+ 776259046150354467574489744231251277628443008558348305569526019013025476343188443165439204414323238975243865348565536603085790022057407195722143637520590569602227488010424952775132642815799222412631499596858234375446423426908028928000p -0.3
+ 776259046150354467574489744231251277628443008558348305569526019013025476343188443165439204414323238975243865348565536603085790022057407195722143637520590569602227488010424952775132642815799222412631499596858234375446423426908028928010p 0.9
+ \]
V_wl_bar_768 (WordLine_bar\\<768\\> gnd!) vsource type=pwl wave=\[
+ 0    0.9
+ 1552518092300708935148979488462502555256886017116696611139052038026050952686376886330878408828646477950487730697131073206171580044114814391444287275041181139204454976020849905550265285631598444825262999193716468750892846853816057855500p 0.9
+ 1552518092300708935148979488462502555256886017116696611139052038026050952686376886330878408828646477950487730697131073206171580044114814391444287275041181139204454976020849905550265285631598444825262999193716468750892846853816057855510p -0.3
+ 1552518092300708935148979488462502555256886017116696611139052038026050952686376886330878408828646477950487730697131073206171580044114814391444287275041181139204454976020849905550265285631598444825262999193716468750892846853816057856000p -0.3
+ 1552518092300708935148979488462502555256886017116696611139052038026050952686376886330878408828646477950487730697131073206171580044114814391444287275041181139204454976020849905550265285631598444825262999193716468750892846853816057856010p 0.9
+ \]
V_wl_bar_769 (WordLine_bar\\<769\\> gnd!) vsource type=pwl wave=\[
+ 0    0.9
+ 3105036184601417870297958976925005110513772034233393222278104076052101905372753772661756817657292955900975461394262146412343160088229628782888574550082362278408909952041699811100530571263196889650525998387432937501785693707632115711500p 0.9
+ 3105036184601417870297958976925005110513772034233393222278104076052101905372753772661756817657292955900975461394262146412343160088229628782888574550082362278408909952041699811100530571263196889650525998387432937501785693707632115711510p -0.3
+ 3105036184601417870297958976925005110513772034233393222278104076052101905372753772661756817657292955900975461394262146412343160088229628782888574550082362278408909952041699811100530571263196889650525998387432937501785693707632115712000p -0.3
+ 3105036184601417870297958976925005110513772034233393222278104076052101905372753772661756817657292955900975461394262146412343160088229628782888574550082362278408909952041699811100530571263196889650525998387432937501785693707632115712010p 0.9
+ \]
V_wl_bar_770 (WordLine_bar\\<770\\> gnd!) vsource type=pwl wave=\[
+ 0    0.9
+ 6210072369202835740595917953850010221027544068466786444556208152104203810745507545323513635314585911801950922788524292824686320176459257565777149100164724556817819904083399622201061142526393779301051996774865875003571387415264231423500p 0.9
+ 6210072369202835740595917953850010221027544068466786444556208152104203810745507545323513635314585911801950922788524292824686320176459257565777149100164724556817819904083399622201061142526393779301051996774865875003571387415264231423510p -0.3
+ 6210072369202835740595917953850010221027544068466786444556208152104203810745507545323513635314585911801950922788524292824686320176459257565777149100164724556817819904083399622201061142526393779301051996774865875003571387415264231424000p -0.3
+ 6210072369202835740595917953850010221027544068466786444556208152104203810745507545323513635314585911801950922788524292824686320176459257565777149100164724556817819904083399622201061142526393779301051996774865875003571387415264231424010p 0.9
+ \]
V_wl_bar_771 (WordLine_bar\\<771\\> gnd!) vsource type=pwl wave=\[
+ 0    0.9
+ 12420144738405671481191835907700020442055088136933572889112416304208407621491015090647027270629171823603901845577048585649372640352918515131554298200329449113635639808166799244402122285052787558602103993549731750007142774830528462847500p 0.9
+ 12420144738405671481191835907700020442055088136933572889112416304208407621491015090647027270629171823603901845577048585649372640352918515131554298200329449113635639808166799244402122285052787558602103993549731750007142774830528462847510p -0.3
+ 12420144738405671481191835907700020442055088136933572889112416304208407621491015090647027270629171823603901845577048585649372640352918515131554298200329449113635639808166799244402122285052787558602103993549731750007142774830528462848000p -0.3
+ 12420144738405671481191835907700020442055088136933572889112416304208407621491015090647027270629171823603901845577048585649372640352918515131554298200329449113635639808166799244402122285052787558602103993549731750007142774830528462848010p 0.9
+ \]
V_wl_bar_772 (WordLine_bar\\<772\\> gnd!) vsource type=pwl wave=\[
+ 0    0.9
+ 24840289476811342962383671815400040884110176273867145778224832608416815242982030181294054541258343647207803691154097171298745280705837030263108596400658898227271279616333598488804244570105575117204207987099463500014285549661056925695500p 0.9
+ 24840289476811342962383671815400040884110176273867145778224832608416815242982030181294054541258343647207803691154097171298745280705837030263108596400658898227271279616333598488804244570105575117204207987099463500014285549661056925695510p -0.3
+ 24840289476811342962383671815400040884110176273867145778224832608416815242982030181294054541258343647207803691154097171298745280705837030263108596400658898227271279616333598488804244570105575117204207987099463500014285549661056925696000p -0.3
+ 24840289476811342962383671815400040884110176273867145778224832608416815242982030181294054541258343647207803691154097171298745280705837030263108596400658898227271279616333598488804244570105575117204207987099463500014285549661056925696010p 0.9
+ \]
V_wl_bar_773 (WordLine_bar\\<773\\> gnd!) vsource type=pwl wave=\[
+ 0    0.9
+ 49680578953622685924767343630800081768220352547734291556449665216833630485964060362588109082516687294415607382308194342597490561411674060526217192801317796454542559232667196977608489140211150234408415974198927000028571099322113851391500p 0.9
+ 49680578953622685924767343630800081768220352547734291556449665216833630485964060362588109082516687294415607382308194342597490561411674060526217192801317796454542559232667196977608489140211150234408415974198927000028571099322113851391510p -0.3
+ 49680578953622685924767343630800081768220352547734291556449665216833630485964060362588109082516687294415607382308194342597490561411674060526217192801317796454542559232667196977608489140211150234408415974198927000028571099322113851392000p -0.3
+ 49680578953622685924767343630800081768220352547734291556449665216833630485964060362588109082516687294415607382308194342597490561411674060526217192801317796454542559232667196977608489140211150234408415974198927000028571099322113851392010p 0.9
+ \]
V_wl_bar_774 (WordLine_bar\\<774\\> gnd!) vsource type=pwl wave=\[
+ 0    0.9
+ 99361157907245371849534687261600163536440705095468583112899330433667260971928120725176218165033374588831214764616388685194981122823348121052434385602635592909085118465334393955216978280422300468816831948397854000057142198644227702783500p 0.9
+ 99361157907245371849534687261600163536440705095468583112899330433667260971928120725176218165033374588831214764616388685194981122823348121052434385602635592909085118465334393955216978280422300468816831948397854000057142198644227702783510p -0.3
+ 99361157907245371849534687261600163536440705095468583112899330433667260971928120725176218165033374588831214764616388685194981122823348121052434385602635592909085118465334393955216978280422300468816831948397854000057142198644227702784000p -0.3
+ 99361157907245371849534687261600163536440705095468583112899330433667260971928120725176218165033374588831214764616388685194981122823348121052434385602635592909085118465334393955216978280422300468816831948397854000057142198644227702784010p 0.9
+ \]
V_wl_bar_775 (WordLine_bar\\<775\\> gnd!) vsource type=pwl wave=\[
+ 0    0.9
+ 198722315814490743699069374523200327072881410190937166225798660867334521943856241450352436330066749177662429529232777370389962245646696242104868771205271185818170236930668787910433956560844600937633663896795708000114284397288455405567500p 0.9
+ 198722315814490743699069374523200327072881410190937166225798660867334521943856241450352436330066749177662429529232777370389962245646696242104868771205271185818170236930668787910433956560844600937633663896795708000114284397288455405567510p -0.3
+ 198722315814490743699069374523200327072881410190937166225798660867334521943856241450352436330066749177662429529232777370389962245646696242104868771205271185818170236930668787910433956560844600937633663896795708000114284397288455405568000p -0.3
+ 198722315814490743699069374523200327072881410190937166225798660867334521943856241450352436330066749177662429529232777370389962245646696242104868771205271185818170236930668787910433956560844600937633663896795708000114284397288455405568010p 0.9
+ \]
V_wl_bar_776 (WordLine_bar\\<776\\> gnd!) vsource type=pwl wave=\[
+ 0    0.9
+ 397444631628981487398138749046400654145762820381874332451597321734669043887712482900704872660133498355324859058465554740779924491293392484209737542410542371636340473861337575820867913121689201875267327793591416000228568794576910811135500p 0.9
+ 397444631628981487398138749046400654145762820381874332451597321734669043887712482900704872660133498355324859058465554740779924491293392484209737542410542371636340473861337575820867913121689201875267327793591416000228568794576910811135510p -0.3
+ 397444631628981487398138749046400654145762820381874332451597321734669043887712482900704872660133498355324859058465554740779924491293392484209737542410542371636340473861337575820867913121689201875267327793591416000228568794576910811136000p -0.3
+ 397444631628981487398138749046400654145762820381874332451597321734669043887712482900704872660133498355324859058465554740779924491293392484209737542410542371636340473861337575820867913121689201875267327793591416000228568794576910811136010p 0.9
+ \]
V_wl_bar_777 (WordLine_bar\\<777\\> gnd!) vsource type=pwl wave=\[
+ 0    0.9
+ 794889263257962974796277498092801308291525640763748664903194643469338087775424965801409745320266996710649718116931109481559848982586784968419475084821084743272680947722675151641735826243378403750534655587182832000457137589153821622271500p 0.9
+ 794889263257962974796277498092801308291525640763748664903194643469338087775424965801409745320266996710649718116931109481559848982586784968419475084821084743272680947722675151641735826243378403750534655587182832000457137589153821622271510p -0.3
+ 794889263257962974796277498092801308291525640763748664903194643469338087775424965801409745320266996710649718116931109481559848982586784968419475084821084743272680947722675151641735826243378403750534655587182832000457137589153821622272000p -0.3
+ 794889263257962974796277498092801308291525640763748664903194643469338087775424965801409745320266996710649718116931109481559848982586784968419475084821084743272680947722675151641735826243378403750534655587182832000457137589153821622272010p 0.9
+ \]
V_wl_bar_778 (WordLine_bar\\<778\\> gnd!) vsource type=pwl wave=\[
+ 0    0.9
+ 1589778526515925949592554996185602616583051281527497329806389286938676175550849931602819490640533993421299436233862218963119697965173569936838950169642169486545361895445350303283471652486756807501069311174365664000914275178307643244543500p 0.9
+ 1589778526515925949592554996185602616583051281527497329806389286938676175550849931602819490640533993421299436233862218963119697965173569936838950169642169486545361895445350303283471652486756807501069311174365664000914275178307643244543510p -0.3
+ 1589778526515925949592554996185602616583051281527497329806389286938676175550849931602819490640533993421299436233862218963119697965173569936838950169642169486545361895445350303283471652486756807501069311174365664000914275178307643244544000p -0.3
+ 1589778526515925949592554996185602616583051281527497329806389286938676175550849931602819490640533993421299436233862218963119697965173569936838950169642169486545361895445350303283471652486756807501069311174365664000914275178307643244544010p 0.9
+ \]
V_wl_bar_779 (WordLine_bar\\<779\\> gnd!) vsource type=pwl wave=\[
+ 0    0.9
+ 3179557053031851899185109992371205233166102563054994659612778573877352351101699863205638981281067986842598872467724437926239395930347139873677900339284338973090723790890700606566943304973513615002138622348731328001828550356615286489087500p 0.9
+ 3179557053031851899185109992371205233166102563054994659612778573877352351101699863205638981281067986842598872467724437926239395930347139873677900339284338973090723790890700606566943304973513615002138622348731328001828550356615286489087510p -0.3
+ 3179557053031851899185109992371205233166102563054994659612778573877352351101699863205638981281067986842598872467724437926239395930347139873677900339284338973090723790890700606566943304973513615002138622348731328001828550356615286489088000p -0.3
+ 3179557053031851899185109992371205233166102563054994659612778573877352351101699863205638981281067986842598872467724437926239395930347139873677900339284338973090723790890700606566943304973513615002138622348731328001828550356615286489088010p 0.9
+ \]
V_wl_bar_780 (WordLine_bar\\<780\\> gnd!) vsource type=pwl wave=\[
+ 0    0.9
+ 6359114106063703798370219984742410466332205126109989319225557147754704702203399726411277962562135973685197744935448875852478791860694279747355800678568677946181447581781401213133886609947027230004277244697462656003657100713230572978175500p 0.9
+ 6359114106063703798370219984742410466332205126109989319225557147754704702203399726411277962562135973685197744935448875852478791860694279747355800678568677946181447581781401213133886609947027230004277244697462656003657100713230572978175510p -0.3
+ 6359114106063703798370219984742410466332205126109989319225557147754704702203399726411277962562135973685197744935448875852478791860694279747355800678568677946181447581781401213133886609947027230004277244697462656003657100713230572978176000p -0.3
+ 6359114106063703798370219984742410466332205126109989319225557147754704702203399726411277962562135973685197744935448875852478791860694279747355800678568677946181447581781401213133886609947027230004277244697462656003657100713230572978176010p 0.9
+ \]
V_wl_bar_781 (WordLine_bar\\<781\\> gnd!) vsource type=pwl wave=\[
+ 0    0.9
+ 12718228212127407596740439969484820932664410252219978638451114295509409404406799452822555925124271947370395489870897751704957583721388559494711601357137355892362895163562802426267773219894054460008554489394925312007314201426461145956351500p 0.9
+ 12718228212127407596740439969484820932664410252219978638451114295509409404406799452822555925124271947370395489870897751704957583721388559494711601357137355892362895163562802426267773219894054460008554489394925312007314201426461145956351510p -0.3
+ 12718228212127407596740439969484820932664410252219978638451114295509409404406799452822555925124271947370395489870897751704957583721388559494711601357137355892362895163562802426267773219894054460008554489394925312007314201426461145956352000p -0.3
+ 12718228212127407596740439969484820932664410252219978638451114295509409404406799452822555925124271947370395489870897751704957583721388559494711601357137355892362895163562802426267773219894054460008554489394925312007314201426461145956352010p 0.9
+ \]
V_wl_bar_782 (WordLine_bar\\<782\\> gnd!) vsource type=pwl wave=\[
+ 0    0.9
+ 25436456424254815193480879938969641865328820504439957276902228591018818808813598905645111850248543894740790979741795503409915167442777118989423202714274711784725790327125604852535546439788108920017108978789850624014628402852922291912703500p 0.9
+ 25436456424254815193480879938969641865328820504439957276902228591018818808813598905645111850248543894740790979741795503409915167442777118989423202714274711784725790327125604852535546439788108920017108978789850624014628402852922291912703510p -0.3
+ 25436456424254815193480879938969641865328820504439957276902228591018818808813598905645111850248543894740790979741795503409915167442777118989423202714274711784725790327125604852535546439788108920017108978789850624014628402852922291912704000p -0.3
+ 25436456424254815193480879938969641865328820504439957276902228591018818808813598905645111850248543894740790979741795503409915167442777118989423202714274711784725790327125604852535546439788108920017108978789850624014628402852922291912704010p 0.9
+ \]
V_wl_bar_783 (WordLine_bar\\<783\\> gnd!) vsource type=pwl wave=\[
+ 0    0.9
+ 50872912848509630386961759877939283730657641008879914553804457182037637617627197811290223700497087789481581959483591006819830334885554237978846405428549423569451580654251209705071092879576217840034217957579701248029256805705844583825407500p 0.9
+ 50872912848509630386961759877939283730657641008879914553804457182037637617627197811290223700497087789481581959483591006819830334885554237978846405428549423569451580654251209705071092879576217840034217957579701248029256805705844583825407510p -0.3
+ 50872912848509630386961759877939283730657641008879914553804457182037637617627197811290223700497087789481581959483591006819830334885554237978846405428549423569451580654251209705071092879576217840034217957579701248029256805705844583825408000p -0.3
+ 50872912848509630386961759877939283730657641008879914553804457182037637617627197811290223700497087789481581959483591006819830334885554237978846405428549423569451580654251209705071092879576217840034217957579701248029256805705844583825408010p 0.9
+ \]
V_wl_bar_784 (WordLine_bar\\<784\\> gnd!) vsource type=pwl wave=\[
+ 0    0.9
+ 101745825697019260773923519755878567461315282017759829107608914364075275235254395622580447400994175578963163918967182013639660669771108475957692810857098847138903161308502419410142185759152435680068435915159402496058513611411689167650815500p 0.9
+ 101745825697019260773923519755878567461315282017759829107608914364075275235254395622580447400994175578963163918967182013639660669771108475957692810857098847138903161308502419410142185759152435680068435915159402496058513611411689167650815510p -0.3
+ 101745825697019260773923519755878567461315282017759829107608914364075275235254395622580447400994175578963163918967182013639660669771108475957692810857098847138903161308502419410142185759152435680068435915159402496058513611411689167650816000p -0.3
+ 101745825697019260773923519755878567461315282017759829107608914364075275235254395622580447400994175578963163918967182013639660669771108475957692810857098847138903161308502419410142185759152435680068435915159402496058513611411689167650816010p 0.9
+ \]
V_wl_bar_785 (WordLine_bar\\<785\\> gnd!) vsource type=pwl wave=\[
+ 0    0.9
+ 203491651394038521547847039511757134922630564035519658215217828728150550470508791245160894801988351157926327837934364027279321339542216951915385621714197694277806322617004838820284371518304871360136871830318804992117027222823378335301631500p 0.9
+ 203491651394038521547847039511757134922630564035519658215217828728150550470508791245160894801988351157926327837934364027279321339542216951915385621714197694277806322617004838820284371518304871360136871830318804992117027222823378335301631510p -0.3
+ 203491651394038521547847039511757134922630564035519658215217828728150550470508791245160894801988351157926327837934364027279321339542216951915385621714197694277806322617004838820284371518304871360136871830318804992117027222823378335301632000p -0.3
+ 203491651394038521547847039511757134922630564035519658215217828728150550470508791245160894801988351157926327837934364027279321339542216951915385621714197694277806322617004838820284371518304871360136871830318804992117027222823378335301632010p 0.9
+ \]
V_wl_bar_786 (WordLine_bar\\<786\\> gnd!) vsource type=pwl wave=\[
+ 0    0.9
+ 406983302788077043095694079023514269845261128071039316430435657456301100941017582490321789603976702315852655675868728054558642679084433903830771243428395388555612645234009677640568743036609742720273743660637609984234054445646756670603263500p 0.9
+ 406983302788077043095694079023514269845261128071039316430435657456301100941017582490321789603976702315852655675868728054558642679084433903830771243428395388555612645234009677640568743036609742720273743660637609984234054445646756670603263510p -0.3
+ 406983302788077043095694079023514269845261128071039316430435657456301100941017582490321789603976702315852655675868728054558642679084433903830771243428395388555612645234009677640568743036609742720273743660637609984234054445646756670603264000p -0.3
+ 406983302788077043095694079023514269845261128071039316430435657456301100941017582490321789603976702315852655675868728054558642679084433903830771243428395388555612645234009677640568743036609742720273743660637609984234054445646756670603264010p 0.9
+ \]
V_wl_bar_787 (WordLine_bar\\<787\\> gnd!) vsource type=pwl wave=\[
+ 0    0.9
+ 813966605576154086191388158047028539690522256142078632860871314912602201882035164980643579207953404631705311351737456109117285358168867807661542486856790777111225290468019355281137486073219485440547487321275219968468108891293513341206527500p 0.9
+ 813966605576154086191388158047028539690522256142078632860871314912602201882035164980643579207953404631705311351737456109117285358168867807661542486856790777111225290468019355281137486073219485440547487321275219968468108891293513341206527510p -0.3
+ 813966605576154086191388158047028539690522256142078632860871314912602201882035164980643579207953404631705311351737456109117285358168867807661542486856790777111225290468019355281137486073219485440547487321275219968468108891293513341206528000p -0.3
+ 813966605576154086191388158047028539690522256142078632860871314912602201882035164980643579207953404631705311351737456109117285358168867807661542486856790777111225290468019355281137486073219485440547487321275219968468108891293513341206528010p 0.9
+ \]
V_wl_bar_788 (WordLine_bar\\<788\\> gnd!) vsource type=pwl wave=\[
+ 0    0.9
+ 1627933211152308172382776316094057079381044512284157265721742629825204403764070329961287158415906809263410622703474912218234570716337735615323084973713581554222450580936038710562274972146438970881094974642550439936936217782587026682413055500p 0.9
+ 1627933211152308172382776316094057079381044512284157265721742629825204403764070329961287158415906809263410622703474912218234570716337735615323084973713581554222450580936038710562274972146438970881094974642550439936936217782587026682413055510p -0.3
+ 1627933211152308172382776316094057079381044512284157265721742629825204403764070329961287158415906809263410622703474912218234570716337735615323084973713581554222450580936038710562274972146438970881094974642550439936936217782587026682413056000p -0.3
+ 1627933211152308172382776316094057079381044512284157265721742629825204403764070329961287158415906809263410622703474912218234570716337735615323084973713581554222450580936038710562274972146438970881094974642550439936936217782587026682413056010p 0.9
+ \]
V_wl_bar_789 (WordLine_bar\\<789\\> gnd!) vsource type=pwl wave=\[
+ 0    0.9
+ 3255866422304616344765552632188114158762089024568314531443485259650408807528140659922574316831813618526821245406949824436469141432675471230646169947427163108444901161872077421124549944292877941762189949285100879873872435565174053364826111500p 0.9
+ 3255866422304616344765552632188114158762089024568314531443485259650408807528140659922574316831813618526821245406949824436469141432675471230646169947427163108444901161872077421124549944292877941762189949285100879873872435565174053364826111510p -0.3
+ 3255866422304616344765552632188114158762089024568314531443485259650408807528140659922574316831813618526821245406949824436469141432675471230646169947427163108444901161872077421124549944292877941762189949285100879873872435565174053364826112000p -0.3
+ 3255866422304616344765552632188114158762089024568314531443485259650408807528140659922574316831813618526821245406949824436469141432675471230646169947427163108444901161872077421124549944292877941762189949285100879873872435565174053364826112010p 0.9
+ \]
V_wl_bar_790 (WordLine_bar\\<790\\> gnd!) vsource type=pwl wave=\[
+ 0    0.9
+ 6511732844609232689531105264376228317524178049136629062886970519300817615056281319845148633663627237053642490813899648872938282865350942461292339894854326216889802323744154842249099888585755883524379898570201759747744871130348106729652223500p 0.9
+ 6511732844609232689531105264376228317524178049136629062886970519300817615056281319845148633663627237053642490813899648872938282865350942461292339894854326216889802323744154842249099888585755883524379898570201759747744871130348106729652223510p -0.3
+ 6511732844609232689531105264376228317524178049136629062886970519300817615056281319845148633663627237053642490813899648872938282865350942461292339894854326216889802323744154842249099888585755883524379898570201759747744871130348106729652224000p -0.3
+ 6511732844609232689531105264376228317524178049136629062886970519300817615056281319845148633663627237053642490813899648872938282865350942461292339894854326216889802323744154842249099888585755883524379898570201759747744871130348106729652224010p 0.9
+ \]
V_wl_bar_791 (WordLine_bar\\<791\\> gnd!) vsource type=pwl wave=\[
+ 0    0.9
+ 13023465689218465379062210528752456635048356098273258125773941038601635230112562639690297267327254474107284981627799297745876565730701884922584679789708652433779604647488309684498199777171511767048759797140403519495489742260696213459304447500p 0.9
+ 13023465689218465379062210528752456635048356098273258125773941038601635230112562639690297267327254474107284981627799297745876565730701884922584679789708652433779604647488309684498199777171511767048759797140403519495489742260696213459304447510p -0.3
+ 13023465689218465379062210528752456635048356098273258125773941038601635230112562639690297267327254474107284981627799297745876565730701884922584679789708652433779604647488309684498199777171511767048759797140403519495489742260696213459304448000p -0.3
+ 13023465689218465379062210528752456635048356098273258125773941038601635230112562639690297267327254474107284981627799297745876565730701884922584679789708652433779604647488309684498199777171511767048759797140403519495489742260696213459304448010p 0.9
+ \]
V_wl_bar_792 (WordLine_bar\\<792\\> gnd!) vsource type=pwl wave=\[
+ 0    0.9
+ 26046931378436930758124421057504913270096712196546516251547882077203270460225125279380594534654508948214569963255598595491753131461403769845169359579417304867559209294976619368996399554343023534097519594280807038990979484521392426918608895500p 0.9
+ 26046931378436930758124421057504913270096712196546516251547882077203270460225125279380594534654508948214569963255598595491753131461403769845169359579417304867559209294976619368996399554343023534097519594280807038990979484521392426918608895510p -0.3
+ 26046931378436930758124421057504913270096712196546516251547882077203270460225125279380594534654508948214569963255598595491753131461403769845169359579417304867559209294976619368996399554343023534097519594280807038990979484521392426918608896000p -0.3
+ 26046931378436930758124421057504913270096712196546516251547882077203270460225125279380594534654508948214569963255598595491753131461403769845169359579417304867559209294976619368996399554343023534097519594280807038990979484521392426918608896010p 0.9
+ \]
V_wl_bar_793 (WordLine_bar\\<793\\> gnd!) vsource type=pwl wave=\[
+ 0    0.9
+ 52093862756873861516248842115009826540193424393093032503095764154406540920450250558761189069309017896429139926511197190983506262922807539690338719158834609735118418589953238737992799108686047068195039188561614077981958969042784853837217791500p 0.9
+ 52093862756873861516248842115009826540193424393093032503095764154406540920450250558761189069309017896429139926511197190983506262922807539690338719158834609735118418589953238737992799108686047068195039188561614077981958969042784853837217791510p -0.3
+ 52093862756873861516248842115009826540193424393093032503095764154406540920450250558761189069309017896429139926511197190983506262922807539690338719158834609735118418589953238737992799108686047068195039188561614077981958969042784853837217792000p -0.3
+ 52093862756873861516248842115009826540193424393093032503095764154406540920450250558761189069309017896429139926511197190983506262922807539690338719158834609735118418589953238737992799108686047068195039188561614077981958969042784853837217792010p 0.9
+ \]
V_wl_bar_794 (WordLine_bar\\<794\\> gnd!) vsource type=pwl wave=\[
+ 0    0.9
+ 104187725513747723032497684230019653080386848786186065006191528308813081840900501117522378138618035792858279853022394381967012525845615079380677438317669219470236837179906477475985598217372094136390078377123228155963917938085569707674435583500p 0.9
+ 104187725513747723032497684230019653080386848786186065006191528308813081840900501117522378138618035792858279853022394381967012525845615079380677438317669219470236837179906477475985598217372094136390078377123228155963917938085569707674435583510p -0.3
+ 104187725513747723032497684230019653080386848786186065006191528308813081840900501117522378138618035792858279853022394381967012525845615079380677438317669219470236837179906477475985598217372094136390078377123228155963917938085569707674435584000p -0.3
+ 104187725513747723032497684230019653080386848786186065006191528308813081840900501117522378138618035792858279853022394381967012525845615079380677438317669219470236837179906477475985598217372094136390078377123228155963917938085569707674435584010p 0.9
+ \]
V_wl_bar_795 (WordLine_bar\\<795\\> gnd!) vsource type=pwl wave=\[
+ 0    0.9
+ 208375451027495446064995368460039306160773697572372130012383056617626163681801002235044756277236071585716559706044788763934025051691230158761354876635338438940473674359812954951971196434744188272780156754246456311927835876171139415348871167500p 0.9
+ 208375451027495446064995368460039306160773697572372130012383056617626163681801002235044756277236071585716559706044788763934025051691230158761354876635338438940473674359812954951971196434744188272780156754246456311927835876171139415348871167510p -0.3
+ 208375451027495446064995368460039306160773697572372130012383056617626163681801002235044756277236071585716559706044788763934025051691230158761354876635338438940473674359812954951971196434744188272780156754246456311927835876171139415348871168000p -0.3
+ 208375451027495446064995368460039306160773697572372130012383056617626163681801002235044756277236071585716559706044788763934025051691230158761354876635338438940473674359812954951971196434744188272780156754246456311927835876171139415348871168010p 0.9
+ \]
V_wl_bar_796 (WordLine_bar\\<796\\> gnd!) vsource type=pwl wave=\[
+ 0    0.9
+ 416750902054990892129990736920078612321547395144744260024766113235252327363602004470089512554472143171433119412089577527868050103382460317522709753270676877880947348719625909903942392869488376545560313508492912623855671752342278830697742335500p 0.9
+ 416750902054990892129990736920078612321547395144744260024766113235252327363602004470089512554472143171433119412089577527868050103382460317522709753270676877880947348719625909903942392869488376545560313508492912623855671752342278830697742335510p -0.3
+ 416750902054990892129990736920078612321547395144744260024766113235252327363602004470089512554472143171433119412089577527868050103382460317522709753270676877880947348719625909903942392869488376545560313508492912623855671752342278830697742336000p -0.3
+ 416750902054990892129990736920078612321547395144744260024766113235252327363602004470089512554472143171433119412089577527868050103382460317522709753270676877880947348719625909903942392869488376545560313508492912623855671752342278830697742336010p 0.9
+ \]
V_wl_bar_797 (WordLine_bar\\<797\\> gnd!) vsource type=pwl wave=\[
+ 0    0.9
+ 833501804109981784259981473840157224643094790289488520049532226470504654727204008940179025108944286342866238824179155055736100206764920635045419506541353755761894697439251819807884785738976753091120627016985825247711343504684557661395484671500p 0.9
+ 833501804109981784259981473840157224643094790289488520049532226470504654727204008940179025108944286342866238824179155055736100206764920635045419506541353755761894697439251819807884785738976753091120627016985825247711343504684557661395484671510p -0.3
+ 833501804109981784259981473840157224643094790289488520049532226470504654727204008940179025108944286342866238824179155055736100206764920635045419506541353755761894697439251819807884785738976753091120627016985825247711343504684557661395484672000p -0.3
+ 833501804109981784259981473840157224643094790289488520049532226470504654727204008940179025108944286342866238824179155055736100206764920635045419506541353755761894697439251819807884785738976753091120627016985825247711343504684557661395484672010p 0.9
+ \]
V_wl_bar_798 (WordLine_bar\\<798\\> gnd!) vsource type=pwl wave=\[
+ 0    0.9
+ 1667003608219963568519962947680314449286189580578977040099064452941009309454408017880358050217888572685732477648358310111472200413529841270090839013082707511523789394878503639615769571477953506182241254033971650495422687009369115322790969343500p 0.9
+ 1667003608219963568519962947680314449286189580578977040099064452941009309454408017880358050217888572685732477648358310111472200413529841270090839013082707511523789394878503639615769571477953506182241254033971650495422687009369115322790969343510p -0.3
+ 1667003608219963568519962947680314449286189580578977040099064452941009309454408017880358050217888572685732477648358310111472200413529841270090839013082707511523789394878503639615769571477953506182241254033971650495422687009369115322790969344000p -0.3
+ 1667003608219963568519962947680314449286189580578977040099064452941009309454408017880358050217888572685732477648358310111472200413529841270090839013082707511523789394878503639615769571477953506182241254033971650495422687009369115322790969344010p 0.9
+ \]
V_wl_bar_799 (WordLine_bar\\<799\\> gnd!) vsource type=pwl wave=\[
+ 0    0.9
+ 3334007216439927137039925895360628898572379161157954080198128905882018618908816035760716100435777145371464955296716620222944400827059682540181678026165415023047578789757007279231539142955907012364482508067943300990845374018738230645581938687500p 0.9
+ 3334007216439927137039925895360628898572379161157954080198128905882018618908816035760716100435777145371464955296716620222944400827059682540181678026165415023047578789757007279231539142955907012364482508067943300990845374018738230645581938687510p -0.3
+ 3334007216439927137039925895360628898572379161157954080198128905882018618908816035760716100435777145371464955296716620222944400827059682540181678026165415023047578789757007279231539142955907012364482508067943300990845374018738230645581938688000p -0.3
+ 3334007216439927137039925895360628898572379161157954080198128905882018618908816035760716100435777145371464955296716620222944400827059682540181678026165415023047578789757007279231539142955907012364482508067943300990845374018738230645581938688010p 0.9
+ \]
V_wl_bar_800 (WordLine_bar\\<800\\> gnd!) vsource type=pwl wave=\[
+ 0    0.9
+ 6668014432879854274079851790721257797144758322315908160396257811764037237817632071521432200871554290742929910593433240445888801654119365080363356052330830046095157579514014558463078285911814024728965016135886601981690748037476461291163877375500p 0.9
+ 6668014432879854274079851790721257797144758322315908160396257811764037237817632071521432200871554290742929910593433240445888801654119365080363356052330830046095157579514014558463078285911814024728965016135886601981690748037476461291163877375510p -0.3
+ 6668014432879854274079851790721257797144758322315908160396257811764037237817632071521432200871554290742929910593433240445888801654119365080363356052330830046095157579514014558463078285911814024728965016135886601981690748037476461291163877376000p -0.3
+ 6668014432879854274079851790721257797144758322315908160396257811764037237817632071521432200871554290742929910593433240445888801654119365080363356052330830046095157579514014558463078285911814024728965016135886601981690748037476461291163877376010p 0.9
+ \]
V_wl_bar_801 (WordLine_bar\\<801\\> gnd!) vsource type=pwl wave=\[
+ 0    0.9
+ 13336028865759708548159703581442515594289516644631816320792515623528074475635264143042864401743108581485859821186866480891777603308238730160726712104661660092190315159028029116926156571823628049457930032271773203963381496074952922582327754751500p 0.9
+ 13336028865759708548159703581442515594289516644631816320792515623528074475635264143042864401743108581485859821186866480891777603308238730160726712104661660092190315159028029116926156571823628049457930032271773203963381496074952922582327754751510p -0.3
+ 13336028865759708548159703581442515594289516644631816320792515623528074475635264143042864401743108581485859821186866480891777603308238730160726712104661660092190315159028029116926156571823628049457930032271773203963381496074952922582327754752000p -0.3
+ 13336028865759708548159703581442515594289516644631816320792515623528074475635264143042864401743108581485859821186866480891777603308238730160726712104661660092190315159028029116926156571823628049457930032271773203963381496074952922582327754752010p 0.9
+ \]
V_wl_bar_802 (WordLine_bar\\<802\\> gnd!) vsource type=pwl wave=\[
+ 0    0.9
+ 26672057731519417096319407162885031188579033289263632641585031247056148951270528286085728803486217162971719642373732961783555206616477460321453424209323320184380630318056058233852313143647256098915860064543546407926762992149905845164655509503500p 0.9
+ 26672057731519417096319407162885031188579033289263632641585031247056148951270528286085728803486217162971719642373732961783555206616477460321453424209323320184380630318056058233852313143647256098915860064543546407926762992149905845164655509503510p -0.3
+ 26672057731519417096319407162885031188579033289263632641585031247056148951270528286085728803486217162971719642373732961783555206616477460321453424209323320184380630318056058233852313143647256098915860064543546407926762992149905845164655509504000p -0.3
+ 26672057731519417096319407162885031188579033289263632641585031247056148951270528286085728803486217162971719642373732961783555206616477460321453424209323320184380630318056058233852313143647256098915860064543546407926762992149905845164655509504010p 0.9
+ \]
V_wl_bar_803 (WordLine_bar\\<803\\> gnd!) vsource type=pwl wave=\[
+ 0    0.9
+ 53344115463038834192638814325770062377158066578527265283170062494112297902541056572171457606972434325943439284747465923567110413232954920642906848418646640368761260636112116467704626287294512197831720129087092815853525984299811690329311019007500p 0.9
+ 53344115463038834192638814325770062377158066578527265283170062494112297902541056572171457606972434325943439284747465923567110413232954920642906848418646640368761260636112116467704626287294512197831720129087092815853525984299811690329311019007510p -0.3
+ 53344115463038834192638814325770062377158066578527265283170062494112297902541056572171457606972434325943439284747465923567110413232954920642906848418646640368761260636112116467704626287294512197831720129087092815853525984299811690329311019008000p -0.3
+ 53344115463038834192638814325770062377158066578527265283170062494112297902541056572171457606972434325943439284747465923567110413232954920642906848418646640368761260636112116467704626287294512197831720129087092815853525984299811690329311019008010p 0.9
+ \]
V_wl_bar_804 (WordLine_bar\\<804\\> gnd!) vsource type=pwl wave=\[
+ 0    0.9
+ 106688230926077668385277628651540124754316133157054530566340124988224595805082113144342915213944868651886878569494931847134220826465909841285813696837293280737522521272224232935409252574589024395663440258174185631707051968599623380658622038015500p 0.9
+ 106688230926077668385277628651540124754316133157054530566340124988224595805082113144342915213944868651886878569494931847134220826465909841285813696837293280737522521272224232935409252574589024395663440258174185631707051968599623380658622038015510p -0.3
+ 106688230926077668385277628651540124754316133157054530566340124988224595805082113144342915213944868651886878569494931847134220826465909841285813696837293280737522521272224232935409252574589024395663440258174185631707051968599623380658622038016000p -0.3
+ 106688230926077668385277628651540124754316133157054530566340124988224595805082113144342915213944868651886878569494931847134220826465909841285813696837293280737522521272224232935409252574589024395663440258174185631707051968599623380658622038016010p 0.9
+ \]
V_wl_bar_805 (WordLine_bar\\<805\\> gnd!) vsource type=pwl wave=\[
+ 0    0.9
+ 213376461852155336770555257303080249508632266314109061132680249976449191610164226288685830427889737303773757138989863694268441652931819682571627393674586561475045042544448465870818505149178048791326880516348371263414103937199246761317244076031500p 0.9
+ 213376461852155336770555257303080249508632266314109061132680249976449191610164226288685830427889737303773757138989863694268441652931819682571627393674586561475045042544448465870818505149178048791326880516348371263414103937199246761317244076031510p -0.3
+ 213376461852155336770555257303080249508632266314109061132680249976449191610164226288685830427889737303773757138989863694268441652931819682571627393674586561475045042544448465870818505149178048791326880516348371263414103937199246761317244076032000p -0.3
+ 213376461852155336770555257303080249508632266314109061132680249976449191610164226288685830427889737303773757138989863694268441652931819682571627393674586561475045042544448465870818505149178048791326880516348371263414103937199246761317244076032010p 0.9
+ \]
V_wl_bar_806 (WordLine_bar\\<806\\> gnd!) vsource type=pwl wave=\[
+ 0    0.9
+ 426752923704310673541110514606160499017264532628218122265360499952898383220328452577371660855779474607547514277979727388536883305863639365143254787349173122950090085088896931741637010298356097582653761032696742526828207874398493522634488152063500p 0.9
+ 426752923704310673541110514606160499017264532628218122265360499952898383220328452577371660855779474607547514277979727388536883305863639365143254787349173122950090085088896931741637010298356097582653761032696742526828207874398493522634488152063510p -0.3
+ 426752923704310673541110514606160499017264532628218122265360499952898383220328452577371660855779474607547514277979727388536883305863639365143254787349173122950090085088896931741637010298356097582653761032696742526828207874398493522634488152064000p -0.3
+ 426752923704310673541110514606160499017264532628218122265360499952898383220328452577371660855779474607547514277979727388536883305863639365143254787349173122950090085088896931741637010298356097582653761032696742526828207874398493522634488152064010p 0.9
+ \]
V_wl_bar_807 (WordLine_bar\\<807\\> gnd!) vsource type=pwl wave=\[
+ 0    0.9
+ 853505847408621347082221029212320998034529065256436244530720999905796766440656905154743321711558949215095028555959454777073766611727278730286509574698346245900180170177793863483274020596712195165307522065393485053656415748796987045268976304127500p 0.9
+ 853505847408621347082221029212320998034529065256436244530720999905796766440656905154743321711558949215095028555959454777073766611727278730286509574698346245900180170177793863483274020596712195165307522065393485053656415748796987045268976304127510p -0.3
+ 853505847408621347082221029212320998034529065256436244530720999905796766440656905154743321711558949215095028555959454777073766611727278730286509574698346245900180170177793863483274020596712195165307522065393485053656415748796987045268976304128000p -0.3
+ 853505847408621347082221029212320998034529065256436244530720999905796766440656905154743321711558949215095028555959454777073766611727278730286509574698346245900180170177793863483274020596712195165307522065393485053656415748796987045268976304128010p 0.9
+ \]
V_wl_bar_808 (WordLine_bar\\<808\\> gnd!) vsource type=pwl wave=\[
+ 0    0.9
+ 1707011694817242694164442058424641996069058130512872489061441999811593532881313810309486643423117898430190057111918909554147533223454557460573019149396692491800360340355587726966548041193424390330615044130786970107312831497593974090537952608255500p 0.9
+ 1707011694817242694164442058424641996069058130512872489061441999811593532881313810309486643423117898430190057111918909554147533223454557460573019149396692491800360340355587726966548041193424390330615044130786970107312831497593974090537952608255510p -0.3
+ 1707011694817242694164442058424641996069058130512872489061441999811593532881313810309486643423117898430190057111918909554147533223454557460573019149396692491800360340355587726966548041193424390330615044130786970107312831497593974090537952608256000p -0.3
+ 1707011694817242694164442058424641996069058130512872489061441999811593532881313810309486643423117898430190057111918909554147533223454557460573019149396692491800360340355587726966548041193424390330615044130786970107312831497593974090537952608256010p 0.9
+ \]
V_wl_bar_809 (WordLine_bar\\<809\\> gnd!) vsource type=pwl wave=\[
+ 0    0.9
+ 3414023389634485388328884116849283992138116261025744978122883999623187065762627620618973286846235796860380114223837819108295066446909114921146038298793384983600720680711175453933096082386848780661230088261573940214625662995187948181075905216511500p 0.9
+ 3414023389634485388328884116849283992138116261025744978122883999623187065762627620618973286846235796860380114223837819108295066446909114921146038298793384983600720680711175453933096082386848780661230088261573940214625662995187948181075905216511510p -0.3
+ 3414023389634485388328884116849283992138116261025744978122883999623187065762627620618973286846235796860380114223837819108295066446909114921146038298793384983600720680711175453933096082386848780661230088261573940214625662995187948181075905216512000p -0.3
+ 3414023389634485388328884116849283992138116261025744978122883999623187065762627620618973286846235796860380114223837819108295066446909114921146038298793384983600720680711175453933096082386848780661230088261573940214625662995187948181075905216512010p 0.9
+ \]
V_wl_bar_810 (WordLine_bar\\<810\\> gnd!) vsource type=pwl wave=\[
+ 0    0.9
+ 6828046779268970776657768233698567984276232522051489956245767999246374131525255241237946573692471593720760228447675638216590132893818229842292076597586769967201441361422350907866192164773697561322460176523147880429251325990375896362151810433023500p 0.9
+ 6828046779268970776657768233698567984276232522051489956245767999246374131525255241237946573692471593720760228447675638216590132893818229842292076597586769967201441361422350907866192164773697561322460176523147880429251325990375896362151810433023510p -0.3
+ 6828046779268970776657768233698567984276232522051489956245767999246374131525255241237946573692471593720760228447675638216590132893818229842292076597586769967201441361422350907866192164773697561322460176523147880429251325990375896362151810433024000p -0.3
+ 6828046779268970776657768233698567984276232522051489956245767999246374131525255241237946573692471593720760228447675638216590132893818229842292076597586769967201441361422350907866192164773697561322460176523147880429251325990375896362151810433024010p 0.9
+ \]
V_wl_bar_811 (WordLine_bar\\<811\\> gnd!) vsource type=pwl wave=\[
+ 0    0.9
+ 13656093558537941553315536467397135968552465044102979912491535998492748263050510482475893147384943187441520456895351276433180265787636459684584153195173539934402882722844701815732384329547395122644920353046295760858502651980751792724303620866047500p 0.9
+ 13656093558537941553315536467397135968552465044102979912491535998492748263050510482475893147384943187441520456895351276433180265787636459684584153195173539934402882722844701815732384329547395122644920353046295760858502651980751792724303620866047510p -0.3
+ 13656093558537941553315536467397135968552465044102979912491535998492748263050510482475893147384943187441520456895351276433180265787636459684584153195173539934402882722844701815732384329547395122644920353046295760858502651980751792724303620866048000p -0.3
+ 13656093558537941553315536467397135968552465044102979912491535998492748263050510482475893147384943187441520456895351276433180265787636459684584153195173539934402882722844701815732384329547395122644920353046295760858502651980751792724303620866048010p 0.9
+ \]
V_wl_bar_812 (WordLine_bar\\<812\\> gnd!) vsource type=pwl wave=\[
+ 0    0.9
+ 27312187117075883106631072934794271937104930088205959824983071996985496526101020964951786294769886374883040913790702552866360531575272919369168306390347079868805765445689403631464768659094790245289840706092591521717005303961503585448607241732095500p 0.9
+ 27312187117075883106631072934794271937104930088205959824983071996985496526101020964951786294769886374883040913790702552866360531575272919369168306390347079868805765445689403631464768659094790245289840706092591521717005303961503585448607241732095510p -0.3
+ 27312187117075883106631072934794271937104930088205959824983071996985496526101020964951786294769886374883040913790702552866360531575272919369168306390347079868805765445689403631464768659094790245289840706092591521717005303961503585448607241732096000p -0.3
+ 27312187117075883106631072934794271937104930088205959824983071996985496526101020964951786294769886374883040913790702552866360531575272919369168306390347079868805765445689403631464768659094790245289840706092591521717005303961503585448607241732096010p 0.9
+ \]
V_wl_bar_813 (WordLine_bar\\<813\\> gnd!) vsource type=pwl wave=\[
+ 0    0.9
+ 54624374234151766213262145869588543874209860176411919649966143993970993052202041929903572589539772749766081827581405105732721063150545838738336612780694159737611530891378807262929537318189580490579681412185183043434010607923007170897214483464191500p 0.9
+ 54624374234151766213262145869588543874209860176411919649966143993970993052202041929903572589539772749766081827581405105732721063150545838738336612780694159737611530891378807262929537318189580490579681412185183043434010607923007170897214483464191510p -0.3
+ 54624374234151766213262145869588543874209860176411919649966143993970993052202041929903572589539772749766081827581405105732721063150545838738336612780694159737611530891378807262929537318189580490579681412185183043434010607923007170897214483464192000p -0.3
+ 54624374234151766213262145869588543874209860176411919649966143993970993052202041929903572589539772749766081827581405105732721063150545838738336612780694159737611530891378807262929537318189580490579681412185183043434010607923007170897214483464192010p 0.9
+ \]
V_wl_bar_814 (WordLine_bar\\<814\\> gnd!) vsource type=pwl wave=\[
+ 0    0.9
+ 109248748468303532426524291739177087748419720352823839299932287987941986104404083859807145179079545499532163655162810211465442126301091677476673225561388319475223061782757614525859074636379160981159362824370366086868021215846014341794428966928383500p 0.9
+ 109248748468303532426524291739177087748419720352823839299932287987941986104404083859807145179079545499532163655162810211465442126301091677476673225561388319475223061782757614525859074636379160981159362824370366086868021215846014341794428966928383510p -0.3
+ 109248748468303532426524291739177087748419720352823839299932287987941986104404083859807145179079545499532163655162810211465442126301091677476673225561388319475223061782757614525859074636379160981159362824370366086868021215846014341794428966928384000p -0.3
+ 109248748468303532426524291739177087748419720352823839299932287987941986104404083859807145179079545499532163655162810211465442126301091677476673225561388319475223061782757614525859074636379160981159362824370366086868021215846014341794428966928384010p 0.9
+ \]
V_wl_bar_815 (WordLine_bar\\<815\\> gnd!) vsource type=pwl wave=\[
+ 0    0.9
+ 218497496936607064853048583478354175496839440705647678599864575975883972208808167719614290358159090999064327310325620422930884252602183354953346451122776638950446123565515229051718149272758321962318725648740732173736042431692028683588857933856767500p 0.9
+ 218497496936607064853048583478354175496839440705647678599864575975883972208808167719614290358159090999064327310325620422930884252602183354953346451122776638950446123565515229051718149272758321962318725648740732173736042431692028683588857933856767510p -0.3
+ 218497496936607064853048583478354175496839440705647678599864575975883972208808167719614290358159090999064327310325620422930884252602183354953346451122776638950446123565515229051718149272758321962318725648740732173736042431692028683588857933856768000p -0.3
+ 218497496936607064853048583478354175496839440705647678599864575975883972208808167719614290358159090999064327310325620422930884252602183354953346451122776638950446123565515229051718149272758321962318725648740732173736042431692028683588857933856768010p 0.9
+ \]
V_wl_bar_816 (WordLine_bar\\<816\\> gnd!) vsource type=pwl wave=\[
+ 0    0.9
+ 436994993873214129706097166956708350993678881411295357199729151951767944417616335439228580716318181998128654620651240845861768505204366709906692902245553277900892247131030458103436298545516643924637451297481464347472084863384057367177715867713535500p 0.9
+ 436994993873214129706097166956708350993678881411295357199729151951767944417616335439228580716318181998128654620651240845861768505204366709906692902245553277900892247131030458103436298545516643924637451297481464347472084863384057367177715867713535510p -0.3
+ 436994993873214129706097166956708350993678881411295357199729151951767944417616335439228580716318181998128654620651240845861768505204366709906692902245553277900892247131030458103436298545516643924637451297481464347472084863384057367177715867713536000p -0.3
+ 436994993873214129706097166956708350993678881411295357199729151951767944417616335439228580716318181998128654620651240845861768505204366709906692902245553277900892247131030458103436298545516643924637451297481464347472084863384057367177715867713536010p 0.9
+ \]
V_wl_bar_817 (WordLine_bar\\<817\\> gnd!) vsource type=pwl wave=\[
+ 0    0.9
+ 873989987746428259412194333913416701987357762822590714399458303903535888835232670878457161432636363996257309241302481691723537010408733419813385804491106555801784494262060916206872597091033287849274902594962928694944169726768114734355431735427071500p 0.9
+ 873989987746428259412194333913416701987357762822590714399458303903535888835232670878457161432636363996257309241302481691723537010408733419813385804491106555801784494262060916206872597091033287849274902594962928694944169726768114734355431735427071510p -0.3
+ 873989987746428259412194333913416701987357762822590714399458303903535888835232670878457161432636363996257309241302481691723537010408733419813385804491106555801784494262060916206872597091033287849274902594962928694944169726768114734355431735427072000p -0.3
+ 873989987746428259412194333913416701987357762822590714399458303903535888835232670878457161432636363996257309241302481691723537010408733419813385804491106555801784494262060916206872597091033287849274902594962928694944169726768114734355431735427072010p 0.9
+ \]
V_wl_bar_818 (WordLine_bar\\<818\\> gnd!) vsource type=pwl wave=\[
+ 0    0.9
+ 1747979975492856518824388667826833403974715525645181428798916607807071777670465341756914322865272727992514618482604963383447074020817466839626771608982213111603568988524121832413745194182066575698549805189925857389888339453536229468710863470854143500p 0.9
+ 1747979975492856518824388667826833403974715525645181428798916607807071777670465341756914322865272727992514618482604963383447074020817466839626771608982213111603568988524121832413745194182066575698549805189925857389888339453536229468710863470854143510p -0.3
+ 1747979975492856518824388667826833403974715525645181428798916607807071777670465341756914322865272727992514618482604963383447074020817466839626771608982213111603568988524121832413745194182066575698549805189925857389888339453536229468710863470854144000p -0.3
+ 1747979975492856518824388667826833403974715525645181428798916607807071777670465341756914322865272727992514618482604963383447074020817466839626771608982213111603568988524121832413745194182066575698549805189925857389888339453536229468710863470854144010p 0.9
+ \]
V_wl_bar_819 (WordLine_bar\\<819\\> gnd!) vsource type=pwl wave=\[
+ 0    0.9
+ 3495959950985713037648777335653666807949431051290362857597833215614143555340930683513828645730545455985029236965209926766894148041634933679253543217964426223207137977048243664827490388364133151397099610379851714779776678907072458937421726941708287500p 0.9
+ 3495959950985713037648777335653666807949431051290362857597833215614143555340930683513828645730545455985029236965209926766894148041634933679253543217964426223207137977048243664827490388364133151397099610379851714779776678907072458937421726941708287510p -0.3
+ 3495959950985713037648777335653666807949431051290362857597833215614143555340930683513828645730545455985029236965209926766894148041634933679253543217964426223207137977048243664827490388364133151397099610379851714779776678907072458937421726941708288000p -0.3
+ 3495959950985713037648777335653666807949431051290362857597833215614143555340930683513828645730545455985029236965209926766894148041634933679253543217964426223207137977048243664827490388364133151397099610379851714779776678907072458937421726941708288010p 0.9
+ \]
V_wl_bar_820 (WordLine_bar\\<820\\> gnd!) vsource type=pwl wave=\[
+ 0    0.9
+ 6991919901971426075297554671307333615898862102580725715195666431228287110681861367027657291461090911970058473930419853533788296083269867358507086435928852446414275954096487329654980776728266302794199220759703429559553357814144917874843453883416575500p 0.9
+ 6991919901971426075297554671307333615898862102580725715195666431228287110681861367027657291461090911970058473930419853533788296083269867358507086435928852446414275954096487329654980776728266302794199220759703429559553357814144917874843453883416575510p -0.3
+ 6991919901971426075297554671307333615898862102580725715195666431228287110681861367027657291461090911970058473930419853533788296083269867358507086435928852446414275954096487329654980776728266302794199220759703429559553357814144917874843453883416576000p -0.3
+ 6991919901971426075297554671307333615898862102580725715195666431228287110681861367027657291461090911970058473930419853533788296083269867358507086435928852446414275954096487329654980776728266302794199220759703429559553357814144917874843453883416576010p 0.9
+ \]
V_wl_bar_821 (WordLine_bar\\<821\\> gnd!) vsource type=pwl wave=\[
+ 0    0.9
+ 13983839803942852150595109342614667231797724205161451430391332862456574221363722734055314582922181823940116947860839707067576592166539734717014172871857704892828551908192974659309961553456532605588398441519406859119106715628289835749686907766833151500p 0.9
+ 13983839803942852150595109342614667231797724205161451430391332862456574221363722734055314582922181823940116947860839707067576592166539734717014172871857704892828551908192974659309961553456532605588398441519406859119106715628289835749686907766833151510p -0.3
+ 13983839803942852150595109342614667231797724205161451430391332862456574221363722734055314582922181823940116947860839707067576592166539734717014172871857704892828551908192974659309961553456532605588398441519406859119106715628289835749686907766833152000p -0.3
+ 13983839803942852150595109342614667231797724205161451430391332862456574221363722734055314582922181823940116947860839707067576592166539734717014172871857704892828551908192974659309961553456532605588398441519406859119106715628289835749686907766833152010p 0.9
+ \]
V_wl_bar_822 (WordLine_bar\\<822\\> gnd!) vsource type=pwl wave=\[
+ 0    0.9
+ 27967679607885704301190218685229334463595448410322902860782665724913148442727445468110629165844363647880233895721679414135153184333079469434028345743715409785657103816385949318619923106913065211176796883038813718238213431256579671499373815533666303500p 0.9
+ 27967679607885704301190218685229334463595448410322902860782665724913148442727445468110629165844363647880233895721679414135153184333079469434028345743715409785657103816385949318619923106913065211176796883038813718238213431256579671499373815533666303510p -0.3
+ 27967679607885704301190218685229334463595448410322902860782665724913148442727445468110629165844363647880233895721679414135153184333079469434028345743715409785657103816385949318619923106913065211176796883038813718238213431256579671499373815533666304000p -0.3
+ 27967679607885704301190218685229334463595448410322902860782665724913148442727445468110629165844363647880233895721679414135153184333079469434028345743715409785657103816385949318619923106913065211176796883038813718238213431256579671499373815533666304010p 0.9
+ \]
V_wl_bar_823 (WordLine_bar\\<823\\> gnd!) vsource type=pwl wave=\[
+ 0    0.9
+ 55935359215771408602380437370458668927190896820645805721565331449826296885454890936221258331688727295760467791443358828270306368666158938868056691487430819571314207632771898637239846213826130422353593766077627436476426862513159342998747631067332607500p 0.9
+ 55935359215771408602380437370458668927190896820645805721565331449826296885454890936221258331688727295760467791443358828270306368666158938868056691487430819571314207632771898637239846213826130422353593766077627436476426862513159342998747631067332607510p -0.3
+ 55935359215771408602380437370458668927190896820645805721565331449826296885454890936221258331688727295760467791443358828270306368666158938868056691487430819571314207632771898637239846213826130422353593766077627436476426862513159342998747631067332608000p -0.3
+ 55935359215771408602380437370458668927190896820645805721565331449826296885454890936221258331688727295760467791443358828270306368666158938868056691487430819571314207632771898637239846213826130422353593766077627436476426862513159342998747631067332608010p 0.9
+ \]
V_wl_bar_824 (WordLine_bar\\<824\\> gnd!) vsource type=pwl wave=\[
+ 0    0.9
+ 111870718431542817204760874740917337854381793641291611443130662899652593770909781872442516663377454591520935582886717656540612737332317877736113382974861639142628415265543797274479692427652260844707187532155254872952853725026318685997495262134665215500p 0.9
+ 111870718431542817204760874740917337854381793641291611443130662899652593770909781872442516663377454591520935582886717656540612737332317877736113382974861639142628415265543797274479692427652260844707187532155254872952853725026318685997495262134665215510p -0.3
+ 111870718431542817204760874740917337854381793641291611443130662899652593770909781872442516663377454591520935582886717656540612737332317877736113382974861639142628415265543797274479692427652260844707187532155254872952853725026318685997495262134665216000p -0.3
+ 111870718431542817204760874740917337854381793641291611443130662899652593770909781872442516663377454591520935582886717656540612737332317877736113382974861639142628415265543797274479692427652260844707187532155254872952853725026318685997495262134665216010p 0.9
+ \]
V_wl_bar_825 (WordLine_bar\\<825\\> gnd!) vsource type=pwl wave=\[
+ 0    0.9
+ 223741436863085634409521749481834675708763587282583222886261325799305187541819563744885033326754909183041871165773435313081225474664635755472226765949723278285256830531087594548959384855304521689414375064310509745905707450052637371994990524269330431500p 0.9
+ 223741436863085634409521749481834675708763587282583222886261325799305187541819563744885033326754909183041871165773435313081225474664635755472226765949723278285256830531087594548959384855304521689414375064310509745905707450052637371994990524269330431510p -0.3
+ 223741436863085634409521749481834675708763587282583222886261325799305187541819563744885033326754909183041871165773435313081225474664635755472226765949723278285256830531087594548959384855304521689414375064310509745905707450052637371994990524269330432000p -0.3
+ 223741436863085634409521749481834675708763587282583222886261325799305187541819563744885033326754909183041871165773435313081225474664635755472226765949723278285256830531087594548959384855304521689414375064310509745905707450052637371994990524269330432010p 0.9
+ \]
V_wl_bar_826 (WordLine_bar\\<826\\> gnd!) vsource type=pwl wave=\[
+ 0    0.9
+ 447482873726171268819043498963669351417527174565166445772522651598610375083639127489770066653509818366083742331546870626162450949329271510944453531899446556570513661062175189097918769710609043378828750128621019491811414900105274743989981048538660863500p 0.9
+ 447482873726171268819043498963669351417527174565166445772522651598610375083639127489770066653509818366083742331546870626162450949329271510944453531899446556570513661062175189097918769710609043378828750128621019491811414900105274743989981048538660863510p -0.3
+ 447482873726171268819043498963669351417527174565166445772522651598610375083639127489770066653509818366083742331546870626162450949329271510944453531899446556570513661062175189097918769710609043378828750128621019491811414900105274743989981048538660864000p -0.3
+ 447482873726171268819043498963669351417527174565166445772522651598610375083639127489770066653509818366083742331546870626162450949329271510944453531899446556570513661062175189097918769710609043378828750128621019491811414900105274743989981048538660864010p 0.9
+ \]
V_wl_bar_827 (WordLine_bar\\<827\\> gnd!) vsource type=pwl wave=\[
+ 0    0.9
+ 894965747452342537638086997927338702835054349130332891545045303197220750167278254979540133307019636732167484663093741252324901898658543021888907063798893113141027322124350378195837539421218086757657500257242038983622829800210549487979962097077321727500p 0.9
+ 894965747452342537638086997927338702835054349130332891545045303197220750167278254979540133307019636732167484663093741252324901898658543021888907063798893113141027322124350378195837539421218086757657500257242038983622829800210549487979962097077321727510p -0.3
+ 894965747452342537638086997927338702835054349130332891545045303197220750167278254979540133307019636732167484663093741252324901898658543021888907063798893113141027322124350378195837539421218086757657500257242038983622829800210549487979962097077321728000p -0.3
+ 894965747452342537638086997927338702835054349130332891545045303197220750167278254979540133307019636732167484663093741252324901898658543021888907063798893113141027322124350378195837539421218086757657500257242038983622829800210549487979962097077321728010p 0.9
+ \]
V_wl_bar_828 (WordLine_bar\\<828\\> gnd!) vsource type=pwl wave=\[
+ 0    0.9
+ 1789931494904685075276173995854677405670108698260665783090090606394441500334556509959080266614039273464334969326187482504649803797317086043777814127597786226282054644248700756391675078842436173515315000514484077967245659600421098975959924194154643455500p 0.9
+ 1789931494904685075276173995854677405670108698260665783090090606394441500334556509959080266614039273464334969326187482504649803797317086043777814127597786226282054644248700756391675078842436173515315000514484077967245659600421098975959924194154643455510p -0.3
+ 1789931494904685075276173995854677405670108698260665783090090606394441500334556509959080266614039273464334969326187482504649803797317086043777814127597786226282054644248700756391675078842436173515315000514484077967245659600421098975959924194154643456000p -0.3
+ 1789931494904685075276173995854677405670108698260665783090090606394441500334556509959080266614039273464334969326187482504649803797317086043777814127597786226282054644248700756391675078842436173515315000514484077967245659600421098975959924194154643456010p 0.9
+ \]
V_wl_bar_829 (WordLine_bar\\<829\\> gnd!) vsource type=pwl wave=\[
+ 0    0.9
+ 3579862989809370150552347991709354811340217396521331566180181212788883000669113019918160533228078546928669938652374965009299607594634172087555628255195572452564109288497401512783350157684872347030630001028968155934491319200842197951919848388309286911500p 0.9
+ 3579862989809370150552347991709354811340217396521331566180181212788883000669113019918160533228078546928669938652374965009299607594634172087555628255195572452564109288497401512783350157684872347030630001028968155934491319200842197951919848388309286911510p -0.3
+ 3579862989809370150552347991709354811340217396521331566180181212788883000669113019918160533228078546928669938652374965009299607594634172087555628255195572452564109288497401512783350157684872347030630001028968155934491319200842197951919848388309286912000p -0.3
+ 3579862989809370150552347991709354811340217396521331566180181212788883000669113019918160533228078546928669938652374965009299607594634172087555628255195572452564109288497401512783350157684872347030630001028968155934491319200842197951919848388309286912010p 0.9
+ \]
V_wl_bar_830 (WordLine_bar\\<830\\> gnd!) vsource type=pwl wave=\[
+ 0    0.9
+ 7159725979618740301104695983418709622680434793042663132360362425577766001338226039836321066456157093857339877304749930018599215189268344175111256510391144905128218576994803025566700315369744694061260002057936311868982638401684395903839696776618573823500p 0.9
+ 7159725979618740301104695983418709622680434793042663132360362425577766001338226039836321066456157093857339877304749930018599215189268344175111256510391144905128218576994803025566700315369744694061260002057936311868982638401684395903839696776618573823510p -0.3
+ 7159725979618740301104695983418709622680434793042663132360362425577766001338226039836321066456157093857339877304749930018599215189268344175111256510391144905128218576994803025566700315369744694061260002057936311868982638401684395903839696776618573824000p -0.3
+ 7159725979618740301104695983418709622680434793042663132360362425577766001338226039836321066456157093857339877304749930018599215189268344175111256510391144905128218576994803025566700315369744694061260002057936311868982638401684395903839696776618573824010p 0.9
+ \]
V_wl_bar_831 (WordLine_bar\\<831\\> gnd!) vsource type=pwl wave=\[
+ 0    0.9
+ 14319451959237480602209391966837419245360869586085326264720724851155532002676452079672642132912314187714679754609499860037198430378536688350222513020782289810256437153989606051133400630739489388122520004115872623737965276803368791807679393553237147647500p 0.9
+ 14319451959237480602209391966837419245360869586085326264720724851155532002676452079672642132912314187714679754609499860037198430378536688350222513020782289810256437153989606051133400630739489388122520004115872623737965276803368791807679393553237147647510p -0.3
+ 14319451959237480602209391966837419245360869586085326264720724851155532002676452079672642132912314187714679754609499860037198430378536688350222513020782289810256437153989606051133400630739489388122520004115872623737965276803368791807679393553237147648000p -0.3
+ 14319451959237480602209391966837419245360869586085326264720724851155532002676452079672642132912314187714679754609499860037198430378536688350222513020782289810256437153989606051133400630739489388122520004115872623737965276803368791807679393553237147648010p 0.9
+ \]
V_wl_bar_832 (WordLine_bar\\<832\\> gnd!) vsource type=pwl wave=\[
+ 0    0.9
+ 28638903918474961204418783933674838490721739172170652529441449702311064005352904159345284265824628375429359509218999720074396860757073376700445026041564579620512874307979212102266801261478978776245040008231745247475930553606737583615358787106474295295500p 0.9
+ 28638903918474961204418783933674838490721739172170652529441449702311064005352904159345284265824628375429359509218999720074396860757073376700445026041564579620512874307979212102266801261478978776245040008231745247475930553606737583615358787106474295295510p -0.3
+ 28638903918474961204418783933674838490721739172170652529441449702311064005352904159345284265824628375429359509218999720074396860757073376700445026041564579620512874307979212102266801261478978776245040008231745247475930553606737583615358787106474295296000p -0.3
+ 28638903918474961204418783933674838490721739172170652529441449702311064005352904159345284265824628375429359509218999720074396860757073376700445026041564579620512874307979212102266801261478978776245040008231745247475930553606737583615358787106474295296010p 0.9
+ \]
V_wl_bar_833 (WordLine_bar\\<833\\> gnd!) vsource type=pwl wave=\[
+ 0    0.9
+ 57277807836949922408837567867349676981443478344341305058882899404622128010705808318690568531649256750858719018437999440148793721514146753400890052083129159241025748615958424204533602522957957552490080016463490494951861107213475167230717574212948590591500p 0.9
+ 57277807836949922408837567867349676981443478344341305058882899404622128010705808318690568531649256750858719018437999440148793721514146753400890052083129159241025748615958424204533602522957957552490080016463490494951861107213475167230717574212948590591510p -0.3
+ 57277807836949922408837567867349676981443478344341305058882899404622128010705808318690568531649256750858719018437999440148793721514146753400890052083129159241025748615958424204533602522957957552490080016463490494951861107213475167230717574212948590592000p -0.3
+ 57277807836949922408837567867349676981443478344341305058882899404622128010705808318690568531649256750858719018437999440148793721514146753400890052083129159241025748615958424204533602522957957552490080016463490494951861107213475167230717574212948590592010p 0.9
+ \]
V_wl_bar_834 (WordLine_bar\\<834\\> gnd!) vsource type=pwl wave=\[
+ 0    0.9
+ 114555615673899844817675135734699353962886956688682610117765798809244256021411616637381137063298513501717438036875998880297587443028293506801780104166258318482051497231916848409067205045915915104980160032926980989903722214426950334461435148425897181183500p 0.9
+ 114555615673899844817675135734699353962886956688682610117765798809244256021411616637381137063298513501717438036875998880297587443028293506801780104166258318482051497231916848409067205045915915104980160032926980989903722214426950334461435148425897181183510p -0.3
+ 114555615673899844817675135734699353962886956688682610117765798809244256021411616637381137063298513501717438036875998880297587443028293506801780104166258318482051497231916848409067205045915915104980160032926980989903722214426950334461435148425897181184000p -0.3
+ 114555615673899844817675135734699353962886956688682610117765798809244256021411616637381137063298513501717438036875998880297587443028293506801780104166258318482051497231916848409067205045915915104980160032926980989903722214426950334461435148425897181184010p 0.9
+ \]
V_wl_bar_835 (WordLine_bar\\<835\\> gnd!) vsource type=pwl wave=\[
+ 0    0.9
+ 229111231347799689635350271469398707925773913377365220235531597618488512042823233274762274126597027003434876073751997760595174886056587013603560208332516636964102994463833696818134410091831830209960320065853961979807444428853900668922870296851794362367500p 0.9
+ 229111231347799689635350271469398707925773913377365220235531597618488512042823233274762274126597027003434876073751997760595174886056587013603560208332516636964102994463833696818134410091831830209960320065853961979807444428853900668922870296851794362367510p -0.3
+ 229111231347799689635350271469398707925773913377365220235531597618488512042823233274762274126597027003434876073751997760595174886056587013603560208332516636964102994463833696818134410091831830209960320065853961979807444428853900668922870296851794362368000p -0.3
+ 229111231347799689635350271469398707925773913377365220235531597618488512042823233274762274126597027003434876073751997760595174886056587013603560208332516636964102994463833696818134410091831830209960320065853961979807444428853900668922870296851794362368010p 0.9
+ \]
V_wl_bar_836 (WordLine_bar\\<836\\> gnd!) vsource type=pwl wave=\[
+ 0    0.9
+ 458222462695599379270700542938797415851547826754730440471063195236977024085646466549524548253194054006869752147503995521190349772113174027207120416665033273928205988927667393636268820183663660419920640131707923959614888857707801337845740593703588724735500p 0.9
+ 458222462695599379270700542938797415851547826754730440471063195236977024085646466549524548253194054006869752147503995521190349772113174027207120416665033273928205988927667393636268820183663660419920640131707923959614888857707801337845740593703588724735510p -0.3
+ 458222462695599379270700542938797415851547826754730440471063195236977024085646466549524548253194054006869752147503995521190349772113174027207120416665033273928205988927667393636268820183663660419920640131707923959614888857707801337845740593703588724736000p -0.3
+ 458222462695599379270700542938797415851547826754730440471063195236977024085646466549524548253194054006869752147503995521190349772113174027207120416665033273928205988927667393636268820183663660419920640131707923959614888857707801337845740593703588724736010p 0.9
+ \]
V_wl_bar_837 (WordLine_bar\\<837\\> gnd!) vsource type=pwl wave=\[
+ 0    0.9
+ 916444925391198758541401085877594831703095653509460880942126390473954048171292933099049096506388108013739504295007991042380699544226348054414240833330066547856411977855334787272537640367327320839841280263415847919229777715415602675691481187407177449471500p 0.9
+ 916444925391198758541401085877594831703095653509460880942126390473954048171292933099049096506388108013739504295007991042380699544226348054414240833330066547856411977855334787272537640367327320839841280263415847919229777715415602675691481187407177449471510p -0.3
+ 916444925391198758541401085877594831703095653509460880942126390473954048171292933099049096506388108013739504295007991042380699544226348054414240833330066547856411977855334787272537640367327320839841280263415847919229777715415602675691481187407177449472000p -0.3
+ 916444925391198758541401085877594831703095653509460880942126390473954048171292933099049096506388108013739504295007991042380699544226348054414240833330066547856411977855334787272537640367327320839841280263415847919229777715415602675691481187407177449472010p 0.9
+ \]
V_wl_bar_838 (WordLine_bar\\<838\\> gnd!) vsource type=pwl wave=\[
+ 0    0.9
+ 1832889850782397517082802171755189663406191307018921761884252780947908096342585866198098193012776216027479008590015982084761399088452696108828481666660133095712823955710669574545075280734654641679682560526831695838459555430831205351382962374814354898943500p 0.9
+ 1832889850782397517082802171755189663406191307018921761884252780947908096342585866198098193012776216027479008590015982084761399088452696108828481666660133095712823955710669574545075280734654641679682560526831695838459555430831205351382962374814354898943510p -0.3
+ 1832889850782397517082802171755189663406191307018921761884252780947908096342585866198098193012776216027479008590015982084761399088452696108828481666660133095712823955710669574545075280734654641679682560526831695838459555430831205351382962374814354898944000p -0.3
+ 1832889850782397517082802171755189663406191307018921761884252780947908096342585866198098193012776216027479008590015982084761399088452696108828481666660133095712823955710669574545075280734654641679682560526831695838459555430831205351382962374814354898944010p 0.9
+ \]
V_wl_bar_839 (WordLine_bar\\<839\\> gnd!) vsource type=pwl wave=\[
+ 0    0.9
+ 3665779701564795034165604343510379326812382614037843523768505561895816192685171732396196386025552432054958017180031964169522798176905392217656963333320266191425647911421339149090150561469309283359365121053663391676919110861662410702765924749628709797887500p 0.9
+ 3665779701564795034165604343510379326812382614037843523768505561895816192685171732396196386025552432054958017180031964169522798176905392217656963333320266191425647911421339149090150561469309283359365121053663391676919110861662410702765924749628709797887510p -0.3
+ 3665779701564795034165604343510379326812382614037843523768505561895816192685171732396196386025552432054958017180031964169522798176905392217656963333320266191425647911421339149090150561469309283359365121053663391676919110861662410702765924749628709797888000p -0.3
+ 3665779701564795034165604343510379326812382614037843523768505561895816192685171732396196386025552432054958017180031964169522798176905392217656963333320266191425647911421339149090150561469309283359365121053663391676919110861662410702765924749628709797888010p 0.9
+ \]
V_wl_bar_840 (WordLine_bar\\<840\\> gnd!) vsource type=pwl wave=\[
+ 0    0.9
+ 7331559403129590068331208687020758653624765228075687047537011123791632385370343464792392772051104864109916034360063928339045596353810784435313926666640532382851295822842678298180301122938618566718730242107326783353838221723324821405531849499257419595775500p 0.9
+ 7331559403129590068331208687020758653624765228075687047537011123791632385370343464792392772051104864109916034360063928339045596353810784435313926666640532382851295822842678298180301122938618566718730242107326783353838221723324821405531849499257419595775510p -0.3
+ 7331559403129590068331208687020758653624765228075687047537011123791632385370343464792392772051104864109916034360063928339045596353810784435313926666640532382851295822842678298180301122938618566718730242107326783353838221723324821405531849499257419595776000p -0.3
+ 7331559403129590068331208687020758653624765228075687047537011123791632385370343464792392772051104864109916034360063928339045596353810784435313926666640532382851295822842678298180301122938618566718730242107326783353838221723324821405531849499257419595776010p 0.9
+ \]
V_wl_bar_841 (WordLine_bar\\<841\\> gnd!) vsource type=pwl wave=\[
+ 0    0.9
+ 14663118806259180136662417374041517307249530456151374095074022247583264770740686929584785544102209728219832068720127856678091192707621568870627853333281064765702591645685356596360602245877237133437460484214653566707676443446649642811063698998514839191551500p 0.9
+ 14663118806259180136662417374041517307249530456151374095074022247583264770740686929584785544102209728219832068720127856678091192707621568870627853333281064765702591645685356596360602245877237133437460484214653566707676443446649642811063698998514839191551510p -0.3
+ 14663118806259180136662417374041517307249530456151374095074022247583264770740686929584785544102209728219832068720127856678091192707621568870627853333281064765702591645685356596360602245877237133437460484214653566707676443446649642811063698998514839191552000p -0.3
+ 14663118806259180136662417374041517307249530456151374095074022247583264770740686929584785544102209728219832068720127856678091192707621568870627853333281064765702591645685356596360602245877237133437460484214653566707676443446649642811063698998514839191552010p 0.9
+ \]
V_wl_bar_842 (WordLine_bar\\<842\\> gnd!) vsource type=pwl wave=\[
+ 0    0.9
+ 29326237612518360273324834748083034614499060912302748190148044495166529541481373859169571088204419456439664137440255713356182385415243137741255706666562129531405183291370713192721204491754474266874920968429307133415352886893299285622127397997029678383103500p 0.9
+ 29326237612518360273324834748083034614499060912302748190148044495166529541481373859169571088204419456439664137440255713356182385415243137741255706666562129531405183291370713192721204491754474266874920968429307133415352886893299285622127397997029678383103510p -0.3
+ 29326237612518360273324834748083034614499060912302748190148044495166529541481373859169571088204419456439664137440255713356182385415243137741255706666562129531405183291370713192721204491754474266874920968429307133415352886893299285622127397997029678383104000p -0.3
+ 29326237612518360273324834748083034614499060912302748190148044495166529541481373859169571088204419456439664137440255713356182385415243137741255706666562129531405183291370713192721204491754474266874920968429307133415352886893299285622127397997029678383104010p 0.9
+ \]
V_wl_bar_843 (WordLine_bar\\<843\\> gnd!) vsource type=pwl wave=\[
+ 0    0.9
+ 58652475225036720546649669496166069228998121824605496380296088990333059082962747718339142176408838912879328274880511426712364770830486275482511413333124259062810366582741426385442408983508948533749841936858614266830705773786598571244254795994059356766207500p 0.9
+ 58652475225036720546649669496166069228998121824605496380296088990333059082962747718339142176408838912879328274880511426712364770830486275482511413333124259062810366582741426385442408983508948533749841936858614266830705773786598571244254795994059356766207510p -0.3
+ 58652475225036720546649669496166069228998121824605496380296088990333059082962747718339142176408838912879328274880511426712364770830486275482511413333124259062810366582741426385442408983508948533749841936858614266830705773786598571244254795994059356766208000p -0.3
+ 58652475225036720546649669496166069228998121824605496380296088990333059082962747718339142176408838912879328274880511426712364770830486275482511413333124259062810366582741426385442408983508948533749841936858614266830705773786598571244254795994059356766208010p 0.9
+ \]
V_wl_bar_844 (WordLine_bar\\<844\\> gnd!) vsource type=pwl wave=\[
+ 0    0.9
+ 117304950450073441093299338992332138457996243649210992760592177980666118165925495436678284352817677825758656549761022853424729541660972550965022826666248518125620733165482852770884817967017897067499683873717228533661411547573197142488509591988118713532415500p 0.9
+ 117304950450073441093299338992332138457996243649210992760592177980666118165925495436678284352817677825758656549761022853424729541660972550965022826666248518125620733165482852770884817967017897067499683873717228533661411547573197142488509591988118713532415510p -0.3
+ 117304950450073441093299338992332138457996243649210992760592177980666118165925495436678284352817677825758656549761022853424729541660972550965022826666248518125620733165482852770884817967017897067499683873717228533661411547573197142488509591988118713532416000p -0.3
+ 117304950450073441093299338992332138457996243649210992760592177980666118165925495436678284352817677825758656549761022853424729541660972550965022826666248518125620733165482852770884817967017897067499683873717228533661411547573197142488509591988118713532416010p 0.9
+ \]
V_wl_bar_845 (WordLine_bar\\<845\\> gnd!) vsource type=pwl wave=\[
+ 0    0.9
+ 234609900900146882186598677984664276915992487298421985521184355961332236331850990873356568705635355651517313099522045706849459083321945101930045653332497036251241466330965705541769635934035794134999367747434457067322823095146394284977019183976237427064831500p 0.9
+ 234609900900146882186598677984664276915992487298421985521184355961332236331850990873356568705635355651517313099522045706849459083321945101930045653332497036251241466330965705541769635934035794134999367747434457067322823095146394284977019183976237427064831510p -0.3
+ 234609900900146882186598677984664276915992487298421985521184355961332236331850990873356568705635355651517313099522045706849459083321945101930045653332497036251241466330965705541769635934035794134999367747434457067322823095146394284977019183976237427064832000p -0.3
+ 234609900900146882186598677984664276915992487298421985521184355961332236331850990873356568705635355651517313099522045706849459083321945101930045653332497036251241466330965705541769635934035794134999367747434457067322823095146394284977019183976237427064832010p 0.9
+ \]
V_wl_bar_846 (WordLine_bar\\<846\\> gnd!) vsource type=pwl wave=\[
+ 0    0.9
+ 469219801800293764373197355969328553831984974596843971042368711922664472663701981746713137411270711303034626199044091413698918166643890203860091306664994072502482932661931411083539271868071588269998735494868914134645646190292788569954038367952474854129663500p 0.9
+ 469219801800293764373197355969328553831984974596843971042368711922664472663701981746713137411270711303034626199044091413698918166643890203860091306664994072502482932661931411083539271868071588269998735494868914134645646190292788569954038367952474854129663510p -0.3
+ 469219801800293764373197355969328553831984974596843971042368711922664472663701981746713137411270711303034626199044091413698918166643890203860091306664994072502482932661931411083539271868071588269998735494868914134645646190292788569954038367952474854129664000p -0.3
+ 469219801800293764373197355969328553831984974596843971042368711922664472663701981746713137411270711303034626199044091413698918166643890203860091306664994072502482932661931411083539271868071588269998735494868914134645646190292788569954038367952474854129664010p 0.9
+ \]
V_wl_bar_847 (WordLine_bar\\<847\\> gnd!) vsource type=pwl wave=\[
+ 0    0.9
+ 938439603600587528746394711938657107663969949193687942084737423845328945327403963493426274822541422606069252398088182827397836333287780407720182613329988145004965865323862822167078543736143176539997470989737828269291292380585577139908076735904949708259327500p 0.9
+ 938439603600587528746394711938657107663969949193687942084737423845328945327403963493426274822541422606069252398088182827397836333287780407720182613329988145004965865323862822167078543736143176539997470989737828269291292380585577139908076735904949708259327510p -0.3
+ 938439603600587528746394711938657107663969949193687942084737423845328945327403963493426274822541422606069252398088182827397836333287780407720182613329988145004965865323862822167078543736143176539997470989737828269291292380585577139908076735904949708259328000p -0.3
+ 938439603600587528746394711938657107663969949193687942084737423845328945327403963493426274822541422606069252398088182827397836333287780407720182613329988145004965865323862822167078543736143176539997470989737828269291292380585577139908076735904949708259328010p 0.9
+ \]
V_wl_bar_848 (WordLine_bar\\<848\\> gnd!) vsource type=pwl wave=\[
+ 0    0.9
+ 1876879207201175057492789423877314215327939898387375884169474847690657890654807926986852549645082845212138504796176365654795672666575560815440365226659976290009931730647725644334157087472286353079994941979475656538582584761171154279816153471809899416518655500p 0.9
+ 1876879207201175057492789423877314215327939898387375884169474847690657890654807926986852549645082845212138504796176365654795672666575560815440365226659976290009931730647725644334157087472286353079994941979475656538582584761171154279816153471809899416518655510p -0.3
+ 1876879207201175057492789423877314215327939898387375884169474847690657890654807926986852549645082845212138504796176365654795672666575560815440365226659976290009931730647725644334157087472286353079994941979475656538582584761171154279816153471809899416518656000p -0.3
+ 1876879207201175057492789423877314215327939898387375884169474847690657890654807926986852549645082845212138504796176365654795672666575560815440365226659976290009931730647725644334157087472286353079994941979475656538582584761171154279816153471809899416518656010p 0.9
+ \]
V_wl_bar_849 (WordLine_bar\\<849\\> gnd!) vsource type=pwl wave=\[
+ 0    0.9
+ 3753758414402350114985578847754628430655879796774751768338949695381315781309615853973705099290165690424277009592352731309591345333151121630880730453319952580019863461295451288668314174944572706159989883958951313077165169522342308559632306943619798833037311500p 0.9
+ 3753758414402350114985578847754628430655879796774751768338949695381315781309615853973705099290165690424277009592352731309591345333151121630880730453319952580019863461295451288668314174944572706159989883958951313077165169522342308559632306943619798833037311510p -0.3
+ 3753758414402350114985578847754628430655879796774751768338949695381315781309615853973705099290165690424277009592352731309591345333151121630880730453319952580019863461295451288668314174944572706159989883958951313077165169522342308559632306943619798833037312000p -0.3
+ 3753758414402350114985578847754628430655879796774751768338949695381315781309615853973705099290165690424277009592352731309591345333151121630880730453319952580019863461295451288668314174944572706159989883958951313077165169522342308559632306943619798833037312010p 0.9
+ \]
V_wl_bar_850 (WordLine_bar\\<850\\> gnd!) vsource type=pwl wave=\[
+ 0    0.9
+ 7507516828804700229971157695509256861311759593549503536677899390762631562619231707947410198580331380848554019184705462619182690666302243261761460906639905160039726922590902577336628349889145412319979767917902626154330339044684617119264613887239597666074623500p 0.9
+ 7507516828804700229971157695509256861311759593549503536677899390762631562619231707947410198580331380848554019184705462619182690666302243261761460906639905160039726922590902577336628349889145412319979767917902626154330339044684617119264613887239597666074623510p -0.3
+ 7507516828804700229971157695509256861311759593549503536677899390762631562619231707947410198580331380848554019184705462619182690666302243261761460906639905160039726922590902577336628349889145412319979767917902626154330339044684617119264613887239597666074624000p -0.3
+ 7507516828804700229971157695509256861311759593549503536677899390762631562619231707947410198580331380848554019184705462619182690666302243261761460906639905160039726922590902577336628349889145412319979767917902626154330339044684617119264613887239597666074624010p 0.9
+ \]
V_wl_bar_851 (WordLine_bar\\<851\\> gnd!) vsource type=pwl wave=\[
+ 0    0.9
+ 15015033657609400459942315391018513722623519187099007073355798781525263125238463415894820397160662761697108038369410925238365381332604486523522921813279810320079453845181805154673256699778290824639959535835805252308660678089369234238529227774479195332149247500p 0.9
+ 15015033657609400459942315391018513722623519187099007073355798781525263125238463415894820397160662761697108038369410925238365381332604486523522921813279810320079453845181805154673256699778290824639959535835805252308660678089369234238529227774479195332149247510p -0.3
+ 15015033657609400459942315391018513722623519187099007073355798781525263125238463415894820397160662761697108038369410925238365381332604486523522921813279810320079453845181805154673256699778290824639959535835805252308660678089369234238529227774479195332149248000p -0.3
+ 15015033657609400459942315391018513722623519187099007073355798781525263125238463415894820397160662761697108038369410925238365381332604486523522921813279810320079453845181805154673256699778290824639959535835805252308660678089369234238529227774479195332149248010p 0.9
+ \]
V_wl_bar_852 (WordLine_bar\\<852\\> gnd!) vsource type=pwl wave=\[
+ 0    0.9
+ 30030067315218800919884630782037027445247038374198014146711597563050526250476926831789640794321325523394216076738821850476730762665208973047045843626559620640158907690363610309346513399556581649279919071671610504617321356178738468477058455548958390664298495500p 0.9
+ 30030067315218800919884630782037027445247038374198014146711597563050526250476926831789640794321325523394216076738821850476730762665208973047045843626559620640158907690363610309346513399556581649279919071671610504617321356178738468477058455548958390664298495510p -0.3
+ 30030067315218800919884630782037027445247038374198014146711597563050526250476926831789640794321325523394216076738821850476730762665208973047045843626559620640158907690363610309346513399556581649279919071671610504617321356178738468477058455548958390664298496000p -0.3
+ 30030067315218800919884630782037027445247038374198014146711597563050526250476926831789640794321325523394216076738821850476730762665208973047045843626559620640158907690363610309346513399556581649279919071671610504617321356178738468477058455548958390664298496010p 0.9
+ \]
V_wl_bar_853 (WordLine_bar\\<853\\> gnd!) vsource type=pwl wave=\[
+ 0    0.9
+ 60060134630437601839769261564074054890494076748396028293423195126101052500953853663579281588642651046788432153477643700953461525330417946094091687253119241280317815380727220618693026799113163298559838143343221009234642712357476936954116911097916781328596991500p 0.9
+ 60060134630437601839769261564074054890494076748396028293423195126101052500953853663579281588642651046788432153477643700953461525330417946094091687253119241280317815380727220618693026799113163298559838143343221009234642712357476936954116911097916781328596991510p -0.3
+ 60060134630437601839769261564074054890494076748396028293423195126101052500953853663579281588642651046788432153477643700953461525330417946094091687253119241280317815380727220618693026799113163298559838143343221009234642712357476936954116911097916781328596992000p -0.3
+ 60060134630437601839769261564074054890494076748396028293423195126101052500953853663579281588642651046788432153477643700953461525330417946094091687253119241280317815380727220618693026799113163298559838143343221009234642712357476936954116911097916781328596992010p 0.9
+ \]
V_wl_bar_854 (WordLine_bar\\<854\\> gnd!) vsource type=pwl wave=\[
+ 0    0.9
+ 120120269260875203679538523128148109780988153496792056586846390252202105001907707327158563177285302093576864306955287401906923050660835892188183374506238482560635630761454441237386053598226326597119676286686442018469285424714953873908233822195833562657193983500p 0.9
+ 120120269260875203679538523128148109780988153496792056586846390252202105001907707327158563177285302093576864306955287401906923050660835892188183374506238482560635630761454441237386053598226326597119676286686442018469285424714953873908233822195833562657193983510p -0.3
+ 120120269260875203679538523128148109780988153496792056586846390252202105001907707327158563177285302093576864306955287401906923050660835892188183374506238482560635630761454441237386053598226326597119676286686442018469285424714953873908233822195833562657193984000p -0.3
+ 120120269260875203679538523128148109780988153496792056586846390252202105001907707327158563177285302093576864306955287401906923050660835892188183374506238482560635630761454441237386053598226326597119676286686442018469285424714953873908233822195833562657193984010p 0.9
+ \]
V_wl_bar_855 (WordLine_bar\\<855\\> gnd!) vsource type=pwl wave=\[
+ 0    0.9
+ 240240538521750407359077046256296219561976306993584113173692780504404210003815414654317126354570604187153728613910574803813846101321671784376366749012476965121271261522908882474772107196452653194239352573372884036938570849429907747816467644391667125314387967500p 0.9
+ 240240538521750407359077046256296219561976306993584113173692780504404210003815414654317126354570604187153728613910574803813846101321671784376366749012476965121271261522908882474772107196452653194239352573372884036938570849429907747816467644391667125314387967510p -0.3
+ 240240538521750407359077046256296219561976306993584113173692780504404210003815414654317126354570604187153728613910574803813846101321671784376366749012476965121271261522908882474772107196452653194239352573372884036938570849429907747816467644391667125314387968000p -0.3
+ 240240538521750407359077046256296219561976306993584113173692780504404210003815414654317126354570604187153728613910574803813846101321671784376366749012476965121271261522908882474772107196452653194239352573372884036938570849429907747816467644391667125314387968010p 0.9
+ \]
V_wl_bar_856 (WordLine_bar\\<856\\> gnd!) vsource type=pwl wave=\[
+ 0    0.9
+ 480481077043500814718154092512592439123952613987168226347385561008808420007630829308634252709141208374307457227821149607627692202643343568752733498024953930242542523045817764949544214392905306388478705146745768073877141698859815495632935288783334250628775935500p 0.9
+ 480481077043500814718154092512592439123952613987168226347385561008808420007630829308634252709141208374307457227821149607627692202643343568752733498024953930242542523045817764949544214392905306388478705146745768073877141698859815495632935288783334250628775935510p -0.3
+ 480481077043500814718154092512592439123952613987168226347385561008808420007630829308634252709141208374307457227821149607627692202643343568752733498024953930242542523045817764949544214392905306388478705146745768073877141698859815495632935288783334250628775936000p -0.3
+ 480481077043500814718154092512592439123952613987168226347385561008808420007630829308634252709141208374307457227821149607627692202643343568752733498024953930242542523045817764949544214392905306388478705146745768073877141698859815495632935288783334250628775936010p 0.9
+ \]
V_wl_bar_857 (WordLine_bar\\<857\\> gnd!) vsource type=pwl wave=\[
+ 0    0.9
+ 960962154087001629436308185025184878247905227974336452694771122017616840015261658617268505418282416748614914455642299215255384405286687137505466996049907860485085046091635529899088428785810612776957410293491536147754283397719630991265870577566668501257551871500p 0.9
+ 960962154087001629436308185025184878247905227974336452694771122017616840015261658617268505418282416748614914455642299215255384405286687137505466996049907860485085046091635529899088428785810612776957410293491536147754283397719630991265870577566668501257551871510p -0.3
+ 960962154087001629436308185025184878247905227974336452694771122017616840015261658617268505418282416748614914455642299215255384405286687137505466996049907860485085046091635529899088428785810612776957410293491536147754283397719630991265870577566668501257551872000p -0.3
+ 960962154087001629436308185025184878247905227974336452694771122017616840015261658617268505418282416748614914455642299215255384405286687137505466996049907860485085046091635529899088428785810612776957410293491536147754283397719630991265870577566668501257551872010p 0.9
+ \]
V_wl_bar_858 (WordLine_bar\\<858\\> gnd!) vsource type=pwl wave=\[
+ 0    0.9
+ 1921924308174003258872616370050369756495810455948672905389542244035233680030523317234537010836564833497229828911284598430510768810573374275010933992099815720970170092183271059798176857571621225553914820586983072295508566795439261982531741155133337002515103743500p 0.9
+ 1921924308174003258872616370050369756495810455948672905389542244035233680030523317234537010836564833497229828911284598430510768810573374275010933992099815720970170092183271059798176857571621225553914820586983072295508566795439261982531741155133337002515103743510p -0.3
+ 1921924308174003258872616370050369756495810455948672905389542244035233680030523317234537010836564833497229828911284598430510768810573374275010933992099815720970170092183271059798176857571621225553914820586983072295508566795439261982531741155133337002515103744000p -0.3
+ 1921924308174003258872616370050369756495810455948672905389542244035233680030523317234537010836564833497229828911284598430510768810573374275010933992099815720970170092183271059798176857571621225553914820586983072295508566795439261982531741155133337002515103744010p 0.9
+ \]
V_wl_bar_859 (WordLine_bar\\<859\\> gnd!) vsource type=pwl wave=\[
+ 0    0.9
+ 3843848616348006517745232740100739512991620911897345810779084488070467360061046634469074021673129666994459657822569196861021537621146748550021867984199631441940340184366542119596353715143242451107829641173966144591017133590878523965063482310266674005030207487500p 0.9
+ 3843848616348006517745232740100739512991620911897345810779084488070467360061046634469074021673129666994459657822569196861021537621146748550021867984199631441940340184366542119596353715143242451107829641173966144591017133590878523965063482310266674005030207487510p -0.3
+ 3843848616348006517745232740100739512991620911897345810779084488070467360061046634469074021673129666994459657822569196861021537621146748550021867984199631441940340184366542119596353715143242451107829641173966144591017133590878523965063482310266674005030207488000p -0.3
+ 3843848616348006517745232740100739512991620911897345810779084488070467360061046634469074021673129666994459657822569196861021537621146748550021867984199631441940340184366542119596353715143242451107829641173966144591017133590878523965063482310266674005030207488010p 0.9
+ \]
V_wl_bar_860 (WordLine_bar\\<860\\> gnd!) vsource type=pwl wave=\[
+ 0    0.9
+ 7687697232696013035490465480201479025983241823794691621558168976140934720122093268938148043346259333988919315645138393722043075242293497100043735968399262883880680368733084239192707430286484902215659282347932289182034267181757047930126964620533348010060414975500p 0.9
+ 7687697232696013035490465480201479025983241823794691621558168976140934720122093268938148043346259333988919315645138393722043075242293497100043735968399262883880680368733084239192707430286484902215659282347932289182034267181757047930126964620533348010060414975510p -0.3
+ 7687697232696013035490465480201479025983241823794691621558168976140934720122093268938148043346259333988919315645138393722043075242293497100043735968399262883880680368733084239192707430286484902215659282347932289182034267181757047930126964620533348010060414976000p -0.3
+ 7687697232696013035490465480201479025983241823794691621558168976140934720122093268938148043346259333988919315645138393722043075242293497100043735968399262883880680368733084239192707430286484902215659282347932289182034267181757047930126964620533348010060414976010p 0.9
+ \]
V_wl_bar_861 (WordLine_bar\\<861\\> gnd!) vsource type=pwl wave=\[
+ 0    0.9
+ 15375394465392026070980930960402958051966483647589383243116337952281869440244186537876296086692518667977838631290276787444086150484586994200087471936798525767761360737466168478385414860572969804431318564695864578364068534363514095860253929241066696020120829951500p 0.9
+ 15375394465392026070980930960402958051966483647589383243116337952281869440244186537876296086692518667977838631290276787444086150484586994200087471936798525767761360737466168478385414860572969804431318564695864578364068534363514095860253929241066696020120829951510p -0.3
+ 15375394465392026070980930960402958051966483647589383243116337952281869440244186537876296086692518667977838631290276787444086150484586994200087471936798525767761360737466168478385414860572969804431318564695864578364068534363514095860253929241066696020120829952000p -0.3
+ 15375394465392026070980930960402958051966483647589383243116337952281869440244186537876296086692518667977838631290276787444086150484586994200087471936798525767761360737466168478385414860572969804431318564695864578364068534363514095860253929241066696020120829952010p 0.9
+ \]
V_wl_bar_862 (WordLine_bar\\<862\\> gnd!) vsource type=pwl wave=\[
+ 0    0.9
+ 30750788930784052141961861920805916103932967295178766486232675904563738880488373075752592173385037335955677262580553574888172300969173988400174943873597051535522721474932336956770829721145939608862637129391729156728137068727028191720507858482133392040241659903500p 0.9
+ 30750788930784052141961861920805916103932967295178766486232675904563738880488373075752592173385037335955677262580553574888172300969173988400174943873597051535522721474932336956770829721145939608862637129391729156728137068727028191720507858482133392040241659903510p -0.3
+ 30750788930784052141961861920805916103932967295178766486232675904563738880488373075752592173385037335955677262580553574888172300969173988400174943873597051535522721474932336956770829721145939608862637129391729156728137068727028191720507858482133392040241659904000p -0.3
+ 30750788930784052141961861920805916103932967295178766486232675904563738880488373075752592173385037335955677262580553574888172300969173988400174943873597051535522721474932336956770829721145939608862637129391729156728137068727028191720507858482133392040241659904010p 0.9
+ \]
V_wl_bar_863 (WordLine_bar\\<863\\> gnd!) vsource type=pwl wave=\[
+ 0    0.9
+ 61501577861568104283923723841611832207865934590357532972465351809127477760976746151505184346770074671911354525161107149776344601938347976800349887747194103071045442949864673913541659442291879217725274258783458313456274137454056383441015716964266784080483319807500p 0.9
+ 61501577861568104283923723841611832207865934590357532972465351809127477760976746151505184346770074671911354525161107149776344601938347976800349887747194103071045442949864673913541659442291879217725274258783458313456274137454056383441015716964266784080483319807510p -0.3
+ 61501577861568104283923723841611832207865934590357532972465351809127477760976746151505184346770074671911354525161107149776344601938347976800349887747194103071045442949864673913541659442291879217725274258783458313456274137454056383441015716964266784080483319808000p -0.3
+ 61501577861568104283923723841611832207865934590357532972465351809127477760976746151505184346770074671911354525161107149776344601938347976800349887747194103071045442949864673913541659442291879217725274258783458313456274137454056383441015716964266784080483319808010p 0.9
+ \]
V_wl_bar_864 (WordLine_bar\\<864\\> gnd!) vsource type=pwl wave=\[
+ 0    0.9
+ 123003155723136208567847447683223664415731869180715065944930703618254955521953492303010368693540149343822709050322214299552689203876695953600699775494388206142090885899729347827083318884583758435450548517566916626912548274908112766882031433928533568160966639615500p 0.9
+ 123003155723136208567847447683223664415731869180715065944930703618254955521953492303010368693540149343822709050322214299552689203876695953600699775494388206142090885899729347827083318884583758435450548517566916626912548274908112766882031433928533568160966639615510p -0.3
+ 123003155723136208567847447683223664415731869180715065944930703618254955521953492303010368693540149343822709050322214299552689203876695953600699775494388206142090885899729347827083318884583758435450548517566916626912548274908112766882031433928533568160966639616000p -0.3
+ 123003155723136208567847447683223664415731869180715065944930703618254955521953492303010368693540149343822709050322214299552689203876695953600699775494388206142090885899729347827083318884583758435450548517566916626912548274908112766882031433928533568160966639616010p 0.9
+ \]
V_wl_bar_865 (WordLine_bar\\<865\\> gnd!) vsource type=pwl wave=\[
+ 0    0.9
+ 246006311446272417135694895366447328831463738361430131889861407236509911043906984606020737387080298687645418100644428599105378407753391907201399550988776412284181771799458695654166637769167516870901097035133833253825096549816225533764062867857067136321933279231500p 0.9
+ 246006311446272417135694895366447328831463738361430131889861407236509911043906984606020737387080298687645418100644428599105378407753391907201399550988776412284181771799458695654166637769167516870901097035133833253825096549816225533764062867857067136321933279231510p -0.3
+ 246006311446272417135694895366447328831463738361430131889861407236509911043906984606020737387080298687645418100644428599105378407753391907201399550988776412284181771799458695654166637769167516870901097035133833253825096549816225533764062867857067136321933279232000p -0.3
+ 246006311446272417135694895366447328831463738361430131889861407236509911043906984606020737387080298687645418100644428599105378407753391907201399550988776412284181771799458695654166637769167516870901097035133833253825096549816225533764062867857067136321933279232010p 0.9
+ \]
V_wl_bar_866 (WordLine_bar\\<866\\> gnd!) vsource type=pwl wave=\[
+ 0    0.9
+ 492012622892544834271389790732894657662927476722860263779722814473019822087813969212041474774160597375290836201288857198210756815506783814402799101977552824568363543598917391308333275538335033741802194070267666507650193099632451067528125735714134272643866558463500p 0.9
+ 492012622892544834271389790732894657662927476722860263779722814473019822087813969212041474774160597375290836201288857198210756815506783814402799101977552824568363543598917391308333275538335033741802194070267666507650193099632451067528125735714134272643866558463510p -0.3
+ 492012622892544834271389790732894657662927476722860263779722814473019822087813969212041474774160597375290836201288857198210756815506783814402799101977552824568363543598917391308333275538335033741802194070267666507650193099632451067528125735714134272643866558464000p -0.3
+ 492012622892544834271389790732894657662927476722860263779722814473019822087813969212041474774160597375290836201288857198210756815506783814402799101977552824568363543598917391308333275538335033741802194070267666507650193099632451067528125735714134272643866558464010p 0.9
+ \]
V_wl_bar_867 (WordLine_bar\\<867\\> gnd!) vsource type=pwl wave=\[
+ 0    0.9
+ 984025245785089668542779581465789315325854953445720527559445628946039644175627938424082949548321194750581672402577714396421513631013567628805598203955105649136727087197834782616666551076670067483604388140535333015300386199264902135056251471428268545287733116927500p 0.9
+ 984025245785089668542779581465789315325854953445720527559445628946039644175627938424082949548321194750581672402577714396421513631013567628805598203955105649136727087197834782616666551076670067483604388140535333015300386199264902135056251471428268545287733116927510p -0.3
+ 984025245785089668542779581465789315325854953445720527559445628946039644175627938424082949548321194750581672402577714396421513631013567628805598203955105649136727087197834782616666551076670067483604388140535333015300386199264902135056251471428268545287733116928000p -0.3
+ 984025245785089668542779581465789315325854953445720527559445628946039644175627938424082949548321194750581672402577714396421513631013567628805598203955105649136727087197834782616666551076670067483604388140535333015300386199264902135056251471428268545287733116928010p 0.9
+ \]
V_wl_bar_868 (WordLine_bar\\<868\\> gnd!) vsource type=pwl wave=\[
+ 0    0.9
+ 1968050491570179337085559162931578630651709906891441055118891257892079288351255876848165899096642389501163344805155428792843027262027135257611196407910211298273454174395669565233333102153340134967208776281070666030600772398529804270112502942856537090575466233855500p 0.9
+ 1968050491570179337085559162931578630651709906891441055118891257892079288351255876848165899096642389501163344805155428792843027262027135257611196407910211298273454174395669565233333102153340134967208776281070666030600772398529804270112502942856537090575466233855510p -0.3
+ 1968050491570179337085559162931578630651709906891441055118891257892079288351255876848165899096642389501163344805155428792843027262027135257611196407910211298273454174395669565233333102153340134967208776281070666030600772398529804270112502942856537090575466233856000p -0.3
+ 1968050491570179337085559162931578630651709906891441055118891257892079288351255876848165899096642389501163344805155428792843027262027135257611196407910211298273454174395669565233333102153340134967208776281070666030600772398529804270112502942856537090575466233856010p 0.9
+ \]
V_wl_bar_869 (WordLine_bar\\<869\\> gnd!) vsource type=pwl wave=\[
+ 0    0.9
+ 3936100983140358674171118325863157261303419813782882110237782515784158576702511753696331798193284779002326689610310857585686054524054270515222392815820422596546908348791339130466666204306680269934417552562141332061201544797059608540225005885713074181150932467711500p 0.9
+ 3936100983140358674171118325863157261303419813782882110237782515784158576702511753696331798193284779002326689610310857585686054524054270515222392815820422596546908348791339130466666204306680269934417552562141332061201544797059608540225005885713074181150932467711510p -0.3
+ 3936100983140358674171118325863157261303419813782882110237782515784158576702511753696331798193284779002326689610310857585686054524054270515222392815820422596546908348791339130466666204306680269934417552562141332061201544797059608540225005885713074181150932467712000p -0.3
+ 3936100983140358674171118325863157261303419813782882110237782515784158576702511753696331798193284779002326689610310857585686054524054270515222392815820422596546908348791339130466666204306680269934417552562141332061201544797059608540225005885713074181150932467712010p 0.9
+ \]
V_wl_bar_870 (WordLine_bar\\<870\\> gnd!) vsource type=pwl wave=\[
+ 0    0.9
+ 7872201966280717348342236651726314522606839627565764220475565031568317153405023507392663596386569558004653379220621715171372109048108541030444785631640845193093816697582678260933332408613360539868835105124282664122403089594119217080450011771426148362301864935423500p 0.9
+ 7872201966280717348342236651726314522606839627565764220475565031568317153405023507392663596386569558004653379220621715171372109048108541030444785631640845193093816697582678260933332408613360539868835105124282664122403089594119217080450011771426148362301864935423510p -0.3
+ 7872201966280717348342236651726314522606839627565764220475565031568317153405023507392663596386569558004653379220621715171372109048108541030444785631640845193093816697582678260933332408613360539868835105124282664122403089594119217080450011771426148362301864935424000p -0.3
+ 7872201966280717348342236651726314522606839627565764220475565031568317153405023507392663596386569558004653379220621715171372109048108541030444785631640845193093816697582678260933332408613360539868835105124282664122403089594119217080450011771426148362301864935424010p 0.9
+ \]
V_wl_bar_871 (WordLine_bar\\<871\\> gnd!) vsource type=pwl wave=\[
+ 0    0.9
+ 15744403932561434696684473303452629045213679255131528440951130063136634306810047014785327192773139116009306758441243430342744218096217082060889571263281690386187633395165356521866664817226721079737670210248565328244806179188238434160900023542852296724603729870847500p 0.9
+ 15744403932561434696684473303452629045213679255131528440951130063136634306810047014785327192773139116009306758441243430342744218096217082060889571263281690386187633395165356521866664817226721079737670210248565328244806179188238434160900023542852296724603729870847510p -0.3
+ 15744403932561434696684473303452629045213679255131528440951130063136634306810047014785327192773139116009306758441243430342744218096217082060889571263281690386187633395165356521866664817226721079737670210248565328244806179188238434160900023542852296724603729870848000p -0.3
+ 15744403932561434696684473303452629045213679255131528440951130063136634306810047014785327192773139116009306758441243430342744218096217082060889571263281690386187633395165356521866664817226721079737670210248565328244806179188238434160900023542852296724603729870848010p 0.9
+ \]
V_wl_bar_872 (WordLine_bar\\<872\\> gnd!) vsource type=pwl wave=\[
+ 0    0.9
+ 31488807865122869393368946606905258090427358510263056881902260126273268613620094029570654385546278232018613516882486860685488436192434164121779142526563380772375266790330713043733329634453442159475340420497130656489612358376476868321800047085704593449207459741695500p 0.9
+ 31488807865122869393368946606905258090427358510263056881902260126273268613620094029570654385546278232018613516882486860685488436192434164121779142526563380772375266790330713043733329634453442159475340420497130656489612358376476868321800047085704593449207459741695510p -0.3
+ 31488807865122869393368946606905258090427358510263056881902260126273268613620094029570654385546278232018613516882486860685488436192434164121779142526563380772375266790330713043733329634453442159475340420497130656489612358376476868321800047085704593449207459741696000p -0.3
+ 31488807865122869393368946606905258090427358510263056881902260126273268613620094029570654385546278232018613516882486860685488436192434164121779142526563380772375266790330713043733329634453442159475340420497130656489612358376476868321800047085704593449207459741696010p 0.9
+ \]
V_wl_bar_873 (WordLine_bar\\<873\\> gnd!) vsource type=pwl wave=\[
+ 0    0.9
+ 62977615730245738786737893213810516180854717020526113763804520252546537227240188059141308771092556464037227033764973721370976872384868328243558285053126761544750533580661426087466659268906884318950680840994261312979224716752953736643600094171409186898414919483391500p 0.9
+ 62977615730245738786737893213810516180854717020526113763804520252546537227240188059141308771092556464037227033764973721370976872384868328243558285053126761544750533580661426087466659268906884318950680840994261312979224716752953736643600094171409186898414919483391510p -0.3
+ 62977615730245738786737893213810516180854717020526113763804520252546537227240188059141308771092556464037227033764973721370976872384868328243558285053126761544750533580661426087466659268906884318950680840994261312979224716752953736643600094171409186898414919483392000p -0.3
+ 62977615730245738786737893213810516180854717020526113763804520252546537227240188059141308771092556464037227033764973721370976872384868328243558285053126761544750533580661426087466659268906884318950680840994261312979224716752953736643600094171409186898414919483392010p 0.9
+ \]
V_wl_bar_874 (WordLine_bar\\<874\\> gnd!) vsource type=pwl wave=\[
+ 0    0.9
+ 125955231460491477573475786427621032361709434041052227527609040505093074454480376118282617542185112928074454067529947442741953744769736656487116570106253523089501067161322852174933318537813768637901361681988522625958449433505907473287200188342818373796829838966783500p 0.9
+ 125955231460491477573475786427621032361709434041052227527609040505093074454480376118282617542185112928074454067529947442741953744769736656487116570106253523089501067161322852174933318537813768637901361681988522625958449433505907473287200188342818373796829838966783510p -0.3
+ 125955231460491477573475786427621032361709434041052227527609040505093074454480376118282617542185112928074454067529947442741953744769736656487116570106253523089501067161322852174933318537813768637901361681988522625958449433505907473287200188342818373796829838966784000p -0.3
+ 125955231460491477573475786427621032361709434041052227527609040505093074454480376118282617542185112928074454067529947442741953744769736656487116570106253523089501067161322852174933318537813768637901361681988522625958449433505907473287200188342818373796829838966784010p 0.9
+ \]
V_wl_bar_875 (WordLine_bar\\<875\\> gnd!) vsource type=pwl wave=\[
+ 0    0.9
+ 251910462920982955146951572855242064723418868082104455055218081010186148908960752236565235084370225856148908135059894885483907489539473312974233140212507046179002134322645704349866637075627537275802723363977045251916898867011814946574400376685636747593659677933567500p 0.9
+ 251910462920982955146951572855242064723418868082104455055218081010186148908960752236565235084370225856148908135059894885483907489539473312974233140212507046179002134322645704349866637075627537275802723363977045251916898867011814946574400376685636747593659677933567510p -0.3
+ 251910462920982955146951572855242064723418868082104455055218081010186148908960752236565235084370225856148908135059894885483907489539473312974233140212507046179002134322645704349866637075627537275802723363977045251916898867011814946574400376685636747593659677933568000p -0.3
+ 251910462920982955146951572855242064723418868082104455055218081010186148908960752236565235084370225856148908135059894885483907489539473312974233140212507046179002134322645704349866637075627537275802723363977045251916898867011814946574400376685636747593659677933568010p 0.9
+ \]
V_wl_bar_876 (WordLine_bar\\<876\\> gnd!) vsource type=pwl wave=\[
+ 0    0.9
+ 503820925841965910293903145710484129446837736164208910110436162020372297817921504473130470168740451712297816270119789770967814979078946625948466280425014092358004268645291408699733274151255074551605446727954090503833797734023629893148800753371273495187319355867135500p 0.9
+ 503820925841965910293903145710484129446837736164208910110436162020372297817921504473130470168740451712297816270119789770967814979078946625948466280425014092358004268645291408699733274151255074551605446727954090503833797734023629893148800753371273495187319355867135510p -0.3
+ 503820925841965910293903145710484129446837736164208910110436162020372297817921504473130470168740451712297816270119789770967814979078946625948466280425014092358004268645291408699733274151255074551605446727954090503833797734023629893148800753371273495187319355867136000p -0.3
+ 503820925841965910293903145710484129446837736164208910110436162020372297817921504473130470168740451712297816270119789770967814979078946625948466280425014092358004268645291408699733274151255074551605446727954090503833797734023629893148800753371273495187319355867136010p 0.9
+ \]
V_wl_bar_877 (WordLine_bar\\<877\\> gnd!) vsource type=pwl wave=\[
+ 0    0.9
+ 1007641851683931820587806291420968258893675472328417820220872324040744595635843008946260940337480903424595632540239579541935629958157893251896932560850028184716008537290582817399466548302510149103210893455908181007667595468047259786297601506742546990374638711734271500p 0.9
+ 1007641851683931820587806291420968258893675472328417820220872324040744595635843008946260940337480903424595632540239579541935629958157893251896932560850028184716008537290582817399466548302510149103210893455908181007667595468047259786297601506742546990374638711734271510p -0.3
+ 1007641851683931820587806291420968258893675472328417820220872324040744595635843008946260940337480903424595632540239579541935629958157893251896932560850028184716008537290582817399466548302510149103210893455908181007667595468047259786297601506742546990374638711734272000p -0.3
+ 1007641851683931820587806291420968258893675472328417820220872324040744595635843008946260940337480903424595632540239579541935629958157893251896932560850028184716008537290582817399466548302510149103210893455908181007667595468047259786297601506742546990374638711734272010p 0.9
+ \]
V_wl_bar_878 (WordLine_bar\\<878\\> gnd!) vsource type=pwl wave=\[
+ 0    0.9
+ 2015283703367863641175612582841936517787350944656835640441744648081489191271686017892521880674961806849191265080479159083871259916315786503793865121700056369432017074581165634798933096605020298206421786911816362015335190936094519572595203013485093980749277423468543500p 0.9
+ 2015283703367863641175612582841936517787350944656835640441744648081489191271686017892521880674961806849191265080479159083871259916315786503793865121700056369432017074581165634798933096605020298206421786911816362015335190936094519572595203013485093980749277423468543510p -0.3
+ 2015283703367863641175612582841936517787350944656835640441744648081489191271686017892521880674961806849191265080479159083871259916315786503793865121700056369432017074581165634798933096605020298206421786911816362015335190936094519572595203013485093980749277423468544000p -0.3
+ 2015283703367863641175612582841936517787350944656835640441744648081489191271686017892521880674961806849191265080479159083871259916315786503793865121700056369432017074581165634798933096605020298206421786911816362015335190936094519572595203013485093980749277423468544010p 0.9
+ \]
V_wl_bar_879 (WordLine_bar\\<879\\> gnd!) vsource type=pwl wave=\[
+ 0    0.9
+ 4030567406735727282351225165683873035574701889313671280883489296162978382543372035785043761349923613698382530160958318167742519832631573007587730243400112738864034149162331269597866193210040596412843573823632724030670381872189039145190406026970187961498554846937087500p 0.9
+ 4030567406735727282351225165683873035574701889313671280883489296162978382543372035785043761349923613698382530160958318167742519832631573007587730243400112738864034149162331269597866193210040596412843573823632724030670381872189039145190406026970187961498554846937087510p -0.3
+ 4030567406735727282351225165683873035574701889313671280883489296162978382543372035785043761349923613698382530160958318167742519832631573007587730243400112738864034149162331269597866193210040596412843573823632724030670381872189039145190406026970187961498554846937088000p -0.3
+ 4030567406735727282351225165683873035574701889313671280883489296162978382543372035785043761349923613698382530160958318167742519832631573007587730243400112738864034149162331269597866193210040596412843573823632724030670381872189039145190406026970187961498554846937088010p 0.9
+ \]
V_wl_bar_880 (WordLine_bar\\<880\\> gnd!) vsource type=pwl wave=\[
+ 0    0.9
+ 8061134813471454564702450331367746071149403778627342561766978592325956765086744071570087522699847227396765060321916636335485039665263146015175460486800225477728068298324662539195732386420081192825687147647265448061340763744378078290380812053940375922997109693874175500p 0.9
+ 8061134813471454564702450331367746071149403778627342561766978592325956765086744071570087522699847227396765060321916636335485039665263146015175460486800225477728068298324662539195732386420081192825687147647265448061340763744378078290380812053940375922997109693874175510p -0.3
+ 8061134813471454564702450331367746071149403778627342561766978592325956765086744071570087522699847227396765060321916636335485039665263146015175460486800225477728068298324662539195732386420081192825687147647265448061340763744378078290380812053940375922997109693874176000p -0.3
+ 8061134813471454564702450331367746071149403778627342561766978592325956765086744071570087522699847227396765060321916636335485039665263146015175460486800225477728068298324662539195732386420081192825687147647265448061340763744378078290380812053940375922997109693874176010p 0.9
+ \]
V_wl_bar_881 (WordLine_bar\\<881\\> gnd!) vsource type=pwl wave=\[
+ 0    0.9
+ 16122269626942909129404900662735492142298807557254685123533957184651913530173488143140175045399694454793530120643833272670970079330526292030350920973600450955456136596649325078391464772840162385651374295294530896122681527488756156580761624107880751845994219387748351500p 0.9
+ 16122269626942909129404900662735492142298807557254685123533957184651913530173488143140175045399694454793530120643833272670970079330526292030350920973600450955456136596649325078391464772840162385651374295294530896122681527488756156580761624107880751845994219387748351510p -0.3
+ 16122269626942909129404900662735492142298807557254685123533957184651913530173488143140175045399694454793530120643833272670970079330526292030350920973600450955456136596649325078391464772840162385651374295294530896122681527488756156580761624107880751845994219387748352000p -0.3
+ 16122269626942909129404900662735492142298807557254685123533957184651913530173488143140175045399694454793530120643833272670970079330526292030350920973600450955456136596649325078391464772840162385651374295294530896122681527488756156580761624107880751845994219387748352010p 0.9
+ \]
V_wl_bar_882 (WordLine_bar\\<882\\> gnd!) vsource type=pwl wave=\[
+ 0    0.9
+ 32244539253885818258809801325470984284597615114509370247067914369303827060346976286280350090799388909587060241287666545341940158661052584060701841947200901910912273193298650156782929545680324771302748590589061792245363054977512313161523248215761503691988438775496703500p 0.9
+ 32244539253885818258809801325470984284597615114509370247067914369303827060346976286280350090799388909587060241287666545341940158661052584060701841947200901910912273193298650156782929545680324771302748590589061792245363054977512313161523248215761503691988438775496703510p -0.3
+ 32244539253885818258809801325470984284597615114509370247067914369303827060346976286280350090799388909587060241287666545341940158661052584060701841947200901910912273193298650156782929545680324771302748590589061792245363054977512313161523248215761503691988438775496704000p -0.3
+ 32244539253885818258809801325470984284597615114509370247067914369303827060346976286280350090799388909587060241287666545341940158661052584060701841947200901910912273193298650156782929545680324771302748590589061792245363054977512313161523248215761503691988438775496704010p 0.9
+ \]
V_wl_bar_883 (WordLine_bar\\<883\\> gnd!) vsource type=pwl wave=\[
+ 0    0.9
+ 64489078507771636517619602650941968569195230229018740494135828738607654120693952572560700181598777819174120482575333090683880317322105168121403683894401803821824546386597300313565859091360649542605497181178123584490726109955024626323046496431523007383976877550993407500p 0.9
+ 64489078507771636517619602650941968569195230229018740494135828738607654120693952572560700181598777819174120482575333090683880317322105168121403683894401803821824546386597300313565859091360649542605497181178123584490726109955024626323046496431523007383976877550993407510p -0.3
+ 64489078507771636517619602650941968569195230229018740494135828738607654120693952572560700181598777819174120482575333090683880317322105168121403683894401803821824546386597300313565859091360649542605497181178123584490726109955024626323046496431523007383976877550993408000p -0.3
+ 64489078507771636517619602650941968569195230229018740494135828738607654120693952572560700181598777819174120482575333090683880317322105168121403683894401803821824546386597300313565859091360649542605497181178123584490726109955024626323046496431523007383976877550993408010p 0.9
+ \]
V_wl_bar_884 (WordLine_bar\\<884\\> gnd!) vsource type=pwl wave=\[
+ 0    0.9
+ 128978157015543273035239205301883937138390460458037480988271657477215308241387905145121400363197555638348240965150666181367760634644210336242807367788803607643649092773194600627131718182721299085210994362356247168981452219910049252646092992863046014767953755101986815500p 0.9
+ 128978157015543273035239205301883937138390460458037480988271657477215308241387905145121400363197555638348240965150666181367760634644210336242807367788803607643649092773194600627131718182721299085210994362356247168981452219910049252646092992863046014767953755101986815510p -0.3
+ 128978157015543273035239205301883937138390460458037480988271657477215308241387905145121400363197555638348240965150666181367760634644210336242807367788803607643649092773194600627131718182721299085210994362356247168981452219910049252646092992863046014767953755101986816000p -0.3
+ 128978157015543273035239205301883937138390460458037480988271657477215308241387905145121400363197555638348240965150666181367760634644210336242807367788803607643649092773194600627131718182721299085210994362356247168981452219910049252646092992863046014767953755101986816010p 0.9
+ \]
V_wl_bar_885 (WordLine_bar\\<885\\> gnd!) vsource type=pwl wave=\[
+ 0    0.9
+ 257956314031086546070478410603767874276780920916074961976543314954430616482775810290242800726395111276696481930301332362735521269288420672485614735577607215287298185546389201254263436365442598170421988724712494337962904439820098505292185985726092029535907510203973631500p 0.9
+ 257956314031086546070478410603767874276780920916074961976543314954430616482775810290242800726395111276696481930301332362735521269288420672485614735577607215287298185546389201254263436365442598170421988724712494337962904439820098505292185985726092029535907510203973631510p -0.3
+ 257956314031086546070478410603767874276780920916074961976543314954430616482775810290242800726395111276696481930301332362735521269288420672485614735577607215287298185546389201254263436365442598170421988724712494337962904439820098505292185985726092029535907510203973632000p -0.3
+ 257956314031086546070478410603767874276780920916074961976543314954430616482775810290242800726395111276696481930301332362735521269288420672485614735577607215287298185546389201254263436365442598170421988724712494337962904439820098505292185985726092029535907510203973632010p 0.9
+ \]
V_wl_bar_886 (WordLine_bar\\<886\\> gnd!) vsource type=pwl wave=\[
+ 0    0.9
+ 515912628062173092140956821207535748553561841832149923953086629908861232965551620580485601452790222553392963860602664725471042538576841344971229471155214430574596371092778402508526872730885196340843977449424988675925808879640197010584371971452184059071815020407947263500p 0.9
+ 515912628062173092140956821207535748553561841832149923953086629908861232965551620580485601452790222553392963860602664725471042538576841344971229471155214430574596371092778402508526872730885196340843977449424988675925808879640197010584371971452184059071815020407947263510p -0.3
+ 515912628062173092140956821207535748553561841832149923953086629908861232965551620580485601452790222553392963860602664725471042538576841344971229471155214430574596371092778402508526872730885196340843977449424988675925808879640197010584371971452184059071815020407947264000p -0.3
+ 515912628062173092140956821207535748553561841832149923953086629908861232965551620580485601452790222553392963860602664725471042538576841344971229471155214430574596371092778402508526872730885196340843977449424988675925808879640197010584371971452184059071815020407947264010p 0.9
+ \]
V_wl_bar_887 (WordLine_bar\\<887\\> gnd!) vsource type=pwl wave=\[
+ 0    0.9
+ 1031825256124346184281913642415071497107123683664299847906173259817722465931103241160971202905580445106785927721205329450942085077153682689942458942310428861149192742185556805017053745461770392681687954898849977351851617759280394021168743942904368118143630040815894527500p 0.9
+ 1031825256124346184281913642415071497107123683664299847906173259817722465931103241160971202905580445106785927721205329450942085077153682689942458942310428861149192742185556805017053745461770392681687954898849977351851617759280394021168743942904368118143630040815894527510p -0.3
+ 1031825256124346184281913642415071497107123683664299847906173259817722465931103241160971202905580445106785927721205329450942085077153682689942458942310428861149192742185556805017053745461770392681687954898849977351851617759280394021168743942904368118143630040815894528000p -0.3
+ 1031825256124346184281913642415071497107123683664299847906173259817722465931103241160971202905580445106785927721205329450942085077153682689942458942310428861149192742185556805017053745461770392681687954898849977351851617759280394021168743942904368118143630040815894528010p 0.9
+ \]
V_wl_bar_888 (WordLine_bar\\<888\\> gnd!) vsource type=pwl wave=\[
+ 0    0.9
+ 2063650512248692368563827284830142994214247367328599695812346519635444931862206482321942405811160890213571855442410658901884170154307365379884917884620857722298385484371113610034107490923540785363375909797699954703703235518560788042337487885808736236287260081631789055500p 0.9
+ 2063650512248692368563827284830142994214247367328599695812346519635444931862206482321942405811160890213571855442410658901884170154307365379884917884620857722298385484371113610034107490923540785363375909797699954703703235518560788042337487885808736236287260081631789055510p -0.3
+ 2063650512248692368563827284830142994214247367328599695812346519635444931862206482321942405811160890213571855442410658901884170154307365379884917884620857722298385484371113610034107490923540785363375909797699954703703235518560788042337487885808736236287260081631789056000p -0.3
+ 2063650512248692368563827284830142994214247367328599695812346519635444931862206482321942405811160890213571855442410658901884170154307365379884917884620857722298385484371113610034107490923540785363375909797699954703703235518560788042337487885808736236287260081631789056010p 0.9
+ \]
V_wl_bar_889 (WordLine_bar\\<889\\> gnd!) vsource type=pwl wave=\[
+ 0    0.9
+ 4127301024497384737127654569660285988428494734657199391624693039270889863724412964643884811622321780427143710884821317803768340308614730759769835769241715444596770968742227220068214981847081570726751819595399909407406471037121576084674975771617472472574520163263578111500p 0.9
+ 4127301024497384737127654569660285988428494734657199391624693039270889863724412964643884811622321780427143710884821317803768340308614730759769835769241715444596770968742227220068214981847081570726751819595399909407406471037121576084674975771617472472574520163263578111510p -0.3
+ 4127301024497384737127654569660285988428494734657199391624693039270889863724412964643884811622321780427143710884821317803768340308614730759769835769241715444596770968742227220068214981847081570726751819595399909407406471037121576084674975771617472472574520163263578112000p -0.3
+ 4127301024497384737127654569660285988428494734657199391624693039270889863724412964643884811622321780427143710884821317803768340308614730759769835769241715444596770968742227220068214981847081570726751819595399909407406471037121576084674975771617472472574520163263578112010p 0.9
+ \]
V_wl_bar_890 (WordLine_bar\\<890\\> gnd!) vsource type=pwl wave=\[
+ 0    0.9
+ 8254602048994769474255309139320571976856989469314398783249386078541779727448825929287769623244643560854287421769642635607536680617229461519539671538483430889193541937484454440136429963694163141453503639190799818814812942074243152169349951543234944945149040326527156223500p 0.9
+ 8254602048994769474255309139320571976856989469314398783249386078541779727448825929287769623244643560854287421769642635607536680617229461519539671538483430889193541937484454440136429963694163141453503639190799818814812942074243152169349951543234944945149040326527156223510p -0.3
+ 8254602048994769474255309139320571976856989469314398783249386078541779727448825929287769623244643560854287421769642635607536680617229461519539671538483430889193541937484454440136429963694163141453503639190799818814812942074243152169349951543234944945149040326527156224000p -0.3
+ 8254602048994769474255309139320571976856989469314398783249386078541779727448825929287769623244643560854287421769642635607536680617229461519539671538483430889193541937484454440136429963694163141453503639190799818814812942074243152169349951543234944945149040326527156224010p 0.9
+ \]
V_wl_bar_891 (WordLine_bar\\<891\\> gnd!) vsource type=pwl wave=\[
+ 0    0.9
+ 16509204097989538948510618278641143953713978938628797566498772157083559454897651858575539246489287121708574843539285271215073361234458923039079343076966861778387083874968908880272859927388326282907007278381599637629625884148486304338699903086469889890298080653054312447500p 0.9
+ 16509204097989538948510618278641143953713978938628797566498772157083559454897651858575539246489287121708574843539285271215073361234458923039079343076966861778387083874968908880272859927388326282907007278381599637629625884148486304338699903086469889890298080653054312447510p -0.3
+ 16509204097989538948510618278641143953713978938628797566498772157083559454897651858575539246489287121708574843539285271215073361234458923039079343076966861778387083874968908880272859927388326282907007278381599637629625884148486304338699903086469889890298080653054312448000p -0.3
+ 16509204097989538948510618278641143953713978938628797566498772157083559454897651858575539246489287121708574843539285271215073361234458923039079343076966861778387083874968908880272859927388326282907007278381599637629625884148486304338699903086469889890298080653054312448010p 0.9
+ \]
V_wl_bar_892 (WordLine_bar\\<892\\> gnd!) vsource type=pwl wave=\[
+ 0    0.9
+ 33018408195979077897021236557282287907427957877257595132997544314167118909795303717151078492978574243417149687078570542430146722468917846078158686153933723556774167749937817760545719854776652565814014556763199275259251768296972608677399806172939779780596161306108624895500p 0.9
+ 33018408195979077897021236557282287907427957877257595132997544314167118909795303717151078492978574243417149687078570542430146722468917846078158686153933723556774167749937817760545719854776652565814014556763199275259251768296972608677399806172939779780596161306108624895510p -0.3
+ 33018408195979077897021236557282287907427957877257595132997544314167118909795303717151078492978574243417149687078570542430146722468917846078158686153933723556774167749937817760545719854776652565814014556763199275259251768296972608677399806172939779780596161306108624896000p -0.3
+ 33018408195979077897021236557282287907427957877257595132997544314167118909795303717151078492978574243417149687078570542430146722468917846078158686153933723556774167749937817760545719854776652565814014556763199275259251768296972608677399806172939779780596161306108624896010p 0.9
+ \]
V_wl_bar_893 (WordLine_bar\\<893\\> gnd!) vsource type=pwl wave=\[
+ 0    0.9
+ 66036816391958155794042473114564575814855915754515190265995088628334237819590607434302156985957148486834299374157141084860293444937835692156317372307867447113548335499875635521091439709553305131628029113526398550518503536593945217354799612345879559561192322612217249791500p 0.9
+ 66036816391958155794042473114564575814855915754515190265995088628334237819590607434302156985957148486834299374157141084860293444937835692156317372307867447113548335499875635521091439709553305131628029113526398550518503536593945217354799612345879559561192322612217249791510p -0.3
+ 66036816391958155794042473114564575814855915754515190265995088628334237819590607434302156985957148486834299374157141084860293444937835692156317372307867447113548335499875635521091439709553305131628029113526398550518503536593945217354799612345879559561192322612217249792000p -0.3
+ 66036816391958155794042473114564575814855915754515190265995088628334237819590607434302156985957148486834299374157141084860293444937835692156317372307867447113548335499875635521091439709553305131628029113526398550518503536593945217354799612345879559561192322612217249792010p 0.9
+ \]
V_wl_bar_894 (WordLine_bar\\<894\\> gnd!) vsource type=pwl wave=\[
+ 0    0.9
+ 132073632783916311588084946229129151629711831509030380531990177256668475639181214868604313971914296973668598748314282169720586889875671384312634744615734894227096670999751271042182879419106610263256058227052797101037007073187890434709599224691759119122384645224434499583500p 0.9
+ 132073632783916311588084946229129151629711831509030380531990177256668475639181214868604313971914296973668598748314282169720586889875671384312634744615734894227096670999751271042182879419106610263256058227052797101037007073187890434709599224691759119122384645224434499583510p -0.3
+ 132073632783916311588084946229129151629711831509030380531990177256668475639181214868604313971914296973668598748314282169720586889875671384312634744615734894227096670999751271042182879419106610263256058227052797101037007073187890434709599224691759119122384645224434499584000p -0.3
+ 132073632783916311588084946229129151629711831509030380531990177256668475639181214868604313971914296973668598748314282169720586889875671384312634744615734894227096670999751271042182879419106610263256058227052797101037007073187890434709599224691759119122384645224434499584010p 0.9
+ \]
V_wl_bar_895 (WordLine_bar\\<895\\> gnd!) vsource type=pwl wave=\[
+ 0    0.9
+ 264147265567832623176169892458258303259423663018060761063980354513336951278362429737208627943828593947337197496628564339441173779751342768625269489231469788454193341999502542084365758838213220526512116454105594202074014146375780869419198449383518238244769290448868999167500p 0.9
+ 264147265567832623176169892458258303259423663018060761063980354513336951278362429737208627943828593947337197496628564339441173779751342768625269489231469788454193341999502542084365758838213220526512116454105594202074014146375780869419198449383518238244769290448868999167510p -0.3
+ 264147265567832623176169892458258303259423663018060761063980354513336951278362429737208627943828593947337197496628564339441173779751342768625269489231469788454193341999502542084365758838213220526512116454105594202074014146375780869419198449383518238244769290448868999168000p -0.3
+ 264147265567832623176169892458258303259423663018060761063980354513336951278362429737208627943828593947337197496628564339441173779751342768625269489231469788454193341999502542084365758838213220526512116454105594202074014146375780869419198449383518238244769290448868999168010p 0.9
+ \]
V_wl_bar_896 (WordLine_bar\\<896\\> gnd!) vsource type=pwl wave=\[
+ 0    0.9
+ 528294531135665246352339784916516606518847326036121522127960709026673902556724859474417255887657187894674394993257128678882347559502685537250538978462939576908386683999005084168731517676426441053024232908211188404148028292751561738838396898767036476489538580897737998335500p 0.9
+ 528294531135665246352339784916516606518847326036121522127960709026673902556724859474417255887657187894674394993257128678882347559502685537250538978462939576908386683999005084168731517676426441053024232908211188404148028292751561738838396898767036476489538580897737998335510p -0.3
+ 528294531135665246352339784916516606518847326036121522127960709026673902556724859474417255887657187894674394993257128678882347559502685537250538978462939576908386683999005084168731517676426441053024232908211188404148028292751561738838396898767036476489538580897737998336000p -0.3
+ 528294531135665246352339784916516606518847326036121522127960709026673902556724859474417255887657187894674394993257128678882347559502685537250538978462939576908386683999005084168731517676426441053024232908211188404148028292751561738838396898767036476489538580897737998336010p 0.9
+ \]
V_wl_bar_897 (WordLine_bar\\<897\\> gnd!) vsource type=pwl wave=\[
+ 0    0.9
+ 1056589062271330492704679569833033213037694652072243044255921418053347805113449718948834511775314375789348789986514257357764695119005371074501077956925879153816773367998010168337463035352852882106048465816422376808296056585503123477676793797534072952979077161795475996671500p 0.9
+ 1056589062271330492704679569833033213037694652072243044255921418053347805113449718948834511775314375789348789986514257357764695119005371074501077956925879153816773367998010168337463035352852882106048465816422376808296056585503123477676793797534072952979077161795475996671510p -0.3
+ 1056589062271330492704679569833033213037694652072243044255921418053347805113449718948834511775314375789348789986514257357764695119005371074501077956925879153816773367998010168337463035352852882106048465816422376808296056585503123477676793797534072952979077161795475996672000p -0.3
+ 1056589062271330492704679569833033213037694652072243044255921418053347805113449718948834511775314375789348789986514257357764695119005371074501077956925879153816773367998010168337463035352852882106048465816422376808296056585503123477676793797534072952979077161795475996672010p 0.9
+ \]
V_wl_bar_898 (WordLine_bar\\<898\\> gnd!) vsource type=pwl wave=\[
+ 0    0.9
+ 2113178124542660985409359139666066426075389304144486088511842836106695610226899437897669023550628751578697579973028514715529390238010742149002155913851758307633546735996020336674926070705705764212096931632844753616592113171006246955353587595068145905958154323590951993343500p 0.9
+ 2113178124542660985409359139666066426075389304144486088511842836106695610226899437897669023550628751578697579973028514715529390238010742149002155913851758307633546735996020336674926070705705764212096931632844753616592113171006246955353587595068145905958154323590951993343510p -0.3
+ 2113178124542660985409359139666066426075389304144486088511842836106695610226899437897669023550628751578697579973028514715529390238010742149002155913851758307633546735996020336674926070705705764212096931632844753616592113171006246955353587595068145905958154323590951993344000p -0.3
+ 2113178124542660985409359139666066426075389304144486088511842836106695610226899437897669023550628751578697579973028514715529390238010742149002155913851758307633546735996020336674926070705705764212096931632844753616592113171006246955353587595068145905958154323590951993344010p 0.9
+ \]
V_wl_bar_899 (WordLine_bar\\<899\\> gnd!) vsource type=pwl wave=\[
+ 0    0.9
+ 4226356249085321970818718279332132852150778608288972177023685672213391220453798875795338047101257503157395159946057029431058780476021484298004311827703516615267093471992040673349852141411411528424193863265689507233184226342012493910707175190136291811916308647181903986687500p 0.9
+ 4226356249085321970818718279332132852150778608288972177023685672213391220453798875795338047101257503157395159946057029431058780476021484298004311827703516615267093471992040673349852141411411528424193863265689507233184226342012493910707175190136291811916308647181903986687510p -0.3
+ 4226356249085321970818718279332132852150778608288972177023685672213391220453798875795338047101257503157395159946057029431058780476021484298004311827703516615267093471992040673349852141411411528424193863265689507233184226342012493910707175190136291811916308647181903986688000p -0.3
+ 4226356249085321970818718279332132852150778608288972177023685672213391220453798875795338047101257503157395159946057029431058780476021484298004311827703516615267093471992040673349852141411411528424193863265689507233184226342012493910707175190136291811916308647181903986688010p 0.9
+ \]
V_wl_bar_900 (WordLine_bar\\<900\\> gnd!) vsource type=pwl wave=\[
+ 0    0.9
+ 8452712498170643941637436558664265704301557216577944354047371344426782440907597751590676094202515006314790319892114058862117560952042968596008623655407033230534186943984081346699704282822823056848387726531379014466368452684024987821414350380272583623832617294363807973375500p 0.9
+ 8452712498170643941637436558664265704301557216577944354047371344426782440907597751590676094202515006314790319892114058862117560952042968596008623655407033230534186943984081346699704282822823056848387726531379014466368452684024987821414350380272583623832617294363807973375510p -0.3
+ 8452712498170643941637436558664265704301557216577944354047371344426782440907597751590676094202515006314790319892114058862117560952042968596008623655407033230534186943984081346699704282822823056848387726531379014466368452684024987821414350380272583623832617294363807973376000p -0.3
+ 8452712498170643941637436558664265704301557216577944354047371344426782440907597751590676094202515006314790319892114058862117560952042968596008623655407033230534186943984081346699704282822823056848387726531379014466368452684024987821414350380272583623832617294363807973376010p 0.9
+ \]
V_wl_bar_901 (WordLine_bar\\<901\\> gnd!) vsource type=pwl wave=\[
+ 0    0.9
+ 16905424996341287883274873117328531408603114433155888708094742688853564881815195503181352188405030012629580639784228117724235121904085937192017247310814066461068373887968162693399408565645646113696775453062758028932736905368049975642828700760545167247665234588727615946751500p 0.9
+ 16905424996341287883274873117328531408603114433155888708094742688853564881815195503181352188405030012629580639784228117724235121904085937192017247310814066461068373887968162693399408565645646113696775453062758028932736905368049975642828700760545167247665234588727615946751510p -0.3
+ 16905424996341287883274873117328531408603114433155888708094742688853564881815195503181352188405030012629580639784228117724235121904085937192017247310814066461068373887968162693399408565645646113696775453062758028932736905368049975642828700760545167247665234588727615946752000p -0.3
+ 16905424996341287883274873117328531408603114433155888708094742688853564881815195503181352188405030012629580639784228117724235121904085937192017247310814066461068373887968162693399408565645646113696775453062758028932736905368049975642828700760545167247665234588727615946752010p 0.9
+ \]
V_wl_bar_902 (WordLine_bar\\<902\\> gnd!) vsource type=pwl wave=\[
+ 0    0.9
+ 33810849992682575766549746234657062817206228866311777416189485377707129763630391006362704376810060025259161279568456235448470243808171874384034494621628132922136747775936325386798817131291292227393550906125516057865473810736099951285657401521090334495330469177455231893503500p 0.9
+ 33810849992682575766549746234657062817206228866311777416189485377707129763630391006362704376810060025259161279568456235448470243808171874384034494621628132922136747775936325386798817131291292227393550906125516057865473810736099951285657401521090334495330469177455231893503510p -0.3
+ 33810849992682575766549746234657062817206228866311777416189485377707129763630391006362704376810060025259161279568456235448470243808171874384034494621628132922136747775936325386798817131291292227393550906125516057865473810736099951285657401521090334495330469177455231893504000p -0.3
+ 33810849992682575766549746234657062817206228866311777416189485377707129763630391006362704376810060025259161279568456235448470243808171874384034494621628132922136747775936325386798817131291292227393550906125516057865473810736099951285657401521090334495330469177455231893504010p 0.9
+ \]
V_wl_bar_903 (WordLine_bar\\<903\\> gnd!) vsource type=pwl wave=\[
+ 0    0.9
+ 67621699985365151533099492469314125634412457732623554832378970755414259527260782012725408753620120050518322559136912470896940487616343748768068989243256265844273495551872650773597634262582584454787101812251032115730947621472199902571314803042180668990660938354910463787007500p 0.9
+ 67621699985365151533099492469314125634412457732623554832378970755414259527260782012725408753620120050518322559136912470896940487616343748768068989243256265844273495551872650773597634262582584454787101812251032115730947621472199902571314803042180668990660938354910463787007510p -0.3
+ 67621699985365151533099492469314125634412457732623554832378970755414259527260782012725408753620120050518322559136912470896940487616343748768068989243256265844273495551872650773597634262582584454787101812251032115730947621472199902571314803042180668990660938354910463787008000p -0.3
+ 67621699985365151533099492469314125634412457732623554832378970755414259527260782012725408753620120050518322559136912470896940487616343748768068989243256265844273495551872650773597634262582584454787101812251032115730947621472199902571314803042180668990660938354910463787008010p 0.9
+ \]
V_wl_bar_904 (WordLine_bar\\<904\\> gnd!) vsource type=pwl wave=\[
+ 0    0.9
+ 135243399970730303066198984938628251268824915465247109664757941510828519054521564025450817507240240101036645118273824941793880975232687497536137978486512531688546991103745301547195268525165168909574203624502064231461895242944399805142629606084361337981321876709820927574015500p 0.9
+ 135243399970730303066198984938628251268824915465247109664757941510828519054521564025450817507240240101036645118273824941793880975232687497536137978486512531688546991103745301547195268525165168909574203624502064231461895242944399805142629606084361337981321876709820927574015510p -0.3
+ 135243399970730303066198984938628251268824915465247109664757941510828519054521564025450817507240240101036645118273824941793880975232687497536137978486512531688546991103745301547195268525165168909574203624502064231461895242944399805142629606084361337981321876709820927574016000p -0.3
+ 135243399970730303066198984938628251268824915465247109664757941510828519054521564025450817507240240101036645118273824941793880975232687497536137978486512531688546991103745301547195268525165168909574203624502064231461895242944399805142629606084361337981321876709820927574016010p 0.9
+ \]
V_wl_bar_905 (WordLine_bar\\<905\\> gnd!) vsource type=pwl wave=\[
+ 0    0.9
+ 270486799941460606132397969877256502537649830930494219329515883021657038109043128050901635014480480202073290236547649883587761950465374995072275956973025063377093982207490603094390537050330337819148407249004128462923790485888799610285259212168722675962643753419641855148031500p 0.9
+ 270486799941460606132397969877256502537649830930494219329515883021657038109043128050901635014480480202073290236547649883587761950465374995072275956973025063377093982207490603094390537050330337819148407249004128462923790485888799610285259212168722675962643753419641855148031510p -0.3
+ 270486799941460606132397969877256502537649830930494219329515883021657038109043128050901635014480480202073290236547649883587761950465374995072275956973025063377093982207490603094390537050330337819148407249004128462923790485888799610285259212168722675962643753419641855148032000p -0.3
+ 270486799941460606132397969877256502537649830930494219329515883021657038109043128050901635014480480202073290236547649883587761950465374995072275956973025063377093982207490603094390537050330337819148407249004128462923790485888799610285259212168722675962643753419641855148032010p 0.9
+ \]
V_wl_bar_906 (WordLine_bar\\<906\\> gnd!) vsource type=pwl wave=\[
+ 0    0.9
+ 540973599882921212264795939754513005075299661860988438659031766043314076218086256101803270028960960404146580473095299767175523900930749990144551913946050126754187964414981206188781074100660675638296814498008256925847580971777599220570518424337445351925287506839283710296063500p 0.9
+ 540973599882921212264795939754513005075299661860988438659031766043314076218086256101803270028960960404146580473095299767175523900930749990144551913946050126754187964414981206188781074100660675638296814498008256925847580971777599220570518424337445351925287506839283710296063510p -0.3
+ 540973599882921212264795939754513005075299661860988438659031766043314076218086256101803270028960960404146580473095299767175523900930749990144551913946050126754187964414981206188781074100660675638296814498008256925847580971777599220570518424337445351925287506839283710296064000p -0.3
+ 540973599882921212264795939754513005075299661860988438659031766043314076218086256101803270028960960404146580473095299767175523900930749990144551913946050126754187964414981206188781074100660675638296814498008256925847580971777599220570518424337445351925287506839283710296064010p 0.9
+ \]
V_wl_bar_907 (WordLine_bar\\<907\\> gnd!) vsource type=pwl wave=\[
+ 0    0.9
+ 1081947199765842424529591879509026010150599323721976877318063532086628152436172512203606540057921920808293160946190599534351047801861499980289103827892100253508375928829962412377562148201321351276593628996016513851695161943555198441141036848674890703850575013678567420592127500p 0.9
+ 1081947199765842424529591879509026010150599323721976877318063532086628152436172512203606540057921920808293160946190599534351047801861499980289103827892100253508375928829962412377562148201321351276593628996016513851695161943555198441141036848674890703850575013678567420592127510p -0.3
+ 1081947199765842424529591879509026010150599323721976877318063532086628152436172512203606540057921920808293160946190599534351047801861499980289103827892100253508375928829962412377562148201321351276593628996016513851695161943555198441141036848674890703850575013678567420592128000p -0.3
+ 1081947199765842424529591879509026010150599323721976877318063532086628152436172512203606540057921920808293160946190599534351047801861499980289103827892100253508375928829962412377562148201321351276593628996016513851695161943555198441141036848674890703850575013678567420592128010p 0.9
+ \]
V_wl_bar_908 (WordLine_bar\\<908\\> gnd!) vsource type=pwl wave=\[
+ 0    0.9
+ 2163894399531684849059183759018052020301198647443953754636127064173256304872345024407213080115843841616586321892381199068702095603722999960578207655784200507016751857659924824755124296402642702553187257992033027703390323887110396882282073697349781407701150027357134841184255500p 0.9
+ 2163894399531684849059183759018052020301198647443953754636127064173256304872345024407213080115843841616586321892381199068702095603722999960578207655784200507016751857659924824755124296402642702553187257992033027703390323887110396882282073697349781407701150027357134841184255510p -0.3
+ 2163894399531684849059183759018052020301198647443953754636127064173256304872345024407213080115843841616586321892381199068702095603722999960578207655784200507016751857659924824755124296402642702553187257992033027703390323887110396882282073697349781407701150027357134841184256000p -0.3
+ 2163894399531684849059183759018052020301198647443953754636127064173256304872345024407213080115843841616586321892381199068702095603722999960578207655784200507016751857659924824755124296402642702553187257992033027703390323887110396882282073697349781407701150027357134841184256010p 0.9
+ \]
V_wl_bar_909 (WordLine_bar\\<909\\> gnd!) vsource type=pwl wave=\[
+ 0    0.9
+ 4327788799063369698118367518036104040602397294887907509272254128346512609744690048814426160231687683233172643784762398137404191207445999921156415311568401014033503715319849649510248592805285405106374515984066055406780647774220793764564147394699562815402300054714269682368511500p 0.9
+ 4327788799063369698118367518036104040602397294887907509272254128346512609744690048814426160231687683233172643784762398137404191207445999921156415311568401014033503715319849649510248592805285405106374515984066055406780647774220793764564147394699562815402300054714269682368511510p -0.3
+ 4327788799063369698118367518036104040602397294887907509272254128346512609744690048814426160231687683233172643784762398137404191207445999921156415311568401014033503715319849649510248592805285405106374515984066055406780647774220793764564147394699562815402300054714269682368512000p -0.3
+ 4327788799063369698118367518036104040602397294887907509272254128346512609744690048814426160231687683233172643784762398137404191207445999921156415311568401014033503715319849649510248592805285405106374515984066055406780647774220793764564147394699562815402300054714269682368512010p 0.9
+ \]
V_wl_bar_910 (WordLine_bar\\<910\\> gnd!) vsource type=pwl wave=\[
+ 0    0.9
+ 8655577598126739396236735036072208081204794589775815018544508256693025219489380097628852320463375366466345287569524796274808382414891999842312830623136802028067007430639699299020497185610570810212749031968132110813561295548441587529128294789399125630804600109428539364737023500p 0.9
+ 8655577598126739396236735036072208081204794589775815018544508256693025219489380097628852320463375366466345287569524796274808382414891999842312830623136802028067007430639699299020497185610570810212749031968132110813561295548441587529128294789399125630804600109428539364737023510p -0.3
+ 8655577598126739396236735036072208081204794589775815018544508256693025219489380097628852320463375366466345287569524796274808382414891999842312830623136802028067007430639699299020497185610570810212749031968132110813561295548441587529128294789399125630804600109428539364737024000p -0.3
+ 8655577598126739396236735036072208081204794589775815018544508256693025219489380097628852320463375366466345287569524796274808382414891999842312830623136802028067007430639699299020497185610570810212749031968132110813561295548441587529128294789399125630804600109428539364737024010p 0.9
+ \]
V_wl_bar_911 (WordLine_bar\\<911\\> gnd!) vsource type=pwl wave=\[
+ 0    0.9
+ 17311155196253478792473470072144416162409589179551630037089016513386050438978760195257704640926750732932690575139049592549616764829783999684625661246273604056134014861279398598040994371221141620425498063936264221627122591096883175058256589578798251261609200218857078729474047500p 0.9
+ 17311155196253478792473470072144416162409589179551630037089016513386050438978760195257704640926750732932690575139049592549616764829783999684625661246273604056134014861279398598040994371221141620425498063936264221627122591096883175058256589578798251261609200218857078729474047510p -0.3
+ 17311155196253478792473470072144416162409589179551630037089016513386050438978760195257704640926750732932690575139049592549616764829783999684625661246273604056134014861279398598040994371221141620425498063936264221627122591096883175058256589578798251261609200218857078729474048000p -0.3
+ 17311155196253478792473470072144416162409589179551630037089016513386050438978760195257704640926750732932690575139049592549616764829783999684625661246273604056134014861279398598040994371221141620425498063936264221627122591096883175058256589578798251261609200218857078729474048010p 0.9
+ \]
V_wl_bar_912 (WordLine_bar\\<912\\> gnd!) vsource type=pwl wave=\[
+ 0    0.9
+ 34622310392506957584946940144288832324819178359103260074178033026772100877957520390515409281853501465865381150278099185099233529659567999369251322492547208112268029722558797196081988742442283240850996127872528443254245182193766350116513179157596502523218400437714157458948095500p 0.9
+ 34622310392506957584946940144288832324819178359103260074178033026772100877957520390515409281853501465865381150278099185099233529659567999369251322492547208112268029722558797196081988742442283240850996127872528443254245182193766350116513179157596502523218400437714157458948095510p -0.3
+ 34622310392506957584946940144288832324819178359103260074178033026772100877957520390515409281853501465865381150278099185099233529659567999369251322492547208112268029722558797196081988742442283240850996127872528443254245182193766350116513179157596502523218400437714157458948096000p -0.3
+ 34622310392506957584946940144288832324819178359103260074178033026772100877957520390515409281853501465865381150278099185099233529659567999369251322492547208112268029722558797196081988742442283240850996127872528443254245182193766350116513179157596502523218400437714157458948096010p 0.9
+ \]
V_wl_bar_913 (WordLine_bar\\<913\\> gnd!) vsource type=pwl wave=\[
+ 0    0.9
+ 69244620785013915169893880288577664649638356718206520148356066053544201755915040781030818563707002931730762300556198370198467059319135998738502644985094416224536059445117594392163977484884566481701992255745056886508490364387532700233026358315193005046436800875428314917896191500p 0.9
+ 69244620785013915169893880288577664649638356718206520148356066053544201755915040781030818563707002931730762300556198370198467059319135998738502644985094416224536059445117594392163977484884566481701992255745056886508490364387532700233026358315193005046436800875428314917896191510p -0.3
+ 69244620785013915169893880288577664649638356718206520148356066053544201755915040781030818563707002931730762300556198370198467059319135998738502644985094416224536059445117594392163977484884566481701992255745056886508490364387532700233026358315193005046436800875428314917896192000p -0.3
+ 69244620785013915169893880288577664649638356718206520148356066053544201755915040781030818563707002931730762300556198370198467059319135998738502644985094416224536059445117594392163977484884566481701992255745056886508490364387532700233026358315193005046436800875428314917896192010p 0.9
+ \]
V_wl_bar_914 (WordLine_bar\\<914\\> gnd!) vsource type=pwl wave=\[
+ 0    0.9
+ 138489241570027830339787760577155329299276713436413040296712132107088403511830081562061637127414005863461524601112396740396934118638271997477005289970188832449072118890235188784327954969769132963403984511490113773016980728775065400466052716630386010092873601750856629835792383500p 0.9
+ 138489241570027830339787760577155329299276713436413040296712132107088403511830081562061637127414005863461524601112396740396934118638271997477005289970188832449072118890235188784327954969769132963403984511490113773016980728775065400466052716630386010092873601750856629835792383510p -0.3
+ 138489241570027830339787760577155329299276713436413040296712132107088403511830081562061637127414005863461524601112396740396934118638271997477005289970188832449072118890235188784327954969769132963403984511490113773016980728775065400466052716630386010092873601750856629835792384000p -0.3
+ 138489241570027830339787760577155329299276713436413040296712132107088403511830081562061637127414005863461524601112396740396934118638271997477005289970188832449072118890235188784327954969769132963403984511490113773016980728775065400466052716630386010092873601750856629835792384010p 0.9
+ \]
V_wl_bar_915 (WordLine_bar\\<915\\> gnd!) vsource type=pwl wave=\[
+ 0    0.9
+ 276978483140055660679575521154310658598553426872826080593424264214176807023660163124123274254828011726923049202224793480793868237276543994954010579940377664898144237780470377568655909939538265926807969022980227546033961457550130800932105433260772020185747203501713259671584767500p 0.9
+ 276978483140055660679575521154310658598553426872826080593424264214176807023660163124123274254828011726923049202224793480793868237276543994954010579940377664898144237780470377568655909939538265926807969022980227546033961457550130800932105433260772020185747203501713259671584767510p -0.3
+ 276978483140055660679575521154310658598553426872826080593424264214176807023660163124123274254828011726923049202224793480793868237276543994954010579940377664898144237780470377568655909939538265926807969022980227546033961457550130800932105433260772020185747203501713259671584768000p -0.3
+ 276978483140055660679575521154310658598553426872826080593424264214176807023660163124123274254828011726923049202224793480793868237276543994954010579940377664898144237780470377568655909939538265926807969022980227546033961457550130800932105433260772020185747203501713259671584768010p 0.9
+ \]
V_wl_bar_916 (WordLine_bar\\<916\\> gnd!) vsource type=pwl wave=\[
+ 0    0.9
+ 553956966280111321359151042308621317197106853745652161186848528428353614047320326248246548509656023453846098404449586961587736474553087989908021159880755329796288475560940755137311819879076531853615938045960455092067922915100261601864210866521544040371494407003426519343169535500p 0.9
+ 553956966280111321359151042308621317197106853745652161186848528428353614047320326248246548509656023453846098404449586961587736474553087989908021159880755329796288475560940755137311819879076531853615938045960455092067922915100261601864210866521544040371494407003426519343169535510p -0.3
+ 553956966280111321359151042308621317197106853745652161186848528428353614047320326248246548509656023453846098404449586961587736474553087989908021159880755329796288475560940755137311819879076531853615938045960455092067922915100261601864210866521544040371494407003426519343169536000p -0.3
+ 553956966280111321359151042308621317197106853745652161186848528428353614047320326248246548509656023453846098404449586961587736474553087989908021159880755329796288475560940755137311819879076531853615938045960455092067922915100261601864210866521544040371494407003426519343169536010p 0.9
+ \]
V_wl_bar_917 (WordLine_bar\\<917\\> gnd!) vsource type=pwl wave=\[
+ 0    0.9
+ 1107913932560222642718302084617242634394213707491304322373697056856707228094640652496493097019312046907692196808899173923175472949106175979816042319761510659592576951121881510274623639758153063707231876091920910184135845830200523203728421733043088080742988814006853038686339071500p 0.9
+ 1107913932560222642718302084617242634394213707491304322373697056856707228094640652496493097019312046907692196808899173923175472949106175979816042319761510659592576951121881510274623639758153063707231876091920910184135845830200523203728421733043088080742988814006853038686339071510p -0.3
+ 1107913932560222642718302084617242634394213707491304322373697056856707228094640652496493097019312046907692196808899173923175472949106175979816042319761510659592576951121881510274623639758153063707231876091920910184135845830200523203728421733043088080742988814006853038686339072000p -0.3
+ 1107913932560222642718302084617242634394213707491304322373697056856707228094640652496493097019312046907692196808899173923175472949106175979816042319761510659592576951121881510274623639758153063707231876091920910184135845830200523203728421733043088080742988814006853038686339072010p 0.9
+ \]
V_wl_bar_918 (WordLine_bar\\<918\\> gnd!) vsource type=pwl wave=\[
+ 0    0.9
+ 2215827865120445285436604169234485268788427414982608644747394113713414456189281304992986194038624093815384393617798347846350945898212351959632084639523021319185153902243763020549247279516306127414463752183841820368271691660401046407456843466086176161485977628013706077372678143500p 0.9
+ 2215827865120445285436604169234485268788427414982608644747394113713414456189281304992986194038624093815384393617798347846350945898212351959632084639523021319185153902243763020549247279516306127414463752183841820368271691660401046407456843466086176161485977628013706077372678143510p -0.3
+ 2215827865120445285436604169234485268788427414982608644747394113713414456189281304992986194038624093815384393617798347846350945898212351959632084639523021319185153902243763020549247279516306127414463752183841820368271691660401046407456843466086176161485977628013706077372678144000p -0.3
+ 2215827865120445285436604169234485268788427414982608644747394113713414456189281304992986194038624093815384393617798347846350945898212351959632084639523021319185153902243763020549247279516306127414463752183841820368271691660401046407456843466086176161485977628013706077372678144010p 0.9
+ \]
V_wl_bar_919 (WordLine_bar\\<919\\> gnd!) vsource type=pwl wave=\[
+ 0    0.9
+ 4431655730240890570873208338468970537576854829965217289494788227426828912378562609985972388077248187630768787235596695692701891796424703919264169279046042638370307804487526041098494559032612254828927504367683640736543383320802092814913686932172352322971955256027412154745356287500p 0.9
+ 4431655730240890570873208338468970537576854829965217289494788227426828912378562609985972388077248187630768787235596695692701891796424703919264169279046042638370307804487526041098494559032612254828927504367683640736543383320802092814913686932172352322971955256027412154745356287510p -0.3
+ 4431655730240890570873208338468970537576854829965217289494788227426828912378562609985972388077248187630768787235596695692701891796424703919264169279046042638370307804487526041098494559032612254828927504367683640736543383320802092814913686932172352322971955256027412154745356288000p -0.3
+ 4431655730240890570873208338468970537576854829965217289494788227426828912378562609985972388077248187630768787235596695692701891796424703919264169279046042638370307804487526041098494559032612254828927504367683640736543383320802092814913686932172352322971955256027412154745356288010p 0.9
+ \]
V_wl_bar_920 (WordLine_bar\\<920\\> gnd!) vsource type=pwl wave=\[
+ 0    0.9
+ 8863311460481781141746416676937941075153709659930434578989576454853657824757125219971944776154496375261537574471193391385403783592849407838528338558092085276740615608975052082196989118065224509657855008735367281473086766641604185629827373864344704645943910512054824309490712575500p 0.9
+ 8863311460481781141746416676937941075153709659930434578989576454853657824757125219971944776154496375261537574471193391385403783592849407838528338558092085276740615608975052082196989118065224509657855008735367281473086766641604185629827373864344704645943910512054824309490712575510p -0.3
+ 8863311460481781141746416676937941075153709659930434578989576454853657824757125219971944776154496375261537574471193391385403783592849407838528338558092085276740615608975052082196989118065224509657855008735367281473086766641604185629827373864344704645943910512054824309490712576000p -0.3
+ 8863311460481781141746416676937941075153709659930434578989576454853657824757125219971944776154496375261537574471193391385403783592849407838528338558092085276740615608975052082196989118065224509657855008735367281473086766641604185629827373864344704645943910512054824309490712576010p 0.9
+ \]
V_wl_bar_921 (WordLine_bar\\<921\\> gnd!) vsource type=pwl wave=\[
+ 0    0.9
+ 17726622920963562283492833353875882150307419319860869157979152909707315649514250439943889552308992750523075148942386782770807567185698815677056677116184170553481231217950104164393978236130449019315710017470734562946173533283208371259654747728689409291887821024109648618981425151500p 0.9
+ 17726622920963562283492833353875882150307419319860869157979152909707315649514250439943889552308992750523075148942386782770807567185698815677056677116184170553481231217950104164393978236130449019315710017470734562946173533283208371259654747728689409291887821024109648618981425151510p -0.3
+ 17726622920963562283492833353875882150307419319860869157979152909707315649514250439943889552308992750523075148942386782770807567185698815677056677116184170553481231217950104164393978236130449019315710017470734562946173533283208371259654747728689409291887821024109648618981425152000p -0.3
+ 17726622920963562283492833353875882150307419319860869157979152909707315649514250439943889552308992750523075148942386782770807567185698815677056677116184170553481231217950104164393978236130449019315710017470734562946173533283208371259654747728689409291887821024109648618981425152010p 0.9
+ \]
V_wl_bar_922 (WordLine_bar\\<922\\> gnd!) vsource type=pwl wave=\[
+ 0    0.9
+ 35453245841927124566985666707751764300614838639721738315958305819414631299028500879887779104617985501046150297884773565541615134371397631354113354232368341106962462435900208328787956472260898038631420034941469125892347066566416742519309495457378818583775642048219297237962850303500p 0.9
+ 35453245841927124566985666707751764300614838639721738315958305819414631299028500879887779104617985501046150297884773565541615134371397631354113354232368341106962462435900208328787956472260898038631420034941469125892347066566416742519309495457378818583775642048219297237962850303510p -0.3
+ 35453245841927124566985666707751764300614838639721738315958305819414631299028500879887779104617985501046150297884773565541615134371397631354113354232368341106962462435900208328787956472260898038631420034941469125892347066566416742519309495457378818583775642048219297237962850304000p -0.3
+ 35453245841927124566985666707751764300614838639721738315958305819414631299028500879887779104617985501046150297884773565541615134371397631354113354232368341106962462435900208328787956472260898038631420034941469125892347066566416742519309495457378818583775642048219297237962850304010p 0.9
+ \]
V_wl_bar_923 (WordLine_bar\\<923\\> gnd!) vsource type=pwl wave=\[
+ 0    0.9
+ 70906491683854249133971333415503528601229677279443476631916611638829262598057001759775558209235971002092300595769547131083230268742795262708226708464736682213924924871800416657575912944521796077262840069882938251784694133132833485038618990914757637167551284096438594475925700607500p 0.9
+ 70906491683854249133971333415503528601229677279443476631916611638829262598057001759775558209235971002092300595769547131083230268742795262708226708464736682213924924871800416657575912944521796077262840069882938251784694133132833485038618990914757637167551284096438594475925700607510p -0.3
+ 70906491683854249133971333415503528601229677279443476631916611638829262598057001759775558209235971002092300595769547131083230268742795262708226708464736682213924924871800416657575912944521796077262840069882938251784694133132833485038618990914757637167551284096438594475925700608000p -0.3
+ 70906491683854249133971333415503528601229677279443476631916611638829262598057001759775558209235971002092300595769547131083230268742795262708226708464736682213924924871800416657575912944521796077262840069882938251784694133132833485038618990914757637167551284096438594475925700608010p 0.9
+ \]
V_wl_bar_924 (WordLine_bar\\<924\\> gnd!) vsource type=pwl wave=\[
+ 0    0.9
+ 141812983367708498267942666831007057202459354558886953263833223277658525196114003519551116418471942004184601191539094262166460537485590525416453416929473364427849849743600833315151825889043592154525680139765876503569388266265666970077237981829515274335102568192877188951851401215500p 0.9
+ 141812983367708498267942666831007057202459354558886953263833223277658525196114003519551116418471942004184601191539094262166460537485590525416453416929473364427849849743600833315151825889043592154525680139765876503569388266265666970077237981829515274335102568192877188951851401215510p -0.3
+ 141812983367708498267942666831007057202459354558886953263833223277658525196114003519551116418471942004184601191539094262166460537485590525416453416929473364427849849743600833315151825889043592154525680139765876503569388266265666970077237981829515274335102568192877188951851401216000p -0.3
+ 141812983367708498267942666831007057202459354558886953263833223277658525196114003519551116418471942004184601191539094262166460537485590525416453416929473364427849849743600833315151825889043592154525680139765876503569388266265666970077237981829515274335102568192877188951851401216010p 0.9
+ \]
V_wl_bar_925 (WordLine_bar\\<925\\> gnd!) vsource type=pwl wave=\[
+ 0    0.9
+ 283625966735416996535885333662014114404918709117773906527666446555317050392228007039102232836943884008369202383078188524332921074971181050832906833858946728855699699487201666630303651778087184309051360279531753007138776532531333940154475963659030548670205136385754377903702802431500p 0.9
+ 283625966735416996535885333662014114404918709117773906527666446555317050392228007039102232836943884008369202383078188524332921074971181050832906833858946728855699699487201666630303651778087184309051360279531753007138776532531333940154475963659030548670205136385754377903702802431510p -0.3
+ 283625966735416996535885333662014114404918709117773906527666446555317050392228007039102232836943884008369202383078188524332921074971181050832906833858946728855699699487201666630303651778087184309051360279531753007138776532531333940154475963659030548670205136385754377903702802432000p -0.3
+ 283625966735416996535885333662014114404918709117773906527666446555317050392228007039102232836943884008369202383078188524332921074971181050832906833858946728855699699487201666630303651778087184309051360279531753007138776532531333940154475963659030548670205136385754377903702802432010p 0.9
+ \]
V_wl_bar_926 (WordLine_bar\\<926\\> gnd!) vsource type=pwl wave=\[
+ 0    0.9
+ 567251933470833993071770667324028228809837418235547813055332893110634100784456014078204465673887768016738404766156377048665842149942362101665813667717893457711399398974403333260607303556174368618102720559063506014277553065062667880308951927318061097340410272771508755807405604863500p 0.9
+ 567251933470833993071770667324028228809837418235547813055332893110634100784456014078204465673887768016738404766156377048665842149942362101665813667717893457711399398974403333260607303556174368618102720559063506014277553065062667880308951927318061097340410272771508755807405604863510p -0.3
+ 567251933470833993071770667324028228809837418235547813055332893110634100784456014078204465673887768016738404766156377048665842149942362101665813667717893457711399398974403333260607303556174368618102720559063506014277553065062667880308951927318061097340410272771508755807405604864000p -0.3
+ 567251933470833993071770667324028228809837418235547813055332893110634100784456014078204465673887768016738404766156377048665842149942362101665813667717893457711399398974403333260607303556174368618102720559063506014277553065062667880308951927318061097340410272771508755807405604864010p 0.9
+ \]
V_wl_bar_927 (WordLine_bar\\<927\\> gnd!) vsource type=pwl wave=\[
+ 0    0.9
+ 1134503866941667986143541334648056457619674836471095626110665786221268201568912028156408931347775536033476809532312754097331684299884724203331627335435786915422798797948806666521214607112348737236205441118127012028555106130125335760617903854636122194680820545543017511614811209727500p 0.9
+ 1134503866941667986143541334648056457619674836471095626110665786221268201568912028156408931347775536033476809532312754097331684299884724203331627335435786915422798797948806666521214607112348737236205441118127012028555106130125335760617903854636122194680820545543017511614811209727510p -0.3
+ 1134503866941667986143541334648056457619674836471095626110665786221268201568912028156408931347775536033476809532312754097331684299884724203331627335435786915422798797948806666521214607112348737236205441118127012028555106130125335760617903854636122194680820545543017511614811209728000p -0.3
+ 1134503866941667986143541334648056457619674836471095626110665786221268201568912028156408931347775536033476809532312754097331684299884724203331627335435786915422798797948806666521214607112348737236205441118127012028555106130125335760617903854636122194680820545543017511614811209728010p 0.9
+ \]
V_wl_bar_928 (WordLine_bar\\<928\\> gnd!) vsource type=pwl wave=\[
+ 0    0.9
+ 2269007733883335972287082669296112915239349672942191252221331572442536403137824056312817862695551072066953619064625508194663368599769448406663254670871573830845597595897613333042429214224697474472410882236254024057110212260250671521235807709272244389361641091086035023229622419455500p 0.9
+ 2269007733883335972287082669296112915239349672942191252221331572442536403137824056312817862695551072066953619064625508194663368599769448406663254670871573830845597595897613333042429214224697474472410882236254024057110212260250671521235807709272244389361641091086035023229622419455510p -0.3
+ 2269007733883335972287082669296112915239349672942191252221331572442536403137824056312817862695551072066953619064625508194663368599769448406663254670871573830845597595897613333042429214224697474472410882236254024057110212260250671521235807709272244389361641091086035023229622419456000p -0.3
+ 2269007733883335972287082669296112915239349672942191252221331572442536403137824056312817862695551072066953619064625508194663368599769448406663254670871573830845597595897613333042429214224697474472410882236254024057110212260250671521235807709272244389361641091086035023229622419456010p 0.9
+ \]
V_wl_bar_929 (WordLine_bar\\<929\\> gnd!) vsource type=pwl wave=\[
+ 0    0.9
+ 4538015467766671944574165338592225830478699345884382504442663144885072806275648112625635725391102144133907238129251016389326737199538896813326509341743147661691195191795226666084858428449394948944821764472508048114220424520501343042471615418544488778723282182172070046459244838911500p 0.9
+ 4538015467766671944574165338592225830478699345884382504442663144885072806275648112625635725391102144133907238129251016389326737199538896813326509341743147661691195191795226666084858428449394948944821764472508048114220424520501343042471615418544488778723282182172070046459244838911510p -0.3
+ 4538015467766671944574165338592225830478699345884382504442663144885072806275648112625635725391102144133907238129251016389326737199538896813326509341743147661691195191795226666084858428449394948944821764472508048114220424520501343042471615418544488778723282182172070046459244838912000p -0.3
+ 4538015467766671944574165338592225830478699345884382504442663144885072806275648112625635725391102144133907238129251016389326737199538896813326509341743147661691195191795226666084858428449394948944821764472508048114220424520501343042471615418544488778723282182172070046459244838912010p 0.9
+ \]
V_wl_bar_930 (WordLine_bar\\<930\\> gnd!) vsource type=pwl wave=\[
+ 0    0.9
+ 9076030935533343889148330677184451660957398691768765008885326289770145612551296225251271450782204288267814476258502032778653474399077793626653018683486295323382390383590453332169716856898789897889643528945016096228440849041002686084943230837088977557446564364344140092918489677823500p 0.9
+ 9076030935533343889148330677184451660957398691768765008885326289770145612551296225251271450782204288267814476258502032778653474399077793626653018683486295323382390383590453332169716856898789897889643528945016096228440849041002686084943230837088977557446564364344140092918489677823510p -0.3
+ 9076030935533343889148330677184451660957398691768765008885326289770145612551296225251271450782204288267814476258502032778653474399077793626653018683486295323382390383590453332169716856898789897889643528945016096228440849041002686084943230837088977557446564364344140092918489677824000p -0.3
+ 9076030935533343889148330677184451660957398691768765008885326289770145612551296225251271450782204288267814476258502032778653474399077793626653018683486295323382390383590453332169716856898789897889643528945016096228440849041002686084943230837088977557446564364344140092918489677824010p 0.9
+ \]
V_wl_bar_931 (WordLine_bar\\<931\\> gnd!) vsource type=pwl wave=\[
+ 0    0.9
+ 18152061871066687778296661354368903321914797383537530017770652579540291225102592450502542901564408576535628952517004065557306948798155587253306037366972590646764780767180906664339433713797579795779287057890032192456881698082005372169886461674177955114893128728688280185836979355647500p 0.9
+ 18152061871066687778296661354368903321914797383537530017770652579540291225102592450502542901564408576535628952517004065557306948798155587253306037366972590646764780767180906664339433713797579795779287057890032192456881698082005372169886461674177955114893128728688280185836979355647510p -0.3
+ 18152061871066687778296661354368903321914797383537530017770652579540291225102592450502542901564408576535628952517004065557306948798155587253306037366972590646764780767180906664339433713797579795779287057890032192456881698082005372169886461674177955114893128728688280185836979355648000p -0.3
+ 18152061871066687778296661354368903321914797383537530017770652579540291225102592450502542901564408576535628952517004065557306948798155587253306037366972590646764780767180906664339433713797579795779287057890032192456881698082005372169886461674177955114893128728688280185836979355648010p 0.9
+ \]
V_wl_bar_932 (WordLine_bar\\<932\\> gnd!) vsource type=pwl wave=\[
+ 0    0.9
+ 36304123742133375556593322708737806643829594767075060035541305159080582450205184901005085803128817153071257905034008131114613897596311174506612074733945181293529561534361813328678867427595159591558574115780064384913763396164010744339772923348355910229786257457376560371673958711295500p 0.9
+ 36304123742133375556593322708737806643829594767075060035541305159080582450205184901005085803128817153071257905034008131114613897596311174506612074733945181293529561534361813328678867427595159591558574115780064384913763396164010744339772923348355910229786257457376560371673958711295510p -0.3
+ 36304123742133375556593322708737806643829594767075060035541305159080582450205184901005085803128817153071257905034008131114613897596311174506612074733945181293529561534361813328678867427595159591558574115780064384913763396164010744339772923348355910229786257457376560371673958711296000p -0.3
+ 36304123742133375556593322708737806643829594767075060035541305159080582450205184901005085803128817153071257905034008131114613897596311174506612074733945181293529561534361813328678867427595159591558574115780064384913763396164010744339772923348355910229786257457376560371673958711296010p 0.9
+ \]
V_wl_bar_933 (WordLine_bar\\<933\\> gnd!) vsource type=pwl wave=\[
+ 0    0.9
+ 72608247484266751113186645417475613287659189534150120071082610318161164900410369802010171606257634306142515810068016262229227795192622349013224149467890362587059123068723626657357734855190319183117148231560128769827526792328021488679545846696711820459572514914753120743347917422591500p 0.9
+ 72608247484266751113186645417475613287659189534150120071082610318161164900410369802010171606257634306142515810068016262229227795192622349013224149467890362587059123068723626657357734855190319183117148231560128769827526792328021488679545846696711820459572514914753120743347917422591510p -0.3
+ 72608247484266751113186645417475613287659189534150120071082610318161164900410369802010171606257634306142515810068016262229227795192622349013224149467890362587059123068723626657357734855190319183117148231560128769827526792328021488679545846696711820459572514914753120743347917422592000p -0.3
+ 72608247484266751113186645417475613287659189534150120071082610318161164900410369802010171606257634306142515810068016262229227795192622349013224149467890362587059123068723626657357734855190319183117148231560128769827526792328021488679545846696711820459572514914753120743347917422592010p 0.9
+ \]
V_wl_bar_934 (WordLine_bar\\<934\\> gnd!) vsource type=pwl wave=\[
+ 0    0.9
+ 145216494968533502226373290834951226575318379068300240142165220636322329800820739604020343212515268612285031620136032524458455590385244698026448298935780725174118246137447253314715469710380638366234296463120257539655053584656042977359091693393423640919145029829506241486695834845183500p 0.9
+ 145216494968533502226373290834951226575318379068300240142165220636322329800820739604020343212515268612285031620136032524458455590385244698026448298935780725174118246137447253314715469710380638366234296463120257539655053584656042977359091693393423640919145029829506241486695834845183510p -0.3
+ 145216494968533502226373290834951226575318379068300240142165220636322329800820739604020343212515268612285031620136032524458455590385244698026448298935780725174118246137447253314715469710380638366234296463120257539655053584656042977359091693393423640919145029829506241486695834845184000p -0.3
+ 145216494968533502226373290834951226575318379068300240142165220636322329800820739604020343212515268612285031620136032524458455590385244698026448298935780725174118246137447253314715469710380638366234296463120257539655053584656042977359091693393423640919145029829506241486695834845184010p 0.9
+ \]
V_wl_bar_935 (WordLine_bar\\<935\\> gnd!) vsource type=pwl wave=\[
+ 0    0.9
+ 290432989937067004452746581669902453150636758136600480284330441272644659601641479208040686425030537224570063240272065048916911180770489396052896597871561450348236492274894506629430939420761276732468592926240515079310107169312085954718183386786847281838290059659012482973391669690367500p 0.9
+ 290432989937067004452746581669902453150636758136600480284330441272644659601641479208040686425030537224570063240272065048916911180770489396052896597871561450348236492274894506629430939420761276732468592926240515079310107169312085954718183386786847281838290059659012482973391669690367510p -0.3
+ 290432989937067004452746581669902453150636758136600480284330441272644659601641479208040686425030537224570063240272065048916911180770489396052896597871561450348236492274894506629430939420761276732468592926240515079310107169312085954718183386786847281838290059659012482973391669690368000p -0.3
+ 290432989937067004452746581669902453150636758136600480284330441272644659601641479208040686425030537224570063240272065048916911180770489396052896597871561450348236492274894506629430939420761276732468592926240515079310107169312085954718183386786847281838290059659012482973391669690368010p 0.9
+ \]
V_wl_bar_936 (WordLine_bar\\<936\\> gnd!) vsource type=pwl wave=\[
+ 0    0.9
+ 580865979874134008905493163339804906301273516273200960568660882545289319203282958416081372850061074449140126480544130097833822361540978792105793195743122900696472984549789013258861878841522553464937185852481030158620214338624171909436366773573694563676580119318024965946783339380735500p 0.9
+ 580865979874134008905493163339804906301273516273200960568660882545289319203282958416081372850061074449140126480544130097833822361540978792105793195743122900696472984549789013258861878841522553464937185852481030158620214338624171909436366773573694563676580119318024965946783339380735510p -0.3
+ 580865979874134008905493163339804906301273516273200960568660882545289319203282958416081372850061074449140126480544130097833822361540978792105793195743122900696472984549789013258861878841522553464937185852481030158620214338624171909436366773573694563676580119318024965946783339380736000p -0.3
+ 580865979874134008905493163339804906301273516273200960568660882545289319203282958416081372850061074449140126480544130097833822361540978792105793195743122900696472984549789013258861878841522553464937185852481030158620214338624171909436366773573694563676580119318024965946783339380736010p 0.9
+ \]
V_wl_bar_937 (WordLine_bar\\<937\\> gnd!) vsource type=pwl wave=\[
+ 0    0.9
+ 1161731959748268017810986326679609812602547032546401921137321765090578638406565916832162745700122148898280252961088260195667644723081957584211586391486245801392945969099578026517723757683045106929874371704962060317240428677248343818872733547147389127353160238636049931893566678761471500p 0.9
+ 1161731959748268017810986326679609812602547032546401921137321765090578638406565916832162745700122148898280252961088260195667644723081957584211586391486245801392945969099578026517723757683045106929874371704962060317240428677248343818872733547147389127353160238636049931893566678761471510p -0.3
+ 1161731959748268017810986326679609812602547032546401921137321765090578638406565916832162745700122148898280252961088260195667644723081957584211586391486245801392945969099578026517723757683045106929874371704962060317240428677248343818872733547147389127353160238636049931893566678761472000p -0.3
+ 1161731959748268017810986326679609812602547032546401921137321765090578638406565916832162745700122148898280252961088260195667644723081957584211586391486245801392945969099578026517723757683045106929874371704962060317240428677248343818872733547147389127353160238636049931893566678761472010p 0.9
+ \]
V_wl_bar_938 (WordLine_bar\\<938\\> gnd!) vsource type=pwl wave=\[
+ 0    0.9
+ 2323463919496536035621972653359219625205094065092803842274643530181157276813131833664325491400244297796560505922176520391335289446163915168423172782972491602785891938199156053035447515366090213859748743409924120634480857354496687637745467094294778254706320477272099863787133357522943500p 0.9
+ 2323463919496536035621972653359219625205094065092803842274643530181157276813131833664325491400244297796560505922176520391335289446163915168423172782972491602785891938199156053035447515366090213859748743409924120634480857354496687637745467094294778254706320477272099863787133357522943510p -0.3
+ 2323463919496536035621972653359219625205094065092803842274643530181157276813131833664325491400244297796560505922176520391335289446163915168423172782972491602785891938199156053035447515366090213859748743409924120634480857354496687637745467094294778254706320477272099863787133357522944000p -0.3
+ 2323463919496536035621972653359219625205094065092803842274643530181157276813131833664325491400244297796560505922176520391335289446163915168423172782972491602785891938199156053035447515366090213859748743409924120634480857354496687637745467094294778254706320477272099863787133357522944010p 0.9
+ \]
V_wl_bar_939 (WordLine_bar\\<939\\> gnd!) vsource type=pwl wave=\[
+ 0    0.9
+ 4646927838993072071243945306718439250410188130185607684549287060362314553626263667328650982800488595593121011844353040782670578892327830336846345565944983205571783876398312106070895030732180427719497486819848241268961714708993375275490934188589556509412640954544199727574266715045887500p 0.9
+ 4646927838993072071243945306718439250410188130185607684549287060362314553626263667328650982800488595593121011844353040782670578892327830336846345565944983205571783876398312106070895030732180427719497486819848241268961714708993375275490934188589556509412640954544199727574266715045887510p -0.3
+ 4646927838993072071243945306718439250410188130185607684549287060362314553626263667328650982800488595593121011844353040782670578892327830336846345565944983205571783876398312106070895030732180427719497486819848241268961714708993375275490934188589556509412640954544199727574266715045888000p -0.3
+ 4646927838993072071243945306718439250410188130185607684549287060362314553626263667328650982800488595593121011844353040782670578892327830336846345565944983205571783876398312106070895030732180427719497486819848241268961714708993375275490934188589556509412640954544199727574266715045888010p 0.9
+ \]
V_wl_bar_940 (WordLine_bar\\<940\\> gnd!) vsource type=pwl wave=\[
+ 0    0.9
+ 9293855677986144142487890613436878500820376260371215369098574120724629107252527334657301965600977191186242023688706081565341157784655660673692691131889966411143567752796624212141790061464360855438994973639696482537923429417986750550981868377179113018825281909088399455148533430091775500p 0.9
+ 9293855677986144142487890613436878500820376260371215369098574120724629107252527334657301965600977191186242023688706081565341157784655660673692691131889966411143567752796624212141790061464360855438994973639696482537923429417986750550981868377179113018825281909088399455148533430091775510p -0.3
+ 9293855677986144142487890613436878500820376260371215369098574120724629107252527334657301965600977191186242023688706081565341157784655660673692691131889966411143567752796624212141790061464360855438994973639696482537923429417986750550981868377179113018825281909088399455148533430091776000p -0.3
+ 9293855677986144142487890613436878500820376260371215369098574120724629107252527334657301965600977191186242023688706081565341157784655660673692691131889966411143567752796624212141790061464360855438994973639696482537923429417986750550981868377179113018825281909088399455148533430091776010p 0.9
+ \]
V_wl_bar_941 (WordLine_bar\\<941\\> gnd!) vsource type=pwl wave=\[
+ 0    0.9
+ 18587711355972288284975781226873757001640752520742430738197148241449258214505054669314603931201954382372484047377412163130682315569311321347385382263779932822287135505593248424283580122928721710877989947279392965075846858835973501101963736754358226037650563818176798910297066860183551500p 0.9
+ 18587711355972288284975781226873757001640752520742430738197148241449258214505054669314603931201954382372484047377412163130682315569311321347385382263779932822287135505593248424283580122928721710877989947279392965075846858835973501101963736754358226037650563818176798910297066860183551510p -0.3
+ 18587711355972288284975781226873757001640752520742430738197148241449258214505054669314603931201954382372484047377412163130682315569311321347385382263779932822287135505593248424283580122928721710877989947279392965075846858835973501101963736754358226037650563818176798910297066860183552000p -0.3
+ 18587711355972288284975781226873757001640752520742430738197148241449258214505054669314603931201954382372484047377412163130682315569311321347385382263779932822287135505593248424283580122928721710877989947279392965075846858835973501101963736754358226037650563818176798910297066860183552010p 0.9
+ \]
V_wl_bar_942 (WordLine_bar\\<942\\> gnd!) vsource type=pwl wave=\[
+ 0    0.9
+ 37175422711944576569951562453747514003281505041484861476394296482898516429010109338629207862403908764744968094754824326261364631138622642694770764527559865644574271011186496848567160245857443421755979894558785930151693717671947002203927473508716452075301127636353597820594133720367103500p 0.9
+ 37175422711944576569951562453747514003281505041484861476394296482898516429010109338629207862403908764744968094754824326261364631138622642694770764527559865644574271011186496848567160245857443421755979894558785930151693717671947002203927473508716452075301127636353597820594133720367103510p -0.3
+ 37175422711944576569951562453747514003281505041484861476394296482898516429010109338629207862403908764744968094754824326261364631138622642694770764527559865644574271011186496848567160245857443421755979894558785930151693717671947002203927473508716452075301127636353597820594133720367104000p -0.3
+ 37175422711944576569951562453747514003281505041484861476394296482898516429010109338629207862403908764744968094754824326261364631138622642694770764527559865644574271011186496848567160245857443421755979894558785930151693717671947002203927473508716452075301127636353597820594133720367104010p 0.9
+ \]
V_wl_bar_943 (WordLine_bar\\<943\\> gnd!) vsource type=pwl wave=\[
+ 0    0.9
+ 74350845423889153139903124907495028006563010082969722952788592965797032858020218677258415724807817529489936189509648652522729262277245285389541529055119731289148542022372993697134320491714886843511959789117571860303387435343894004407854947017432904150602255272707195641188267440734207500p 0.9
+ 74350845423889153139903124907495028006563010082969722952788592965797032858020218677258415724807817529489936189509648652522729262277245285389541529055119731289148542022372993697134320491714886843511959789117571860303387435343894004407854947017432904150602255272707195641188267440734207510p -0.3
+ 74350845423889153139903124907495028006563010082969722952788592965797032858020218677258415724807817529489936189509648652522729262277245285389541529055119731289148542022372993697134320491714886843511959789117571860303387435343894004407854947017432904150602255272707195641188267440734208000p -0.3
+ 74350845423889153139903124907495028006563010082969722952788592965797032858020218677258415724807817529489936189509648652522729262277245285389541529055119731289148542022372993697134320491714886843511959789117571860303387435343894004407854947017432904150602255272707195641188267440734208010p 0.9
+ \]
V_wl_bar_944 (WordLine_bar\\<944\\> gnd!) vsource type=pwl wave=\[
+ 0    0.9
+ 148701690847778306279806249814990056013126020165939445905577185931594065716040437354516831449615635058979872379019297305045458524554490570779083058110239462578297084044745987394268640983429773687023919578235143720606774870687788008815709894034865808301204510545414391282376534881468415500p 0.9
+ 148701690847778306279806249814990056013126020165939445905577185931594065716040437354516831449615635058979872379019297305045458524554490570779083058110239462578297084044745987394268640983429773687023919578235143720606774870687788008815709894034865808301204510545414391282376534881468415510p -0.3
+ 148701690847778306279806249814990056013126020165939445905577185931594065716040437354516831449615635058979872379019297305045458524554490570779083058110239462578297084044745987394268640983429773687023919578235143720606774870687788008815709894034865808301204510545414391282376534881468416000p -0.3
+ 148701690847778306279806249814990056013126020165939445905577185931594065716040437354516831449615635058979872379019297305045458524554490570779083058110239462578297084044745987394268640983429773687023919578235143720606774870687788008815709894034865808301204510545414391282376534881468416010p 0.9
+ \]
V_wl_bar_945 (WordLine_bar\\<945\\> gnd!) vsource type=pwl wave=\[
+ 0    0.9
+ 297403381695556612559612499629980112026252040331878891811154371863188131432080874709033662899231270117959744758038594610090917049108981141558166116220478925156594168089491974788537281966859547374047839156470287441213549741375576017631419788069731616602409021090828782564753069762936831500p 0.9
+ 297403381695556612559612499629980112026252040331878891811154371863188131432080874709033662899231270117959744758038594610090917049108981141558166116220478925156594168089491974788537281966859547374047839156470287441213549741375576017631419788069731616602409021090828782564753069762936831510p -0.3
+ 297403381695556612559612499629980112026252040331878891811154371863188131432080874709033662899231270117959744758038594610090917049108981141558166116220478925156594168089491974788537281966859547374047839156470287441213549741375576017631419788069731616602409021090828782564753069762936832000p -0.3
+ 297403381695556612559612499629980112026252040331878891811154371863188131432080874709033662899231270117959744758038594610090917049108981141558166116220478925156594168089491974788537281966859547374047839156470287441213549741375576017631419788069731616602409021090828782564753069762936832010p 0.9
+ \]
V_wl_bar_946 (WordLine_bar\\<946\\> gnd!) vsource type=pwl wave=\[
+ 0    0.9
+ 594806763391113225119224999259960224052504080663757783622308743726376262864161749418067325798462540235919489516077189220181834098217962283116332232440957850313188336178983949577074563933719094748095678312940574882427099482751152035262839576139463233204818042181657565129506139525873663500p 0.9
+ 594806763391113225119224999259960224052504080663757783622308743726376262864161749418067325798462540235919489516077189220181834098217962283116332232440957850313188336178983949577074563933719094748095678312940574882427099482751152035262839576139463233204818042181657565129506139525873663510p -0.3
+ 594806763391113225119224999259960224052504080663757783622308743726376262864161749418067325798462540235919489516077189220181834098217962283116332232440957850313188336178983949577074563933719094748095678312940574882427099482751152035262839576139463233204818042181657565129506139525873664000p -0.3
+ 594806763391113225119224999259960224052504080663757783622308743726376262864161749418067325798462540235919489516077189220181834098217962283116332232440957850313188336178983949577074563933719094748095678312940574882427099482751152035262839576139463233204818042181657565129506139525873664010p 0.9
+ \]
V_wl_bar_947 (WordLine_bar\\<947\\> gnd!) vsource type=pwl wave=\[
+ 0    0.9
+ 1189613526782226450238449998519920448105008161327515567244617487452752525728323498836134651596925080471838979032154378440363668196435924566232664464881915700626376672357967899154149127867438189496191356625881149764854198965502304070525679152278926466409636084363315130259012279051747327500p 0.9
+ 1189613526782226450238449998519920448105008161327515567244617487452752525728323498836134651596925080471838979032154378440363668196435924566232664464881915700626376672357967899154149127867438189496191356625881149764854198965502304070525679152278926466409636084363315130259012279051747327510p -0.3
+ 1189613526782226450238449998519920448105008161327515567244617487452752525728323498836134651596925080471838979032154378440363668196435924566232664464881915700626376672357967899154149127867438189496191356625881149764854198965502304070525679152278926466409636084363315130259012279051747328000p -0.3
+ 1189613526782226450238449998519920448105008161327515567244617487452752525728323498836134651596925080471838979032154378440363668196435924566232664464881915700626376672357967899154149127867438189496191356625881149764854198965502304070525679152278926466409636084363315130259012279051747328010p 0.9
+ \]
V_wl_bar_948 (WordLine_bar\\<948\\> gnd!) vsource type=pwl wave=\[
+ 0    0.9
+ 2379227053564452900476899997039840896210016322655031134489234974905505051456646997672269303193850160943677958064308756880727336392871849132465328929763831401252753344715935798308298255734876378992382713251762299529708397931004608141051358304557852932819272168726630260518024558103494655500p 0.9
+ 2379227053564452900476899997039840896210016322655031134489234974905505051456646997672269303193850160943677958064308756880727336392871849132465328929763831401252753344715935798308298255734876378992382713251762299529708397931004608141051358304557852932819272168726630260518024558103494655510p -0.3
+ 2379227053564452900476899997039840896210016322655031134489234974905505051456646997672269303193850160943677958064308756880727336392871849132465328929763831401252753344715935798308298255734876378992382713251762299529708397931004608141051358304557852932819272168726630260518024558103494656000p -0.3
+ 2379227053564452900476899997039840896210016322655031134489234974905505051456646997672269303193850160943677958064308756880727336392871849132465328929763831401252753344715935798308298255734876378992382713251762299529708397931004608141051358304557852932819272168726630260518024558103494656010p 0.9
+ \]
V_wl_bar_949 (WordLine_bar\\<949\\> gnd!) vsource type=pwl wave=\[
+ 0    0.9
+ 4758454107128905800953799994079681792420032645310062268978469949811010102913293995344538606387700321887355916128617513761454672785743698264930657859527662802505506689431871596616596511469752757984765426503524599059416795862009216282102716609115705865638544337453260521036049116206989311500p 0.9
+ 4758454107128905800953799994079681792420032645310062268978469949811010102913293995344538606387700321887355916128617513761454672785743698264930657859527662802505506689431871596616596511469752757984765426503524599059416795862009216282102716609115705865638544337453260521036049116206989311510p -0.3
+ 4758454107128905800953799994079681792420032645310062268978469949811010102913293995344538606387700321887355916128617513761454672785743698264930657859527662802505506689431871596616596511469752757984765426503524599059416795862009216282102716609115705865638544337453260521036049116206989312000p -0.3
+ 4758454107128905800953799994079681792420032645310062268978469949811010102913293995344538606387700321887355916128617513761454672785743698264930657859527662802505506689431871596616596511469752757984765426503524599059416795862009216282102716609115705865638544337453260521036049116206989312010p 0.9
+ \]
V_wl_bar_950 (WordLine_bar\\<950\\> gnd!) vsource type=pwl wave=\[
+ 0    0.9
+ 9516908214257811601907599988159363584840065290620124537956939899622020205826587990689077212775400643774711832257235027522909345571487396529861315719055325605011013378863743193233193022939505515969530853007049198118833591724018432564205433218231411731277088674906521042072098232413978623500p 0.9
+ 9516908214257811601907599988159363584840065290620124537956939899622020205826587990689077212775400643774711832257235027522909345571487396529861315719055325605011013378863743193233193022939505515969530853007049198118833591724018432564205433218231411731277088674906521042072098232413978623510p -0.3
+ 9516908214257811601907599988159363584840065290620124537956939899622020205826587990689077212775400643774711832257235027522909345571487396529861315719055325605011013378863743193233193022939505515969530853007049198118833591724018432564205433218231411731277088674906521042072098232413978624000p -0.3
+ 9516908214257811601907599988159363584840065290620124537956939899622020205826587990689077212775400643774711832257235027522909345571487396529861315719055325605011013378863743193233193022939505515969530853007049198118833591724018432564205433218231411731277088674906521042072098232413978624010p 0.9
+ \]
V_wl_bar_951 (WordLine_bar\\<951\\> gnd!) vsource type=pwl wave=\[
+ 0    0.9
+ 19033816428515623203815199976318727169680130581240249075913879799244040411653175981378154425550801287549423664514470055045818691142974793059722631438110651210022026757727486386466386045879011031939061706014098396237667183448036865128410866436462823462554177349813042084144196464827957247500p 0.9
+ 19033816428515623203815199976318727169680130581240249075913879799244040411653175981378154425550801287549423664514470055045818691142974793059722631438110651210022026757727486386466386045879011031939061706014098396237667183448036865128410866436462823462554177349813042084144196464827957247510p -0.3
+ 19033816428515623203815199976318727169680130581240249075913879799244040411653175981378154425550801287549423664514470055045818691142974793059722631438110651210022026757727486386466386045879011031939061706014098396237667183448036865128410866436462823462554177349813042084144196464827957248000p -0.3
+ 19033816428515623203815199976318727169680130581240249075913879799244040411653175981378154425550801287549423664514470055045818691142974793059722631438110651210022026757727486386466386045879011031939061706014098396237667183448036865128410866436462823462554177349813042084144196464827957248010p 0.9
+ \]
V_wl_bar_952 (WordLine_bar\\<952\\> gnd!) vsource type=pwl wave=\[
+ 0    0.9
+ 38067632857031246407630399952637454339360261162480498151827759598488080823306351962756308851101602575098847329028940110091637382285949586119445262876221302420044053515454972772932772091758022063878123412028196792475334366896073730256821732872925646925108354699626084168288392929655914495500p 0.9
+ 38067632857031246407630399952637454339360261162480498151827759598488080823306351962756308851101602575098847329028940110091637382285949586119445262876221302420044053515454972772932772091758022063878123412028196792475334366896073730256821732872925646925108354699626084168288392929655914495510p -0.3
+ 38067632857031246407630399952637454339360261162480498151827759598488080823306351962756308851101602575098847329028940110091637382285949586119445262876221302420044053515454972772932772091758022063878123412028196792475334366896073730256821732872925646925108354699626084168288392929655914496000p -0.3
+ 38067632857031246407630399952637454339360261162480498151827759598488080823306351962756308851101602575098847329028940110091637382285949586119445262876221302420044053515454972772932772091758022063878123412028196792475334366896073730256821732872925646925108354699626084168288392929655914496010p 0.9
+ \]
V_wl_bar_953 (WordLine_bar\\<953\\> gnd!) vsource type=pwl wave=\[
+ 0    0.9
+ 76135265714062492815260799905274908678720522324960996303655519196976161646612703925512617702203205150197694658057880220183274764571899172238890525752442604840088107030909945545865544183516044127756246824056393584950668733792147460513643465745851293850216709399252168336576785859311828991500p 0.9
+ 76135265714062492815260799905274908678720522324960996303655519196976161646612703925512617702203205150197694658057880220183274764571899172238890525752442604840088107030909945545865544183516044127756246824056393584950668733792147460513643465745851293850216709399252168336576785859311828991510p -0.3
+ 76135265714062492815260799905274908678720522324960996303655519196976161646612703925512617702203205150197694658057880220183274764571899172238890525752442604840088107030909945545865544183516044127756246824056393584950668733792147460513643465745851293850216709399252168336576785859311828992000p -0.3
+ 76135265714062492815260799905274908678720522324960996303655519196976161646612703925512617702203205150197694658057880220183274764571899172238890525752442604840088107030909945545865544183516044127756246824056393584950668733792147460513643465745851293850216709399252168336576785859311828992010p 0.9
+ \]
V_wl_bar_954 (WordLine_bar\\<954\\> gnd!) vsource type=pwl wave=\[
+ 0    0.9
+ 152270531428124985630521599810549817357441044649921992607311038393952323293225407851025235404406410300395389316115760440366549529143798344477781051504885209680176214061819891091731088367032088255512493648112787169901337467584294921027286931491702587700433418798504336673153571718623657983500p 0.9
+ 152270531428124985630521599810549817357441044649921992607311038393952323293225407851025235404406410300395389316115760440366549529143798344477781051504885209680176214061819891091731088367032088255512493648112787169901337467584294921027286931491702587700433418798504336673153571718623657983510p -0.3
+ 152270531428124985630521599810549817357441044649921992607311038393952323293225407851025235404406410300395389316115760440366549529143798344477781051504885209680176214061819891091731088367032088255512493648112787169901337467584294921027286931491702587700433418798504336673153571718623657984000p -0.3
+ 152270531428124985630521599810549817357441044649921992607311038393952323293225407851025235404406410300395389316115760440366549529143798344477781051504885209680176214061819891091731088367032088255512493648112787169901337467584294921027286931491702587700433418798504336673153571718623657984010p 0.9
+ \]
V_wl_bar_955 (WordLine_bar\\<955\\> gnd!) vsource type=pwl wave=\[
+ 0    0.9
+ 304541062856249971261043199621099634714882089299843985214622076787904646586450815702050470808812820600790778632231520880733099058287596688955562103009770419360352428123639782183462176734064176511024987296225574339802674935168589842054573862983405175400866837597008673346307143437247315967500p 0.9
+ 304541062856249971261043199621099634714882089299843985214622076787904646586450815702050470808812820600790778632231520880733099058287596688955562103009770419360352428123639782183462176734064176511024987296225574339802674935168589842054573862983405175400866837597008673346307143437247315967510p -0.3
+ 304541062856249971261043199621099634714882089299843985214622076787904646586450815702050470808812820600790778632231520880733099058287596688955562103009770419360352428123639782183462176734064176511024987296225574339802674935168589842054573862983405175400866837597008673346307143437247315968000p -0.3
+ 304541062856249971261043199621099634714882089299843985214622076787904646586450815702050470808812820600790778632231520880733099058287596688955562103009770419360352428123639782183462176734064176511024987296225574339802674935168589842054573862983405175400866837597008673346307143437247315968010p 0.9
+ \]
V_wl_bar_956 (WordLine_bar\\<956\\> gnd!) vsource type=pwl wave=\[
+ 0    0.9
+ 609082125712499942522086399242199269429764178599687970429244153575809293172901631404100941617625641201581557264463041761466198116575193377911124206019540838720704856247279564366924353468128353022049974592451148679605349870337179684109147725966810350801733675194017346692614286874494631935500p 0.9
+ 609082125712499942522086399242199269429764178599687970429244153575809293172901631404100941617625641201581557264463041761466198116575193377911124206019540838720704856247279564366924353468128353022049974592451148679605349870337179684109147725966810350801733675194017346692614286874494631935510p -0.3
+ 609082125712499942522086399242199269429764178599687970429244153575809293172901631404100941617625641201581557264463041761466198116575193377911124206019540838720704856247279564366924353468128353022049974592451148679605349870337179684109147725966810350801733675194017346692614286874494631936000p -0.3
+ 609082125712499942522086399242199269429764178599687970429244153575809293172901631404100941617625641201581557264463041761466198116575193377911124206019540838720704856247279564366924353468128353022049974592451148679605349870337179684109147725966810350801733675194017346692614286874494631936010p 0.9
+ \]
V_wl_bar_957 (WordLine_bar\\<957\\> gnd!) vsource type=pwl wave=\[
+ 0    0.9
+ 1218164251424999885044172798484398538859528357199375940858488307151618586345803262808201883235251282403163114528926083522932396233150386755822248412039081677441409712494559128733848706936256706044099949184902297359210699740674359368218295451933620701603467350388034693385228573748989263871500p 0.9
+ 1218164251424999885044172798484398538859528357199375940858488307151618586345803262808201883235251282403163114528926083522932396233150386755822248412039081677441409712494559128733848706936256706044099949184902297359210699740674359368218295451933620701603467350388034693385228573748989263871510p -0.3
+ 1218164251424999885044172798484398538859528357199375940858488307151618586345803262808201883235251282403163114528926083522932396233150386755822248412039081677441409712494559128733848706936256706044099949184902297359210699740674359368218295451933620701603467350388034693385228573748989263872000p -0.3
+ 1218164251424999885044172798484398538859528357199375940858488307151618586345803262808201883235251282403163114528926083522932396233150386755822248412039081677441409712494559128733848706936256706044099949184902297359210699740674359368218295451933620701603467350388034693385228573748989263872010p 0.9
+ \]
V_wl_bar_958 (WordLine_bar\\<958\\> gnd!) vsource type=pwl wave=\[
+ 0    0.9
+ 2436328502849999770088345596968797077719056714398751881716976614303237172691606525616403766470502564806326229057852167045864792466300773511644496824078163354882819424989118257467697413872513412088199898369804594718421399481348718736436590903867241403206934700776069386770457147497978527743500p 0.9
+ 2436328502849999770088345596968797077719056714398751881716976614303237172691606525616403766470502564806326229057852167045864792466300773511644496824078163354882819424989118257467697413872513412088199898369804594718421399481348718736436590903867241403206934700776069386770457147497978527743510p -0.3
+ 2436328502849999770088345596968797077719056714398751881716976614303237172691606525616403766470502564806326229057852167045864792466300773511644496824078163354882819424989118257467697413872513412088199898369804594718421399481348718736436590903867241403206934700776069386770457147497978527744000p -0.3
+ 2436328502849999770088345596968797077719056714398751881716976614303237172691606525616403766470502564806326229057852167045864792466300773511644496824078163354882819424989118257467697413872513412088199898369804594718421399481348718736436590903867241403206934700776069386770457147497978527744010p 0.9
+ \]
V_wl_bar_959 (WordLine_bar\\<959\\> gnd!) vsource type=pwl wave=\[
+ 0    0.9
+ 4872657005699999540176691193937594155438113428797503763433953228606474345383213051232807532941005129612652458115704334091729584932601547023288993648156326709765638849978236514935394827745026824176399796739609189436842798962697437472873181807734482806413869401552138773540914294995957055487500p 0.9
+ 4872657005699999540176691193937594155438113428797503763433953228606474345383213051232807532941005129612652458115704334091729584932601547023288993648156326709765638849978236514935394827745026824176399796739609189436842798962697437472873181807734482806413869401552138773540914294995957055487510p -0.3
+ 4872657005699999540176691193937594155438113428797503763433953228606474345383213051232807532941005129612652458115704334091729584932601547023288993648156326709765638849978236514935394827745026824176399796739609189436842798962697437472873181807734482806413869401552138773540914294995957055488000p -0.3
+ 4872657005699999540176691193937594155438113428797503763433953228606474345383213051232807532941005129612652458115704334091729584932601547023288993648156326709765638849978236514935394827745026824176399796739609189436842798962697437472873181807734482806413869401552138773540914294995957055488010p 0.9
+ \]
V_wl_bar_960 (WordLine_bar\\<960\\> gnd!) vsource type=pwl wave=\[
+ 0    0.9
+ 9745314011399999080353382387875188310876226857595007526867906457212948690766426102465615065882010259225304916231408668183459169865203094046577987296312653419531277699956473029870789655490053648352799593479218378873685597925394874945746363615468965612827738803104277547081828589991914110975500p 0.9
+ 9745314011399999080353382387875188310876226857595007526867906457212948690766426102465615065882010259225304916231408668183459169865203094046577987296312653419531277699956473029870789655490053648352799593479218378873685597925394874945746363615468965612827738803104277547081828589991914110975510p -0.3
+ 9745314011399999080353382387875188310876226857595007526867906457212948690766426102465615065882010259225304916231408668183459169865203094046577987296312653419531277699956473029870789655490053648352799593479218378873685597925394874945746363615468965612827738803104277547081828589991914110976000p -0.3
+ 9745314011399999080353382387875188310876226857595007526867906457212948690766426102465615065882010259225304916231408668183459169865203094046577987296312653419531277699956473029870789655490053648352799593479218378873685597925394874945746363615468965612827738803104277547081828589991914110976010p 0.9
+ \]
V_wl_bar_961 (WordLine_bar\\<961\\> gnd!) vsource type=pwl wave=\[
+ 0    0.9
+ 19490628022799998160706764775750376621752453715190015053735812914425897381532852204931230131764020518450609832462817336366918339730406188093155974592625306839062555399912946059741579310980107296705599186958436757747371195850789749891492727230937931225655477606208555094163657179983828221951500p 0.9
+ 19490628022799998160706764775750376621752453715190015053735812914425897381532852204931230131764020518450609832462817336366918339730406188093155974592625306839062555399912946059741579310980107296705599186958436757747371195850789749891492727230937931225655477606208555094163657179983828221951510p -0.3
+ 19490628022799998160706764775750376621752453715190015053735812914425897381532852204931230131764020518450609832462817336366918339730406188093155974592625306839062555399912946059741579310980107296705599186958436757747371195850789749891492727230937931225655477606208555094163657179983828221952000p -0.3
+ 19490628022799998160706764775750376621752453715190015053735812914425897381532852204931230131764020518450609832462817336366918339730406188093155974592625306839062555399912946059741579310980107296705599186958436757747371195850789749891492727230937931225655477606208555094163657179983828221952010p 0.9
+ \]
V_wl_bar_962 (WordLine_bar\\<962\\> gnd!) vsource type=pwl wave=\[
+ 0    0.9
+ 38981256045599996321413529551500753243504907430380030107471625828851794763065704409862460263528041036901219664925634672733836679460812376186311949185250613678125110799825892119483158621960214593411198373916873515494742391701579499782985454461875862451310955212417110188327314359967656443903500p 0.9
+ 38981256045599996321413529551500753243504907430380030107471625828851794763065704409862460263528041036901219664925634672733836679460812376186311949185250613678125110799825892119483158621960214593411198373916873515494742391701579499782985454461875862451310955212417110188327314359967656443903510p -0.3
+ 38981256045599996321413529551500753243504907430380030107471625828851794763065704409862460263528041036901219664925634672733836679460812376186311949185250613678125110799825892119483158621960214593411198373916873515494742391701579499782985454461875862451310955212417110188327314359967656443904000p -0.3
+ 38981256045599996321413529551500753243504907430380030107471625828851794763065704409862460263528041036901219664925634672733836679460812376186311949185250613678125110799825892119483158621960214593411198373916873515494742391701579499782985454461875862451310955212417110188327314359967656443904010p 0.9
+ \]
V_wl_bar_963 (WordLine_bar\\<963\\> gnd!) vsource type=pwl wave=\[
+ 0    0.9
+ 77962512091199992642827059103001506487009814860760060214943251657703589526131408819724920527056082073802439329851269345467673358921624752372623898370501227356250221599651784238966317243920429186822396747833747030989484783403158999565970908923751724902621910424834220376654628719935312887807500p 0.9
+ 77962512091199992642827059103001506487009814860760060214943251657703589526131408819724920527056082073802439329851269345467673358921624752372623898370501227356250221599651784238966317243920429186822396747833747030989484783403158999565970908923751724902621910424834220376654628719935312887807510p -0.3
+ 77962512091199992642827059103001506487009814860760060214943251657703589526131408819724920527056082073802439329851269345467673358921624752372623898370501227356250221599651784238966317243920429186822396747833747030989484783403158999565970908923751724902621910424834220376654628719935312887808000p -0.3
+ 77962512091199992642827059103001506487009814860760060214943251657703589526131408819724920527056082073802439329851269345467673358921624752372623898370501227356250221599651784238966317243920429186822396747833747030989484783403158999565970908923751724902621910424834220376654628719935312887808010p 0.9
+ \]
V_wl_bar_964 (WordLine_bar\\<964\\> gnd!) vsource type=pwl wave=\[
+ 0    0.9
+ 155925024182399985285654118206003012974019629721520120429886503315407179052262817639449841054112164147604878659702538690935346717843249504745247796741002454712500443199303568477932634487840858373644793495667494061978969566806317999131941817847503449805243820849668440753309257439870625775615500p 0.9
+ 155925024182399985285654118206003012974019629721520120429886503315407179052262817639449841054112164147604878659702538690935346717843249504745247796741002454712500443199303568477932634487840858373644793495667494061978969566806317999131941817847503449805243820849668440753309257439870625775615510p -0.3
+ 155925024182399985285654118206003012974019629721520120429886503315407179052262817639449841054112164147604878659702538690935346717843249504745247796741002454712500443199303568477932634487840858373644793495667494061978969566806317999131941817847503449805243820849668440753309257439870625775616000p -0.3
+ 155925024182399985285654118206003012974019629721520120429886503315407179052262817639449841054112164147604878659702538690935346717843249504745247796741002454712500443199303568477932634487840858373644793495667494061978969566806317999131941817847503449805243820849668440753309257439870625775616010p 0.9
+ \]
V_wl_bar_965 (WordLine_bar\\<965\\> gnd!) vsource type=pwl wave=\[
+ 0    0.9
+ 311850048364799970571308236412006025948039259443040240859773006630814358104525635278899682108224328295209757319405077381870693435686499009490495593482004909425000886398607136955865268975681716747289586991334988123957939133612635998263883635695006899610487641699336881506618514879741251551231500p 0.9
+ 311850048364799970571308236412006025948039259443040240859773006630814358104525635278899682108224328295209757319405077381870693435686499009490495593482004909425000886398607136955865268975681716747289586991334988123957939133612635998263883635695006899610487641699336881506618514879741251551231510p -0.3
+ 311850048364799970571308236412006025948039259443040240859773006630814358104525635278899682108224328295209757319405077381870693435686499009490495593482004909425000886398607136955865268975681716747289586991334988123957939133612635998263883635695006899610487641699336881506618514879741251551232000p -0.3
+ 311850048364799970571308236412006025948039259443040240859773006630814358104525635278899682108224328295209757319405077381870693435686499009490495593482004909425000886398607136955865268975681716747289586991334988123957939133612635998263883635695006899610487641699336881506618514879741251551232010p 0.9
+ \]
V_wl_bar_966 (WordLine_bar\\<966\\> gnd!) vsource type=pwl wave=\[
+ 0    0.9
+ 623700096729599941142616472824012051896078518886080481719546013261628716209051270557799364216448656590419514638810154763741386871372998018980991186964009818850001772797214273911730537951363433494579173982669976247915878267225271996527767271390013799220975283398673763013237029759482503102463500p 0.9
+ 623700096729599941142616472824012051896078518886080481719546013261628716209051270557799364216448656590419514638810154763741386871372998018980991186964009818850001772797214273911730537951363433494579173982669976247915878267225271996527767271390013799220975283398673763013237029759482503102463510p -0.3
+ 623700096729599941142616472824012051896078518886080481719546013261628716209051270557799364216448656590419514638810154763741386871372998018980991186964009818850001772797214273911730537951363433494579173982669976247915878267225271996527767271390013799220975283398673763013237029759482503102464000p -0.3
+ 623700096729599941142616472824012051896078518886080481719546013261628716209051270557799364216448656590419514638810154763741386871372998018980991186964009818850001772797214273911730537951363433494579173982669976247915878267225271996527767271390013799220975283398673763013237029759482503102464010p 0.9
+ \]
V_wl_bar_967 (WordLine_bar\\<967\\> gnd!) vsource type=pwl wave=\[
+ 0    0.9
+ 1247400193459199882285232945648024103792157037772160963439092026523257432418102541115598728432897313180839029277620309527482773742745996037961982373928019637700003545594428547823461075902726866989158347965339952495831756534450543993055534542780027598441950566797347526026474059518965006204927500p 0.9
+ 1247400193459199882285232945648024103792157037772160963439092026523257432418102541115598728432897313180839029277620309527482773742745996037961982373928019637700003545594428547823461075902726866989158347965339952495831756534450543993055534542780027598441950566797347526026474059518965006204927510p -0.3
+ 1247400193459199882285232945648024103792157037772160963439092026523257432418102541115598728432897313180839029277620309527482773742745996037961982373928019637700003545594428547823461075902726866989158347965339952495831756534450543993055534542780027598441950566797347526026474059518965006204928000p -0.3
+ 1247400193459199882285232945648024103792157037772160963439092026523257432418102541115598728432897313180839029277620309527482773742745996037961982373928019637700003545594428547823461075902726866989158347965339952495831756534450543993055534542780027598441950566797347526026474059518965006204928010p 0.9
+ \]
V_wl_bar_968 (WordLine_bar\\<968\\> gnd!) vsource type=pwl wave=\[
+ 0    0.9
+ 2494800386918399764570465891296048207584314075544321926878184053046514864836205082231197456865794626361678058555240619054965547485491992075923964747856039275400007091188857095646922151805453733978316695930679904991663513068901087986111069085560055196883901133594695052052948119037930012409855500p 0.9
+ 2494800386918399764570465891296048207584314075544321926878184053046514864836205082231197456865794626361678058555240619054965547485491992075923964747856039275400007091188857095646922151805453733978316695930679904991663513068901087986111069085560055196883901133594695052052948119037930012409855510p -0.3
+ 2494800386918399764570465891296048207584314075544321926878184053046514864836205082231197456865794626361678058555240619054965547485491992075923964747856039275400007091188857095646922151805453733978316695930679904991663513068901087986111069085560055196883901133594695052052948119037930012409856000p -0.3
+ 2494800386918399764570465891296048207584314075544321926878184053046514864836205082231197456865794626361678058555240619054965547485491992075923964747856039275400007091188857095646922151805453733978316695930679904991663513068901087986111069085560055196883901133594695052052948119037930012409856010p 0.9
+ \]
V_wl_bar_969 (WordLine_bar\\<969\\> gnd!) vsource type=pwl wave=\[
+ 0    0.9
+ 4989600773836799529140931782592096415168628151088643853756368106093029729672410164462394913731589252723356117110481238109931094970983984151847929495712078550800014182377714191293844303610907467956633391861359809983327026137802175972222138171120110393767802267189390104105896238075860024819711500p 0.9
+ 4989600773836799529140931782592096415168628151088643853756368106093029729672410164462394913731589252723356117110481238109931094970983984151847929495712078550800014182377714191293844303610907467956633391861359809983327026137802175972222138171120110393767802267189390104105896238075860024819711510p -0.3
+ 4989600773836799529140931782592096415168628151088643853756368106093029729672410164462394913731589252723356117110481238109931094970983984151847929495712078550800014182377714191293844303610907467956633391861359809983327026137802175972222138171120110393767802267189390104105896238075860024819712000p -0.3
+ 4989600773836799529140931782592096415168628151088643853756368106093029729672410164462394913731589252723356117110481238109931094970983984151847929495712078550800014182377714191293844303610907467956633391861359809983327026137802175972222138171120110393767802267189390104105896238075860024819712010p 0.9
+ \]
V_wl_bar_970 (WordLine_bar\\<970\\> gnd!) vsource type=pwl wave=\[
+ 0    0.9
+ 9979201547673599058281863565184192830337256302177287707512736212186059459344820328924789827463178505446712234220962476219862189941967968303695858991424157101600028364755428382587688607221814935913266783722719619966654052275604351944444276342240220787535604534378780208211792476151720049639423500p 0.9
+ 9979201547673599058281863565184192830337256302177287707512736212186059459344820328924789827463178505446712234220962476219862189941967968303695858991424157101600028364755428382587688607221814935913266783722719619966654052275604351944444276342240220787535604534378780208211792476151720049639423510p -0.3
+ 9979201547673599058281863565184192830337256302177287707512736212186059459344820328924789827463178505446712234220962476219862189941967968303695858991424157101600028364755428382587688607221814935913266783722719619966654052275604351944444276342240220787535604534378780208211792476151720049639424000p -0.3
+ 9979201547673599058281863565184192830337256302177287707512736212186059459344820328924789827463178505446712234220962476219862189941967968303695858991424157101600028364755428382587688607221814935913266783722719619966654052275604351944444276342240220787535604534378780208211792476151720049639424010p 0.9
+ \]
V_wl_bar_971 (WordLine_bar\\<971\\> gnd!) vsource type=pwl wave=\[
+ 0    0.9
+ 19958403095347198116563727130368385660674512604354575415025472424372118918689640657849579654926357010893424468441924952439724379883935936607391717982848314203200056729510856765175377214443629871826533567445439239933308104551208703888888552684480441575071209068757560416423584952303440099278847500p 0.9
+ 19958403095347198116563727130368385660674512604354575415025472424372118918689640657849579654926357010893424468441924952439724379883935936607391717982848314203200056729510856765175377214443629871826533567445439239933308104551208703888888552684480441575071209068757560416423584952303440099278847510p -0.3
+ 19958403095347198116563727130368385660674512604354575415025472424372118918689640657849579654926357010893424468441924952439724379883935936607391717982848314203200056729510856765175377214443629871826533567445439239933308104551208703888888552684480441575071209068757560416423584952303440099278848000p -0.3
+ 19958403095347198116563727130368385660674512604354575415025472424372118918689640657849579654926357010893424468441924952439724379883935936607391717982848314203200056729510856765175377214443629871826533567445439239933308104551208703888888552684480441575071209068757560416423584952303440099278848010p 0.9
+ \]
V_wl_bar_972 (WordLine_bar\\<972\\> gnd!) vsource type=pwl wave=\[
+ 0    0.9
+ 39916806190694396233127454260736771321349025208709150830050944848744237837379281315699159309852714021786848936883849904879448759767871873214783435965696628406400113459021713530350754428887259743653067134890878479866616209102417407777777105368960883150142418137515120832847169904606880198557695500p 0.9
+ 39916806190694396233127454260736771321349025208709150830050944848744237837379281315699159309852714021786848936883849904879448759767871873214783435965696628406400113459021713530350754428887259743653067134890878479866616209102417407777777105368960883150142418137515120832847169904606880198557695510p -0.3
+ 39916806190694396233127454260736771321349025208709150830050944848744237837379281315699159309852714021786848936883849904879448759767871873214783435965696628406400113459021713530350754428887259743653067134890878479866616209102417407777777105368960883150142418137515120832847169904606880198557696000p -0.3
+ 39916806190694396233127454260736771321349025208709150830050944848744237837379281315699159309852714021786848936883849904879448759767871873214783435965696628406400113459021713530350754428887259743653067134890878479866616209102417407777777105368960883150142418137515120832847169904606880198557696010p 0.9
+ \]
V_wl_bar_973 (WordLine_bar\\<973\\> gnd!) vsource type=pwl wave=\[
+ 0    0.9
+ 79833612381388792466254908521473542642698050417418301660101889697488475674758562631398318619705428043573697873767699809758897519535743746429566871931393256812800226918043427060701508857774519487306134269781756959733232418204834815555554210737921766300284836275030241665694339809213760397115391500p 0.9
+ 79833612381388792466254908521473542642698050417418301660101889697488475674758562631398318619705428043573697873767699809758897519535743746429566871931393256812800226918043427060701508857774519487306134269781756959733232418204834815555554210737921766300284836275030241665694339809213760397115391510p -0.3
+ 79833612381388792466254908521473542642698050417418301660101889697488475674758562631398318619705428043573697873767699809758897519535743746429566871931393256812800226918043427060701508857774519487306134269781756959733232418204834815555554210737921766300284836275030241665694339809213760397115392000p -0.3
+ 79833612381388792466254908521473542642698050417418301660101889697488475674758562631398318619705428043573697873767699809758897519535743746429566871931393256812800226918043427060701508857774519487306134269781756959733232418204834815555554210737921766300284836275030241665694339809213760397115392010p 0.9
+ \]
V_wl_bar_974 (WordLine_bar\\<974\\> gnd!) vsource type=pwl wave=\[
+ 0    0.9
+ 159667224762777584932509817042947085285396100834836603320203779394976951349517125262796637239410856087147395747535399619517795039071487492859133743862786513625600453836086854121403017715549038974612268539563513919466464836409669631111108421475843532600569672550060483331388679618427520794230783500p 0.9
+ 159667224762777584932509817042947085285396100834836603320203779394976951349517125262796637239410856087147395747535399619517795039071487492859133743862786513625600453836086854121403017715549038974612268539563513919466464836409669631111108421475843532600569672550060483331388679618427520794230783510p -0.3
+ 159667224762777584932509817042947085285396100834836603320203779394976951349517125262796637239410856087147395747535399619517795039071487492859133743862786513625600453836086854121403017715549038974612268539563513919466464836409669631111108421475843532600569672550060483331388679618427520794230784000p -0.3
+ 159667224762777584932509817042947085285396100834836603320203779394976951349517125262796637239410856087147395747535399619517795039071487492859133743862786513625600453836086854121403017715549038974612268539563513919466464836409669631111108421475843532600569672550060483331388679618427520794230784010p 0.9
+ \]
V_wl_bar_975 (WordLine_bar\\<975\\> gnd!) vsource type=pwl wave=\[
+ 0    0.9
+ 319334449525555169865019634085894170570792201669673206640407558789953902699034250525593274478821712174294791495070799239035590078142974985718267487725573027251200907672173708242806035431098077949224537079127027838932929672819339262222216842951687065201139345100120966662777359236855041588461567500p 0.9
+ 319334449525555169865019634085894170570792201669673206640407558789953902699034250525593274478821712174294791495070799239035590078142974985718267487725573027251200907672173708242806035431098077949224537079127027838932929672819339262222216842951687065201139345100120966662777359236855041588461567510p -0.3
+ 319334449525555169865019634085894170570792201669673206640407558789953902699034250525593274478821712174294791495070799239035590078142974985718267487725573027251200907672173708242806035431098077949224537079127027838932929672819339262222216842951687065201139345100120966662777359236855041588461568000p -0.3
+ 319334449525555169865019634085894170570792201669673206640407558789953902699034250525593274478821712174294791495070799239035590078142974985718267487725573027251200907672173708242806035431098077949224537079127027838932929672819339262222216842951687065201139345100120966662777359236855041588461568010p 0.9
+ \]
V_wl_bar_976 (WordLine_bar\\<976\\> gnd!) vsource type=pwl wave=\[
+ 0    0.9
+ 638668899051110339730039268171788341141584403339346413280815117579907805398068501051186548957643424348589582990141598478071180156285949971436534975451146054502401815344347416485612070862196155898449074158254055677865859345638678524444433685903374130402278690200241933325554718473710083176923135500p 0.9
+ 638668899051110339730039268171788341141584403339346413280815117579907805398068501051186548957643424348589582990141598478071180156285949971436534975451146054502401815344347416485612070862196155898449074158254055677865859345638678524444433685903374130402278690200241933325554718473710083176923135510p -0.3
+ 638668899051110339730039268171788341141584403339346413280815117579907805398068501051186548957643424348589582990141598478071180156285949971436534975451146054502401815344347416485612070862196155898449074158254055677865859345638678524444433685903374130402278690200241933325554718473710083176923136000p -0.3
+ 638668899051110339730039268171788341141584403339346413280815117579907805398068501051186548957643424348589582990141598478071180156285949971436534975451146054502401815344347416485612070862196155898449074158254055677865859345638678524444433685903374130402278690200241933325554718473710083176923136010p 0.9
+ \]
V_wl_bar_977 (WordLine_bar\\<977\\> gnd!) vsource type=pwl wave=\[
+ 0    0.9
+ 1277337798102220679460078536343576682283168806678692826561630235159815610796137002102373097915286848697179165980283196956142360312571899942873069950902292109004803630688694832971224141724392311796898148316508111355731718691277357048888867371806748260804557380400483866651109436947420166353846271500p 0.9
+ 1277337798102220679460078536343576682283168806678692826561630235159815610796137002102373097915286848697179165980283196956142360312571899942873069950902292109004803630688694832971224141724392311796898148316508111355731718691277357048888867371806748260804557380400483866651109436947420166353846271510p -0.3
+ 1277337798102220679460078536343576682283168806678692826561630235159815610796137002102373097915286848697179165980283196956142360312571899942873069950902292109004803630688694832971224141724392311796898148316508111355731718691277357048888867371806748260804557380400483866651109436947420166353846272000p -0.3
+ 1277337798102220679460078536343576682283168806678692826561630235159815610796137002102373097915286848697179165980283196956142360312571899942873069950902292109004803630688694832971224141724392311796898148316508111355731718691277357048888867371806748260804557380400483866651109436947420166353846272010p 0.9
+ \]
V_wl_bar_978 (WordLine_bar\\<978\\> gnd!) vsource type=pwl wave=\[
+ 0    0.9
+ 2554675596204441358920157072687153364566337613357385653123260470319631221592274004204746195830573697394358331960566393912284720625143799885746139901804584218009607261377389665942448283448784623593796296633016222711463437382554714097777734743613496521609114760800967733302218873894840332707692543500p 0.9
+ 2554675596204441358920157072687153364566337613357385653123260470319631221592274004204746195830573697394358331960566393912284720625143799885746139901804584218009607261377389665942448283448784623593796296633016222711463437382554714097777734743613496521609114760800967733302218873894840332707692543510p -0.3
+ 2554675596204441358920157072687153364566337613357385653123260470319631221592274004204746195830573697394358331960566393912284720625143799885746139901804584218009607261377389665942448283448784623593796296633016222711463437382554714097777734743613496521609114760800967733302218873894840332707692544000p -0.3
+ 2554675596204441358920157072687153364566337613357385653123260470319631221592274004204746195830573697394358331960566393912284720625143799885746139901804584218009607261377389665942448283448784623593796296633016222711463437382554714097777734743613496521609114760800967733302218873894840332707692544010p 0.9
+ \]
V_wl_bar_979 (WordLine_bar\\<979\\> gnd!) vsource type=pwl wave=\[
+ 0    0.9
+ 5109351192408882717840314145374306729132675226714771306246520940639262443184548008409492391661147394788716663921132787824569441250287599771492279803609168436019214522754779331884896566897569247187592593266032445422926874765109428195555469487226993043218229521601935466604437747789680665415385087500p 0.9
+ 5109351192408882717840314145374306729132675226714771306246520940639262443184548008409492391661147394788716663921132787824569441250287599771492279803609168436019214522754779331884896566897569247187592593266032445422926874765109428195555469487226993043218229521601935466604437747789680665415385087510p -0.3
+ 5109351192408882717840314145374306729132675226714771306246520940639262443184548008409492391661147394788716663921132787824569441250287599771492279803609168436019214522754779331884896566897569247187592593266032445422926874765109428195555469487226993043218229521601935466604437747789680665415385088000p -0.3
+ 5109351192408882717840314145374306729132675226714771306246520940639262443184548008409492391661147394788716663921132787824569441250287599771492279803609168436019214522754779331884896566897569247187592593266032445422926874765109428195555469487226993043218229521601935466604437747789680665415385088010p 0.9
+ \]
V_wl_bar_980 (WordLine_bar\\<980\\> gnd!) vsource type=pwl wave=\[
+ 0    0.9
+ 10218702384817765435680628290748613458265350453429542612493041881278524886369096016818984783322294789577433327842265575649138882500575199542984559607218336872038429045509558663769793133795138494375185186532064890845853749530218856391110938974453986086436459043203870933208875495579361330830770175500p 0.9
+ 10218702384817765435680628290748613458265350453429542612493041881278524886369096016818984783322294789577433327842265575649138882500575199542984559607218336872038429045509558663769793133795138494375185186532064890845853749530218856391110938974453986086436459043203870933208875495579361330830770175510p -0.3
+ 10218702384817765435680628290748613458265350453429542612493041881278524886369096016818984783322294789577433327842265575649138882500575199542984559607218336872038429045509558663769793133795138494375185186532064890845853749530218856391110938974453986086436459043203870933208875495579361330830770176000p -0.3
+ 10218702384817765435680628290748613458265350453429542612493041881278524886369096016818984783322294789577433327842265575649138882500575199542984559607218336872038429045509558663769793133795138494375185186532064890845853749530218856391110938974453986086436459043203870933208875495579361330830770176010p 0.9
+ \]
V_wl_bar_981 (WordLine_bar\\<981\\> gnd!) vsource type=pwl wave=\[
+ 0    0.9
+ 20437404769635530871361256581497226916530700906859085224986083762557049772738192033637969566644589579154866655684531151298277765001150399085969119214436673744076858091019117327539586267590276988750370373064129781691707499060437712782221877948907972172872918086407741866417750991158722661661540351500p 0.9
+ 20437404769635530871361256581497226916530700906859085224986083762557049772738192033637969566644589579154866655684531151298277765001150399085969119214436673744076858091019117327539586267590276988750370373064129781691707499060437712782221877948907972172872918086407741866417750991158722661661540351510p -0.3
+ 20437404769635530871361256581497226916530700906859085224986083762557049772738192033637969566644589579154866655684531151298277765001150399085969119214436673744076858091019117327539586267590276988750370373064129781691707499060437712782221877948907972172872918086407741866417750991158722661661540352000p -0.3
+ 20437404769635530871361256581497226916530700906859085224986083762557049772738192033637969566644589579154866655684531151298277765001150399085969119214436673744076858091019117327539586267590276988750370373064129781691707499060437712782221877948907972172872918086407741866417750991158722661661540352010p 0.9
+ \]
V_wl_bar_982 (WordLine_bar\\<982\\> gnd!) vsource type=pwl wave=\[
+ 0    0.9
+ 40874809539271061742722513162994453833061401813718170449972167525114099545476384067275939133289179158309733311369062302596555530002300798171938238428873347488153716182038234655079172535180553977500740746128259563383414998120875425564443755897815944345745836172815483732835501982317445323323080703500p 0.9
+ 40874809539271061742722513162994453833061401813718170449972167525114099545476384067275939133289179158309733311369062302596555530002300798171938238428873347488153716182038234655079172535180553977500740746128259563383414998120875425564443755897815944345745836172815483732835501982317445323323080703510p -0.3
+ 40874809539271061742722513162994453833061401813718170449972167525114099545476384067275939133289179158309733311369062302596555530002300798171938238428873347488153716182038234655079172535180553977500740746128259563383414998120875425564443755897815944345745836172815483732835501982317445323323080704000p -0.3
+ 40874809539271061742722513162994453833061401813718170449972167525114099545476384067275939133289179158309733311369062302596555530002300798171938238428873347488153716182038234655079172535180553977500740746128259563383414998120875425564443755897815944345745836172815483732835501982317445323323080704010p 0.9
+ \]
V_wl_bar_983 (WordLine_bar\\<983\\> gnd!) vsource type=pwl wave=\[
+ 0    0.9
+ 81749619078542123485445026325988907666122803627436340899944335050228199090952768134551878266578358316619466622738124605193111060004601596343876476857746694976307432364076469310158345070361107955001481492256519126766829996241750851128887511795631888691491672345630967465671003964634890646646161407500p 0.9
+ 81749619078542123485445026325988907666122803627436340899944335050228199090952768134551878266578358316619466622738124605193111060004601596343876476857746694976307432364076469310158345070361107955001481492256519126766829996241750851128887511795631888691491672345630967465671003964634890646646161407510p -0.3
+ 81749619078542123485445026325988907666122803627436340899944335050228199090952768134551878266578358316619466622738124605193111060004601596343876476857746694976307432364076469310158345070361107955001481492256519126766829996241750851128887511795631888691491672345630967465671003964634890646646161408000p -0.3
+ 81749619078542123485445026325988907666122803627436340899944335050228199090952768134551878266578358316619466622738124605193111060004601596343876476857746694976307432364076469310158345070361107955001481492256519126766829996241750851128887511795631888691491672345630967465671003964634890646646161408010p 0.9
+ \]
V_wl_bar_984 (WordLine_bar\\<984\\> gnd!) vsource type=pwl wave=\[
+ 0    0.9
+ 163499238157084246970890052651977815332245607254872681799888670100456398181905536269103756533156716633238933245476249210386222120009203192687752953715493389952614864728152938620316690140722215910002962984513038253533659992483501702257775023591263777382983344691261934931342007929269781293292322815500p 0.9
+ 163499238157084246970890052651977815332245607254872681799888670100456398181905536269103756533156716633238933245476249210386222120009203192687752953715493389952614864728152938620316690140722215910002962984513038253533659992483501702257775023591263777382983344691261934931342007929269781293292322815510p -0.3
+ 163499238157084246970890052651977815332245607254872681799888670100456398181905536269103756533156716633238933245476249210386222120009203192687752953715493389952614864728152938620316690140722215910002962984513038253533659992483501702257775023591263777382983344691261934931342007929269781293292322816000p -0.3
+ 163499238157084246970890052651977815332245607254872681799888670100456398181905536269103756533156716633238933245476249210386222120009203192687752953715493389952614864728152938620316690140722215910002962984513038253533659992483501702257775023591263777382983344691261934931342007929269781293292322816010p 0.9
+ \]
V_wl_bar_985 (WordLine_bar\\<985\\> gnd!) vsource type=pwl wave=\[
+ 0    0.9
+ 326998476314168493941780105303955630664491214509745363599777340200912796363811072538207513066313433266477866490952498420772444240018406385375505907430986779905229729456305877240633380281444431820005925969026076507067319984967003404515550047182527554765966689382523869862684015858539562586584645631500p 0.9
+ 326998476314168493941780105303955630664491214509745363599777340200912796363811072538207513066313433266477866490952498420772444240018406385375505907430986779905229729456305877240633380281444431820005925969026076507067319984967003404515550047182527554765966689382523869862684015858539562586584645631510p -0.3
+ 326998476314168493941780105303955630664491214509745363599777340200912796363811072538207513066313433266477866490952498420772444240018406385375505907430986779905229729456305877240633380281444431820005925969026076507067319984967003404515550047182527554765966689382523869862684015858539562586584645632000p -0.3
+ 326998476314168493941780105303955630664491214509745363599777340200912796363811072538207513066313433266477866490952498420772444240018406385375505907430986779905229729456305877240633380281444431820005925969026076507067319984967003404515550047182527554765966689382523869862684015858539562586584645632010p 0.9
+ \]
V_wl_bar_986 (WordLine_bar\\<986\\> gnd!) vsource type=pwl wave=\[
+ 0    0.9
+ 653996952628336987883560210607911261328982429019490727199554680401825592727622145076415026132626866532955732981904996841544888480036812770751011814861973559810459458912611754481266760562888863640011851938052153014134639969934006809031100094365055109531933378765047739725368031717079125173169291263500p 0.9
+ 653996952628336987883560210607911261328982429019490727199554680401825592727622145076415026132626866532955732981904996841544888480036812770751011814861973559810459458912611754481266760562888863640011851938052153014134639969934006809031100094365055109531933378765047739725368031717079125173169291263510p -0.3
+ 653996952628336987883560210607911261328982429019490727199554680401825592727622145076415026132626866532955732981904996841544888480036812770751011814861973559810459458912611754481266760562888863640011851938052153014134639969934006809031100094365055109531933378765047739725368031717079125173169291264000p -0.3
+ 653996952628336987883560210607911261328982429019490727199554680401825592727622145076415026132626866532955732981904996841544888480036812770751011814861973559810459458912611754481266760562888863640011851938052153014134639969934006809031100094365055109531933378765047739725368031717079125173169291264010p 0.9
+ \]
V_wl_bar_987 (WordLine_bar\\<987\\> gnd!) vsource type=pwl wave=\[
+ 0    0.9
+ 1307993905256673975767120421215822522657964858038981454399109360803651185455244290152830052265253733065911465963809993683089776960073625541502023629723947119620918917825223508962533521125777727280023703876104306028269279939868013618062200188730110219063866757530095479450736063434158250346338582527500p 0.9
+ 1307993905256673975767120421215822522657964858038981454399109360803651185455244290152830052265253733065911465963809993683089776960073625541502023629723947119620918917825223508962533521125777727280023703876104306028269279939868013618062200188730110219063866757530095479450736063434158250346338582527510p -0.3
+ 1307993905256673975767120421215822522657964858038981454399109360803651185455244290152830052265253733065911465963809993683089776960073625541502023629723947119620918917825223508962533521125777727280023703876104306028269279939868013618062200188730110219063866757530095479450736063434158250346338582528000p -0.3
+ 1307993905256673975767120421215822522657964858038981454399109360803651185455244290152830052265253733065911465963809993683089776960073625541502023629723947119620918917825223508962533521125777727280023703876104306028269279939868013618062200188730110219063866757530095479450736063434158250346338582528010p 0.9
+ \]
V_wl_bar_988 (WordLine_bar\\<988\\> gnd!) vsource type=pwl wave=\[
+ 0    0.9
+ 2615987810513347951534240842431645045315929716077962908798218721607302370910488580305660104530507466131822931927619987366179553920147251083004047259447894239241837835650447017925067042251555454560047407752208612056538559879736027236124400377460220438127733515060190958901472126868316500692677165055500p 0.9
+ 2615987810513347951534240842431645045315929716077962908798218721607302370910488580305660104530507466131822931927619987366179553920147251083004047259447894239241837835650447017925067042251555454560047407752208612056538559879736027236124400377460220438127733515060190958901472126868316500692677165055510p -0.3
+ 2615987810513347951534240842431645045315929716077962908798218721607302370910488580305660104530507466131822931927619987366179553920147251083004047259447894239241837835650447017925067042251555454560047407752208612056538559879736027236124400377460220438127733515060190958901472126868316500692677165056000p -0.3
+ 2615987810513347951534240842431645045315929716077962908798218721607302370910488580305660104530507466131822931927619987366179553920147251083004047259447894239241837835650447017925067042251555454560047407752208612056538559879736027236124400377460220438127733515060190958901472126868316500692677165056010p 0.9
+ \]
V_wl_bar_989 (WordLine_bar\\<989\\> gnd!) vsource type=pwl wave=\[
+ 0    0.9
+ 5231975621026695903068481684863290090631859432155925817596437443214604741820977160611320209061014932263645863855239974732359107840294502166008094518895788478483675671300894035850134084503110909120094815504417224113077119759472054472248800754920440876255467030120381917802944253736633001385354330111500p 0.9
+ 5231975621026695903068481684863290090631859432155925817596437443214604741820977160611320209061014932263645863855239974732359107840294502166008094518895788478483675671300894035850134084503110909120094815504417224113077119759472054472248800754920440876255467030120381917802944253736633001385354330111510p -0.3
+ 5231975621026695903068481684863290090631859432155925817596437443214604741820977160611320209061014932263645863855239974732359107840294502166008094518895788478483675671300894035850134084503110909120094815504417224113077119759472054472248800754920440876255467030120381917802944253736633001385354330112000p -0.3
+ 5231975621026695903068481684863290090631859432155925817596437443214604741820977160611320209061014932263645863855239974732359107840294502166008094518895788478483675671300894035850134084503110909120094815504417224113077119759472054472248800754920440876255467030120381917802944253736633001385354330112010p 0.9
+ \]
V_wl_bar_990 (WordLine_bar\\<990\\> gnd!) vsource type=pwl wave=\[
+ 0    0.9
+ 10463951242053391806136963369726580181263718864311851635192874886429209483641954321222640418122029864527291727710479949464718215680589004332016189037791576956967351342601788071700268169006221818240189631008834448226154239518944108944497601509840881752510934060240763835605888507473266002770708660223500p 0.9
+ 10463951242053391806136963369726580181263718864311851635192874886429209483641954321222640418122029864527291727710479949464718215680589004332016189037791576956967351342601788071700268169006221818240189631008834448226154239518944108944497601509840881752510934060240763835605888507473266002770708660223510p -0.3
+ 10463951242053391806136963369726580181263718864311851635192874886429209483641954321222640418122029864527291727710479949464718215680589004332016189037791576956967351342601788071700268169006221818240189631008834448226154239518944108944497601509840881752510934060240763835605888507473266002770708660224000p -0.3
+ 10463951242053391806136963369726580181263718864311851635192874886429209483641954321222640418122029864527291727710479949464718215680589004332016189037791576956967351342601788071700268169006221818240189631008834448226154239518944108944497601509840881752510934060240763835605888507473266002770708660224010p 0.9
+ \]
V_wl_bar_991 (WordLine_bar\\<991\\> gnd!) vsource type=pwl wave=\[
+ 0    0.9
+ 20927902484106783612273926739453160362527437728623703270385749772858418967283908642445280836244059729054583455420959898929436431361178008664032378075583153913934702685203576143400536338012443636480379262017668896452308479037888217888995203019681763505021868120481527671211777014946532005541417320447500p 0.9
+ 20927902484106783612273926739453160362527437728623703270385749772858418967283908642445280836244059729054583455420959898929436431361178008664032378075583153913934702685203576143400536338012443636480379262017668896452308479037888217888995203019681763505021868120481527671211777014946532005541417320447510p -0.3
+ 20927902484106783612273926739453160362527437728623703270385749772858418967283908642445280836244059729054583455420959898929436431361178008664032378075583153913934702685203576143400536338012443636480379262017668896452308479037888217888995203019681763505021868120481527671211777014946532005541417320448000p -0.3
+ 20927902484106783612273926739453160362527437728623703270385749772858418967283908642445280836244059729054583455420959898929436431361178008664032378075583153913934702685203576143400536338012443636480379262017668896452308479037888217888995203019681763505021868120481527671211777014946532005541417320448010p 0.9
+ \]
V_wl_bar_992 (WordLine_bar\\<992\\> gnd!) vsource type=pwl wave=\[
+ 0    0.9
+ 41855804968213567224547853478906320725054875457247406540771499545716837934567817284890561672488119458109166910841919797858872862722356017328064756151166307827869405370407152286801072676024887272960758524035337792904616958075776435777990406039363527010043736240963055342423554029893064011082834640895500p 0.9
+ 41855804968213567224547853478906320725054875457247406540771499545716837934567817284890561672488119458109166910841919797858872862722356017328064756151166307827869405370407152286801072676024887272960758524035337792904616958075776435777990406039363527010043736240963055342423554029893064011082834640895510p -0.3
+ 41855804968213567224547853478906320725054875457247406540771499545716837934567817284890561672488119458109166910841919797858872862722356017328064756151166307827869405370407152286801072676024887272960758524035337792904616958075776435777990406039363527010043736240963055342423554029893064011082834640896000p -0.3
+ 41855804968213567224547853478906320725054875457247406540771499545716837934567817284890561672488119458109166910841919797858872862722356017328064756151166307827869405370407152286801072676024887272960758524035337792904616958075776435777990406039363527010043736240963055342423554029893064011082834640896010p 0.9
+ \]
V_wl_bar_993 (WordLine_bar\\<993\\> gnd!) vsource type=pwl wave=\[
+ 0    0.9
+ 83711609936427134449095706957812641450109750914494813081542999091433675869135634569781123344976238916218333821683839595717745725444712034656129512302332615655738810740814304573602145352049774545921517048070675585809233916151552871555980812078727054020087472481926110684847108059786128022165669281791500p 0.9
+ 83711609936427134449095706957812641450109750914494813081542999091433675869135634569781123344976238916218333821683839595717745725444712034656129512302332615655738810740814304573602145352049774545921517048070675585809233916151552871555980812078727054020087472481926110684847108059786128022165669281791510p -0.3
+ 83711609936427134449095706957812641450109750914494813081542999091433675869135634569781123344976238916218333821683839595717745725444712034656129512302332615655738810740814304573602145352049774545921517048070675585809233916151552871555980812078727054020087472481926110684847108059786128022165669281792000p -0.3
+ 83711609936427134449095706957812641450109750914494813081542999091433675869135634569781123344976238916218333821683839595717745725444712034656129512302332615655738810740814304573602145352049774545921517048070675585809233916151552871555980812078727054020087472481926110684847108059786128022165669281792010p 0.9
+ \]
V_wl_bar_994 (WordLine_bar\\<994\\> gnd!) vsource type=pwl wave=\[
+ 0    0.9
+ 167423219872854268898191413915625282900219501828989626163085998182867351738271269139562246689952477832436667643367679191435491450889424069312259024604665231311477621481628609147204290704099549091843034096141351171618467832303105743111961624157454108040174944963852221369694216119572256044331338563583500p 0.9
+ 167423219872854268898191413915625282900219501828989626163085998182867351738271269139562246689952477832436667643367679191435491450889424069312259024604665231311477621481628609147204290704099549091843034096141351171618467832303105743111961624157454108040174944963852221369694216119572256044331338563583510p -0.3
+ 167423219872854268898191413915625282900219501828989626163085998182867351738271269139562246689952477832436667643367679191435491450889424069312259024604665231311477621481628609147204290704099549091843034096141351171618467832303105743111961624157454108040174944963852221369694216119572256044331338563584000p -0.3
+ 167423219872854268898191413915625282900219501828989626163085998182867351738271269139562246689952477832436667643367679191435491450889424069312259024604665231311477621481628609147204290704099549091843034096141351171618467832303105743111961624157454108040174944963852221369694216119572256044331338563584010p 0.9
+ \]
V_wl_bar_995 (WordLine_bar\\<995\\> gnd!) vsource type=pwl wave=\[
+ 0    0.9
+ 334846439745708537796382827831250565800439003657979252326171996365734703476542538279124493379904955664873335286735358382870982901778848138624518049209330462622955242963257218294408581408199098183686068192282702343236935664606211486223923248314908216080349889927704442739388432239144512088662677127167500p 0.9
+ 334846439745708537796382827831250565800439003657979252326171996365734703476542538279124493379904955664873335286735358382870982901778848138624518049209330462622955242963257218294408581408199098183686068192282702343236935664606211486223923248314908216080349889927704442739388432239144512088662677127167510p -0.3
+ 334846439745708537796382827831250565800439003657979252326171996365734703476542538279124493379904955664873335286735358382870982901778848138624518049209330462622955242963257218294408581408199098183686068192282702343236935664606211486223923248314908216080349889927704442739388432239144512088662677127168000p -0.3
+ 334846439745708537796382827831250565800439003657979252326171996365734703476542538279124493379904955664873335286735358382870982901778848138624518049209330462622955242963257218294408581408199098183686068192282702343236935664606211486223923248314908216080349889927704442739388432239144512088662677127168010p 0.9
+ \]
V_wl_bar_996 (WordLine_bar\\<996\\> gnd!) vsource type=pwl wave=\[
+ 0    0.9
+ 669692879491417075592765655662501131600878007315958504652343992731469406953085076558248986759809911329746670573470716765741965803557696277249036098418660925245910485926514436588817162816398196367372136384565404686473871329212422972447846496629816432160699779855408885478776864478289024177325354254335500p 0.9
+ 669692879491417075592765655662501131600878007315958504652343992731469406953085076558248986759809911329746670573470716765741965803557696277249036098418660925245910485926514436588817162816398196367372136384565404686473871329212422972447846496629816432160699779855408885478776864478289024177325354254335510p -0.3
+ 669692879491417075592765655662501131600878007315958504652343992731469406953085076558248986759809911329746670573470716765741965803557696277249036098418660925245910485926514436588817162816398196367372136384565404686473871329212422972447846496629816432160699779855408885478776864478289024177325354254336000p -0.3
+ 669692879491417075592765655662501131600878007315958504652343992731469406953085076558248986759809911329746670573470716765741965803557696277249036098418660925245910485926514436588817162816398196367372136384565404686473871329212422972447846496629816432160699779855408885478776864478289024177325354254336010p 0.9
+ \]
V_wl_bar_997 (WordLine_bar\\<997\\> gnd!) vsource type=pwl wave=\[
+ 0    0.9
+ 1339385758982834151185531311325002263201756014631917009304687985462938813906170153116497973519619822659493341146941433531483931607115392554498072196837321850491820971853028873177634325632796392734744272769130809372947742658424845944895692993259632864321399559710817770957553728956578048354650708508671500p 0.9
+ 1339385758982834151185531311325002263201756014631917009304687985462938813906170153116497973519619822659493341146941433531483931607115392554498072196837321850491820971853028873177634325632796392734744272769130809372947742658424845944895692993259632864321399559710817770957553728956578048354650708508671510p -0.3
+ 1339385758982834151185531311325002263201756014631917009304687985462938813906170153116497973519619822659493341146941433531483931607115392554498072196837321850491820971853028873177634325632796392734744272769130809372947742658424845944895692993259632864321399559710817770957553728956578048354650708508672000p -0.3
+ 1339385758982834151185531311325002263201756014631917009304687985462938813906170153116497973519619822659493341146941433531483931607115392554498072196837321850491820971853028873177634325632796392734744272769130809372947742658424845944895692993259632864321399559710817770957553728956578048354650708508672010p 0.9
+ \]
V_wl_bar_998 (WordLine_bar\\<998\\> gnd!) vsource type=pwl wave=\[
+ 0    0.9
+ 2678771517965668302371062622650004526403512029263834018609375970925877627812340306232995947039239645318986682293882867062967863214230785108996144393674643700983641943706057746355268651265592785469488545538261618745895485316849691889791385986519265728642799119421635541915107457913156096709301417017343500p 0.9
+ 2678771517965668302371062622650004526403512029263834018609375970925877627812340306232995947039239645318986682293882867062967863214230785108996144393674643700983641943706057746355268651265592785469488545538261618745895485316849691889791385986519265728642799119421635541915107457913156096709301417017343510p -0.3
+ 2678771517965668302371062622650004526403512029263834018609375970925877627812340306232995947039239645318986682293882867062967863214230785108996144393674643700983641943706057746355268651265592785469488545538261618745895485316849691889791385986519265728642799119421635541915107457913156096709301417017344000p -0.3
+ 2678771517965668302371062622650004526403512029263834018609375970925877627812340306232995947039239645318986682293882867062967863214230785108996144393674643700983641943706057746355268651265592785469488545538261618745895485316849691889791385986519265728642799119421635541915107457913156096709301417017344010p 0.9
+ \]
V_wl_bar_999 (WordLine_bar\\<999\\> gnd!) vsource type=pwl wave=\[
+ 0    0.9
+ 5357543035931336604742125245300009052807024058527668037218751941851755255624680612465991894078479290637973364587765734125935726428461570217992288787349287401967283887412115492710537302531185570938977091076523237491790970633699383779582771973038531457285598238843271083830214915826312193418602834034687500p 0.9
+ 5357543035931336604742125245300009052807024058527668037218751941851755255624680612465991894078479290637973364587765734125935726428461570217992288787349287401967283887412115492710537302531185570938977091076523237491790970633699383779582771973038531457285598238843271083830214915826312193418602834034687510p -0.3
+ 5357543035931336604742125245300009052807024058527668037218751941851755255624680612465991894078479290637973364587765734125935726428461570217992288787349287401967283887412115492710537302531185570938977091076523237491790970633699383779582771973038531457285598238843271083830214915826312193418602834034688000p -0.3
+ 5357543035931336604742125245300009052807024058527668037218751941851755255624680612465991894078479290637973364587765734125935726428461570217992288787349287401967283887412115492710537302531185570938977091076523237491790970633699383779582771973038531457285598238843271083830214915826312193418602834034688010p 0.9
+ \]
V_wl_bar_1000 (WordLine_bar\\<1000\\> gnd!) vsource type=pwl wave=\[
+ 0    0.9
+ 10715086071862673209484250490600018105614048117055336074437503883703510511249361224931983788156958581275946729175531468251871452856923140435984577574698574803934567774824230985421074605062371141877954182153046474983581941267398767559165543946077062914571196477686542167660429831652624386837205668069375500p 0.9
+ 10715086071862673209484250490600018105614048117055336074437503883703510511249361224931983788156958581275946729175531468251871452856923140435984577574698574803934567774824230985421074605062371141877954182153046474983581941267398767559165543946077062914571196477686542167660429831652624386837205668069375510p -0.3
+ 10715086071862673209484250490600018105614048117055336074437503883703510511249361224931983788156958581275946729175531468251871452856923140435984577574698574803934567774824230985421074605062371141877954182153046474983581941267398767559165543946077062914571196477686542167660429831652624386837205668069376000p -0.3
+ 10715086071862673209484250490600018105614048117055336074437503883703510511249361224931983788156958581275946729175531468251871452856923140435984577574698574803934567774824230985421074605062371141877954182153046474983581941267398767559165543946077062914571196477686542167660429831652624386837205668069376010p 0.9
+ \]
V_wl_bar_1001 (WordLine_bar\\<1001\\> gnd!) vsource type=pwl wave=\[
+ 0    0.9
+ 21430172143725346418968500981200036211228096234110672148875007767407021022498722449863967576313917162551893458351062936503742905713846280871969155149397149607869135549648461970842149210124742283755908364306092949967163882534797535118331087892154125829142392955373084335320859663305248773674411336138751500p 0.9
+ 21430172143725346418968500981200036211228096234110672148875007767407021022498722449863967576313917162551893458351062936503742905713846280871969155149397149607869135549648461970842149210124742283755908364306092949967163882534797535118331087892154125829142392955373084335320859663305248773674411336138751510p -0.3
+ 21430172143725346418968500981200036211228096234110672148875007767407021022498722449863967576313917162551893458351062936503742905713846280871969155149397149607869135549648461970842149210124742283755908364306092949967163882534797535118331087892154125829142392955373084335320859663305248773674411336138752000p -0.3
+ 21430172143725346418968500981200036211228096234110672148875007767407021022498722449863967576313917162551893458351062936503742905713846280871969155149397149607869135549648461970842149210124742283755908364306092949967163882534797535118331087892154125829142392955373084335320859663305248773674411336138752010p 0.9
+ \]
V_wl_bar_1002 (WordLine_bar\\<1002\\> gnd!) vsource type=pwl wave=\[
+ 0    0.9
+ 42860344287450692837937001962400072422456192468221344297750015534814042044997444899727935152627834325103786916702125873007485811427692561743938310298794299215738271099296923941684298420249484567511816728612185899934327765069595070236662175784308251658284785910746168670641719326610497547348822672277503500p 0.9
+ 42860344287450692837937001962400072422456192468221344297750015534814042044997444899727935152627834325103786916702125873007485811427692561743938310298794299215738271099296923941684298420249484567511816728612185899934327765069595070236662175784308251658284785910746168670641719326610497547348822672277503510p -0.3
+ 42860344287450692837937001962400072422456192468221344297750015534814042044997444899727935152627834325103786916702125873007485811427692561743938310298794299215738271099296923941684298420249484567511816728612185899934327765069595070236662175784308251658284785910746168670641719326610497547348822672277504000p -0.3
+ 42860344287450692837937001962400072422456192468221344297750015534814042044997444899727935152627834325103786916702125873007485811427692561743938310298794299215738271099296923941684298420249484567511816728612185899934327765069595070236662175784308251658284785910746168670641719326610497547348822672277504010p 0.9
+ \]
V_wl_bar_1003 (WordLine_bar\\<1003\\> gnd!) vsource type=pwl wave=\[
+ 0    0.9
+ 85720688574901385675874003924800144844912384936442688595500031069628084089994889799455870305255668650207573833404251746014971622855385123487876620597588598431476542198593847883368596840498969135023633457224371799868655530139190140473324351568616503316569571821492337341283438653220995094697645344555007500p 0.9
+ 85720688574901385675874003924800144844912384936442688595500031069628084089994889799455870305255668650207573833404251746014971622855385123487876620597588598431476542198593847883368596840498969135023633457224371799868655530139190140473324351568616503316569571821492337341283438653220995094697645344555007510p -0.3
+ 85720688574901385675874003924800144844912384936442688595500031069628084089994889799455870305255668650207573833404251746014971622855385123487876620597588598431476542198593847883368596840498969135023633457224371799868655530139190140473324351568616503316569571821492337341283438653220995094697645344555008000p -0.3
+ 85720688574901385675874003924800144844912384936442688595500031069628084089994889799455870305255668650207573833404251746014971622855385123487876620597588598431476542198593847883368596840498969135023633457224371799868655530139190140473324351568616503316569571821492337341283438653220995094697645344555008010p 0.9
+ \]
V_wl_bar_1004 (WordLine_bar\\<1004\\> gnd!) vsource type=pwl wave=\[
+ 0    0.9
+ 171441377149802771351748007849600289689824769872885377191000062139256168179989779598911740610511337300415147666808503492029943245710770246975753241195177196862953084397187695766737193680997938270047266914448743599737311060278380280946648703137233006633139143642984674682566877306441990189395290689110015500p 0.9
+ 171441377149802771351748007849600289689824769872885377191000062139256168179989779598911740610511337300415147666808503492029943245710770246975753241195177196862953084397187695766737193680997938270047266914448743599737311060278380280946648703137233006633139143642984674682566877306441990189395290689110015510p -0.3
+ 171441377149802771351748007849600289689824769872885377191000062139256168179989779598911740610511337300415147666808503492029943245710770246975753241195177196862953084397187695766737193680997938270047266914448743599737311060278380280946648703137233006633139143642984674682566877306441990189395290689110016000p -0.3
+ 171441377149802771351748007849600289689824769872885377191000062139256168179989779598911740610511337300415147666808503492029943245710770246975753241195177196862953084397187695766737193680997938270047266914448743599737311060278380280946648703137233006633139143642984674682566877306441990189395290689110016010p 0.9
+ \]
V_wl_bar_1005 (WordLine_bar\\<1005\\> gnd!) vsource type=pwl wave=\[
+ 0    0.9
+ 342882754299605542703496015699200579379649539745770754382000124278512336359979559197823481221022674600830295333617006984059886491421540493951506482390354393725906168794375391533474387361995876540094533828897487199474622120556760561893297406274466013266278287285969349365133754612883980378790581378220031500p 0.9
+ 342882754299605542703496015699200579379649539745770754382000124278512336359979559197823481221022674600830295333617006984059886491421540493951506482390354393725906168794375391533474387361995876540094533828897487199474622120556760561893297406274466013266278287285969349365133754612883980378790581378220031510p -0.3
+ 342882754299605542703496015699200579379649539745770754382000124278512336359979559197823481221022674600830295333617006984059886491421540493951506482390354393725906168794375391533474387361995876540094533828897487199474622120556760561893297406274466013266278287285969349365133754612883980378790581378220032000p -0.3
+ 342882754299605542703496015699200579379649539745770754382000124278512336359979559197823481221022674600830295333617006984059886491421540493951506482390354393725906168794375391533474387361995876540094533828897487199474622120556760561893297406274466013266278287285969349365133754612883980378790581378220032010p 0.9
+ \]
V_wl_bar_1006 (WordLine_bar\\<1006\\> gnd!) vsource type=pwl wave=\[
+ 0    0.9
+ 685765508599211085406992031398401158759299079491541508764000248557024672719959118395646962442045349201660590667234013968119772982843080987903012964780708787451812337588750783066948774723991753080189067657794974398949244241113521123786594812548932026532556574571938698730267509225767960757581162756440063500p 0.9
+ 685765508599211085406992031398401158759299079491541508764000248557024672719959118395646962442045349201660590667234013968119772982843080987903012964780708787451812337588750783066948774723991753080189067657794974398949244241113521123786594812548932026532556574571938698730267509225767960757581162756440063510p -0.3
+ 685765508599211085406992031398401158759299079491541508764000248557024672719959118395646962442045349201660590667234013968119772982843080987903012964780708787451812337588750783066948774723991753080189067657794974398949244241113521123786594812548932026532556574571938698730267509225767960757581162756440064000p -0.3
+ 685765508599211085406992031398401158759299079491541508764000248557024672719959118395646962442045349201660590667234013968119772982843080987903012964780708787451812337588750783066948774723991753080189067657794974398949244241113521123786594812548932026532556574571938698730267509225767960757581162756440064010p 0.9
+ \]
V_wl_bar_1007 (WordLine_bar\\<1007\\> gnd!) vsource type=pwl wave=\[
+ 0    0.9
+ 1371531017198422170813984062796802317518598158983083017528000497114049345439918236791293924884090698403321181334468027936239545965686161975806025929561417574903624675177501566133897549447983506160378135315589948797898488482227042247573189625097864053065113149143877397460535018451535921515162325512880127500p 0.9
+ 1371531017198422170813984062796802317518598158983083017528000497114049345439918236791293924884090698403321181334468027936239545965686161975806025929561417574903624675177501566133897549447983506160378135315589948797898488482227042247573189625097864053065113149143877397460535018451535921515162325512880127510p -0.3
+ 1371531017198422170813984062796802317518598158983083017528000497114049345439918236791293924884090698403321181334468027936239545965686161975806025929561417574903624675177501566133897549447983506160378135315589948797898488482227042247573189625097864053065113149143877397460535018451535921515162325512880128000p -0.3
+ 1371531017198422170813984062796802317518598158983083017528000497114049345439918236791293924884090698403321181334468027936239545965686161975806025929561417574903624675177501566133897549447983506160378135315589948797898488482227042247573189625097864053065113149143877397460535018451535921515162325512880128010p 0.9
+ \]
V_wl_bar_1008 (WordLine_bar\\<1008\\> gnd!) vsource type=pwl wave=\[
+ 0    0.9
+ 2743062034396844341627968125593604635037196317966166035056000994228098690879836473582587849768181396806642362668936055872479091931372323951612051859122835149807249350355003132267795098895967012320756270631179897595796976964454084495146379250195728106130226298287754794921070036903071843030324651025760255500p 0.9
+ 2743062034396844341627968125593604635037196317966166035056000994228098690879836473582587849768181396806642362668936055872479091931372323951612051859122835149807249350355003132267795098895967012320756270631179897595796976964454084495146379250195728106130226298287754794921070036903071843030324651025760255510p -0.3
+ 2743062034396844341627968125593604635037196317966166035056000994228098690879836473582587849768181396806642362668936055872479091931372323951612051859122835149807249350355003132267795098895967012320756270631179897595796976964454084495146379250195728106130226298287754794921070036903071843030324651025760256000p -0.3
+ 2743062034396844341627968125593604635037196317966166035056000994228098690879836473582587849768181396806642362668936055872479091931372323951612051859122835149807249350355003132267795098895967012320756270631179897595796976964454084495146379250195728106130226298287754794921070036903071843030324651025760256010p 0.9
+ \]
V_wl_bar_1009 (WordLine_bar\\<1009\\> gnd!) vsource type=pwl wave=\[
+ 0    0.9
+ 5486124068793688683255936251187209270074392635932332070112001988456197381759672947165175699536362793613284725337872111744958183862744647903224103718245670299614498700710006264535590197791934024641512541262359795191593953928908168990292758500391456212260452596575509589842140073806143686060649302051520511500p 0.9
+ 5486124068793688683255936251187209270074392635932332070112001988456197381759672947165175699536362793613284725337872111744958183862744647903224103718245670299614498700710006264535590197791934024641512541262359795191593953928908168990292758500391456212260452596575509589842140073806143686060649302051520511510p -0.3
+ 5486124068793688683255936251187209270074392635932332070112001988456197381759672947165175699536362793613284725337872111744958183862744647903224103718245670299614498700710006264535590197791934024641512541262359795191593953928908168990292758500391456212260452596575509589842140073806143686060649302051520512000p -0.3
+ 5486124068793688683255936251187209270074392635932332070112001988456197381759672947165175699536362793613284725337872111744958183862744647903224103718245670299614498700710006264535590197791934024641512541262359795191593953928908168990292758500391456212260452596575509589842140073806143686060649302051520512010p 0.9
+ \]
V_wl_bar_1010 (WordLine_bar\\<1010\\> gnd!) vsource type=pwl wave=\[
+ 0    0.9
+ 10972248137587377366511872502374418540148785271864664140224003976912394763519345894330351399072725587226569450675744223489916367725489295806448207436491340599228997401420012529071180395583868049283025082524719590383187907857816337980585517000782912424520905193151019179684280147612287372121298604103041023500p 0.9
+ 10972248137587377366511872502374418540148785271864664140224003976912394763519345894330351399072725587226569450675744223489916367725489295806448207436491340599228997401420012529071180395583868049283025082524719590383187907857816337980585517000782912424520905193151019179684280147612287372121298604103041023510p -0.3
+ 10972248137587377366511872502374418540148785271864664140224003976912394763519345894330351399072725587226569450675744223489916367725489295806448207436491340599228997401420012529071180395583868049283025082524719590383187907857816337980585517000782912424520905193151019179684280147612287372121298604103041024000p -0.3
+ 10972248137587377366511872502374418540148785271864664140224003976912394763519345894330351399072725587226569450675744223489916367725489295806448207436491340599228997401420012529071180395583868049283025082524719590383187907857816337980585517000782912424520905193151019179684280147612287372121298604103041024010p 0.9
+ \]
V_wl_bar_1011 (WordLine_bar\\<1011\\> gnd!) vsource type=pwl wave=\[
+ 0    0.9
+ 21944496275174754733023745004748837080297570543729328280448007953824789527038691788660702798145451174453138901351488446979832735450978591612896414872982681198457994802840025058142360791167736098566050165049439180766375815715632675961171034001565824849041810386302038359368560295224574744242597208206082047500p 0.9
+ 21944496275174754733023745004748837080297570543729328280448007953824789527038691788660702798145451174453138901351488446979832735450978591612896414872982681198457994802840025058142360791167736098566050165049439180766375815715632675961171034001565824849041810386302038359368560295224574744242597208206082047510p -0.3
+ 21944496275174754733023745004748837080297570543729328280448007953824789527038691788660702798145451174453138901351488446979832735450978591612896414872982681198457994802840025058142360791167736098566050165049439180766375815715632675961171034001565824849041810386302038359368560295224574744242597208206082048000p -0.3
+ 21944496275174754733023745004748837080297570543729328280448007953824789527038691788660702798145451174453138901351488446979832735450978591612896414872982681198457994802840025058142360791167736098566050165049439180766375815715632675961171034001565824849041810386302038359368560295224574744242597208206082048010p 0.9
+ \]
V_wl_bar_1012 (WordLine_bar\\<1012\\> gnd!) vsource type=pwl wave=\[
+ 0    0.9
+ 43888992550349509466047490009497674160595141087458656560896015907649579054077383577321405596290902348906277802702976893959665470901957183225792829745965362396915989605680050116284721582335472197132100330098878361532751631431265351922342068003131649698083620772604076718737120590449149488485194416412164095500p 0.9
+ 43888992550349509466047490009497674160595141087458656560896015907649579054077383577321405596290902348906277802702976893959665470901957183225792829745965362396915989605680050116284721582335472197132100330098878361532751631431265351922342068003131649698083620772604076718737120590449149488485194416412164095510p -0.3
+ 43888992550349509466047490009497674160595141087458656560896015907649579054077383577321405596290902348906277802702976893959665470901957183225792829745965362396915989605680050116284721582335472197132100330098878361532751631431265351922342068003131649698083620772604076718737120590449149488485194416412164096000p -0.3
+ 43888992550349509466047490009497674160595141087458656560896015907649579054077383577321405596290902348906277802702976893959665470901957183225792829745965362396915989605680050116284721582335472197132100330098878361532751631431265351922342068003131649698083620772604076718737120590449149488485194416412164096010p 0.9
+ \]
V_wl_bar_1013 (WordLine_bar\\<1013\\> gnd!) vsource type=pwl wave=\[
+ 0    0.9
+ 87777985100699018932094980018995348321190282174917313121792031815299158108154767154642811192581804697812555605405953787919330941803914366451585659491930724793831979211360100232569443164670944394264200660197756723065503262862530703844684136006263299396167241545208153437474241180898298976970388832824328191500p 0.9
+ 87777985100699018932094980018995348321190282174917313121792031815299158108154767154642811192581804697812555605405953787919330941803914366451585659491930724793831979211360100232569443164670944394264200660197756723065503262862530703844684136006263299396167241545208153437474241180898298976970388832824328191510p -0.3
+ 87777985100699018932094980018995348321190282174917313121792031815299158108154767154642811192581804697812555605405953787919330941803914366451585659491930724793831979211360100232569443164670944394264200660197756723065503262862530703844684136006263299396167241545208153437474241180898298976970388832824328192000p -0.3
+ 87777985100699018932094980018995348321190282174917313121792031815299158108154767154642811192581804697812555605405953787919330941803914366451585659491930724793831979211360100232569443164670944394264200660197756723065503262862530703844684136006263299396167241545208153437474241180898298976970388832824328192010p 0.9
+ \]
V_wl_bar_1014 (WordLine_bar\\<1014\\> gnd!) vsource type=pwl wave=\[
+ 0    0.9
+ 175555970201398037864189960037990696642380564349834626243584063630598316216309534309285622385163609395625111210811907575838661883607828732903171318983861449587663958422720200465138886329341888788528401320395513446131006525725061407689368272012526598792334483090416306874948482361796597953940777665648656383500p 0.9
+ 175555970201398037864189960037990696642380564349834626243584063630598316216309534309285622385163609395625111210811907575838661883607828732903171318983861449587663958422720200465138886329341888788528401320395513446131006525725061407689368272012526598792334483090416306874948482361796597953940777665648656383510p -0.3
+ 175555970201398037864189960037990696642380564349834626243584063630598316216309534309285622385163609395625111210811907575838661883607828732903171318983861449587663958422720200465138886329341888788528401320395513446131006525725061407689368272012526598792334483090416306874948482361796597953940777665648656384000p -0.3
+ 175555970201398037864189960037990696642380564349834626243584063630598316216309534309285622385163609395625111210811907575838661883607828732903171318983861449587663958422720200465138886329341888788528401320395513446131006525725061407689368272012526598792334483090416306874948482361796597953940777665648656384010p 0.9
+ \]
V_wl_bar_1015 (WordLine_bar\\<1015\\> gnd!) vsource type=pwl wave=\[
+ 0    0.9
+ 351111940402796075728379920075981393284761128699669252487168127261196632432619068618571244770327218791250222421623815151677323767215657465806342637967722899175327916845440400930277772658683777577056802640791026892262013051450122815378736544025053197584668966180832613749896964723593195907881555331297312767500p 0.9
+ 351111940402796075728379920075981393284761128699669252487168127261196632432619068618571244770327218791250222421623815151677323767215657465806342637967722899175327916845440400930277772658683777577056802640791026892262013051450122815378736544025053197584668966180832613749896964723593195907881555331297312767510p -0.3
+ 351111940402796075728379920075981393284761128699669252487168127261196632432619068618571244770327218791250222421623815151677323767215657465806342637967722899175327916845440400930277772658683777577056802640791026892262013051450122815378736544025053197584668966180832613749896964723593195907881555331297312768000p -0.3
+ 351111940402796075728379920075981393284761128699669252487168127261196632432619068618571244770327218791250222421623815151677323767215657465806342637967722899175327916845440400930277772658683777577056802640791026892262013051450122815378736544025053197584668966180832613749896964723593195907881555331297312768010p 0.9
+ \]
V_wl_bar_1016 (WordLine_bar\\<1016\\> gnd!) vsource type=pwl wave=\[
+ 0    0.9
+ 702223880805592151456759840151962786569522257399338504974336254522393264865238137237142489540654437582500444843247630303354647534431314931612685275935445798350655833690880801860555545317367555154113605281582053784524026102900245630757473088050106395169337932361665227499793929447186391815763110662594625535500p 0.9
+ 702223880805592151456759840151962786569522257399338504974336254522393264865238137237142489540654437582500444843247630303354647534431314931612685275935445798350655833690880801860555545317367555154113605281582053784524026102900245630757473088050106395169337932361665227499793929447186391815763110662594625535510p -0.3
+ 702223880805592151456759840151962786569522257399338504974336254522393264865238137237142489540654437582500444843247630303354647534431314931612685275935445798350655833690880801860555545317367555154113605281582053784524026102900245630757473088050106395169337932361665227499793929447186391815763110662594625536000p -0.3
+ 702223880805592151456759840151962786569522257399338504974336254522393264865238137237142489540654437582500444843247630303354647534431314931612685275935445798350655833690880801860555545317367555154113605281582053784524026102900245630757473088050106395169337932361665227499793929447186391815763110662594625536010p 0.9
+ \]
V_wl_bar_1017 (WordLine_bar\\<1017\\> gnd!) vsource type=pwl wave=\[
+ 0    0.9
+ 1404447761611184302913519680303925573139044514798677009948672509044786529730476274474284979081308875165000889686495260606709295068862629863225370551870891596701311667381761603721111090634735110308227210563164107569048052205800491261514946176100212790338675864723330454999587858894372783631526221325189251071500p 0.9
+ 1404447761611184302913519680303925573139044514798677009948672509044786529730476274474284979081308875165000889686495260606709295068862629863225370551870891596701311667381761603721111090634735110308227210563164107569048052205800491261514946176100212790338675864723330454999587858894372783631526221325189251071510p -0.3
+ 1404447761611184302913519680303925573139044514798677009948672509044786529730476274474284979081308875165000889686495260606709295068862629863225370551870891596701311667381761603721111090634735110308227210563164107569048052205800491261514946176100212790338675864723330454999587858894372783631526221325189251072000p -0.3
+ 1404447761611184302913519680303925573139044514798677009948672509044786529730476274474284979081308875165000889686495260606709295068862629863225370551870891596701311667381761603721111090634735110308227210563164107569048052205800491261514946176100212790338675864723330454999587858894372783631526221325189251072010p 0.9
+ \]
V_wl_bar_1018 (WordLine_bar\\<1018\\> gnd!) vsource type=pwl wave=\[
+ 0    0.9
+ 2808895523222368605827039360607851146278089029597354019897345018089573059460952548948569958162617750330001779372990521213418590137725259726450741103741783193402623334763523207442222181269470220616454421126328215138096104411600982523029892352200425580677351729446660909999175717788745567263052442650378502143500p 0.9
+ 2808895523222368605827039360607851146278089029597354019897345018089573059460952548948569958162617750330001779372990521213418590137725259726450741103741783193402623334763523207442222181269470220616454421126328215138096104411600982523029892352200425580677351729446660909999175717788745567263052442650378502143510p -0.3
+ 2808895523222368605827039360607851146278089029597354019897345018089573059460952548948569958162617750330001779372990521213418590137725259726450741103741783193402623334763523207442222181269470220616454421126328215138096104411600982523029892352200425580677351729446660909999175717788745567263052442650378502144000p -0.3
+ 2808895523222368605827039360607851146278089029597354019897345018089573059460952548948569958162617750330001779372990521213418590137725259726450741103741783193402623334763523207442222181269470220616454421126328215138096104411600982523029892352200425580677351729446660909999175717788745567263052442650378502144010p 0.9
+ \]
V_wl_bar_1019 (WordLine_bar\\<1019\\> gnd!) vsource type=pwl wave=\[
+ 0    0.9
+ 5617791046444737211654078721215702292556178059194708039794690036179146118921905097897139916325235500660003558745981042426837180275450519452901482207483566386805246669527046414884444362538940441232908842252656430276192208823201965046059784704400851161354703458893321819998351435577491134526104885300757004287500p 0.9
+ 5617791046444737211654078721215702292556178059194708039794690036179146118921905097897139916325235500660003558745981042426837180275450519452901482207483566386805246669527046414884444362538940441232908842252656430276192208823201965046059784704400851161354703458893321819998351435577491134526104885300757004287510p -0.3
+ 5617791046444737211654078721215702292556178059194708039794690036179146118921905097897139916325235500660003558745981042426837180275450519452901482207483566386805246669527046414884444362538940441232908842252656430276192208823201965046059784704400851161354703458893321819998351435577491134526104885300757004288000p -0.3
+ 5617791046444737211654078721215702292556178059194708039794690036179146118921905097897139916325235500660003558745981042426837180275450519452901482207483566386805246669527046414884444362538940441232908842252656430276192208823201965046059784704400851161354703458893321819998351435577491134526104885300757004288010p 0.9
+ \]
V_wl_bar_1020 (WordLine_bar\\<1020\\> gnd!) vsource type=pwl wave=\[
+ 0    0.9
+ 11235582092889474423308157442431404585112356118389416079589380072358292237843810195794279832650471001320007117491962084853674360550901038905802964414967132773610493339054092829768888725077880882465817684505312860552384417646403930092119569408801702322709406917786643639996702871154982269052209770601514008575500p 0.9
+ 11235582092889474423308157442431404585112356118389416079589380072358292237843810195794279832650471001320007117491962084853674360550901038905802964414967132773610493339054092829768888725077880882465817684505312860552384417646403930092119569408801702322709406917786643639996702871154982269052209770601514008575510p -0.3
+ 11235582092889474423308157442431404585112356118389416079589380072358292237843810195794279832650471001320007117491962084853674360550901038905802964414967132773610493339054092829768888725077880882465817684505312860552384417646403930092119569408801702322709406917786643639996702871154982269052209770601514008576000p -0.3
+ 11235582092889474423308157442431404585112356118389416079589380072358292237843810195794279832650471001320007117491962084853674360550901038905802964414967132773610493339054092829768888725077880882465817684505312860552384417646403930092119569408801702322709406917786643639996702871154982269052209770601514008576010p 0.9
+ \]
V_wl_bar_1021 (WordLine_bar\\<1021\\> gnd!) vsource type=pwl wave=\[
+ 0    0.9
+ 22471164185778948846616314884862809170224712236778832159178760144716584475687620391588559665300942002640014234983924169707348721101802077811605928829934265547220986678108185659537777450155761764931635369010625721104768835292807860184239138817603404645418813835573287279993405742309964538104419541203028017151500p 0.9
+ 22471164185778948846616314884862809170224712236778832159178760144716584475687620391588559665300942002640014234983924169707348721101802077811605928829934265547220986678108185659537777450155761764931635369010625721104768835292807860184239138817603404645418813835573287279993405742309964538104419541203028017151510p -0.3
+ 22471164185778948846616314884862809170224712236778832159178760144716584475687620391588559665300942002640014234983924169707348721101802077811605928829934265547220986678108185659537777450155761764931635369010625721104768835292807860184239138817603404645418813835573287279993405742309964538104419541203028017152000p -0.3
+ 22471164185778948846616314884862809170224712236778832159178760144716584475687620391588559665300942002640014234983924169707348721101802077811605928829934265547220986678108185659537777450155761764931635369010625721104768835292807860184239138817603404645418813835573287279993405742309964538104419541203028017152010p 0.9
+ \]
V_wl_bar_1022 (WordLine_bar\\<1022\\> gnd!) vsource type=pwl wave=\[
+ 0    0.9
+ 44942328371557897693232629769725618340449424473557664318357520289433168951375240783177119330601884005280028469967848339414697442203604155623211857659868531094441973356216371319075554900311523529863270738021251442209537670585615720368478277635206809290837627671146574559986811484619929076208839082406056034303500p 0.9
+ 44942328371557897693232629769725618340449424473557664318357520289433168951375240783177119330601884005280028469967848339414697442203604155623211857659868531094441973356216371319075554900311523529863270738021251442209537670585615720368478277635206809290837627671146574559986811484619929076208839082406056034303510p -0.3
+ 44942328371557897693232629769725618340449424473557664318357520289433168951375240783177119330601884005280028469967848339414697442203604155623211857659868531094441973356216371319075554900311523529863270738021251442209537670585615720368478277635206809290837627671146574559986811484619929076208839082406056034304000p -0.3
+ 44942328371557897693232629769725618340449424473557664318357520289433168951375240783177119330601884005280028469967848339414697442203604155623211857659868531094441973356216371319075554900311523529863270738021251442209537670585615720368478277635206809290837627671146574559986811484619929076208839082406056034304010p 0.9
+ \]
V_wl_bar_1023 (WordLine_bar\\<1023\\> gnd!) vsource type=pwl wave=\[
+ 0    0.9
+ 89884656743115795386465259539451236680898848947115328636715040578866337902750481566354238661203768010560056939935696678829394884407208311246423715319737062188883946712432742638151109800623047059726541476042502884419075341171231440736956555270413618581675255342293149119973622969239858152417678164812112068607500p 0.9
+ 89884656743115795386465259539451236680898848947115328636715040578866337902750481566354238661203768010560056939935696678829394884407208311246423715319737062188883946712432742638151109800623047059726541476042502884419075341171231440736956555270413618581675255342293149119973622969239858152417678164812112068607510p -0.3
+ 89884656743115795386465259539451236680898848947115328636715040578866337902750481566354238661203768010560056939935696678829394884407208311246423715319737062188883946712432742638151109800623047059726541476042502884419075341171231440736956555270413618581675255342293149119973622969239858152417678164812112068608000p -0.3
+ 89884656743115795386465259539451236680898848947115328636715040578866337902750481566354238661203768010560056939935696678829394884407208311246423715319737062188883946712432742638151109800623047059726541476042502884419075341171231440736956555270413618581675255342293149119973622969239858152417678164812112068608010p 0.9
+ \]
V_wl_0 (WordLine\\<0\\> gnd!) vsource type=pwl wave=\[
+ 0    -0.3
+ 700p -0.3
+ 710p 0.9
+ 1400p 0.9
+ 1410p -0.3
+ \]
V_wl_1 (WordLine\\<1\\> gnd!) vsource type=pwl wave=\[
+ 0    -0.3
+ 2100p -0.3
+ 2110p 0.9
+ 2800p 0.9
+ 2810p -0.3
+ \]
V_wl_2 (WordLine\\<2\\> gnd!) vsource type=pwl wave=\[
+ 0    -0.3
+ 4900p -0.3
+ 4910p 0.9
+ 5600p 0.9
+ 5610p -0.3
+ \]
V_wl_3 (WordLine\\<3\\> gnd!) vsource type=pwl wave=\[
+ 0    -0.3
+ 10500p -0.3
+ 10510p 0.9
+ 11200p 0.9
+ 11210p -0.3
+ \]
V_wl_4 (WordLine\\<4\\> gnd!) vsource type=pwl wave=\[
+ 0    -0.3
+ 21700p -0.3
+ 21710p 0.9
+ 22400p 0.9
+ 22410p -0.3
+ \]
V_wl_5 (WordLine\\<5\\> gnd!) vsource type=pwl wave=\[
+ 0    -0.3
+ 44100p -0.3
+ 44110p 0.9
+ 44800p 0.9
+ 44810p -0.3
+ \]
V_wl_6 (WordLine\\<6\\> gnd!) vsource type=pwl wave=\[
+ 0    -0.3
+ 88900p -0.3
+ 88910p 0.9
+ 89600p 0.9
+ 89610p -0.3
+ \]
V_wl_7 (WordLine\\<7\\> gnd!) vsource type=pwl wave=\[
+ 0    -0.3
+ 178500p -0.3
+ 178510p 0.9
+ 179200p 0.9
+ 179210p -0.3
+ \]
V_wl_8 (WordLine\\<8\\> gnd!) vsource type=pwl wave=\[
+ 0    -0.3
+ 357700p -0.3
+ 357710p 0.9
+ 358400p 0.9
+ 358410p -0.3
+ \]
V_wl_9 (WordLine\\<9\\> gnd!) vsource type=pwl wave=\[
+ 0    -0.3
+ 716100p -0.3
+ 716110p 0.9
+ 716800p 0.9
+ 716810p -0.3
+ \]
V_wl_10 (WordLine\\<10\\> gnd!) vsource type=pwl wave=\[
+ 0    -0.3
+ 1432900p -0.3
+ 1432910p 0.9
+ 1433600p 0.9
+ 1433610p -0.3
+ \]
V_wl_11 (WordLine\\<11\\> gnd!) vsource type=pwl wave=\[
+ 0    -0.3
+ 2866500p -0.3
+ 2866510p 0.9
+ 2867200p 0.9
+ 2867210p -0.3
+ \]
V_wl_12 (WordLine\\<12\\> gnd!) vsource type=pwl wave=\[
+ 0    -0.3
+ 5733700p -0.3
+ 5733710p 0.9
+ 5734400p 0.9
+ 5734410p -0.3
+ \]
V_wl_13 (WordLine\\<13\\> gnd!) vsource type=pwl wave=\[
+ 0    -0.3
+ 11468100p -0.3
+ 11468110p 0.9
+ 11468800p 0.9
+ 11468810p -0.3
+ \]
V_wl_14 (WordLine\\<14\\> gnd!) vsource type=pwl wave=\[
+ 0    -0.3
+ 22936900p -0.3
+ 22936910p 0.9
+ 22937600p 0.9
+ 22937610p -0.3
+ \]
V_wl_15 (WordLine\\<15\\> gnd!) vsource type=pwl wave=\[
+ 0    -0.3
+ 45874500p -0.3
+ 45874510p 0.9
+ 45875200p 0.9
+ 45875210p -0.3
+ \]
V_wl_16 (WordLine\\<16\\> gnd!) vsource type=pwl wave=\[
+ 0    -0.3
+ 91749700p -0.3
+ 91749710p 0.9
+ 91750400p 0.9
+ 91750410p -0.3
+ \]
V_wl_17 (WordLine\\<17\\> gnd!) vsource type=pwl wave=\[
+ 0    -0.3
+ 183500100p -0.3
+ 183500110p 0.9
+ 183500800p 0.9
+ 183500810p -0.3
+ \]
V_wl_18 (WordLine\\<18\\> gnd!) vsource type=pwl wave=\[
+ 0    -0.3
+ 367000900p -0.3
+ 367000910p 0.9
+ 367001600p 0.9
+ 367001610p -0.3
+ \]
V_wl_19 (WordLine\\<19\\> gnd!) vsource type=pwl wave=\[
+ 0    -0.3
+ 734002500p -0.3
+ 734002510p 0.9
+ 734003200p 0.9
+ 734003210p -0.3
+ \]
V_wl_20 (WordLine\\<20\\> gnd!) vsource type=pwl wave=\[
+ 0    -0.3
+ 1468005700p -0.3
+ 1468005710p 0.9
+ 1468006400p 0.9
+ 1468006410p -0.3
+ \]
V_wl_21 (WordLine\\<21\\> gnd!) vsource type=pwl wave=\[
+ 0    -0.3
+ 2936012100p -0.3
+ 2936012110p 0.9
+ 2936012800p 0.9
+ 2936012810p -0.3
+ \]
V_wl_22 (WordLine\\<22\\> gnd!) vsource type=pwl wave=\[
+ 0    -0.3
+ 5872024900p -0.3
+ 5872024910p 0.9
+ 5872025600p 0.9
+ 5872025610p -0.3
+ \]
V_wl_23 (WordLine\\<23\\> gnd!) vsource type=pwl wave=\[
+ 0    -0.3
+ 11744050500p -0.3
+ 11744050510p 0.9
+ 11744051200p 0.9
+ 11744051210p -0.3
+ \]
V_wl_24 (WordLine\\<24\\> gnd!) vsource type=pwl wave=\[
+ 0    -0.3
+ 23488101700p -0.3
+ 23488101710p 0.9
+ 23488102400p 0.9
+ 23488102410p -0.3
+ \]
V_wl_25 (WordLine\\<25\\> gnd!) vsource type=pwl wave=\[
+ 0    -0.3
+ 46976204100p -0.3
+ 46976204110p 0.9
+ 46976204800p 0.9
+ 46976204810p -0.3
+ \]
V_wl_26 (WordLine\\<26\\> gnd!) vsource type=pwl wave=\[
+ 0    -0.3
+ 93952408900p -0.3
+ 93952408910p 0.9
+ 93952409600p 0.9
+ 93952409610p -0.3
+ \]
V_wl_27 (WordLine\\<27\\> gnd!) vsource type=pwl wave=\[
+ 0    -0.3
+ 187904818500p -0.3
+ 187904818510p 0.9
+ 187904819200p 0.9
+ 187904819210p -0.3
+ \]
V_wl_28 (WordLine\\<28\\> gnd!) vsource type=pwl wave=\[
+ 0    -0.3
+ 375809637700p -0.3
+ 375809637710p 0.9
+ 375809638400p 0.9
+ 375809638410p -0.3
+ \]
V_wl_29 (WordLine\\<29\\> gnd!) vsource type=pwl wave=\[
+ 0    -0.3
+ 751619276100p -0.3
+ 751619276110p 0.9
+ 751619276800p 0.9
+ 751619276810p -0.3
+ \]
V_wl_30 (WordLine\\<30\\> gnd!) vsource type=pwl wave=\[
+ 0    -0.3
+ 1503238552900p -0.3
+ 1503238552910p 0.9
+ 1503238553600p 0.9
+ 1503238553610p -0.3
+ \]
V_wl_31 (WordLine\\<31\\> gnd!) vsource type=pwl wave=\[
+ 0    -0.3
+ 3006477106500p -0.3
+ 3006477106510p 0.9
+ 3006477107200p 0.9
+ 3006477107210p -0.3
+ \]
V_wl_32 (WordLine\\<32\\> gnd!) vsource type=pwl wave=\[
+ 0    -0.3
+ 6012954213700p -0.3
+ 6012954213710p 0.9
+ 6012954214400p 0.9
+ 6012954214410p -0.3
+ \]
V_wl_33 (WordLine\\<33\\> gnd!) vsource type=pwl wave=\[
+ 0    -0.3
+ 12025908428100p -0.3
+ 12025908428110p 0.9
+ 12025908428800p 0.9
+ 12025908428810p -0.3
+ \]
V_wl_34 (WordLine\\<34\\> gnd!) vsource type=pwl wave=\[
+ 0    -0.3
+ 24051816856900p -0.3
+ 24051816856910p 0.9
+ 24051816857600p 0.9
+ 24051816857610p -0.3
+ \]
V_wl_35 (WordLine\\<35\\> gnd!) vsource type=pwl wave=\[
+ 0    -0.3
+ 48103633714500p -0.3
+ 48103633714510p 0.9
+ 48103633715200p 0.9
+ 48103633715210p -0.3
+ \]
V_wl_36 (WordLine\\<36\\> gnd!) vsource type=pwl wave=\[
+ 0    -0.3
+ 96207267429700p -0.3
+ 96207267429710p 0.9
+ 96207267430400p 0.9
+ 96207267430410p -0.3
+ \]
V_wl_37 (WordLine\\<37\\> gnd!) vsource type=pwl wave=\[
+ 0    -0.3
+ 192414534860100p -0.3
+ 192414534860110p 0.9
+ 192414534860800p 0.9
+ 192414534860810p -0.3
+ \]
V_wl_38 (WordLine\\<38\\> gnd!) vsource type=pwl wave=\[
+ 0    -0.3
+ 384829069720900p -0.3
+ 384829069720910p 0.9
+ 384829069721600p 0.9
+ 384829069721610p -0.3
+ \]
V_wl_39 (WordLine\\<39\\> gnd!) vsource type=pwl wave=\[
+ 0    -0.3
+ 769658139442500p -0.3
+ 769658139442510p 0.9
+ 769658139443200p 0.9
+ 769658139443210p -0.3
+ \]
V_wl_40 (WordLine\\<40\\> gnd!) vsource type=pwl wave=\[
+ 0    -0.3
+ 1539316278885700p -0.3
+ 1539316278885710p 0.9
+ 1539316278886400p 0.9
+ 1539316278886410p -0.3
+ \]
V_wl_41 (WordLine\\<41\\> gnd!) vsource type=pwl wave=\[
+ 0    -0.3
+ 3078632557772100p -0.3
+ 3078632557772110p 0.9
+ 3078632557772800p 0.9
+ 3078632557772810p -0.3
+ \]
V_wl_42 (WordLine\\<42\\> gnd!) vsource type=pwl wave=\[
+ 0    -0.3
+ 6157265115544900p -0.3
+ 6157265115544910p 0.9
+ 6157265115545600p 0.9
+ 6157265115545610p -0.3
+ \]
V_wl_43 (WordLine\\<43\\> gnd!) vsource type=pwl wave=\[
+ 0    -0.3
+ 12314530231090500p -0.3
+ 12314530231090510p 0.9
+ 12314530231091200p 0.9
+ 12314530231091210p -0.3
+ \]
V_wl_44 (WordLine\\<44\\> gnd!) vsource type=pwl wave=\[
+ 0    -0.3
+ 24629060462181700p -0.3
+ 24629060462181710p 0.9
+ 24629060462182400p 0.9
+ 24629060462182410p -0.3
+ \]
V_wl_45 (WordLine\\<45\\> gnd!) vsource type=pwl wave=\[
+ 0    -0.3
+ 49258120924364100p -0.3
+ 49258120924364110p 0.9
+ 49258120924364800p 0.9
+ 49258120924364810p -0.3
+ \]
V_wl_46 (WordLine\\<46\\> gnd!) vsource type=pwl wave=\[
+ 0    -0.3
+ 98516241848728900p -0.3
+ 98516241848728910p 0.9
+ 98516241848729600p 0.9
+ 98516241848729610p -0.3
+ \]
V_wl_47 (WordLine\\<47\\> gnd!) vsource type=pwl wave=\[
+ 0    -0.3
+ 197032483697458500p -0.3
+ 197032483697458510p 0.9
+ 197032483697459200p 0.9
+ 197032483697459210p -0.3
+ \]
V_wl_48 (WordLine\\<48\\> gnd!) vsource type=pwl wave=\[
+ 0    -0.3
+ 394064967394917700p -0.3
+ 394064967394917710p 0.9
+ 394064967394918400p 0.9
+ 394064967394918410p -0.3
+ \]
V_wl_49 (WordLine\\<49\\> gnd!) vsource type=pwl wave=\[
+ 0    -0.3
+ 788129934789836100p -0.3
+ 788129934789836110p 0.9
+ 788129934789836800p 0.9
+ 788129934789836810p -0.3
+ \]
V_wl_50 (WordLine\\<50\\> gnd!) vsource type=pwl wave=\[
+ 0    -0.3
+ 1576259869579672900p -0.3
+ 1576259869579672910p 0.9
+ 1576259869579673600p 0.9
+ 1576259869579673610p -0.3
+ \]
V_wl_51 (WordLine\\<51\\> gnd!) vsource type=pwl wave=\[
+ 0    -0.3
+ 3152519739159346500p -0.3
+ 3152519739159346510p 0.9
+ 3152519739159347200p 0.9
+ 3152519739159347210p -0.3
+ \]
V_wl_52 (WordLine\\<52\\> gnd!) vsource type=pwl wave=\[
+ 0    -0.3
+ 6305039478318693700p -0.3
+ 6305039478318693710p 0.9
+ 6305039478318694400p 0.9
+ 6305039478318694410p -0.3
+ \]
V_wl_53 (WordLine\\<53\\> gnd!) vsource type=pwl wave=\[
+ 0    -0.3
+ 12610078956637388100p -0.3
+ 12610078956637388110p 0.9
+ 12610078956637388800p 0.9
+ 12610078956637388810p -0.3
+ \]
V_wl_54 (WordLine\\<54\\> gnd!) vsource type=pwl wave=\[
+ 0    -0.3
+ 25220157913274776900p -0.3
+ 25220157913274776910p 0.9
+ 25220157913274777600p 0.9
+ 25220157913274777610p -0.3
+ \]
V_wl_55 (WordLine\\<55\\> gnd!) vsource type=pwl wave=\[
+ 0    -0.3
+ 50440315826549554500p -0.3
+ 50440315826549554510p 0.9
+ 50440315826549555200p 0.9
+ 50440315826549555210p -0.3
+ \]
V_wl_56 (WordLine\\<56\\> gnd!) vsource type=pwl wave=\[
+ 0    -0.3
+ 100880631653099109700p -0.3
+ 100880631653099109710p 0.9
+ 100880631653099110400p 0.9
+ 100880631653099110410p -0.3
+ \]
V_wl_57 (WordLine\\<57\\> gnd!) vsource type=pwl wave=\[
+ 0    -0.3
+ 201761263306198220100p -0.3
+ 201761263306198220110p 0.9
+ 201761263306198220800p 0.9
+ 201761263306198220810p -0.3
+ \]
V_wl_58 (WordLine\\<58\\> gnd!) vsource type=pwl wave=\[
+ 0    -0.3
+ 403522526612396440900p -0.3
+ 403522526612396440910p 0.9
+ 403522526612396441600p 0.9
+ 403522526612396441610p -0.3
+ \]
V_wl_59 (WordLine\\<59\\> gnd!) vsource type=pwl wave=\[
+ 0    -0.3
+ 807045053224792882500p -0.3
+ 807045053224792882510p 0.9
+ 807045053224792883200p 0.9
+ 807045053224792883210p -0.3
+ \]
V_wl_60 (WordLine\\<60\\> gnd!) vsource type=pwl wave=\[
+ 0    -0.3
+ 1614090106449585765700p -0.3
+ 1614090106449585765710p 0.9
+ 1614090106449585766400p 0.9
+ 1614090106449585766410p -0.3
+ \]
V_wl_61 (WordLine\\<61\\> gnd!) vsource type=pwl wave=\[
+ 0    -0.3
+ 3228180212899171532100p -0.3
+ 3228180212899171532110p 0.9
+ 3228180212899171532800p 0.9
+ 3228180212899171532810p -0.3
+ \]
V_wl_62 (WordLine\\<62\\> gnd!) vsource type=pwl wave=\[
+ 0    -0.3
+ 6456360425798343064900p -0.3
+ 6456360425798343064910p 0.9
+ 6456360425798343065600p 0.9
+ 6456360425798343065610p -0.3
+ \]
V_wl_63 (WordLine\\<63\\> gnd!) vsource type=pwl wave=\[
+ 0    -0.3
+ 12912720851596686130500p -0.3
+ 12912720851596686130510p 0.9
+ 12912720851596686131200p 0.9
+ 12912720851596686131210p -0.3
+ \]
V_wl_64 (WordLine\\<64\\> gnd!) vsource type=pwl wave=\[
+ 0    -0.3
+ 25825441703193372261700p -0.3
+ 25825441703193372261710p 0.9
+ 25825441703193372262400p 0.9
+ 25825441703193372262410p -0.3
+ \]
V_wl_65 (WordLine\\<65\\> gnd!) vsource type=pwl wave=\[
+ 0    -0.3
+ 51650883406386744524100p -0.3
+ 51650883406386744524110p 0.9
+ 51650883406386744524800p 0.9
+ 51650883406386744524810p -0.3
+ \]
V_wl_66 (WordLine\\<66\\> gnd!) vsource type=pwl wave=\[
+ 0    -0.3
+ 103301766812773489048900p -0.3
+ 103301766812773489048910p 0.9
+ 103301766812773489049600p 0.9
+ 103301766812773489049610p -0.3
+ \]
V_wl_67 (WordLine\\<67\\> gnd!) vsource type=pwl wave=\[
+ 0    -0.3
+ 206603533625546978098500p -0.3
+ 206603533625546978098510p 0.9
+ 206603533625546978099200p 0.9
+ 206603533625546978099210p -0.3
+ \]
V_wl_68 (WordLine\\<68\\> gnd!) vsource type=pwl wave=\[
+ 0    -0.3
+ 413207067251093956197700p -0.3
+ 413207067251093956197710p 0.9
+ 413207067251093956198400p 0.9
+ 413207067251093956198410p -0.3
+ \]
V_wl_69 (WordLine\\<69\\> gnd!) vsource type=pwl wave=\[
+ 0    -0.3
+ 826414134502187912396100p -0.3
+ 826414134502187912396110p 0.9
+ 826414134502187912396800p 0.9
+ 826414134502187912396810p -0.3
+ \]
V_wl_70 (WordLine\\<70\\> gnd!) vsource type=pwl wave=\[
+ 0    -0.3
+ 1652828269004375824792900p -0.3
+ 1652828269004375824792910p 0.9
+ 1652828269004375824793600p 0.9
+ 1652828269004375824793610p -0.3
+ \]
V_wl_71 (WordLine\\<71\\> gnd!) vsource type=pwl wave=\[
+ 0    -0.3
+ 3305656538008751649586500p -0.3
+ 3305656538008751649586510p 0.9
+ 3305656538008751649587200p 0.9
+ 3305656538008751649587210p -0.3
+ \]
V_wl_72 (WordLine\\<72\\> gnd!) vsource type=pwl wave=\[
+ 0    -0.3
+ 6611313076017503299173700p -0.3
+ 6611313076017503299173710p 0.9
+ 6611313076017503299174400p 0.9
+ 6611313076017503299174410p -0.3
+ \]
V_wl_73 (WordLine\\<73\\> gnd!) vsource type=pwl wave=\[
+ 0    -0.3
+ 13222626152035006598348100p -0.3
+ 13222626152035006598348110p 0.9
+ 13222626152035006598348800p 0.9
+ 13222626152035006598348810p -0.3
+ \]
V_wl_74 (WordLine\\<74\\> gnd!) vsource type=pwl wave=\[
+ 0    -0.3
+ 26445252304070013196696900p -0.3
+ 26445252304070013196696910p 0.9
+ 26445252304070013196697600p 0.9
+ 26445252304070013196697610p -0.3
+ \]
V_wl_75 (WordLine\\<75\\> gnd!) vsource type=pwl wave=\[
+ 0    -0.3
+ 52890504608140026393394500p -0.3
+ 52890504608140026393394510p 0.9
+ 52890504608140026393395200p 0.9
+ 52890504608140026393395210p -0.3
+ \]
V_wl_76 (WordLine\\<76\\> gnd!) vsource type=pwl wave=\[
+ 0    -0.3
+ 105781009216280052786789700p -0.3
+ 105781009216280052786789710p 0.9
+ 105781009216280052786790400p 0.9
+ 105781009216280052786790410p -0.3
+ \]
V_wl_77 (WordLine\\<77\\> gnd!) vsource type=pwl wave=\[
+ 0    -0.3
+ 211562018432560105573580100p -0.3
+ 211562018432560105573580110p 0.9
+ 211562018432560105573580800p 0.9
+ 211562018432560105573580810p -0.3
+ \]
V_wl_78 (WordLine\\<78\\> gnd!) vsource type=pwl wave=\[
+ 0    -0.3
+ 423124036865120211147160900p -0.3
+ 423124036865120211147160910p 0.9
+ 423124036865120211147161600p 0.9
+ 423124036865120211147161610p -0.3
+ \]
V_wl_79 (WordLine\\<79\\> gnd!) vsource type=pwl wave=\[
+ 0    -0.3
+ 846248073730240422294322500p -0.3
+ 846248073730240422294322510p 0.9
+ 846248073730240422294323200p 0.9
+ 846248073730240422294323210p -0.3
+ \]
V_wl_80 (WordLine\\<80\\> gnd!) vsource type=pwl wave=\[
+ 0    -0.3
+ 1692496147460480844588645700p -0.3
+ 1692496147460480844588645710p 0.9
+ 1692496147460480844588646400p 0.9
+ 1692496147460480844588646410p -0.3
+ \]
V_wl_81 (WordLine\\<81\\> gnd!) vsource type=pwl wave=\[
+ 0    -0.3
+ 3384992294920961689177292100p -0.3
+ 3384992294920961689177292110p 0.9
+ 3384992294920961689177292800p 0.9
+ 3384992294920961689177292810p -0.3
+ \]
V_wl_82 (WordLine\\<82\\> gnd!) vsource type=pwl wave=\[
+ 0    -0.3
+ 6769984589841923378354584900p -0.3
+ 6769984589841923378354584910p 0.9
+ 6769984589841923378354585600p 0.9
+ 6769984589841923378354585610p -0.3
+ \]
V_wl_83 (WordLine\\<83\\> gnd!) vsource type=pwl wave=\[
+ 0    -0.3
+ 13539969179683846756709170500p -0.3
+ 13539969179683846756709170510p 0.9
+ 13539969179683846756709171200p 0.9
+ 13539969179683846756709171210p -0.3
+ \]
V_wl_84 (WordLine\\<84\\> gnd!) vsource type=pwl wave=\[
+ 0    -0.3
+ 27079938359367693513418341700p -0.3
+ 27079938359367693513418341710p 0.9
+ 27079938359367693513418342400p 0.9
+ 27079938359367693513418342410p -0.3
+ \]
V_wl_85 (WordLine\\<85\\> gnd!) vsource type=pwl wave=\[
+ 0    -0.3
+ 54159876718735387026836684100p -0.3
+ 54159876718735387026836684110p 0.9
+ 54159876718735387026836684800p 0.9
+ 54159876718735387026836684810p -0.3
+ \]
V_wl_86 (WordLine\\<86\\> gnd!) vsource type=pwl wave=\[
+ 0    -0.3
+ 108319753437470774053673368900p -0.3
+ 108319753437470774053673368910p 0.9
+ 108319753437470774053673369600p 0.9
+ 108319753437470774053673369610p -0.3
+ \]
V_wl_87 (WordLine\\<87\\> gnd!) vsource type=pwl wave=\[
+ 0    -0.3
+ 216639506874941548107346738500p -0.3
+ 216639506874941548107346738510p 0.9
+ 216639506874941548107346739200p 0.9
+ 216639506874941548107346739210p -0.3
+ \]
V_wl_88 (WordLine\\<88\\> gnd!) vsource type=pwl wave=\[
+ 0    -0.3
+ 433279013749883096214693477700p -0.3
+ 433279013749883096214693477710p 0.9
+ 433279013749883096214693478400p 0.9
+ 433279013749883096214693478410p -0.3
+ \]
V_wl_89 (WordLine\\<89\\> gnd!) vsource type=pwl wave=\[
+ 0    -0.3
+ 866558027499766192429386956100p -0.3
+ 866558027499766192429386956110p 0.9
+ 866558027499766192429386956800p 0.9
+ 866558027499766192429386956810p -0.3
+ \]
V_wl_90 (WordLine\\<90\\> gnd!) vsource type=pwl wave=\[
+ 0    -0.3
+ 1733116054999532384858773912900p -0.3
+ 1733116054999532384858773912910p 0.9
+ 1733116054999532384858773913600p 0.9
+ 1733116054999532384858773913610p -0.3
+ \]
V_wl_91 (WordLine\\<91\\> gnd!) vsource type=pwl wave=\[
+ 0    -0.3
+ 3466232109999064769717547826500p -0.3
+ 3466232109999064769717547826510p 0.9
+ 3466232109999064769717547827200p 0.9
+ 3466232109999064769717547827210p -0.3
+ \]
V_wl_92 (WordLine\\<92\\> gnd!) vsource type=pwl wave=\[
+ 0    -0.3
+ 6932464219998129539435095653700p -0.3
+ 6932464219998129539435095653710p 0.9
+ 6932464219998129539435095654400p 0.9
+ 6932464219998129539435095654410p -0.3
+ \]
V_wl_93 (WordLine\\<93\\> gnd!) vsource type=pwl wave=\[
+ 0    -0.3
+ 13864928439996259078870191308100p -0.3
+ 13864928439996259078870191308110p 0.9
+ 13864928439996259078870191308800p 0.9
+ 13864928439996259078870191308810p -0.3
+ \]
V_wl_94 (WordLine\\<94\\> gnd!) vsource type=pwl wave=\[
+ 0    -0.3
+ 27729856879992518157740382616900p -0.3
+ 27729856879992518157740382616910p 0.9
+ 27729856879992518157740382617600p 0.9
+ 27729856879992518157740382617610p -0.3
+ \]
V_wl_95 (WordLine\\<95\\> gnd!) vsource type=pwl wave=\[
+ 0    -0.3
+ 55459713759985036315480765234500p -0.3
+ 55459713759985036315480765234510p 0.9
+ 55459713759985036315480765235200p 0.9
+ 55459713759985036315480765235210p -0.3
+ \]
V_wl_96 (WordLine\\<96\\> gnd!) vsource type=pwl wave=\[
+ 0    -0.3
+ 110919427519970072630961530469700p -0.3
+ 110919427519970072630961530469710p 0.9
+ 110919427519970072630961530470400p 0.9
+ 110919427519970072630961530470410p -0.3
+ \]
V_wl_97 (WordLine\\<97\\> gnd!) vsource type=pwl wave=\[
+ 0    -0.3
+ 221838855039940145261923060940100p -0.3
+ 221838855039940145261923060940110p 0.9
+ 221838855039940145261923060940800p 0.9
+ 221838855039940145261923060940810p -0.3
+ \]
V_wl_98 (WordLine\\<98\\> gnd!) vsource type=pwl wave=\[
+ 0    -0.3
+ 443677710079880290523846121880900p -0.3
+ 443677710079880290523846121880910p 0.9
+ 443677710079880290523846121881600p 0.9
+ 443677710079880290523846121881610p -0.3
+ \]
V_wl_99 (WordLine\\<99\\> gnd!) vsource type=pwl wave=\[
+ 0    -0.3
+ 887355420159760581047692243762500p -0.3
+ 887355420159760581047692243762510p 0.9
+ 887355420159760581047692243763200p 0.9
+ 887355420159760581047692243763210p -0.3
+ \]
V_wl_100 (WordLine\\<100\\> gnd!) vsource type=pwl wave=\[
+ 0    -0.3
+ 1774710840319521162095384487525700p -0.3
+ 1774710840319521162095384487525710p 0.9
+ 1774710840319521162095384487526400p 0.9
+ 1774710840319521162095384487526410p -0.3
+ \]
V_wl_101 (WordLine\\<101\\> gnd!) vsource type=pwl wave=\[
+ 0    -0.3
+ 3549421680639042324190768975052100p -0.3
+ 3549421680639042324190768975052110p 0.9
+ 3549421680639042324190768975052800p 0.9
+ 3549421680639042324190768975052810p -0.3
+ \]
V_wl_102 (WordLine\\<102\\> gnd!) vsource type=pwl wave=\[
+ 0    -0.3
+ 7098843361278084648381537950104900p -0.3
+ 7098843361278084648381537950104910p 0.9
+ 7098843361278084648381537950105600p 0.9
+ 7098843361278084648381537950105610p -0.3
+ \]
V_wl_103 (WordLine\\<103\\> gnd!) vsource type=pwl wave=\[
+ 0    -0.3
+ 14197686722556169296763075900210500p -0.3
+ 14197686722556169296763075900210510p 0.9
+ 14197686722556169296763075900211200p 0.9
+ 14197686722556169296763075900211210p -0.3
+ \]
V_wl_104 (WordLine\\<104\\> gnd!) vsource type=pwl wave=\[
+ 0    -0.3
+ 28395373445112338593526151800421700p -0.3
+ 28395373445112338593526151800421710p 0.9
+ 28395373445112338593526151800422400p 0.9
+ 28395373445112338593526151800422410p -0.3
+ \]
V_wl_105 (WordLine\\<105\\> gnd!) vsource type=pwl wave=\[
+ 0    -0.3
+ 56790746890224677187052303600844100p -0.3
+ 56790746890224677187052303600844110p 0.9
+ 56790746890224677187052303600844800p 0.9
+ 56790746890224677187052303600844810p -0.3
+ \]
V_wl_106 (WordLine\\<106\\> gnd!) vsource type=pwl wave=\[
+ 0    -0.3
+ 113581493780449354374104607201688900p -0.3
+ 113581493780449354374104607201688910p 0.9
+ 113581493780449354374104607201689600p 0.9
+ 113581493780449354374104607201689610p -0.3
+ \]
V_wl_107 (WordLine\\<107\\> gnd!) vsource type=pwl wave=\[
+ 0    -0.3
+ 227162987560898708748209214403378500p -0.3
+ 227162987560898708748209214403378510p 0.9
+ 227162987560898708748209214403379200p 0.9
+ 227162987560898708748209214403379210p -0.3
+ \]
V_wl_108 (WordLine\\<108\\> gnd!) vsource type=pwl wave=\[
+ 0    -0.3
+ 454325975121797417496418428806757700p -0.3
+ 454325975121797417496418428806757710p 0.9
+ 454325975121797417496418428806758400p 0.9
+ 454325975121797417496418428806758410p -0.3
+ \]
V_wl_109 (WordLine\\<109\\> gnd!) vsource type=pwl wave=\[
+ 0    -0.3
+ 908651950243594834992836857613516100p -0.3
+ 908651950243594834992836857613516110p 0.9
+ 908651950243594834992836857613516800p 0.9
+ 908651950243594834992836857613516810p -0.3
+ \]
V_wl_110 (WordLine\\<110\\> gnd!) vsource type=pwl wave=\[
+ 0    -0.3
+ 1817303900487189669985673715227032900p -0.3
+ 1817303900487189669985673715227032910p 0.9
+ 1817303900487189669985673715227033600p 0.9
+ 1817303900487189669985673715227033610p -0.3
+ \]
V_wl_111 (WordLine\\<111\\> gnd!) vsource type=pwl wave=\[
+ 0    -0.3
+ 3634607800974379339971347430454066500p -0.3
+ 3634607800974379339971347430454066510p 0.9
+ 3634607800974379339971347430454067200p 0.9
+ 3634607800974379339971347430454067210p -0.3
+ \]
V_wl_112 (WordLine\\<112\\> gnd!) vsource type=pwl wave=\[
+ 0    -0.3
+ 7269215601948758679942694860908133700p -0.3
+ 7269215601948758679942694860908133710p 0.9
+ 7269215601948758679942694860908134400p 0.9
+ 7269215601948758679942694860908134410p -0.3
+ \]
V_wl_113 (WordLine\\<113\\> gnd!) vsource type=pwl wave=\[
+ 0    -0.3
+ 14538431203897517359885389721816268100p -0.3
+ 14538431203897517359885389721816268110p 0.9
+ 14538431203897517359885389721816268800p 0.9
+ 14538431203897517359885389721816268810p -0.3
+ \]
V_wl_114 (WordLine\\<114\\> gnd!) vsource type=pwl wave=\[
+ 0    -0.3
+ 29076862407795034719770779443632536900p -0.3
+ 29076862407795034719770779443632536910p 0.9
+ 29076862407795034719770779443632537600p 0.9
+ 29076862407795034719770779443632537610p -0.3
+ \]
V_wl_115 (WordLine\\<115\\> gnd!) vsource type=pwl wave=\[
+ 0    -0.3
+ 58153724815590069439541558887265074500p -0.3
+ 58153724815590069439541558887265074510p 0.9
+ 58153724815590069439541558887265075200p 0.9
+ 58153724815590069439541558887265075210p -0.3
+ \]
V_wl_116 (WordLine\\<116\\> gnd!) vsource type=pwl wave=\[
+ 0    -0.3
+ 116307449631180138879083117774530149700p -0.3
+ 116307449631180138879083117774530149710p 0.9
+ 116307449631180138879083117774530150400p 0.9
+ 116307449631180138879083117774530150410p -0.3
+ \]
V_wl_117 (WordLine\\<117\\> gnd!) vsource type=pwl wave=\[
+ 0    -0.3
+ 232614899262360277758166235549060300100p -0.3
+ 232614899262360277758166235549060300110p 0.9
+ 232614899262360277758166235549060300800p 0.9
+ 232614899262360277758166235549060300810p -0.3
+ \]
V_wl_118 (WordLine\\<118\\> gnd!) vsource type=pwl wave=\[
+ 0    -0.3
+ 465229798524720555516332471098120600900p -0.3
+ 465229798524720555516332471098120600910p 0.9
+ 465229798524720555516332471098120601600p 0.9
+ 465229798524720555516332471098120601610p -0.3
+ \]
V_wl_119 (WordLine\\<119\\> gnd!) vsource type=pwl wave=\[
+ 0    -0.3
+ 930459597049441111032664942196241202500p -0.3
+ 930459597049441111032664942196241202510p 0.9
+ 930459597049441111032664942196241203200p 0.9
+ 930459597049441111032664942196241203210p -0.3
+ \]
V_wl_120 (WordLine\\<120\\> gnd!) vsource type=pwl wave=\[
+ 0    -0.3
+ 1860919194098882222065329884392482405700p -0.3
+ 1860919194098882222065329884392482405710p 0.9
+ 1860919194098882222065329884392482406400p 0.9
+ 1860919194098882222065329884392482406410p -0.3
+ \]
V_wl_121 (WordLine\\<121\\> gnd!) vsource type=pwl wave=\[
+ 0    -0.3
+ 3721838388197764444130659768784964812100p -0.3
+ 3721838388197764444130659768784964812110p 0.9
+ 3721838388197764444130659768784964812800p 0.9
+ 3721838388197764444130659768784964812810p -0.3
+ \]
V_wl_122 (WordLine\\<122\\> gnd!) vsource type=pwl wave=\[
+ 0    -0.3
+ 7443676776395528888261319537569929624900p -0.3
+ 7443676776395528888261319537569929624910p 0.9
+ 7443676776395528888261319537569929625600p 0.9
+ 7443676776395528888261319537569929625610p -0.3
+ \]
V_wl_123 (WordLine\\<123\\> gnd!) vsource type=pwl wave=\[
+ 0    -0.3
+ 14887353552791057776522639075139859250500p -0.3
+ 14887353552791057776522639075139859250510p 0.9
+ 14887353552791057776522639075139859251200p 0.9
+ 14887353552791057776522639075139859251210p -0.3
+ \]
V_wl_124 (WordLine\\<124\\> gnd!) vsource type=pwl wave=\[
+ 0    -0.3
+ 29774707105582115553045278150279718501700p -0.3
+ 29774707105582115553045278150279718501710p 0.9
+ 29774707105582115553045278150279718502400p 0.9
+ 29774707105582115553045278150279718502410p -0.3
+ \]
V_wl_125 (WordLine\\<125\\> gnd!) vsource type=pwl wave=\[
+ 0    -0.3
+ 59549414211164231106090556300559437004100p -0.3
+ 59549414211164231106090556300559437004110p 0.9
+ 59549414211164231106090556300559437004800p 0.9
+ 59549414211164231106090556300559437004810p -0.3
+ \]
V_wl_126 (WordLine\\<126\\> gnd!) vsource type=pwl wave=\[
+ 0    -0.3
+ 119098828422328462212181112601118874008900p -0.3
+ 119098828422328462212181112601118874008910p 0.9
+ 119098828422328462212181112601118874009600p 0.9
+ 119098828422328462212181112601118874009610p -0.3
+ \]
V_wl_127 (WordLine\\<127\\> gnd!) vsource type=pwl wave=\[
+ 0    -0.3
+ 238197656844656924424362225202237748018500p -0.3
+ 238197656844656924424362225202237748018510p 0.9
+ 238197656844656924424362225202237748019200p 0.9
+ 238197656844656924424362225202237748019210p -0.3
+ \]
V_wl_128 (WordLine\\<128\\> gnd!) vsource type=pwl wave=\[
+ 0    -0.3
+ 476395313689313848848724450404475496037700p -0.3
+ 476395313689313848848724450404475496037710p 0.9
+ 476395313689313848848724450404475496038400p 0.9
+ 476395313689313848848724450404475496038410p -0.3
+ \]
V_wl_129 (WordLine\\<129\\> gnd!) vsource type=pwl wave=\[
+ 0    -0.3
+ 952790627378627697697448900808950992076100p -0.3
+ 952790627378627697697448900808950992076110p 0.9
+ 952790627378627697697448900808950992076800p 0.9
+ 952790627378627697697448900808950992076810p -0.3
+ \]
V_wl_130 (WordLine\\<130\\> gnd!) vsource type=pwl wave=\[
+ 0    -0.3
+ 1905581254757255395394897801617901984152900p -0.3
+ 1905581254757255395394897801617901984152910p 0.9
+ 1905581254757255395394897801617901984153600p 0.9
+ 1905581254757255395394897801617901984153610p -0.3
+ \]
V_wl_131 (WordLine\\<131\\> gnd!) vsource type=pwl wave=\[
+ 0    -0.3
+ 3811162509514510790789795603235803968306500p -0.3
+ 3811162509514510790789795603235803968306510p 0.9
+ 3811162509514510790789795603235803968307200p 0.9
+ 3811162509514510790789795603235803968307210p -0.3
+ \]
V_wl_132 (WordLine\\<132\\> gnd!) vsource type=pwl wave=\[
+ 0    -0.3
+ 7622325019029021581579591206471607936613700p -0.3
+ 7622325019029021581579591206471607936613710p 0.9
+ 7622325019029021581579591206471607936614400p 0.9
+ 7622325019029021581579591206471607936614410p -0.3
+ \]
V_wl_133 (WordLine\\<133\\> gnd!) vsource type=pwl wave=\[
+ 0    -0.3
+ 15244650038058043163159182412943215873228100p -0.3
+ 15244650038058043163159182412943215873228110p 0.9
+ 15244650038058043163159182412943215873228800p 0.9
+ 15244650038058043163159182412943215873228810p -0.3
+ \]
V_wl_134 (WordLine\\<134\\> gnd!) vsource type=pwl wave=\[
+ 0    -0.3
+ 30489300076116086326318364825886431746456900p -0.3
+ 30489300076116086326318364825886431746456910p 0.9
+ 30489300076116086326318364825886431746457600p 0.9
+ 30489300076116086326318364825886431746457610p -0.3
+ \]
V_wl_135 (WordLine\\<135\\> gnd!) vsource type=pwl wave=\[
+ 0    -0.3
+ 60978600152232172652636729651772863492914500p -0.3
+ 60978600152232172652636729651772863492914510p 0.9
+ 60978600152232172652636729651772863492915200p 0.9
+ 60978600152232172652636729651772863492915210p -0.3
+ \]
V_wl_136 (WordLine\\<136\\> gnd!) vsource type=pwl wave=\[
+ 0    -0.3
+ 121957200304464345305273459303545726985829700p -0.3
+ 121957200304464345305273459303545726985829710p 0.9
+ 121957200304464345305273459303545726985830400p 0.9
+ 121957200304464345305273459303545726985830410p -0.3
+ \]
V_wl_137 (WordLine\\<137\\> gnd!) vsource type=pwl wave=\[
+ 0    -0.3
+ 243914400608928690610546918607091453971660100p -0.3
+ 243914400608928690610546918607091453971660110p 0.9
+ 243914400608928690610546918607091453971660800p 0.9
+ 243914400608928690610546918607091453971660810p -0.3
+ \]
V_wl_138 (WordLine\\<138\\> gnd!) vsource type=pwl wave=\[
+ 0    -0.3
+ 487828801217857381221093837214182907943320900p -0.3
+ 487828801217857381221093837214182907943320910p 0.9
+ 487828801217857381221093837214182907943321600p 0.9
+ 487828801217857381221093837214182907943321610p -0.3
+ \]
V_wl_139 (WordLine\\<139\\> gnd!) vsource type=pwl wave=\[
+ 0    -0.3
+ 975657602435714762442187674428365815886642500p -0.3
+ 975657602435714762442187674428365815886642510p 0.9
+ 975657602435714762442187674428365815886643200p 0.9
+ 975657602435714762442187674428365815886643210p -0.3
+ \]
V_wl_140 (WordLine\\<140\\> gnd!) vsource type=pwl wave=\[
+ 0    -0.3
+ 1951315204871429524884375348856731631773285700p -0.3
+ 1951315204871429524884375348856731631773285710p 0.9
+ 1951315204871429524884375348856731631773286400p 0.9
+ 1951315204871429524884375348856731631773286410p -0.3
+ \]
V_wl_141 (WordLine\\<141\\> gnd!) vsource type=pwl wave=\[
+ 0    -0.3
+ 3902630409742859049768750697713463263546572100p -0.3
+ 3902630409742859049768750697713463263546572110p 0.9
+ 3902630409742859049768750697713463263546572800p 0.9
+ 3902630409742859049768750697713463263546572810p -0.3
+ \]
V_wl_142 (WordLine\\<142\\> gnd!) vsource type=pwl wave=\[
+ 0    -0.3
+ 7805260819485718099537501395426926527093144900p -0.3
+ 7805260819485718099537501395426926527093144910p 0.9
+ 7805260819485718099537501395426926527093145600p 0.9
+ 7805260819485718099537501395426926527093145610p -0.3
+ \]
V_wl_143 (WordLine\\<143\\> gnd!) vsource type=pwl wave=\[
+ 0    -0.3
+ 15610521638971436199075002790853853054186290500p -0.3
+ 15610521638971436199075002790853853054186290510p 0.9
+ 15610521638971436199075002790853853054186291200p 0.9
+ 15610521638971436199075002790853853054186291210p -0.3
+ \]
V_wl_144 (WordLine\\<144\\> gnd!) vsource type=pwl wave=\[
+ 0    -0.3
+ 31221043277942872398150005581707706108372581700p -0.3
+ 31221043277942872398150005581707706108372581710p 0.9
+ 31221043277942872398150005581707706108372582400p 0.9
+ 31221043277942872398150005581707706108372582410p -0.3
+ \]
V_wl_145 (WordLine\\<145\\> gnd!) vsource type=pwl wave=\[
+ 0    -0.3
+ 62442086555885744796300011163415412216745164100p -0.3
+ 62442086555885744796300011163415412216745164110p 0.9
+ 62442086555885744796300011163415412216745164800p 0.9
+ 62442086555885744796300011163415412216745164810p -0.3
+ \]
V_wl_146 (WordLine\\<146\\> gnd!) vsource type=pwl wave=\[
+ 0    -0.3
+ 124884173111771489592600022326830824433490328900p -0.3
+ 124884173111771489592600022326830824433490328910p 0.9
+ 124884173111771489592600022326830824433490329600p 0.9
+ 124884173111771489592600022326830824433490329610p -0.3
+ \]
V_wl_147 (WordLine\\<147\\> gnd!) vsource type=pwl wave=\[
+ 0    -0.3
+ 249768346223542979185200044653661648866980658500p -0.3
+ 249768346223542979185200044653661648866980658510p 0.9
+ 249768346223542979185200044653661648866980659200p 0.9
+ 249768346223542979185200044653661648866980659210p -0.3
+ \]
V_wl_148 (WordLine\\<148\\> gnd!) vsource type=pwl wave=\[
+ 0    -0.3
+ 499536692447085958370400089307323297733961317700p -0.3
+ 499536692447085958370400089307323297733961317710p 0.9
+ 499536692447085958370400089307323297733961318400p 0.9
+ 499536692447085958370400089307323297733961318410p -0.3
+ \]
V_wl_149 (WordLine\\<149\\> gnd!) vsource type=pwl wave=\[
+ 0    -0.3
+ 999073384894171916740800178614646595467922636100p -0.3
+ 999073384894171916740800178614646595467922636110p 0.9
+ 999073384894171916740800178614646595467922636800p 0.9
+ 999073384894171916740800178614646595467922636810p -0.3
+ \]
V_wl_150 (WordLine\\<150\\> gnd!) vsource type=pwl wave=\[
+ 0    -0.3
+ 1998146769788343833481600357229293190935845272900p -0.3
+ 1998146769788343833481600357229293190935845272910p 0.9
+ 1998146769788343833481600357229293190935845273600p 0.9
+ 1998146769788343833481600357229293190935845273610p -0.3
+ \]
V_wl_151 (WordLine\\<151\\> gnd!) vsource type=pwl wave=\[
+ 0    -0.3
+ 3996293539576687666963200714458586381871690546500p -0.3
+ 3996293539576687666963200714458586381871690546510p 0.9
+ 3996293539576687666963200714458586381871690547200p 0.9
+ 3996293539576687666963200714458586381871690547210p -0.3
+ \]
V_wl_152 (WordLine\\<152\\> gnd!) vsource type=pwl wave=\[
+ 0    -0.3
+ 7992587079153375333926401428917172763743381093700p -0.3
+ 7992587079153375333926401428917172763743381093710p 0.9
+ 7992587079153375333926401428917172763743381094400p 0.9
+ 7992587079153375333926401428917172763743381094410p -0.3
+ \]
V_wl_153 (WordLine\\<153\\> gnd!) vsource type=pwl wave=\[
+ 0    -0.3
+ 15985174158306750667852802857834345527486762188100p -0.3
+ 15985174158306750667852802857834345527486762188110p 0.9
+ 15985174158306750667852802857834345527486762188800p 0.9
+ 15985174158306750667852802857834345527486762188810p -0.3
+ \]
V_wl_154 (WordLine\\<154\\> gnd!) vsource type=pwl wave=\[
+ 0    -0.3
+ 31970348316613501335705605715668691054973524376900p -0.3
+ 31970348316613501335705605715668691054973524376910p 0.9
+ 31970348316613501335705605715668691054973524377600p 0.9
+ 31970348316613501335705605715668691054973524377610p -0.3
+ \]
V_wl_155 (WordLine\\<155\\> gnd!) vsource type=pwl wave=\[
+ 0    -0.3
+ 63940696633227002671411211431337382109947048754500p -0.3
+ 63940696633227002671411211431337382109947048754510p 0.9
+ 63940696633227002671411211431337382109947048755200p 0.9
+ 63940696633227002671411211431337382109947048755210p -0.3
+ \]
V_wl_156 (WordLine\\<156\\> gnd!) vsource type=pwl wave=\[
+ 0    -0.3
+ 127881393266454005342822422862674764219894097509700p -0.3
+ 127881393266454005342822422862674764219894097509710p 0.9
+ 127881393266454005342822422862674764219894097510400p 0.9
+ 127881393266454005342822422862674764219894097510410p -0.3
+ \]
V_wl_157 (WordLine\\<157\\> gnd!) vsource type=pwl wave=\[
+ 0    -0.3
+ 255762786532908010685644845725349528439788195020100p -0.3
+ 255762786532908010685644845725349528439788195020110p 0.9
+ 255762786532908010685644845725349528439788195020800p 0.9
+ 255762786532908010685644845725349528439788195020810p -0.3
+ \]
V_wl_158 (WordLine\\<158\\> gnd!) vsource type=pwl wave=\[
+ 0    -0.3
+ 511525573065816021371289691450699056879576390040900p -0.3
+ 511525573065816021371289691450699056879576390040910p 0.9
+ 511525573065816021371289691450699056879576390041600p 0.9
+ 511525573065816021371289691450699056879576390041610p -0.3
+ \]
V_wl_159 (WordLine\\<159\\> gnd!) vsource type=pwl wave=\[
+ 0    -0.3
+ 1023051146131632042742579382901398113759152780082500p -0.3
+ 1023051146131632042742579382901398113759152780082510p 0.9
+ 1023051146131632042742579382901398113759152780083200p 0.9
+ 1023051146131632042742579382901398113759152780083210p -0.3
+ \]
V_wl_160 (WordLine\\<160\\> gnd!) vsource type=pwl wave=\[
+ 0    -0.3
+ 2046102292263264085485158765802796227518305560165700p -0.3
+ 2046102292263264085485158765802796227518305560165710p 0.9
+ 2046102292263264085485158765802796227518305560166400p 0.9
+ 2046102292263264085485158765802796227518305560166410p -0.3
+ \]
V_wl_161 (WordLine\\<161\\> gnd!) vsource type=pwl wave=\[
+ 0    -0.3
+ 4092204584526528170970317531605592455036611120332100p -0.3
+ 4092204584526528170970317531605592455036611120332110p 0.9
+ 4092204584526528170970317531605592455036611120332800p 0.9
+ 4092204584526528170970317531605592455036611120332810p -0.3
+ \]
V_wl_162 (WordLine\\<162\\> gnd!) vsource type=pwl wave=\[
+ 0    -0.3
+ 8184409169053056341940635063211184910073222240664900p -0.3
+ 8184409169053056341940635063211184910073222240664910p 0.9
+ 8184409169053056341940635063211184910073222240665600p 0.9
+ 8184409169053056341940635063211184910073222240665610p -0.3
+ \]
V_wl_163 (WordLine\\<163\\> gnd!) vsource type=pwl wave=\[
+ 0    -0.3
+ 16368818338106112683881270126422369820146444481330500p -0.3
+ 16368818338106112683881270126422369820146444481330510p 0.9
+ 16368818338106112683881270126422369820146444481331200p 0.9
+ 16368818338106112683881270126422369820146444481331210p -0.3
+ \]
V_wl_164 (WordLine\\<164\\> gnd!) vsource type=pwl wave=\[
+ 0    -0.3
+ 32737636676212225367762540252844739640292888962661700p -0.3
+ 32737636676212225367762540252844739640292888962661710p 0.9
+ 32737636676212225367762540252844739640292888962662400p 0.9
+ 32737636676212225367762540252844739640292888962662410p -0.3
+ \]
V_wl_165 (WordLine\\<165\\> gnd!) vsource type=pwl wave=\[
+ 0    -0.3
+ 65475273352424450735525080505689479280585777925324100p -0.3
+ 65475273352424450735525080505689479280585777925324110p 0.9
+ 65475273352424450735525080505689479280585777925324800p 0.9
+ 65475273352424450735525080505689479280585777925324810p -0.3
+ \]
V_wl_166 (WordLine\\<166\\> gnd!) vsource type=pwl wave=\[
+ 0    -0.3
+ 130950546704848901471050161011378958561171555850648900p -0.3
+ 130950546704848901471050161011378958561171555850648910p 0.9
+ 130950546704848901471050161011378958561171555850649600p 0.9
+ 130950546704848901471050161011378958561171555850649610p -0.3
+ \]
V_wl_167 (WordLine\\<167\\> gnd!) vsource type=pwl wave=\[
+ 0    -0.3
+ 261901093409697802942100322022757917122343111701298500p -0.3
+ 261901093409697802942100322022757917122343111701298510p 0.9
+ 261901093409697802942100322022757917122343111701299200p 0.9
+ 261901093409697802942100322022757917122343111701299210p -0.3
+ \]
V_wl_168 (WordLine\\<168\\> gnd!) vsource type=pwl wave=\[
+ 0    -0.3
+ 523802186819395605884200644045515834244686223402597700p -0.3
+ 523802186819395605884200644045515834244686223402597710p 0.9
+ 523802186819395605884200644045515834244686223402598400p 0.9
+ 523802186819395605884200644045515834244686223402598410p -0.3
+ \]
V_wl_169 (WordLine\\<169\\> gnd!) vsource type=pwl wave=\[
+ 0    -0.3
+ 1047604373638791211768401288091031668489372446805196100p -0.3
+ 1047604373638791211768401288091031668489372446805196110p 0.9
+ 1047604373638791211768401288091031668489372446805196800p 0.9
+ 1047604373638791211768401288091031668489372446805196810p -0.3
+ \]
V_wl_170 (WordLine\\<170\\> gnd!) vsource type=pwl wave=\[
+ 0    -0.3
+ 2095208747277582423536802576182063336978744893610392900p -0.3
+ 2095208747277582423536802576182063336978744893610392910p 0.9
+ 2095208747277582423536802576182063336978744893610393600p 0.9
+ 2095208747277582423536802576182063336978744893610393610p -0.3
+ \]
V_wl_171 (WordLine\\<171\\> gnd!) vsource type=pwl wave=\[
+ 0    -0.3
+ 4190417494555164847073605152364126673957489787220786500p -0.3
+ 4190417494555164847073605152364126673957489787220786510p 0.9
+ 4190417494555164847073605152364126673957489787220787200p 0.9
+ 4190417494555164847073605152364126673957489787220787210p -0.3
+ \]
V_wl_172 (WordLine\\<172\\> gnd!) vsource type=pwl wave=\[
+ 0    -0.3
+ 8380834989110329694147210304728253347914979574441573700p -0.3
+ 8380834989110329694147210304728253347914979574441573710p 0.9
+ 8380834989110329694147210304728253347914979574441574400p 0.9
+ 8380834989110329694147210304728253347914979574441574410p -0.3
+ \]
V_wl_173 (WordLine\\<173\\> gnd!) vsource type=pwl wave=\[
+ 0    -0.3
+ 16761669978220659388294420609456506695829959148883148100p -0.3
+ 16761669978220659388294420609456506695829959148883148110p 0.9
+ 16761669978220659388294420609456506695829959148883148800p 0.9
+ 16761669978220659388294420609456506695829959148883148810p -0.3
+ \]
V_wl_174 (WordLine\\<174\\> gnd!) vsource type=pwl wave=\[
+ 0    -0.3
+ 33523339956441318776588841218913013391659918297766296900p -0.3
+ 33523339956441318776588841218913013391659918297766296910p 0.9
+ 33523339956441318776588841218913013391659918297766297600p 0.9
+ 33523339956441318776588841218913013391659918297766297610p -0.3
+ \]
V_wl_175 (WordLine\\<175\\> gnd!) vsource type=pwl wave=\[
+ 0    -0.3
+ 67046679912882637553177682437826026783319836595532594500p -0.3
+ 67046679912882637553177682437826026783319836595532594510p 0.9
+ 67046679912882637553177682437826026783319836595532595200p 0.9
+ 67046679912882637553177682437826026783319836595532595210p -0.3
+ \]
V_wl_176 (WordLine\\<176\\> gnd!) vsource type=pwl wave=\[
+ 0    -0.3
+ 134093359825765275106355364875652053566639673191065189700p -0.3
+ 134093359825765275106355364875652053566639673191065189710p 0.9
+ 134093359825765275106355364875652053566639673191065190400p 0.9
+ 134093359825765275106355364875652053566639673191065190410p -0.3
+ \]
V_wl_177 (WordLine\\<177\\> gnd!) vsource type=pwl wave=\[
+ 0    -0.3
+ 268186719651530550212710729751304107133279346382130380100p -0.3
+ 268186719651530550212710729751304107133279346382130380110p 0.9
+ 268186719651530550212710729751304107133279346382130380800p 0.9
+ 268186719651530550212710729751304107133279346382130380810p -0.3
+ \]
V_wl_178 (WordLine\\<178\\> gnd!) vsource type=pwl wave=\[
+ 0    -0.3
+ 536373439303061100425421459502608214266558692764260760900p -0.3
+ 536373439303061100425421459502608214266558692764260760910p 0.9
+ 536373439303061100425421459502608214266558692764260761600p 0.9
+ 536373439303061100425421459502608214266558692764260761610p -0.3
+ \]
V_wl_179 (WordLine\\<179\\> gnd!) vsource type=pwl wave=\[
+ 0    -0.3
+ 1072746878606122200850842919005216428533117385528521522500p -0.3
+ 1072746878606122200850842919005216428533117385528521522510p 0.9
+ 1072746878606122200850842919005216428533117385528521523200p 0.9
+ 1072746878606122200850842919005216428533117385528521523210p -0.3
+ \]
V_wl_180 (WordLine\\<180\\> gnd!) vsource type=pwl wave=\[
+ 0    -0.3
+ 2145493757212244401701685838010432857066234771057043045700p -0.3
+ 2145493757212244401701685838010432857066234771057043045710p 0.9
+ 2145493757212244401701685838010432857066234771057043046400p 0.9
+ 2145493757212244401701685838010432857066234771057043046410p -0.3
+ \]
V_wl_181 (WordLine\\<181\\> gnd!) vsource type=pwl wave=\[
+ 0    -0.3
+ 4290987514424488803403371676020865714132469542114086092100p -0.3
+ 4290987514424488803403371676020865714132469542114086092110p 0.9
+ 4290987514424488803403371676020865714132469542114086092800p 0.9
+ 4290987514424488803403371676020865714132469542114086092810p -0.3
+ \]
V_wl_182 (WordLine\\<182\\> gnd!) vsource type=pwl wave=\[
+ 0    -0.3
+ 8581975028848977606806743352041731428264939084228172184900p -0.3
+ 8581975028848977606806743352041731428264939084228172184910p 0.9
+ 8581975028848977606806743352041731428264939084228172185600p 0.9
+ 8581975028848977606806743352041731428264939084228172185610p -0.3
+ \]
V_wl_183 (WordLine\\<183\\> gnd!) vsource type=pwl wave=\[
+ 0    -0.3
+ 17163950057697955213613486704083462856529878168456344370500p -0.3
+ 17163950057697955213613486704083462856529878168456344370510p 0.9
+ 17163950057697955213613486704083462856529878168456344371200p 0.9
+ 17163950057697955213613486704083462856529878168456344371210p -0.3
+ \]
V_wl_184 (WordLine\\<184\\> gnd!) vsource type=pwl wave=\[
+ 0    -0.3
+ 34327900115395910427226973408166925713059756336912688741700p -0.3
+ 34327900115395910427226973408166925713059756336912688741710p 0.9
+ 34327900115395910427226973408166925713059756336912688742400p 0.9
+ 34327900115395910427226973408166925713059756336912688742410p -0.3
+ \]
V_wl_185 (WordLine\\<185\\> gnd!) vsource type=pwl wave=\[
+ 0    -0.3
+ 68655800230791820854453946816333851426119512673825377484100p -0.3
+ 68655800230791820854453946816333851426119512673825377484110p 0.9
+ 68655800230791820854453946816333851426119512673825377484800p 0.9
+ 68655800230791820854453946816333851426119512673825377484810p -0.3
+ \]
V_wl_186 (WordLine\\<186\\> gnd!) vsource type=pwl wave=\[
+ 0    -0.3
+ 137311600461583641708907893632667702852239025347650754968900p -0.3
+ 137311600461583641708907893632667702852239025347650754968910p 0.9
+ 137311600461583641708907893632667702852239025347650754969600p 0.9
+ 137311600461583641708907893632667702852239025347650754969610p -0.3
+ \]
V_wl_187 (WordLine\\<187\\> gnd!) vsource type=pwl wave=\[
+ 0    -0.3
+ 274623200923167283417815787265335405704478050695301509938500p -0.3
+ 274623200923167283417815787265335405704478050695301509938510p 0.9
+ 274623200923167283417815787265335405704478050695301509939200p 0.9
+ 274623200923167283417815787265335405704478050695301509939210p -0.3
+ \]
V_wl_188 (WordLine\\<188\\> gnd!) vsource type=pwl wave=\[
+ 0    -0.3
+ 549246401846334566835631574530670811408956101390603019877700p -0.3
+ 549246401846334566835631574530670811408956101390603019877710p 0.9
+ 549246401846334566835631574530670811408956101390603019878400p 0.9
+ 549246401846334566835631574530670811408956101390603019878410p -0.3
+ \]
V_wl_189 (WordLine\\<189\\> gnd!) vsource type=pwl wave=\[
+ 0    -0.3
+ 1098492803692669133671263149061341622817912202781206039756100p -0.3
+ 1098492803692669133671263149061341622817912202781206039756110p 0.9
+ 1098492803692669133671263149061341622817912202781206039756800p 0.9
+ 1098492803692669133671263149061341622817912202781206039756810p -0.3
+ \]
V_wl_190 (WordLine\\<190\\> gnd!) vsource type=pwl wave=\[
+ 0    -0.3
+ 2196985607385338267342526298122683245635824405562412079512900p -0.3
+ 2196985607385338267342526298122683245635824405562412079512910p 0.9
+ 2196985607385338267342526298122683245635824405562412079513600p 0.9
+ 2196985607385338267342526298122683245635824405562412079513610p -0.3
+ \]
V_wl_191 (WordLine\\<191\\> gnd!) vsource type=pwl wave=\[
+ 0    -0.3
+ 4393971214770676534685052596245366491271648811124824159026500p -0.3
+ 4393971214770676534685052596245366491271648811124824159026510p 0.9
+ 4393971214770676534685052596245366491271648811124824159027200p 0.9
+ 4393971214770676534685052596245366491271648811124824159027210p -0.3
+ \]
V_wl_192 (WordLine\\<192\\> gnd!) vsource type=pwl wave=\[
+ 0    -0.3
+ 8787942429541353069370105192490732982543297622249648318053700p -0.3
+ 8787942429541353069370105192490732982543297622249648318053710p 0.9
+ 8787942429541353069370105192490732982543297622249648318054400p 0.9
+ 8787942429541353069370105192490732982543297622249648318054410p -0.3
+ \]
V_wl_193 (WordLine\\<193\\> gnd!) vsource type=pwl wave=\[
+ 0    -0.3
+ 17575884859082706138740210384981465965086595244499296636108100p -0.3
+ 17575884859082706138740210384981465965086595244499296636108110p 0.9
+ 17575884859082706138740210384981465965086595244499296636108800p 0.9
+ 17575884859082706138740210384981465965086595244499296636108810p -0.3
+ \]
V_wl_194 (WordLine\\<194\\> gnd!) vsource type=pwl wave=\[
+ 0    -0.3
+ 35151769718165412277480420769962931930173190488998593272216900p -0.3
+ 35151769718165412277480420769962931930173190488998593272216910p 0.9
+ 35151769718165412277480420769962931930173190488998593272217600p 0.9
+ 35151769718165412277480420769962931930173190488998593272217610p -0.3
+ \]
V_wl_195 (WordLine\\<195\\> gnd!) vsource type=pwl wave=\[
+ 0    -0.3
+ 70303539436330824554960841539925863860346380977997186544434500p -0.3
+ 70303539436330824554960841539925863860346380977997186544434510p 0.9
+ 70303539436330824554960841539925863860346380977997186544435200p 0.9
+ 70303539436330824554960841539925863860346380977997186544435210p -0.3
+ \]
V_wl_196 (WordLine\\<196\\> gnd!) vsource type=pwl wave=\[
+ 0    -0.3
+ 140607078872661649109921683079851727720692761955994373088869700p -0.3
+ 140607078872661649109921683079851727720692761955994373088869710p 0.9
+ 140607078872661649109921683079851727720692761955994373088870400p 0.9
+ 140607078872661649109921683079851727720692761955994373088870410p -0.3
+ \]
V_wl_197 (WordLine\\<197\\> gnd!) vsource type=pwl wave=\[
+ 0    -0.3
+ 281214157745323298219843366159703455441385523911988746177740100p -0.3
+ 281214157745323298219843366159703455441385523911988746177740110p 0.9
+ 281214157745323298219843366159703455441385523911988746177740800p 0.9
+ 281214157745323298219843366159703455441385523911988746177740810p -0.3
+ \]
V_wl_198 (WordLine\\<198\\> gnd!) vsource type=pwl wave=\[
+ 0    -0.3
+ 562428315490646596439686732319406910882771047823977492355480900p -0.3
+ 562428315490646596439686732319406910882771047823977492355480910p 0.9
+ 562428315490646596439686732319406910882771047823977492355481600p 0.9
+ 562428315490646596439686732319406910882771047823977492355481610p -0.3
+ \]
V_wl_199 (WordLine\\<199\\> gnd!) vsource type=pwl wave=\[
+ 0    -0.3
+ 1124856630981293192879373464638813821765542095647954984710962500p -0.3
+ 1124856630981293192879373464638813821765542095647954984710962510p 0.9
+ 1124856630981293192879373464638813821765542095647954984710963200p 0.9
+ 1124856630981293192879373464638813821765542095647954984710963210p -0.3
+ \]
V_wl_200 (WordLine\\<200\\> gnd!) vsource type=pwl wave=\[
+ 0    -0.3
+ 2249713261962586385758746929277627643531084191295909969421925700p -0.3
+ 2249713261962586385758746929277627643531084191295909969421925710p 0.9
+ 2249713261962586385758746929277627643531084191295909969421926400p 0.9
+ 2249713261962586385758746929277627643531084191295909969421926410p -0.3
+ \]
V_wl_201 (WordLine\\<201\\> gnd!) vsource type=pwl wave=\[
+ 0    -0.3
+ 4499426523925172771517493858555255287062168382591819938843852100p -0.3
+ 4499426523925172771517493858555255287062168382591819938843852110p 0.9
+ 4499426523925172771517493858555255287062168382591819938843852800p 0.9
+ 4499426523925172771517493858555255287062168382591819938843852810p -0.3
+ \]
V_wl_202 (WordLine\\<202\\> gnd!) vsource type=pwl wave=\[
+ 0    -0.3
+ 8998853047850345543034987717110510574124336765183639877687704900p -0.3
+ 8998853047850345543034987717110510574124336765183639877687704910p 0.9
+ 8998853047850345543034987717110510574124336765183639877687705600p 0.9
+ 8998853047850345543034987717110510574124336765183639877687705610p -0.3
+ \]
V_wl_203 (WordLine\\<203\\> gnd!) vsource type=pwl wave=\[
+ 0    -0.3
+ 17997706095700691086069975434221021148248673530367279755375410500p -0.3
+ 17997706095700691086069975434221021148248673530367279755375410510p 0.9
+ 17997706095700691086069975434221021148248673530367279755375411200p 0.9
+ 17997706095700691086069975434221021148248673530367279755375411210p -0.3
+ \]
V_wl_204 (WordLine\\<204\\> gnd!) vsource type=pwl wave=\[
+ 0    -0.3
+ 35995412191401382172139950868442042296497347060734559510750821700p -0.3
+ 35995412191401382172139950868442042296497347060734559510750821710p 0.9
+ 35995412191401382172139950868442042296497347060734559510750822400p 0.9
+ 35995412191401382172139950868442042296497347060734559510750822410p -0.3
+ \]
V_wl_205 (WordLine\\<205\\> gnd!) vsource type=pwl wave=\[
+ 0    -0.3
+ 71990824382802764344279901736884084592994694121469119021501644100p -0.3
+ 71990824382802764344279901736884084592994694121469119021501644110p 0.9
+ 71990824382802764344279901736884084592994694121469119021501644800p 0.9
+ 71990824382802764344279901736884084592994694121469119021501644810p -0.3
+ \]
V_wl_206 (WordLine\\<206\\> gnd!) vsource type=pwl wave=\[
+ 0    -0.3
+ 143981648765605528688559803473768169185989388242938238043003288900p -0.3
+ 143981648765605528688559803473768169185989388242938238043003288910p 0.9
+ 143981648765605528688559803473768169185989388242938238043003289600p 0.9
+ 143981648765605528688559803473768169185989388242938238043003289610p -0.3
+ \]
V_wl_207 (WordLine\\<207\\> gnd!) vsource type=pwl wave=\[
+ 0    -0.3
+ 287963297531211057377119606947536338371978776485876476086006578500p -0.3
+ 287963297531211057377119606947536338371978776485876476086006578510p 0.9
+ 287963297531211057377119606947536338371978776485876476086006579200p 0.9
+ 287963297531211057377119606947536338371978776485876476086006579210p -0.3
+ \]
V_wl_208 (WordLine\\<208\\> gnd!) vsource type=pwl wave=\[
+ 0    -0.3
+ 575926595062422114754239213895072676743957552971752952172013157700p -0.3
+ 575926595062422114754239213895072676743957552971752952172013157710p 0.9
+ 575926595062422114754239213895072676743957552971752952172013158400p 0.9
+ 575926595062422114754239213895072676743957552971752952172013158410p -0.3
+ \]
V_wl_209 (WordLine\\<209\\> gnd!) vsource type=pwl wave=\[
+ 0    -0.3
+ 1151853190124844229508478427790145353487915105943505904344026316100p -0.3
+ 1151853190124844229508478427790145353487915105943505904344026316110p 0.9
+ 1151853190124844229508478427790145353487915105943505904344026316800p 0.9
+ 1151853190124844229508478427790145353487915105943505904344026316810p -0.3
+ \]
V_wl_210 (WordLine\\<210\\> gnd!) vsource type=pwl wave=\[
+ 0    -0.3
+ 2303706380249688459016956855580290706975830211887011808688052632900p -0.3
+ 2303706380249688459016956855580290706975830211887011808688052632910p 0.9
+ 2303706380249688459016956855580290706975830211887011808688052633600p 0.9
+ 2303706380249688459016956855580290706975830211887011808688052633610p -0.3
+ \]
V_wl_211 (WordLine\\<211\\> gnd!) vsource type=pwl wave=\[
+ 0    -0.3
+ 4607412760499376918033913711160581413951660423774023617376105266500p -0.3
+ 4607412760499376918033913711160581413951660423774023617376105266510p 0.9
+ 4607412760499376918033913711160581413951660423774023617376105267200p 0.9
+ 4607412760499376918033913711160581413951660423774023617376105267210p -0.3
+ \]
V_wl_212 (WordLine\\<212\\> gnd!) vsource type=pwl wave=\[
+ 0    -0.3
+ 9214825520998753836067827422321162827903320847548047234752210533700p -0.3
+ 9214825520998753836067827422321162827903320847548047234752210533710p 0.9
+ 9214825520998753836067827422321162827903320847548047234752210534400p 0.9
+ 9214825520998753836067827422321162827903320847548047234752210534410p -0.3
+ \]
V_wl_213 (WordLine\\<213\\> gnd!) vsource type=pwl wave=\[
+ 0    -0.3
+ 18429651041997507672135654844642325655806641695096094469504421068100p -0.3
+ 18429651041997507672135654844642325655806641695096094469504421068110p 0.9
+ 18429651041997507672135654844642325655806641695096094469504421068800p 0.9
+ 18429651041997507672135654844642325655806641695096094469504421068810p -0.3
+ \]
V_wl_214 (WordLine\\<214\\> gnd!) vsource type=pwl wave=\[
+ 0    -0.3
+ 36859302083995015344271309689284651311613283390192188939008842136900p -0.3
+ 36859302083995015344271309689284651311613283390192188939008842136910p 0.9
+ 36859302083995015344271309689284651311613283390192188939008842137600p 0.9
+ 36859302083995015344271309689284651311613283390192188939008842137610p -0.3
+ \]
V_wl_215 (WordLine\\<215\\> gnd!) vsource type=pwl wave=\[
+ 0    -0.3
+ 73718604167990030688542619378569302623226566780384377878017684274500p -0.3
+ 73718604167990030688542619378569302623226566780384377878017684274510p 0.9
+ 73718604167990030688542619378569302623226566780384377878017684275200p 0.9
+ 73718604167990030688542619378569302623226566780384377878017684275210p -0.3
+ \]
V_wl_216 (WordLine\\<216\\> gnd!) vsource type=pwl wave=\[
+ 0    -0.3
+ 147437208335980061377085238757138605246453133560768755756035368549700p -0.3
+ 147437208335980061377085238757138605246453133560768755756035368549710p 0.9
+ 147437208335980061377085238757138605246453133560768755756035368550400p 0.9
+ 147437208335980061377085238757138605246453133560768755756035368550410p -0.3
+ \]
V_wl_217 (WordLine\\<217\\> gnd!) vsource type=pwl wave=\[
+ 0    -0.3
+ 294874416671960122754170477514277210492906267121537511512070737100100p -0.3
+ 294874416671960122754170477514277210492906267121537511512070737100110p 0.9
+ 294874416671960122754170477514277210492906267121537511512070737100800p 0.9
+ 294874416671960122754170477514277210492906267121537511512070737100810p -0.3
+ \]
V_wl_218 (WordLine\\<218\\> gnd!) vsource type=pwl wave=\[
+ 0    -0.3
+ 589748833343920245508340955028554420985812534243075023024141474200900p -0.3
+ 589748833343920245508340955028554420985812534243075023024141474200910p 0.9
+ 589748833343920245508340955028554420985812534243075023024141474201600p 0.9
+ 589748833343920245508340955028554420985812534243075023024141474201610p -0.3
+ \]
V_wl_219 (WordLine\\<219\\> gnd!) vsource type=pwl wave=\[
+ 0    -0.3
+ 1179497666687840491016681910057108841971625068486150046048282948402500p -0.3
+ 1179497666687840491016681910057108841971625068486150046048282948402510p 0.9
+ 1179497666687840491016681910057108841971625068486150046048282948403200p 0.9
+ 1179497666687840491016681910057108841971625068486150046048282948403210p -0.3
+ \]
V_wl_220 (WordLine\\<220\\> gnd!) vsource type=pwl wave=\[
+ 0    -0.3
+ 2358995333375680982033363820114217683943250136972300092096565896805700p -0.3
+ 2358995333375680982033363820114217683943250136972300092096565896805710p 0.9
+ 2358995333375680982033363820114217683943250136972300092096565896806400p 0.9
+ 2358995333375680982033363820114217683943250136972300092096565896806410p -0.3
+ \]
V_wl_221 (WordLine\\<221\\> gnd!) vsource type=pwl wave=\[
+ 0    -0.3
+ 4717990666751361964066727640228435367886500273944600184193131793612100p -0.3
+ 4717990666751361964066727640228435367886500273944600184193131793612110p 0.9
+ 4717990666751361964066727640228435367886500273944600184193131793612800p 0.9
+ 4717990666751361964066727640228435367886500273944600184193131793612810p -0.3
+ \]
V_wl_222 (WordLine\\<222\\> gnd!) vsource type=pwl wave=\[
+ 0    -0.3
+ 9435981333502723928133455280456870735773000547889200368386263587224900p -0.3
+ 9435981333502723928133455280456870735773000547889200368386263587224910p 0.9
+ 9435981333502723928133455280456870735773000547889200368386263587225600p 0.9
+ 9435981333502723928133455280456870735773000547889200368386263587225610p -0.3
+ \]
V_wl_223 (WordLine\\<223\\> gnd!) vsource type=pwl wave=\[
+ 0    -0.3
+ 18871962667005447856266910560913741471546001095778400736772527174450500p -0.3
+ 18871962667005447856266910560913741471546001095778400736772527174450510p 0.9
+ 18871962667005447856266910560913741471546001095778400736772527174451200p 0.9
+ 18871962667005447856266910560913741471546001095778400736772527174451210p -0.3
+ \]
V_wl_224 (WordLine\\<224\\> gnd!) vsource type=pwl wave=\[
+ 0    -0.3
+ 37743925334010895712533821121827482943092002191556801473545054348901700p -0.3
+ 37743925334010895712533821121827482943092002191556801473545054348901710p 0.9
+ 37743925334010895712533821121827482943092002191556801473545054348902400p 0.9
+ 37743925334010895712533821121827482943092002191556801473545054348902410p -0.3
+ \]
V_wl_225 (WordLine\\<225\\> gnd!) vsource type=pwl wave=\[
+ 0    -0.3
+ 75487850668021791425067642243654965886184004383113602947090108697804100p -0.3
+ 75487850668021791425067642243654965886184004383113602947090108697804110p 0.9
+ 75487850668021791425067642243654965886184004383113602947090108697804800p 0.9
+ 75487850668021791425067642243654965886184004383113602947090108697804810p -0.3
+ \]
V_wl_226 (WordLine\\<226\\> gnd!) vsource type=pwl wave=\[
+ 0    -0.3
+ 150975701336043582850135284487309931772368008766227205894180217395608900p -0.3
+ 150975701336043582850135284487309931772368008766227205894180217395608910p 0.9
+ 150975701336043582850135284487309931772368008766227205894180217395609600p 0.9
+ 150975701336043582850135284487309931772368008766227205894180217395609610p -0.3
+ \]
V_wl_227 (WordLine\\<227\\> gnd!) vsource type=pwl wave=\[
+ 0    -0.3
+ 301951402672087165700270568974619863544736017532454411788360434791218500p -0.3
+ 301951402672087165700270568974619863544736017532454411788360434791218510p 0.9
+ 301951402672087165700270568974619863544736017532454411788360434791219200p 0.9
+ 301951402672087165700270568974619863544736017532454411788360434791219210p -0.3
+ \]
V_wl_228 (WordLine\\<228\\> gnd!) vsource type=pwl wave=\[
+ 0    -0.3
+ 603902805344174331400541137949239727089472035064908823576720869582437700p -0.3
+ 603902805344174331400541137949239727089472035064908823576720869582437710p 0.9
+ 603902805344174331400541137949239727089472035064908823576720869582438400p 0.9
+ 603902805344174331400541137949239727089472035064908823576720869582438410p -0.3
+ \]
V_wl_229 (WordLine\\<229\\> gnd!) vsource type=pwl wave=\[
+ 0    -0.3
+ 1207805610688348662801082275898479454178944070129817647153441739164876100p -0.3
+ 1207805610688348662801082275898479454178944070129817647153441739164876110p 0.9
+ 1207805610688348662801082275898479454178944070129817647153441739164876800p 0.9
+ 1207805610688348662801082275898479454178944070129817647153441739164876810p -0.3
+ \]
V_wl_230 (WordLine\\<230\\> gnd!) vsource type=pwl wave=\[
+ 0    -0.3
+ 2415611221376697325602164551796958908357888140259635294306883478329752900p -0.3
+ 2415611221376697325602164551796958908357888140259635294306883478329752910p 0.9
+ 2415611221376697325602164551796958908357888140259635294306883478329753600p 0.9
+ 2415611221376697325602164551796958908357888140259635294306883478329753610p -0.3
+ \]
V_wl_231 (WordLine\\<231\\> gnd!) vsource type=pwl wave=\[
+ 0    -0.3
+ 4831222442753394651204329103593917816715776280519270588613766956659506500p -0.3
+ 4831222442753394651204329103593917816715776280519270588613766956659506510p 0.9
+ 4831222442753394651204329103593917816715776280519270588613766956659507200p 0.9
+ 4831222442753394651204329103593917816715776280519270588613766956659507210p -0.3
+ \]
V_wl_232 (WordLine\\<232\\> gnd!) vsource type=pwl wave=\[
+ 0    -0.3
+ 9662444885506789302408658207187835633431552561038541177227533913319013700p -0.3
+ 9662444885506789302408658207187835633431552561038541177227533913319013710p 0.9
+ 9662444885506789302408658207187835633431552561038541177227533913319014400p 0.9
+ 9662444885506789302408658207187835633431552561038541177227533913319014410p -0.3
+ \]
V_wl_233 (WordLine\\<233\\> gnd!) vsource type=pwl wave=\[
+ 0    -0.3
+ 19324889771013578604817316414375671266863105122077082354455067826638028100p -0.3
+ 19324889771013578604817316414375671266863105122077082354455067826638028110p 0.9
+ 19324889771013578604817316414375671266863105122077082354455067826638028800p 0.9
+ 19324889771013578604817316414375671266863105122077082354455067826638028810p -0.3
+ \]
V_wl_234 (WordLine\\<234\\> gnd!) vsource type=pwl wave=\[
+ 0    -0.3
+ 38649779542027157209634632828751342533726210244154164708910135653276056900p -0.3
+ 38649779542027157209634632828751342533726210244154164708910135653276056910p 0.9
+ 38649779542027157209634632828751342533726210244154164708910135653276057600p 0.9
+ 38649779542027157209634632828751342533726210244154164708910135653276057610p -0.3
+ \]
V_wl_235 (WordLine\\<235\\> gnd!) vsource type=pwl wave=\[
+ 0    -0.3
+ 77299559084054314419269265657502685067452420488308329417820271306552114500p -0.3
+ 77299559084054314419269265657502685067452420488308329417820271306552114510p 0.9
+ 77299559084054314419269265657502685067452420488308329417820271306552115200p 0.9
+ 77299559084054314419269265657502685067452420488308329417820271306552115210p -0.3
+ \]
V_wl_236 (WordLine\\<236\\> gnd!) vsource type=pwl wave=\[
+ 0    -0.3
+ 154599118168108628838538531315005370134904840976616658835640542613104229700p -0.3
+ 154599118168108628838538531315005370134904840976616658835640542613104229710p 0.9
+ 154599118168108628838538531315005370134904840976616658835640542613104230400p 0.9
+ 154599118168108628838538531315005370134904840976616658835640542613104230410p -0.3
+ \]
V_wl_237 (WordLine\\<237\\> gnd!) vsource type=pwl wave=\[
+ 0    -0.3
+ 309198236336217257677077062630010740269809681953233317671281085226208460100p -0.3
+ 309198236336217257677077062630010740269809681953233317671281085226208460110p 0.9
+ 309198236336217257677077062630010740269809681953233317671281085226208460800p 0.9
+ 309198236336217257677077062630010740269809681953233317671281085226208460810p -0.3
+ \]
V_wl_238 (WordLine\\<238\\> gnd!) vsource type=pwl wave=\[
+ 0    -0.3
+ 618396472672434515354154125260021480539619363906466635342562170452416920900p -0.3
+ 618396472672434515354154125260021480539619363906466635342562170452416920910p 0.9
+ 618396472672434515354154125260021480539619363906466635342562170452416921600p 0.9
+ 618396472672434515354154125260021480539619363906466635342562170452416921610p -0.3
+ \]
V_wl_239 (WordLine\\<239\\> gnd!) vsource type=pwl wave=\[
+ 0    -0.3
+ 1236792945344869030708308250520042961079238727812933270685124340904833842500p -0.3
+ 1236792945344869030708308250520042961079238727812933270685124340904833842510p 0.9
+ 1236792945344869030708308250520042961079238727812933270685124340904833843200p 0.9
+ 1236792945344869030708308250520042961079238727812933270685124340904833843210p -0.3
+ \]
V_wl_240 (WordLine\\<240\\> gnd!) vsource type=pwl wave=\[
+ 0    -0.3
+ 2473585890689738061416616501040085922158477455625866541370248681809667685700p -0.3
+ 2473585890689738061416616501040085922158477455625866541370248681809667685710p 0.9
+ 2473585890689738061416616501040085922158477455625866541370248681809667686400p 0.9
+ 2473585890689738061416616501040085922158477455625866541370248681809667686410p -0.3
+ \]
V_wl_241 (WordLine\\<241\\> gnd!) vsource type=pwl wave=\[
+ 0    -0.3
+ 4947171781379476122833233002080171844316954911251733082740497363619335372100p -0.3
+ 4947171781379476122833233002080171844316954911251733082740497363619335372110p 0.9
+ 4947171781379476122833233002080171844316954911251733082740497363619335372800p 0.9
+ 4947171781379476122833233002080171844316954911251733082740497363619335372810p -0.3
+ \]
V_wl_242 (WordLine\\<242\\> gnd!) vsource type=pwl wave=\[
+ 0    -0.3
+ 9894343562758952245666466004160343688633909822503466165480994727238670744900p -0.3
+ 9894343562758952245666466004160343688633909822503466165480994727238670744910p 0.9
+ 9894343562758952245666466004160343688633909822503466165480994727238670745600p 0.9
+ 9894343562758952245666466004160343688633909822503466165480994727238670745610p -0.3
+ \]
V_wl_243 (WordLine\\<243\\> gnd!) vsource type=pwl wave=\[
+ 0    -0.3
+ 19788687125517904491332932008320687377267819645006932330961989454477341490500p -0.3
+ 19788687125517904491332932008320687377267819645006932330961989454477341490510p 0.9
+ 19788687125517904491332932008320687377267819645006932330961989454477341491200p 0.9
+ 19788687125517904491332932008320687377267819645006932330961989454477341491210p -0.3
+ \]
V_wl_244 (WordLine\\<244\\> gnd!) vsource type=pwl wave=\[
+ 0    -0.3
+ 39577374251035808982665864016641374754535639290013864661923978908954682981700p -0.3
+ 39577374251035808982665864016641374754535639290013864661923978908954682981710p 0.9
+ 39577374251035808982665864016641374754535639290013864661923978908954682982400p 0.9
+ 39577374251035808982665864016641374754535639290013864661923978908954682982410p -0.3
+ \]
V_wl_245 (WordLine\\<245\\> gnd!) vsource type=pwl wave=\[
+ 0    -0.3
+ 79154748502071617965331728033282749509071278580027729323847957817909365964100p -0.3
+ 79154748502071617965331728033282749509071278580027729323847957817909365964110p 0.9
+ 79154748502071617965331728033282749509071278580027729323847957817909365964800p 0.9
+ 79154748502071617965331728033282749509071278580027729323847957817909365964810p -0.3
+ \]
V_wl_246 (WordLine\\<246\\> gnd!) vsource type=pwl wave=\[
+ 0    -0.3
+ 158309497004143235930663456066565499018142557160055458647695915635818731928900p -0.3
+ 158309497004143235930663456066565499018142557160055458647695915635818731928910p 0.9
+ 158309497004143235930663456066565499018142557160055458647695915635818731929600p 0.9
+ 158309497004143235930663456066565499018142557160055458647695915635818731929610p -0.3
+ \]
V_wl_247 (WordLine\\<247\\> gnd!) vsource type=pwl wave=\[
+ 0    -0.3
+ 316618994008286471861326912133130998036285114320110917295391831271637463858500p -0.3
+ 316618994008286471861326912133130998036285114320110917295391831271637463858510p 0.9
+ 316618994008286471861326912133130998036285114320110917295391831271637463859200p 0.9
+ 316618994008286471861326912133130998036285114320110917295391831271637463859210p -0.3
+ \]
V_wl_248 (WordLine\\<248\\> gnd!) vsource type=pwl wave=\[
+ 0    -0.3
+ 633237988016572943722653824266261996072570228640221834590783662543274927717700p -0.3
+ 633237988016572943722653824266261996072570228640221834590783662543274927717710p 0.9
+ 633237988016572943722653824266261996072570228640221834590783662543274927718400p 0.9
+ 633237988016572943722653824266261996072570228640221834590783662543274927718410p -0.3
+ \]
V_wl_249 (WordLine\\<249\\> gnd!) vsource type=pwl wave=\[
+ 0    -0.3
+ 1266475976033145887445307648532523992145140457280443669181567325086549855436100p -0.3
+ 1266475976033145887445307648532523992145140457280443669181567325086549855436110p 0.9
+ 1266475976033145887445307648532523992145140457280443669181567325086549855436800p 0.9
+ 1266475976033145887445307648532523992145140457280443669181567325086549855436810p -0.3
+ \]
V_wl_250 (WordLine\\<250\\> gnd!) vsource type=pwl wave=\[
+ 0    -0.3
+ 2532951952066291774890615297065047984290280914560887338363134650173099710872900p -0.3
+ 2532951952066291774890615297065047984290280914560887338363134650173099710872910p 0.9
+ 2532951952066291774890615297065047984290280914560887338363134650173099710873600p 0.9
+ 2532951952066291774890615297065047984290280914560887338363134650173099710873610p -0.3
+ \]
V_wl_251 (WordLine\\<251\\> gnd!) vsource type=pwl wave=\[
+ 0    -0.3
+ 5065903904132583549781230594130095968580561829121774676726269300346199421746500p -0.3
+ 5065903904132583549781230594130095968580561829121774676726269300346199421746510p 0.9
+ 5065903904132583549781230594130095968580561829121774676726269300346199421747200p 0.9
+ 5065903904132583549781230594130095968580561829121774676726269300346199421747210p -0.3
+ \]
V_wl_252 (WordLine\\<252\\> gnd!) vsource type=pwl wave=\[
+ 0    -0.3
+ 10131807808265167099562461188260191937161123658243549353452538600692398843493700p -0.3
+ 10131807808265167099562461188260191937161123658243549353452538600692398843493710p 0.9
+ 10131807808265167099562461188260191937161123658243549353452538600692398843494400p 0.9
+ 10131807808265167099562461188260191937161123658243549353452538600692398843494410p -0.3
+ \]
V_wl_253 (WordLine\\<253\\> gnd!) vsource type=pwl wave=\[
+ 0    -0.3
+ 20263615616530334199124922376520383874322247316487098706905077201384797686988100p -0.3
+ 20263615616530334199124922376520383874322247316487098706905077201384797686988110p 0.9
+ 20263615616530334199124922376520383874322247316487098706905077201384797686988800p 0.9
+ 20263615616530334199124922376520383874322247316487098706905077201384797686988810p -0.3
+ \]
V_wl_254 (WordLine\\<254\\> gnd!) vsource type=pwl wave=\[
+ 0    -0.3
+ 40527231233060668398249844753040767748644494632974197413810154402769595373976900p -0.3
+ 40527231233060668398249844753040767748644494632974197413810154402769595373976910p 0.9
+ 40527231233060668398249844753040767748644494632974197413810154402769595373977600p 0.9
+ 40527231233060668398249844753040767748644494632974197413810154402769595373977610p -0.3
+ \]
V_wl_255 (WordLine\\<255\\> gnd!) vsource type=pwl wave=\[
+ 0    -0.3
+ 81054462466121336796499689506081535497288989265948394827620308805539190747954500p -0.3
+ 81054462466121336796499689506081535497288989265948394827620308805539190747954510p 0.9
+ 81054462466121336796499689506081535497288989265948394827620308805539190747955200p 0.9
+ 81054462466121336796499689506081535497288989265948394827620308805539190747955210p -0.3
+ \]
V_wl_256 (WordLine\\<256\\> gnd!) vsource type=pwl wave=\[
+ 0    -0.3
+ 162108924932242673592999379012163070994577978531896789655240617611078381495909700p -0.3
+ 162108924932242673592999379012163070994577978531896789655240617611078381495909710p 0.9
+ 162108924932242673592999379012163070994577978531896789655240617611078381495910400p 0.9
+ 162108924932242673592999379012163070994577978531896789655240617611078381495910410p -0.3
+ \]
V_wl_257 (WordLine\\<257\\> gnd!) vsource type=pwl wave=\[
+ 0    -0.3
+ 324217849864485347185998758024326141989155957063793579310481235222156762991820100p -0.3
+ 324217849864485347185998758024326141989155957063793579310481235222156762991820110p 0.9
+ 324217849864485347185998758024326141989155957063793579310481235222156762991820800p 0.9
+ 324217849864485347185998758024326141989155957063793579310481235222156762991820810p -0.3
+ \]
V_wl_258 (WordLine\\<258\\> gnd!) vsource type=pwl wave=\[
+ 0    -0.3
+ 648435699728970694371997516048652283978311914127587158620962470444313525983640900p -0.3
+ 648435699728970694371997516048652283978311914127587158620962470444313525983640910p 0.9
+ 648435699728970694371997516048652283978311914127587158620962470444313525983641600p 0.9
+ 648435699728970694371997516048652283978311914127587158620962470444313525983641610p -0.3
+ \]
V_wl_259 (WordLine\\<259\\> gnd!) vsource type=pwl wave=\[
+ 0    -0.3
+ 1296871399457941388743995032097304567956623828255174317241924940888627051967282500p -0.3
+ 1296871399457941388743995032097304567956623828255174317241924940888627051967282510p 0.9
+ 1296871399457941388743995032097304567956623828255174317241924940888627051967283200p 0.9
+ 1296871399457941388743995032097304567956623828255174317241924940888627051967283210p -0.3
+ \]
V_wl_260 (WordLine\\<260\\> gnd!) vsource type=pwl wave=\[
+ 0    -0.3
+ 2593742798915882777487990064194609135913247656510348634483849881777254103934565700p -0.3
+ 2593742798915882777487990064194609135913247656510348634483849881777254103934565710p 0.9
+ 2593742798915882777487990064194609135913247656510348634483849881777254103934566400p 0.9
+ 2593742798915882777487990064194609135913247656510348634483849881777254103934566410p -0.3
+ \]
V_wl_261 (WordLine\\<261\\> gnd!) vsource type=pwl wave=\[
+ 0    -0.3
+ 5187485597831765554975980128389218271826495313020697268967699763554508207869132100p -0.3
+ 5187485597831765554975980128389218271826495313020697268967699763554508207869132110p 0.9
+ 5187485597831765554975980128389218271826495313020697268967699763554508207869132800p 0.9
+ 5187485597831765554975980128389218271826495313020697268967699763554508207869132810p -0.3
+ \]
V_wl_262 (WordLine\\<262\\> gnd!) vsource type=pwl wave=\[
+ 0    -0.3
+ 10374971195663531109951960256778436543652990626041394537935399527109016415738264900p -0.3
+ 10374971195663531109951960256778436543652990626041394537935399527109016415738264910p 0.9
+ 10374971195663531109951960256778436543652990626041394537935399527109016415738265600p 0.9
+ 10374971195663531109951960256778436543652990626041394537935399527109016415738265610p -0.3
+ \]
V_wl_263 (WordLine\\<263\\> gnd!) vsource type=pwl wave=\[
+ 0    -0.3
+ 20749942391327062219903920513556873087305981252082789075870799054218032831476530500p -0.3
+ 20749942391327062219903920513556873087305981252082789075870799054218032831476530510p 0.9
+ 20749942391327062219903920513556873087305981252082789075870799054218032831476531200p 0.9
+ 20749942391327062219903920513556873087305981252082789075870799054218032831476531210p -0.3
+ \]
V_wl_264 (WordLine\\<264\\> gnd!) vsource type=pwl wave=\[
+ 0    -0.3
+ 41499884782654124439807841027113746174611962504165578151741598108436065662953061700p -0.3
+ 41499884782654124439807841027113746174611962504165578151741598108436065662953061710p 0.9
+ 41499884782654124439807841027113746174611962504165578151741598108436065662953062400p 0.9
+ 41499884782654124439807841027113746174611962504165578151741598108436065662953062410p -0.3
+ \]
V_wl_265 (WordLine\\<265\\> gnd!) vsource type=pwl wave=\[
+ 0    -0.3
+ 82999769565308248879615682054227492349223925008331156303483196216872131325906124100p -0.3
+ 82999769565308248879615682054227492349223925008331156303483196216872131325906124110p 0.9
+ 82999769565308248879615682054227492349223925008331156303483196216872131325906124800p 0.9
+ 82999769565308248879615682054227492349223925008331156303483196216872131325906124810p -0.3
+ \]
V_wl_266 (WordLine\\<266\\> gnd!) vsource type=pwl wave=\[
+ 0    -0.3
+ 165999539130616497759231364108454984698447850016662312606966392433744262651812248900p -0.3
+ 165999539130616497759231364108454984698447850016662312606966392433744262651812248910p 0.9
+ 165999539130616497759231364108454984698447850016662312606966392433744262651812249600p 0.9
+ 165999539130616497759231364108454984698447850016662312606966392433744262651812249610p -0.3
+ \]
V_wl_267 (WordLine\\<267\\> gnd!) vsource type=pwl wave=\[
+ 0    -0.3
+ 331999078261232995518462728216909969396895700033324625213932784867488525303624498500p -0.3
+ 331999078261232995518462728216909969396895700033324625213932784867488525303624498510p 0.9
+ 331999078261232995518462728216909969396895700033324625213932784867488525303624499200p 0.9
+ 331999078261232995518462728216909969396895700033324625213932784867488525303624499210p -0.3
+ \]
V_wl_268 (WordLine\\<268\\> gnd!) vsource type=pwl wave=\[
+ 0    -0.3
+ 663998156522465991036925456433819938793791400066649250427865569734977050607248997700p -0.3
+ 663998156522465991036925456433819938793791400066649250427865569734977050607248997710p 0.9
+ 663998156522465991036925456433819938793791400066649250427865569734977050607248998400p 0.9
+ 663998156522465991036925456433819938793791400066649250427865569734977050607248998410p -0.3
+ \]
V_wl_269 (WordLine\\<269\\> gnd!) vsource type=pwl wave=\[
+ 0    -0.3
+ 1327996313044931982073850912867639877587582800133298500855731139469954101214497996100p -0.3
+ 1327996313044931982073850912867639877587582800133298500855731139469954101214497996110p 0.9
+ 1327996313044931982073850912867639877587582800133298500855731139469954101214497996800p 0.9
+ 1327996313044931982073850912867639877587582800133298500855731139469954101214497996810p -0.3
+ \]
V_wl_270 (WordLine\\<270\\> gnd!) vsource type=pwl wave=\[
+ 0    -0.3
+ 2655992626089863964147701825735279755175165600266597001711462278939908202428995992900p -0.3
+ 2655992626089863964147701825735279755175165600266597001711462278939908202428995992910p 0.9
+ 2655992626089863964147701825735279755175165600266597001711462278939908202428995993600p 0.9
+ 2655992626089863964147701825735279755175165600266597001711462278939908202428995993610p -0.3
+ \]
V_wl_271 (WordLine\\<271\\> gnd!) vsource type=pwl wave=\[
+ 0    -0.3
+ 5311985252179727928295403651470559510350331200533194003422924557879816404857991986500p -0.3
+ 5311985252179727928295403651470559510350331200533194003422924557879816404857991986510p 0.9
+ 5311985252179727928295403651470559510350331200533194003422924557879816404857991987200p 0.9
+ 5311985252179727928295403651470559510350331200533194003422924557879816404857991987210p -0.3
+ \]
V_wl_272 (WordLine\\<272\\> gnd!) vsource type=pwl wave=\[
+ 0    -0.3
+ 10623970504359455856590807302941119020700662401066388006845849115759632809715983973700p -0.3
+ 10623970504359455856590807302941119020700662401066388006845849115759632809715983973710p 0.9
+ 10623970504359455856590807302941119020700662401066388006845849115759632809715983974400p 0.9
+ 10623970504359455856590807302941119020700662401066388006845849115759632809715983974410p -0.3
+ \]
V_wl_273 (WordLine\\<273\\> gnd!) vsource type=pwl wave=\[
+ 0    -0.3
+ 21247941008718911713181614605882238041401324802132776013691698231519265619431967948100p -0.3
+ 21247941008718911713181614605882238041401324802132776013691698231519265619431967948110p 0.9
+ 21247941008718911713181614605882238041401324802132776013691698231519265619431967948800p 0.9
+ 21247941008718911713181614605882238041401324802132776013691698231519265619431967948810p -0.3
+ \]
V_wl_274 (WordLine\\<274\\> gnd!) vsource type=pwl wave=\[
+ 0    -0.3
+ 42495882017437823426363229211764476082802649604265552027383396463038531238863935896900p -0.3
+ 42495882017437823426363229211764476082802649604265552027383396463038531238863935896910p 0.9
+ 42495882017437823426363229211764476082802649604265552027383396463038531238863935897600p 0.9
+ 42495882017437823426363229211764476082802649604265552027383396463038531238863935897610p -0.3
+ \]
V_wl_275 (WordLine\\<275\\> gnd!) vsource type=pwl wave=\[
+ 0    -0.3
+ 84991764034875646852726458423528952165605299208531104054766792926077062477727871794500p -0.3
+ 84991764034875646852726458423528952165605299208531104054766792926077062477727871794510p 0.9
+ 84991764034875646852726458423528952165605299208531104054766792926077062477727871795200p 0.9
+ 84991764034875646852726458423528952165605299208531104054766792926077062477727871795210p -0.3
+ \]
V_wl_276 (WordLine\\<276\\> gnd!) vsource type=pwl wave=\[
+ 0    -0.3
+ 169983528069751293705452916847057904331210598417062208109533585852154124955455743589700p -0.3
+ 169983528069751293705452916847057904331210598417062208109533585852154124955455743589710p 0.9
+ 169983528069751293705452916847057904331210598417062208109533585852154124955455743590400p 0.9
+ 169983528069751293705452916847057904331210598417062208109533585852154124955455743590410p -0.3
+ \]
V_wl_277 (WordLine\\<277\\> gnd!) vsource type=pwl wave=\[
+ 0    -0.3
+ 339967056139502587410905833694115808662421196834124416219067171704308249910911487180100p -0.3
+ 339967056139502587410905833694115808662421196834124416219067171704308249910911487180110p 0.9
+ 339967056139502587410905833694115808662421196834124416219067171704308249910911487180800p 0.9
+ 339967056139502587410905833694115808662421196834124416219067171704308249910911487180810p -0.3
+ \]
V_wl_278 (WordLine\\<278\\> gnd!) vsource type=pwl wave=\[
+ 0    -0.3
+ 679934112279005174821811667388231617324842393668248832438134343408616499821822974360900p -0.3
+ 679934112279005174821811667388231617324842393668248832438134343408616499821822974360910p 0.9
+ 679934112279005174821811667388231617324842393668248832438134343408616499821822974361600p 0.9
+ 679934112279005174821811667388231617324842393668248832438134343408616499821822974361610p -0.3
+ \]
V_wl_279 (WordLine\\<279\\> gnd!) vsource type=pwl wave=\[
+ 0    -0.3
+ 1359868224558010349643623334776463234649684787336497664876268686817232999643645948722500p -0.3
+ 1359868224558010349643623334776463234649684787336497664876268686817232999643645948722510p 0.9
+ 1359868224558010349643623334776463234649684787336497664876268686817232999643645948723200p 0.9
+ 1359868224558010349643623334776463234649684787336497664876268686817232999643645948723210p -0.3
+ \]
V_wl_280 (WordLine\\<280\\> gnd!) vsource type=pwl wave=\[
+ 0    -0.3
+ 2719736449116020699287246669552926469299369574672995329752537373634465999287291897445700p -0.3
+ 2719736449116020699287246669552926469299369574672995329752537373634465999287291897445710p 0.9
+ 2719736449116020699287246669552926469299369574672995329752537373634465999287291897446400p 0.9
+ 2719736449116020699287246669552926469299369574672995329752537373634465999287291897446410p -0.3
+ \]
V_wl_281 (WordLine\\<281\\> gnd!) vsource type=pwl wave=\[
+ 0    -0.3
+ 5439472898232041398574493339105852938598739149345990659505074747268931998574583794892100p -0.3
+ 5439472898232041398574493339105852938598739149345990659505074747268931998574583794892110p 0.9
+ 5439472898232041398574493339105852938598739149345990659505074747268931998574583794892800p 0.9
+ 5439472898232041398574493339105852938598739149345990659505074747268931998574583794892810p -0.3
+ \]
V_wl_282 (WordLine\\<282\\> gnd!) vsource type=pwl wave=\[
+ 0    -0.3
+ 10878945796464082797148986678211705877197478298691981319010149494537863997149167589784900p -0.3
+ 10878945796464082797148986678211705877197478298691981319010149494537863997149167589784910p 0.9
+ 10878945796464082797148986678211705877197478298691981319010149494537863997149167589785600p 0.9
+ 10878945796464082797148986678211705877197478298691981319010149494537863997149167589785610p -0.3
+ \]
V_wl_283 (WordLine\\<283\\> gnd!) vsource type=pwl wave=\[
+ 0    -0.3
+ 21757891592928165594297973356423411754394956597383962638020298989075727994298335179570500p -0.3
+ 21757891592928165594297973356423411754394956597383962638020298989075727994298335179570510p 0.9
+ 21757891592928165594297973356423411754394956597383962638020298989075727994298335179571200p 0.9
+ 21757891592928165594297973356423411754394956597383962638020298989075727994298335179571210p -0.3
+ \]
V_wl_284 (WordLine\\<284\\> gnd!) vsource type=pwl wave=\[
+ 0    -0.3
+ 43515783185856331188595946712846823508789913194767925276040597978151455988596670359141700p -0.3
+ 43515783185856331188595946712846823508789913194767925276040597978151455988596670359141710p 0.9
+ 43515783185856331188595946712846823508789913194767925276040597978151455988596670359142400p 0.9
+ 43515783185856331188595946712846823508789913194767925276040597978151455988596670359142410p -0.3
+ \]
V_wl_285 (WordLine\\<285\\> gnd!) vsource type=pwl wave=\[
+ 0    -0.3
+ 87031566371712662377191893425693647017579826389535850552081195956302911977193340718284100p -0.3
+ 87031566371712662377191893425693647017579826389535850552081195956302911977193340718284110p 0.9
+ 87031566371712662377191893425693647017579826389535850552081195956302911977193340718284800p 0.9
+ 87031566371712662377191893425693647017579826389535850552081195956302911977193340718284810p -0.3
+ \]
V_wl_286 (WordLine\\<286\\> gnd!) vsource type=pwl wave=\[
+ 0    -0.3
+ 174063132743425324754383786851387294035159652779071701104162391912605823954386681436568900p -0.3
+ 174063132743425324754383786851387294035159652779071701104162391912605823954386681436568910p 0.9
+ 174063132743425324754383786851387294035159652779071701104162391912605823954386681436569600p 0.9
+ 174063132743425324754383786851387294035159652779071701104162391912605823954386681436569610p -0.3
+ \]
V_wl_287 (WordLine\\<287\\> gnd!) vsource type=pwl wave=\[
+ 0    -0.3
+ 348126265486850649508767573702774588070319305558143402208324783825211647908773362873138500p -0.3
+ 348126265486850649508767573702774588070319305558143402208324783825211647908773362873138510p 0.9
+ 348126265486850649508767573702774588070319305558143402208324783825211647908773362873139200p 0.9
+ 348126265486850649508767573702774588070319305558143402208324783825211647908773362873139210p -0.3
+ \]
V_wl_288 (WordLine\\<288\\> gnd!) vsource type=pwl wave=\[
+ 0    -0.3
+ 696252530973701299017535147405549176140638611116286804416649567650423295817546725746277700p -0.3
+ 696252530973701299017535147405549176140638611116286804416649567650423295817546725746277710p 0.9
+ 696252530973701299017535147405549176140638611116286804416649567650423295817546725746278400p 0.9
+ 696252530973701299017535147405549176140638611116286804416649567650423295817546725746278410p -0.3
+ \]
V_wl_289 (WordLine\\<289\\> gnd!) vsource type=pwl wave=\[
+ 0    -0.3
+ 1392505061947402598035070294811098352281277222232573608833299135300846591635093451492556100p -0.3
+ 1392505061947402598035070294811098352281277222232573608833299135300846591635093451492556110p 0.9
+ 1392505061947402598035070294811098352281277222232573608833299135300846591635093451492556800p 0.9
+ 1392505061947402598035070294811098352281277222232573608833299135300846591635093451492556810p -0.3
+ \]
V_wl_290 (WordLine\\<290\\> gnd!) vsource type=pwl wave=\[
+ 0    -0.3
+ 2785010123894805196070140589622196704562554444465147217666598270601693183270186902985112900p -0.3
+ 2785010123894805196070140589622196704562554444465147217666598270601693183270186902985112910p 0.9
+ 2785010123894805196070140589622196704562554444465147217666598270601693183270186902985113600p 0.9
+ 2785010123894805196070140589622196704562554444465147217666598270601693183270186902985113610p -0.3
+ \]
V_wl_291 (WordLine\\<291\\> gnd!) vsource type=pwl wave=\[
+ 0    -0.3
+ 5570020247789610392140281179244393409125108888930294435333196541203386366540373805970226500p -0.3
+ 5570020247789610392140281179244393409125108888930294435333196541203386366540373805970226510p 0.9
+ 5570020247789610392140281179244393409125108888930294435333196541203386366540373805970227200p 0.9
+ 5570020247789610392140281179244393409125108888930294435333196541203386366540373805970227210p -0.3
+ \]
V_wl_292 (WordLine\\<292\\> gnd!) vsource type=pwl wave=\[
+ 0    -0.3
+ 11140040495579220784280562358488786818250217777860588870666393082406772733080747611940453700p -0.3
+ 11140040495579220784280562358488786818250217777860588870666393082406772733080747611940453710p 0.9
+ 11140040495579220784280562358488786818250217777860588870666393082406772733080747611940454400p 0.9
+ 11140040495579220784280562358488786818250217777860588870666393082406772733080747611940454410p -0.3
+ \]
V_wl_293 (WordLine\\<293\\> gnd!) vsource type=pwl wave=\[
+ 0    -0.3
+ 22280080991158441568561124716977573636500435555721177741332786164813545466161495223880908100p -0.3
+ 22280080991158441568561124716977573636500435555721177741332786164813545466161495223880908110p 0.9
+ 22280080991158441568561124716977573636500435555721177741332786164813545466161495223880908800p 0.9
+ 22280080991158441568561124716977573636500435555721177741332786164813545466161495223880908810p -0.3
+ \]
V_wl_294 (WordLine\\<294\\> gnd!) vsource type=pwl wave=\[
+ 0    -0.3
+ 44560161982316883137122249433955147273000871111442355482665572329627090932322990447761816900p -0.3
+ 44560161982316883137122249433955147273000871111442355482665572329627090932322990447761816910p 0.9
+ 44560161982316883137122249433955147273000871111442355482665572329627090932322990447761817600p 0.9
+ 44560161982316883137122249433955147273000871111442355482665572329627090932322990447761817610p -0.3
+ \]
V_wl_295 (WordLine\\<295\\> gnd!) vsource type=pwl wave=\[
+ 0    -0.3
+ 89120323964633766274244498867910294546001742222884710965331144659254181864645980895523634500p -0.3
+ 89120323964633766274244498867910294546001742222884710965331144659254181864645980895523634510p 0.9
+ 89120323964633766274244498867910294546001742222884710965331144659254181864645980895523635200p 0.9
+ 89120323964633766274244498867910294546001742222884710965331144659254181864645980895523635210p -0.3
+ \]
V_wl_296 (WordLine\\<296\\> gnd!) vsource type=pwl wave=\[
+ 0    -0.3
+ 178240647929267532548488997735820589092003484445769421930662289318508363729291961791047269700p -0.3
+ 178240647929267532548488997735820589092003484445769421930662289318508363729291961791047269710p 0.9
+ 178240647929267532548488997735820589092003484445769421930662289318508363729291961791047270400p 0.9
+ 178240647929267532548488997735820589092003484445769421930662289318508363729291961791047270410p -0.3
+ \]
V_wl_297 (WordLine\\<297\\> gnd!) vsource type=pwl wave=\[
+ 0    -0.3
+ 356481295858535065096977995471641178184006968891538843861324578637016727458583923582094540100p -0.3
+ 356481295858535065096977995471641178184006968891538843861324578637016727458583923582094540110p 0.9
+ 356481295858535065096977995471641178184006968891538843861324578637016727458583923582094540800p 0.9
+ 356481295858535065096977995471641178184006968891538843861324578637016727458583923582094540810p -0.3
+ \]
V_wl_298 (WordLine\\<298\\> gnd!) vsource type=pwl wave=\[
+ 0    -0.3
+ 712962591717070130193955990943282356368013937783077687722649157274033454917167847164189080900p -0.3
+ 712962591717070130193955990943282356368013937783077687722649157274033454917167847164189080910p 0.9
+ 712962591717070130193955990943282356368013937783077687722649157274033454917167847164189081600p 0.9
+ 712962591717070130193955990943282356368013937783077687722649157274033454917167847164189081610p -0.3
+ \]
V_wl_299 (WordLine\\<299\\> gnd!) vsource type=pwl wave=\[
+ 0    -0.3
+ 1425925183434140260387911981886564712736027875566155375445298314548066909834335694328378162500p -0.3
+ 1425925183434140260387911981886564712736027875566155375445298314548066909834335694328378162510p 0.9
+ 1425925183434140260387911981886564712736027875566155375445298314548066909834335694328378163200p 0.9
+ 1425925183434140260387911981886564712736027875566155375445298314548066909834335694328378163210p -0.3
+ \]
V_wl_300 (WordLine\\<300\\> gnd!) vsource type=pwl wave=\[
+ 0    -0.3
+ 2851850366868280520775823963773129425472055751132310750890596629096133819668671388656756325700p -0.3
+ 2851850366868280520775823963773129425472055751132310750890596629096133819668671388656756325710p 0.9
+ 2851850366868280520775823963773129425472055751132310750890596629096133819668671388656756326400p 0.9
+ 2851850366868280520775823963773129425472055751132310750890596629096133819668671388656756326410p -0.3
+ \]
V_wl_301 (WordLine\\<301\\> gnd!) vsource type=pwl wave=\[
+ 0    -0.3
+ 5703700733736561041551647927546258850944111502264621501781193258192267639337342777313512652100p -0.3
+ 5703700733736561041551647927546258850944111502264621501781193258192267639337342777313512652110p 0.9
+ 5703700733736561041551647927546258850944111502264621501781193258192267639337342777313512652800p 0.9
+ 5703700733736561041551647927546258850944111502264621501781193258192267639337342777313512652810p -0.3
+ \]
V_wl_302 (WordLine\\<302\\> gnd!) vsource type=pwl wave=\[
+ 0    -0.3
+ 11407401467473122083103295855092517701888223004529243003562386516384535278674685554627025304900p -0.3
+ 11407401467473122083103295855092517701888223004529243003562386516384535278674685554627025304910p 0.9
+ 11407401467473122083103295855092517701888223004529243003562386516384535278674685554627025305600p 0.9
+ 11407401467473122083103295855092517701888223004529243003562386516384535278674685554627025305610p -0.3
+ \]
V_wl_303 (WordLine\\<303\\> gnd!) vsource type=pwl wave=\[
+ 0    -0.3
+ 22814802934946244166206591710185035403776446009058486007124773032769070557349371109254050610500p -0.3
+ 22814802934946244166206591710185035403776446009058486007124773032769070557349371109254050610510p 0.9
+ 22814802934946244166206591710185035403776446009058486007124773032769070557349371109254050611200p 0.9
+ 22814802934946244166206591710185035403776446009058486007124773032769070557349371109254050611210p -0.3
+ \]
V_wl_304 (WordLine\\<304\\> gnd!) vsource type=pwl wave=\[
+ 0    -0.3
+ 45629605869892488332413183420370070807552892018116972014249546065538141114698742218508101221700p -0.3
+ 45629605869892488332413183420370070807552892018116972014249546065538141114698742218508101221710p 0.9
+ 45629605869892488332413183420370070807552892018116972014249546065538141114698742218508101222400p 0.9
+ 45629605869892488332413183420370070807552892018116972014249546065538141114698742218508101222410p -0.3
+ \]
V_wl_305 (WordLine\\<305\\> gnd!) vsource type=pwl wave=\[
+ 0    -0.3
+ 91259211739784976664826366840740141615105784036233944028499092131076282229397484437016202444100p -0.3
+ 91259211739784976664826366840740141615105784036233944028499092131076282229397484437016202444110p 0.9
+ 91259211739784976664826366840740141615105784036233944028499092131076282229397484437016202444800p 0.9
+ 91259211739784976664826366840740141615105784036233944028499092131076282229397484437016202444810p -0.3
+ \]
V_wl_306 (WordLine\\<306\\> gnd!) vsource type=pwl wave=\[
+ 0    -0.3
+ 182518423479569953329652733681480283230211568072467888056998184262152564458794968874032404888900p -0.3
+ 182518423479569953329652733681480283230211568072467888056998184262152564458794968874032404888910p 0.9
+ 182518423479569953329652733681480283230211568072467888056998184262152564458794968874032404889600p 0.9
+ 182518423479569953329652733681480283230211568072467888056998184262152564458794968874032404889610p -0.3
+ \]
V_wl_307 (WordLine\\<307\\> gnd!) vsource type=pwl wave=\[
+ 0    -0.3
+ 365036846959139906659305467362960566460423136144935776113996368524305128917589937748064809778500p -0.3
+ 365036846959139906659305467362960566460423136144935776113996368524305128917589937748064809778510p 0.9
+ 365036846959139906659305467362960566460423136144935776113996368524305128917589937748064809779200p 0.9
+ 365036846959139906659305467362960566460423136144935776113996368524305128917589937748064809779210p -0.3
+ \]
V_wl_308 (WordLine\\<308\\> gnd!) vsource type=pwl wave=\[
+ 0    -0.3
+ 730073693918279813318610934725921132920846272289871552227992737048610257835179875496129619557700p -0.3
+ 730073693918279813318610934725921132920846272289871552227992737048610257835179875496129619557710p 0.9
+ 730073693918279813318610934725921132920846272289871552227992737048610257835179875496129619558400p 0.9
+ 730073693918279813318610934725921132920846272289871552227992737048610257835179875496129619558410p -0.3
+ \]
V_wl_309 (WordLine\\<309\\> gnd!) vsource type=pwl wave=\[
+ 0    -0.3
+ 1460147387836559626637221869451842265841692544579743104455985474097220515670359750992259239116100p -0.3
+ 1460147387836559626637221869451842265841692544579743104455985474097220515670359750992259239116110p 0.9
+ 1460147387836559626637221869451842265841692544579743104455985474097220515670359750992259239116800p 0.9
+ 1460147387836559626637221869451842265841692544579743104455985474097220515670359750992259239116810p -0.3
+ \]
V_wl_310 (WordLine\\<310\\> gnd!) vsource type=pwl wave=\[
+ 0    -0.3
+ 2920294775673119253274443738903684531683385089159486208911970948194441031340719501984518478232900p -0.3
+ 2920294775673119253274443738903684531683385089159486208911970948194441031340719501984518478232910p 0.9
+ 2920294775673119253274443738903684531683385089159486208911970948194441031340719501984518478233600p 0.9
+ 2920294775673119253274443738903684531683385089159486208911970948194441031340719501984518478233610p -0.3
+ \]
V_wl_311 (WordLine\\<311\\> gnd!) vsource type=pwl wave=\[
+ 0    -0.3
+ 5840589551346238506548887477807369063366770178318972417823941896388882062681439003969036956466500p -0.3
+ 5840589551346238506548887477807369063366770178318972417823941896388882062681439003969036956466510p 0.9
+ 5840589551346238506548887477807369063366770178318972417823941896388882062681439003969036956467200p 0.9
+ 5840589551346238506548887477807369063366770178318972417823941896388882062681439003969036956467210p -0.3
+ \]
V_wl_312 (WordLine\\<312\\> gnd!) vsource type=pwl wave=\[
+ 0    -0.3
+ 11681179102692477013097774955614738126733540356637944835647883792777764125362878007938073912933700p -0.3
+ 11681179102692477013097774955614738126733540356637944835647883792777764125362878007938073912933710p 0.9
+ 11681179102692477013097774955614738126733540356637944835647883792777764125362878007938073912934400p 0.9
+ 11681179102692477013097774955614738126733540356637944835647883792777764125362878007938073912934410p -0.3
+ \]
V_wl_313 (WordLine\\<313\\> gnd!) vsource type=pwl wave=\[
+ 0    -0.3
+ 23362358205384954026195549911229476253467080713275889671295767585555528250725756015876147825868100p -0.3
+ 23362358205384954026195549911229476253467080713275889671295767585555528250725756015876147825868110p 0.9
+ 23362358205384954026195549911229476253467080713275889671295767585555528250725756015876147825868800p 0.9
+ 23362358205384954026195549911229476253467080713275889671295767585555528250725756015876147825868810p -0.3
+ \]
V_wl_314 (WordLine\\<314\\> gnd!) vsource type=pwl wave=\[
+ 0    -0.3
+ 46724716410769908052391099822458952506934161426551779342591535171111056501451512031752295651736900p -0.3
+ 46724716410769908052391099822458952506934161426551779342591535171111056501451512031752295651736910p 0.9
+ 46724716410769908052391099822458952506934161426551779342591535171111056501451512031752295651737600p 0.9
+ 46724716410769908052391099822458952506934161426551779342591535171111056501451512031752295651737610p -0.3
+ \]
V_wl_315 (WordLine\\<315\\> gnd!) vsource type=pwl wave=\[
+ 0    -0.3
+ 93449432821539816104782199644917905013868322853103558685183070342222113002903024063504591303474500p -0.3
+ 93449432821539816104782199644917905013868322853103558685183070342222113002903024063504591303474510p 0.9
+ 93449432821539816104782199644917905013868322853103558685183070342222113002903024063504591303475200p 0.9
+ 93449432821539816104782199644917905013868322853103558685183070342222113002903024063504591303475210p -0.3
+ \]
V_wl_316 (WordLine\\<316\\> gnd!) vsource type=pwl wave=\[
+ 0    -0.3
+ 186898865643079632209564399289835810027736645706207117370366140684444226005806048127009182606949700p -0.3
+ 186898865643079632209564399289835810027736645706207117370366140684444226005806048127009182606949710p 0.9
+ 186898865643079632209564399289835810027736645706207117370366140684444226005806048127009182606950400p 0.9
+ 186898865643079632209564399289835810027736645706207117370366140684444226005806048127009182606950410p -0.3
+ \]
V_wl_317 (WordLine\\<317\\> gnd!) vsource type=pwl wave=\[
+ 0    -0.3
+ 373797731286159264419128798579671620055473291412414234740732281368888452011612096254018365213900100p -0.3
+ 373797731286159264419128798579671620055473291412414234740732281368888452011612096254018365213900110p 0.9
+ 373797731286159264419128798579671620055473291412414234740732281368888452011612096254018365213900800p 0.9
+ 373797731286159264419128798579671620055473291412414234740732281368888452011612096254018365213900810p -0.3
+ \]
V_wl_318 (WordLine\\<318\\> gnd!) vsource type=pwl wave=\[
+ 0    -0.3
+ 747595462572318528838257597159343240110946582824828469481464562737776904023224192508036730427800900p -0.3
+ 747595462572318528838257597159343240110946582824828469481464562737776904023224192508036730427800910p 0.9
+ 747595462572318528838257597159343240110946582824828469481464562737776904023224192508036730427801600p 0.9
+ 747595462572318528838257597159343240110946582824828469481464562737776904023224192508036730427801610p -0.3
+ \]
V_wl_319 (WordLine\\<319\\> gnd!) vsource type=pwl wave=\[
+ 0    -0.3
+ 1495190925144637057676515194318686480221893165649656938962929125475553808046448385016073460855602500p -0.3
+ 1495190925144637057676515194318686480221893165649656938962929125475553808046448385016073460855602510p 0.9
+ 1495190925144637057676515194318686480221893165649656938962929125475553808046448385016073460855603200p 0.9
+ 1495190925144637057676515194318686480221893165649656938962929125475553808046448385016073460855603210p -0.3
+ \]
V_wl_320 (WordLine\\<320\\> gnd!) vsource type=pwl wave=\[
+ 0    -0.3
+ 2990381850289274115353030388637372960443786331299313877925858250951107616092896770032146921711205700p -0.3
+ 2990381850289274115353030388637372960443786331299313877925858250951107616092896770032146921711205710p 0.9
+ 2990381850289274115353030388637372960443786331299313877925858250951107616092896770032146921711206400p 0.9
+ 2990381850289274115353030388637372960443786331299313877925858250951107616092896770032146921711206410p -0.3
+ \]
V_wl_321 (WordLine\\<321\\> gnd!) vsource type=pwl wave=\[
+ 0    -0.3
+ 5980763700578548230706060777274745920887572662598627755851716501902215232185793540064293843422412100p -0.3
+ 5980763700578548230706060777274745920887572662598627755851716501902215232185793540064293843422412110p 0.9
+ 5980763700578548230706060777274745920887572662598627755851716501902215232185793540064293843422412800p 0.9
+ 5980763700578548230706060777274745920887572662598627755851716501902215232185793540064293843422412810p -0.3
+ \]
V_wl_322 (WordLine\\<322\\> gnd!) vsource type=pwl wave=\[
+ 0    -0.3
+ 11961527401157096461412121554549491841775145325197255511703433003804430464371587080128587686844824900p -0.3
+ 11961527401157096461412121554549491841775145325197255511703433003804430464371587080128587686844824910p 0.9
+ 11961527401157096461412121554549491841775145325197255511703433003804430464371587080128587686844825600p 0.9
+ 11961527401157096461412121554549491841775145325197255511703433003804430464371587080128587686844825610p -0.3
+ \]
V_wl_323 (WordLine\\<323\\> gnd!) vsource type=pwl wave=\[
+ 0    -0.3
+ 23923054802314192922824243109098983683550290650394511023406866007608860928743174160257175373689650500p -0.3
+ 23923054802314192922824243109098983683550290650394511023406866007608860928743174160257175373689650510p 0.9
+ 23923054802314192922824243109098983683550290650394511023406866007608860928743174160257175373689651200p 0.9
+ 23923054802314192922824243109098983683550290650394511023406866007608860928743174160257175373689651210p -0.3
+ \]
V_wl_324 (WordLine\\<324\\> gnd!) vsource type=pwl wave=\[
+ 0    -0.3
+ 47846109604628385845648486218197967367100581300789022046813732015217721857486348320514350747379301700p -0.3
+ 47846109604628385845648486218197967367100581300789022046813732015217721857486348320514350747379301710p 0.9
+ 47846109604628385845648486218197967367100581300789022046813732015217721857486348320514350747379302400p 0.9
+ 47846109604628385845648486218197967367100581300789022046813732015217721857486348320514350747379302410p -0.3
+ \]
V_wl_325 (WordLine\\<325\\> gnd!) vsource type=pwl wave=\[
+ 0    -0.3
+ 95692219209256771691296972436395934734201162601578044093627464030435443714972696641028701494758604100p -0.3
+ 95692219209256771691296972436395934734201162601578044093627464030435443714972696641028701494758604110p 0.9
+ 95692219209256771691296972436395934734201162601578044093627464030435443714972696641028701494758604800p 0.9
+ 95692219209256771691296972436395934734201162601578044093627464030435443714972696641028701494758604810p -0.3
+ \]
V_wl_326 (WordLine\\<326\\> gnd!) vsource type=pwl wave=\[
+ 0    -0.3
+ 191384438418513543382593944872791869468402325203156088187254928060870887429945393282057402989517208900p -0.3
+ 191384438418513543382593944872791869468402325203156088187254928060870887429945393282057402989517208910p 0.9
+ 191384438418513543382593944872791869468402325203156088187254928060870887429945393282057402989517209600p 0.9
+ 191384438418513543382593944872791869468402325203156088187254928060870887429945393282057402989517209610p -0.3
+ \]
V_wl_327 (WordLine\\<327\\> gnd!) vsource type=pwl wave=\[
+ 0    -0.3
+ 382768876837027086765187889745583738936804650406312176374509856121741774859890786564114805979034418500p -0.3
+ 382768876837027086765187889745583738936804650406312176374509856121741774859890786564114805979034418510p 0.9
+ 382768876837027086765187889745583738936804650406312176374509856121741774859890786564114805979034419200p 0.9
+ 382768876837027086765187889745583738936804650406312176374509856121741774859890786564114805979034419210p -0.3
+ \]
V_wl_328 (WordLine\\<328\\> gnd!) vsource type=pwl wave=\[
+ 0    -0.3
+ 765537753674054173530375779491167477873609300812624352749019712243483549719781573128229611958068837700p -0.3
+ 765537753674054173530375779491167477873609300812624352749019712243483549719781573128229611958068837710p 0.9
+ 765537753674054173530375779491167477873609300812624352749019712243483549719781573128229611958068838400p 0.9
+ 765537753674054173530375779491167477873609300812624352749019712243483549719781573128229611958068838410p -0.3
+ \]
V_wl_329 (WordLine\\<329\\> gnd!) vsource type=pwl wave=\[
+ 0    -0.3
+ 1531075507348108347060751558982334955747218601625248705498039424486967099439563146256459223916137676100p -0.3
+ 1531075507348108347060751558982334955747218601625248705498039424486967099439563146256459223916137676110p 0.9
+ 1531075507348108347060751558982334955747218601625248705498039424486967099439563146256459223916137676800p 0.9
+ 1531075507348108347060751558982334955747218601625248705498039424486967099439563146256459223916137676810p -0.3
+ \]
V_wl_330 (WordLine\\<330\\> gnd!) vsource type=pwl wave=\[
+ 0    -0.3
+ 3062151014696216694121503117964669911494437203250497410996078848973934198879126292512918447832275352900p -0.3
+ 3062151014696216694121503117964669911494437203250497410996078848973934198879126292512918447832275352910p 0.9
+ 3062151014696216694121503117964669911494437203250497410996078848973934198879126292512918447832275353600p 0.9
+ 3062151014696216694121503117964669911494437203250497410996078848973934198879126292512918447832275353610p -0.3
+ \]
V_wl_331 (WordLine\\<331\\> gnd!) vsource type=pwl wave=\[
+ 0    -0.3
+ 6124302029392433388243006235929339822988874406500994821992157697947868397758252585025836895664550706500p -0.3
+ 6124302029392433388243006235929339822988874406500994821992157697947868397758252585025836895664550706510p 0.9
+ 6124302029392433388243006235929339822988874406500994821992157697947868397758252585025836895664550707200p 0.9
+ 6124302029392433388243006235929339822988874406500994821992157697947868397758252585025836895664550707210p -0.3
+ \]
V_wl_332 (WordLine\\<332\\> gnd!) vsource type=pwl wave=\[
+ 0    -0.3
+ 12248604058784866776486012471858679645977748813001989643984315395895736795516505170051673791329101413700p -0.3
+ 12248604058784866776486012471858679645977748813001989643984315395895736795516505170051673791329101413710p 0.9
+ 12248604058784866776486012471858679645977748813001989643984315395895736795516505170051673791329101414400p 0.9
+ 12248604058784866776486012471858679645977748813001989643984315395895736795516505170051673791329101414410p -0.3
+ \]
V_wl_333 (WordLine\\<333\\> gnd!) vsource type=pwl wave=\[
+ 0    -0.3
+ 24497208117569733552972024943717359291955497626003979287968630791791473591033010340103347582658202828100p -0.3
+ 24497208117569733552972024943717359291955497626003979287968630791791473591033010340103347582658202828110p 0.9
+ 24497208117569733552972024943717359291955497626003979287968630791791473591033010340103347582658202828800p 0.9
+ 24497208117569733552972024943717359291955497626003979287968630791791473591033010340103347582658202828810p -0.3
+ \]
V_wl_334 (WordLine\\<334\\> gnd!) vsource type=pwl wave=\[
+ 0    -0.3
+ 48994416235139467105944049887434718583910995252007958575937261583582947182066020680206695165316405656900p -0.3
+ 48994416235139467105944049887434718583910995252007958575937261583582947182066020680206695165316405656910p 0.9
+ 48994416235139467105944049887434718583910995252007958575937261583582947182066020680206695165316405657600p 0.9
+ 48994416235139467105944049887434718583910995252007958575937261583582947182066020680206695165316405657610p -0.3
+ \]
V_wl_335 (WordLine\\<335\\> gnd!) vsource type=pwl wave=\[
+ 0    -0.3
+ 97988832470278934211888099774869437167821990504015917151874523167165894364132041360413390330632811314500p -0.3
+ 97988832470278934211888099774869437167821990504015917151874523167165894364132041360413390330632811314510p 0.9
+ 97988832470278934211888099774869437167821990504015917151874523167165894364132041360413390330632811315200p 0.9
+ 97988832470278934211888099774869437167821990504015917151874523167165894364132041360413390330632811315210p -0.3
+ \]
V_wl_336 (WordLine\\<336\\> gnd!) vsource type=pwl wave=\[
+ 0    -0.3
+ 195977664940557868423776199549738874335643981008031834303749046334331788728264082720826780661265622629700p -0.3
+ 195977664940557868423776199549738874335643981008031834303749046334331788728264082720826780661265622629710p 0.9
+ 195977664940557868423776199549738874335643981008031834303749046334331788728264082720826780661265622630400p 0.9
+ 195977664940557868423776199549738874335643981008031834303749046334331788728264082720826780661265622630410p -0.3
+ \]
V_wl_337 (WordLine\\<337\\> gnd!) vsource type=pwl wave=\[
+ 0    -0.3
+ 391955329881115736847552399099477748671287962016063668607498092668663577456528165441653561322531245260100p -0.3
+ 391955329881115736847552399099477748671287962016063668607498092668663577456528165441653561322531245260110p 0.9
+ 391955329881115736847552399099477748671287962016063668607498092668663577456528165441653561322531245260800p 0.9
+ 391955329881115736847552399099477748671287962016063668607498092668663577456528165441653561322531245260810p -0.3
+ \]
V_wl_338 (WordLine\\<338\\> gnd!) vsource type=pwl wave=\[
+ 0    -0.3
+ 783910659762231473695104798198955497342575924032127337214996185337327154913056330883307122645062490520900p -0.3
+ 783910659762231473695104798198955497342575924032127337214996185337327154913056330883307122645062490520910p 0.9
+ 783910659762231473695104798198955497342575924032127337214996185337327154913056330883307122645062490521600p 0.9
+ 783910659762231473695104798198955497342575924032127337214996185337327154913056330883307122645062490521610p -0.3
+ \]
V_wl_339 (WordLine\\<339\\> gnd!) vsource type=pwl wave=\[
+ 0    -0.3
+ 1567821319524462947390209596397910994685151848064254674429992370674654309826112661766614245290124981042500p -0.3
+ 1567821319524462947390209596397910994685151848064254674429992370674654309826112661766614245290124981042510p 0.9
+ 1567821319524462947390209596397910994685151848064254674429992370674654309826112661766614245290124981043200p 0.9
+ 1567821319524462947390209596397910994685151848064254674429992370674654309826112661766614245290124981043210p -0.3
+ \]
V_wl_340 (WordLine\\<340\\> gnd!) vsource type=pwl wave=\[
+ 0    -0.3
+ 3135642639048925894780419192795821989370303696128509348859984741349308619652225323533228490580249962085700p -0.3
+ 3135642639048925894780419192795821989370303696128509348859984741349308619652225323533228490580249962085710p 0.9
+ 3135642639048925894780419192795821989370303696128509348859984741349308619652225323533228490580249962086400p 0.9
+ 3135642639048925894780419192795821989370303696128509348859984741349308619652225323533228490580249962086410p -0.3
+ \]
V_wl_341 (WordLine\\<341\\> gnd!) vsource type=pwl wave=\[
+ 0    -0.3
+ 6271285278097851789560838385591643978740607392257018697719969482698617239304450647066456981160499924172100p -0.3
+ 6271285278097851789560838385591643978740607392257018697719969482698617239304450647066456981160499924172110p 0.9
+ 6271285278097851789560838385591643978740607392257018697719969482698617239304450647066456981160499924172800p 0.9
+ 6271285278097851789560838385591643978740607392257018697719969482698617239304450647066456981160499924172810p -0.3
+ \]
V_wl_342 (WordLine\\<342\\> gnd!) vsource type=pwl wave=\[
+ 0    -0.3
+ 12542570556195703579121676771183287957481214784514037395439938965397234478608901294132913962320999848344900p -0.3
+ 12542570556195703579121676771183287957481214784514037395439938965397234478608901294132913962320999848344910p 0.9
+ 12542570556195703579121676771183287957481214784514037395439938965397234478608901294132913962320999848345600p 0.9
+ 12542570556195703579121676771183287957481214784514037395439938965397234478608901294132913962320999848345610p -0.3
+ \]
V_wl_343 (WordLine\\<343\\> gnd!) vsource type=pwl wave=\[
+ 0    -0.3
+ 25085141112391407158243353542366575914962429569028074790879877930794468957217802588265827924641999696690500p -0.3
+ 25085141112391407158243353542366575914962429569028074790879877930794468957217802588265827924641999696690510p 0.9
+ 25085141112391407158243353542366575914962429569028074790879877930794468957217802588265827924641999696691200p 0.9
+ 25085141112391407158243353542366575914962429569028074790879877930794468957217802588265827924641999696691210p -0.3
+ \]
V_wl_344 (WordLine\\<344\\> gnd!) vsource type=pwl wave=\[
+ 0    -0.3
+ 50170282224782814316486707084733151829924859138056149581759755861588937914435605176531655849283999393381700p -0.3
+ 50170282224782814316486707084733151829924859138056149581759755861588937914435605176531655849283999393381710p 0.9
+ 50170282224782814316486707084733151829924859138056149581759755861588937914435605176531655849283999393382400p 0.9
+ 50170282224782814316486707084733151829924859138056149581759755861588937914435605176531655849283999393382410p -0.3
+ \]
V_wl_345 (WordLine\\<345\\> gnd!) vsource type=pwl wave=\[
+ 0    -0.3
+ 100340564449565628632973414169466303659849718276112299163519511723177875828871210353063311698567998786764100p -0.3
+ 100340564449565628632973414169466303659849718276112299163519511723177875828871210353063311698567998786764110p 0.9
+ 100340564449565628632973414169466303659849718276112299163519511723177875828871210353063311698567998786764800p 0.9
+ 100340564449565628632973414169466303659849718276112299163519511723177875828871210353063311698567998786764810p -0.3
+ \]
V_wl_346 (WordLine\\<346\\> gnd!) vsource type=pwl wave=\[
+ 0    -0.3
+ 200681128899131257265946828338932607319699436552224598327039023446355751657742420706126623397135997573528900p -0.3
+ 200681128899131257265946828338932607319699436552224598327039023446355751657742420706126623397135997573528910p 0.9
+ 200681128899131257265946828338932607319699436552224598327039023446355751657742420706126623397135997573529600p 0.9
+ 200681128899131257265946828338932607319699436552224598327039023446355751657742420706126623397135997573529610p -0.3
+ \]
V_wl_347 (WordLine\\<347\\> gnd!) vsource type=pwl wave=\[
+ 0    -0.3
+ 401362257798262514531893656677865214639398873104449196654078046892711503315484841412253246794271995147058500p -0.3
+ 401362257798262514531893656677865214639398873104449196654078046892711503315484841412253246794271995147058510p 0.9
+ 401362257798262514531893656677865214639398873104449196654078046892711503315484841412253246794271995147059200p 0.9
+ 401362257798262514531893656677865214639398873104449196654078046892711503315484841412253246794271995147059210p -0.3
+ \]
V_wl_348 (WordLine\\<348\\> gnd!) vsource type=pwl wave=\[
+ 0    -0.3
+ 802724515596525029063787313355730429278797746208898393308156093785423006630969682824506493588543990294117700p -0.3
+ 802724515596525029063787313355730429278797746208898393308156093785423006630969682824506493588543990294117710p 0.9
+ 802724515596525029063787313355730429278797746208898393308156093785423006630969682824506493588543990294118400p 0.9
+ 802724515596525029063787313355730429278797746208898393308156093785423006630969682824506493588543990294118410p -0.3
+ \]
V_wl_349 (WordLine\\<349\\> gnd!) vsource type=pwl wave=\[
+ 0    -0.3
+ 1605449031193050058127574626711460858557595492417796786616312187570846013261939365649012987177087980588236100p -0.3
+ 1605449031193050058127574626711460858557595492417796786616312187570846013261939365649012987177087980588236110p 0.9
+ 1605449031193050058127574626711460858557595492417796786616312187570846013261939365649012987177087980588236800p 0.9
+ 1605449031193050058127574626711460858557595492417796786616312187570846013261939365649012987177087980588236810p -0.3
+ \]
V_wl_350 (WordLine\\<350\\> gnd!) vsource type=pwl wave=\[
+ 0    -0.3
+ 3210898062386100116255149253422921717115190984835593573232624375141692026523878731298025974354175961176472900p -0.3
+ 3210898062386100116255149253422921717115190984835593573232624375141692026523878731298025974354175961176472910p 0.9
+ 3210898062386100116255149253422921717115190984835593573232624375141692026523878731298025974354175961176473600p 0.9
+ 3210898062386100116255149253422921717115190984835593573232624375141692026523878731298025974354175961176473610p -0.3
+ \]
V_wl_351 (WordLine\\<351\\> gnd!) vsource type=pwl wave=\[
+ 0    -0.3
+ 6421796124772200232510298506845843434230381969671187146465248750283384053047757462596051948708351922352946500p -0.3
+ 6421796124772200232510298506845843434230381969671187146465248750283384053047757462596051948708351922352946510p 0.9
+ 6421796124772200232510298506845843434230381969671187146465248750283384053047757462596051948708351922352947200p 0.9
+ 6421796124772200232510298506845843434230381969671187146465248750283384053047757462596051948708351922352947210p -0.3
+ \]
V_wl_352 (WordLine\\<352\\> gnd!) vsource type=pwl wave=\[
+ 0    -0.3
+ 12843592249544400465020597013691686868460763939342374292930497500566768106095514925192103897416703844705893700p -0.3
+ 12843592249544400465020597013691686868460763939342374292930497500566768106095514925192103897416703844705893710p 0.9
+ 12843592249544400465020597013691686868460763939342374292930497500566768106095514925192103897416703844705894400p 0.9
+ 12843592249544400465020597013691686868460763939342374292930497500566768106095514925192103897416703844705894410p -0.3
+ \]
V_wl_353 (WordLine\\<353\\> gnd!) vsource type=pwl wave=\[
+ 0    -0.3
+ 25687184499088800930041194027383373736921527878684748585860995001133536212191029850384207794833407689411788100p -0.3
+ 25687184499088800930041194027383373736921527878684748585860995001133536212191029850384207794833407689411788110p 0.9
+ 25687184499088800930041194027383373736921527878684748585860995001133536212191029850384207794833407689411788800p 0.9
+ 25687184499088800930041194027383373736921527878684748585860995001133536212191029850384207794833407689411788810p -0.3
+ \]
V_wl_354 (WordLine\\<354\\> gnd!) vsource type=pwl wave=\[
+ 0    -0.3
+ 51374368998177601860082388054766747473843055757369497171721990002267072424382059700768415589666815378823576900p -0.3
+ 51374368998177601860082388054766747473843055757369497171721990002267072424382059700768415589666815378823576910p 0.9
+ 51374368998177601860082388054766747473843055757369497171721990002267072424382059700768415589666815378823577600p 0.9
+ 51374368998177601860082388054766747473843055757369497171721990002267072424382059700768415589666815378823577610p -0.3
+ \]
V_wl_355 (WordLine\\<355\\> gnd!) vsource type=pwl wave=\[
+ 0    -0.3
+ 102748737996355203720164776109533494947686111514738994343443980004534144848764119401536831179333630757647154500p -0.3
+ 102748737996355203720164776109533494947686111514738994343443980004534144848764119401536831179333630757647154510p 0.9
+ 102748737996355203720164776109533494947686111514738994343443980004534144848764119401536831179333630757647155200p 0.9
+ 102748737996355203720164776109533494947686111514738994343443980004534144848764119401536831179333630757647155210p -0.3
+ \]
V_wl_356 (WordLine\\<356\\> gnd!) vsource type=pwl wave=\[
+ 0    -0.3
+ 205497475992710407440329552219066989895372223029477988686887960009068289697528238803073662358667261515294309700p -0.3
+ 205497475992710407440329552219066989895372223029477988686887960009068289697528238803073662358667261515294309710p 0.9
+ 205497475992710407440329552219066989895372223029477988686887960009068289697528238803073662358667261515294310400p 0.9
+ 205497475992710407440329552219066989895372223029477988686887960009068289697528238803073662358667261515294310410p -0.3
+ \]
V_wl_357 (WordLine\\<357\\> gnd!) vsource type=pwl wave=\[
+ 0    -0.3
+ 410994951985420814880659104438133979790744446058955977373775920018136579395056477606147324717334523030588620100p -0.3
+ 410994951985420814880659104438133979790744446058955977373775920018136579395056477606147324717334523030588620110p 0.9
+ 410994951985420814880659104438133979790744446058955977373775920018136579395056477606147324717334523030588620800p 0.9
+ 410994951985420814880659104438133979790744446058955977373775920018136579395056477606147324717334523030588620810p -0.3
+ \]
V_wl_358 (WordLine\\<358\\> gnd!) vsource type=pwl wave=\[
+ 0    -0.3
+ 821989903970841629761318208876267959581488892117911954747551840036273158790112955212294649434669046061177240900p -0.3
+ 821989903970841629761318208876267959581488892117911954747551840036273158790112955212294649434669046061177240910p 0.9
+ 821989903970841629761318208876267959581488892117911954747551840036273158790112955212294649434669046061177241600p 0.9
+ 821989903970841629761318208876267959581488892117911954747551840036273158790112955212294649434669046061177241610p -0.3
+ \]
V_wl_359 (WordLine\\<359\\> gnd!) vsource type=pwl wave=\[
+ 0    -0.3
+ 1643979807941683259522636417752535919162977784235823909495103680072546317580225910424589298869338092122354482500p -0.3
+ 1643979807941683259522636417752535919162977784235823909495103680072546317580225910424589298869338092122354482510p 0.9
+ 1643979807941683259522636417752535919162977784235823909495103680072546317580225910424589298869338092122354483200p 0.9
+ 1643979807941683259522636417752535919162977784235823909495103680072546317580225910424589298869338092122354483210p -0.3
+ \]
V_wl_360 (WordLine\\<360\\> gnd!) vsource type=pwl wave=\[
+ 0    -0.3
+ 3287959615883366519045272835505071838325955568471647818990207360145092635160451820849178597738676184244708965700p -0.3
+ 3287959615883366519045272835505071838325955568471647818990207360145092635160451820849178597738676184244708965710p 0.9
+ 3287959615883366519045272835505071838325955568471647818990207360145092635160451820849178597738676184244708966400p 0.9
+ 3287959615883366519045272835505071838325955568471647818990207360145092635160451820849178597738676184244708966410p -0.3
+ \]
V_wl_361 (WordLine\\<361\\> gnd!) vsource type=pwl wave=\[
+ 0    -0.3
+ 6575919231766733038090545671010143676651911136943295637980414720290185270320903641698357195477352368489417932100p -0.3
+ 6575919231766733038090545671010143676651911136943295637980414720290185270320903641698357195477352368489417932110p 0.9
+ 6575919231766733038090545671010143676651911136943295637980414720290185270320903641698357195477352368489417932800p 0.9
+ 6575919231766733038090545671010143676651911136943295637980414720290185270320903641698357195477352368489417932810p -0.3
+ \]
V_wl_362 (WordLine\\<362\\> gnd!) vsource type=pwl wave=\[
+ 0    -0.3
+ 13151838463533466076181091342020287353303822273886591275960829440580370540641807283396714390954704736978835864900p -0.3
+ 13151838463533466076181091342020287353303822273886591275960829440580370540641807283396714390954704736978835864910p 0.9
+ 13151838463533466076181091342020287353303822273886591275960829440580370540641807283396714390954704736978835865600p 0.9
+ 13151838463533466076181091342020287353303822273886591275960829440580370540641807283396714390954704736978835865610p -0.3
+ \]
V_wl_363 (WordLine\\<363\\> gnd!) vsource type=pwl wave=\[
+ 0    -0.3
+ 26303676927066932152362182684040574706607644547773182551921658881160741081283614566793428781909409473957671730500p -0.3
+ 26303676927066932152362182684040574706607644547773182551921658881160741081283614566793428781909409473957671730510p 0.9
+ 26303676927066932152362182684040574706607644547773182551921658881160741081283614566793428781909409473957671731200p 0.9
+ 26303676927066932152362182684040574706607644547773182551921658881160741081283614566793428781909409473957671731210p -0.3
+ \]
V_wl_364 (WordLine\\<364\\> gnd!) vsource type=pwl wave=\[
+ 0    -0.3
+ 52607353854133864304724365368081149413215289095546365103843317762321482162567229133586857563818818947915343461700p -0.3
+ 52607353854133864304724365368081149413215289095546365103843317762321482162567229133586857563818818947915343461710p 0.9
+ 52607353854133864304724365368081149413215289095546365103843317762321482162567229133586857563818818947915343462400p 0.9
+ 52607353854133864304724365368081149413215289095546365103843317762321482162567229133586857563818818947915343462410p -0.3
+ \]
V_wl_365 (WordLine\\<365\\> gnd!) vsource type=pwl wave=\[
+ 0    -0.3
+ 105214707708267728609448730736162298826430578191092730207686635524642964325134458267173715127637637895830686924100p -0.3
+ 105214707708267728609448730736162298826430578191092730207686635524642964325134458267173715127637637895830686924110p 0.9
+ 105214707708267728609448730736162298826430578191092730207686635524642964325134458267173715127637637895830686924800p 0.9
+ 105214707708267728609448730736162298826430578191092730207686635524642964325134458267173715127637637895830686924810p -0.3
+ \]
V_wl_366 (WordLine\\<366\\> gnd!) vsource type=pwl wave=\[
+ 0    -0.3
+ 210429415416535457218897461472324597652861156382185460415373271049285928650268916534347430255275275791661373848900p -0.3
+ 210429415416535457218897461472324597652861156382185460415373271049285928650268916534347430255275275791661373848910p 0.9
+ 210429415416535457218897461472324597652861156382185460415373271049285928650268916534347430255275275791661373849600p 0.9
+ 210429415416535457218897461472324597652861156382185460415373271049285928650268916534347430255275275791661373849610p -0.3
+ \]
V_wl_367 (WordLine\\<367\\> gnd!) vsource type=pwl wave=\[
+ 0    -0.3
+ 420858830833070914437794922944649195305722312764370920830746542098571857300537833068694860510550551583322747698500p -0.3
+ 420858830833070914437794922944649195305722312764370920830746542098571857300537833068694860510550551583322747698510p 0.9
+ 420858830833070914437794922944649195305722312764370920830746542098571857300537833068694860510550551583322747699200p 0.9
+ 420858830833070914437794922944649195305722312764370920830746542098571857300537833068694860510550551583322747699210p -0.3
+ \]
V_wl_368 (WordLine\\<368\\> gnd!) vsource type=pwl wave=\[
+ 0    -0.3
+ 841717661666141828875589845889298390611444625528741841661493084197143714601075666137389721021101103166645495397700p -0.3
+ 841717661666141828875589845889298390611444625528741841661493084197143714601075666137389721021101103166645495397710p 0.9
+ 841717661666141828875589845889298390611444625528741841661493084197143714601075666137389721021101103166645495398400p 0.9
+ 841717661666141828875589845889298390611444625528741841661493084197143714601075666137389721021101103166645495398410p -0.3
+ \]
V_wl_369 (WordLine\\<369\\> gnd!) vsource type=pwl wave=\[
+ 0    -0.3
+ 1683435323332283657751179691778596781222889251057483683322986168394287429202151332274779442042202206333290990796100p -0.3
+ 1683435323332283657751179691778596781222889251057483683322986168394287429202151332274779442042202206333290990796110p 0.9
+ 1683435323332283657751179691778596781222889251057483683322986168394287429202151332274779442042202206333290990796800p 0.9
+ 1683435323332283657751179691778596781222889251057483683322986168394287429202151332274779442042202206333290990796810p -0.3
+ \]
V_wl_370 (WordLine\\<370\\> gnd!) vsource type=pwl wave=\[
+ 0    -0.3
+ 3366870646664567315502359383557193562445778502114967366645972336788574858404302664549558884084404412666581981592900p -0.3
+ 3366870646664567315502359383557193562445778502114967366645972336788574858404302664549558884084404412666581981592910p 0.9
+ 3366870646664567315502359383557193562445778502114967366645972336788574858404302664549558884084404412666581981593600p 0.9
+ 3366870646664567315502359383557193562445778502114967366645972336788574858404302664549558884084404412666581981593610p -0.3
+ \]
V_wl_371 (WordLine\\<371\\> gnd!) vsource type=pwl wave=\[
+ 0    -0.3
+ 6733741293329134631004718767114387124891557004229934733291944673577149716808605329099117768168808825333163963186500p -0.3
+ 6733741293329134631004718767114387124891557004229934733291944673577149716808605329099117768168808825333163963186510p 0.9
+ 6733741293329134631004718767114387124891557004229934733291944673577149716808605329099117768168808825333163963187200p 0.9
+ 6733741293329134631004718767114387124891557004229934733291944673577149716808605329099117768168808825333163963187210p -0.3
+ \]
V_wl_372 (WordLine\\<372\\> gnd!) vsource type=pwl wave=\[
+ 0    -0.3
+ 13467482586658269262009437534228774249783114008459869466583889347154299433617210658198235536337617650666327926373700p -0.3
+ 13467482586658269262009437534228774249783114008459869466583889347154299433617210658198235536337617650666327926373710p 0.9
+ 13467482586658269262009437534228774249783114008459869466583889347154299433617210658198235536337617650666327926374400p 0.9
+ 13467482586658269262009437534228774249783114008459869466583889347154299433617210658198235536337617650666327926374410p -0.3
+ \]
V_wl_373 (WordLine\\<373\\> gnd!) vsource type=pwl wave=\[
+ 0    -0.3
+ 26934965173316538524018875068457548499566228016919738933167778694308598867234421316396471072675235301332655852748100p -0.3
+ 26934965173316538524018875068457548499566228016919738933167778694308598867234421316396471072675235301332655852748110p 0.9
+ 26934965173316538524018875068457548499566228016919738933167778694308598867234421316396471072675235301332655852748800p 0.9
+ 26934965173316538524018875068457548499566228016919738933167778694308598867234421316396471072675235301332655852748810p -0.3
+ \]
V_wl_374 (WordLine\\<374\\> gnd!) vsource type=pwl wave=\[
+ 0    -0.3
+ 53869930346633077048037750136915096999132456033839477866335557388617197734468842632792942145350470602665311705496900p -0.3
+ 53869930346633077048037750136915096999132456033839477866335557388617197734468842632792942145350470602665311705496910p 0.9
+ 53869930346633077048037750136915096999132456033839477866335557388617197734468842632792942145350470602665311705497600p 0.9
+ 53869930346633077048037750136915096999132456033839477866335557388617197734468842632792942145350470602665311705497610p -0.3
+ \]
V_wl_375 (WordLine\\<375\\> gnd!) vsource type=pwl wave=\[
+ 0    -0.3
+ 107739860693266154096075500273830193998264912067678955732671114777234395468937685265585884290700941205330623410994500p -0.3
+ 107739860693266154096075500273830193998264912067678955732671114777234395468937685265585884290700941205330623410994510p 0.9
+ 107739860693266154096075500273830193998264912067678955732671114777234395468937685265585884290700941205330623410995200p 0.9
+ 107739860693266154096075500273830193998264912067678955732671114777234395468937685265585884290700941205330623410995210p -0.3
+ \]
V_wl_376 (WordLine\\<376\\> gnd!) vsource type=pwl wave=\[
+ 0    -0.3
+ 215479721386532308192151000547660387996529824135357911465342229554468790937875370531171768581401882410661246821989700p -0.3
+ 215479721386532308192151000547660387996529824135357911465342229554468790937875370531171768581401882410661246821989710p 0.9
+ 215479721386532308192151000547660387996529824135357911465342229554468790937875370531171768581401882410661246821990400p 0.9
+ 215479721386532308192151000547660387996529824135357911465342229554468790937875370531171768581401882410661246821990410p -0.3
+ \]
V_wl_377 (WordLine\\<377\\> gnd!) vsource type=pwl wave=\[
+ 0    -0.3
+ 430959442773064616384302001095320775993059648270715822930684459108937581875750741062343537162803764821322493643980100p -0.3
+ 430959442773064616384302001095320775993059648270715822930684459108937581875750741062343537162803764821322493643980110p 0.9
+ 430959442773064616384302001095320775993059648270715822930684459108937581875750741062343537162803764821322493643980800p 0.9
+ 430959442773064616384302001095320775993059648270715822930684459108937581875750741062343537162803764821322493643980810p -0.3
+ \]
V_wl_378 (WordLine\\<378\\> gnd!) vsource type=pwl wave=\[
+ 0    -0.3
+ 861918885546129232768604002190641551986119296541431645861368918217875163751501482124687074325607529642644987287960900p -0.3
+ 861918885546129232768604002190641551986119296541431645861368918217875163751501482124687074325607529642644987287960910p 0.9
+ 861918885546129232768604002190641551986119296541431645861368918217875163751501482124687074325607529642644987287961600p 0.9
+ 861918885546129232768604002190641551986119296541431645861368918217875163751501482124687074325607529642644987287961610p -0.3
+ \]
V_wl_379 (WordLine\\<379\\> gnd!) vsource type=pwl wave=\[
+ 0    -0.3
+ 1723837771092258465537208004381283103972238593082863291722737836435750327503002964249374148651215059285289974575922500p -0.3
+ 1723837771092258465537208004381283103972238593082863291722737836435750327503002964249374148651215059285289974575922510p 0.9
+ 1723837771092258465537208004381283103972238593082863291722737836435750327503002964249374148651215059285289974575923200p 0.9
+ 1723837771092258465537208004381283103972238593082863291722737836435750327503002964249374148651215059285289974575923210p -0.3
+ \]
V_wl_380 (WordLine\\<380\\> gnd!) vsource type=pwl wave=\[
+ 0    -0.3
+ 3447675542184516931074416008762566207944477186165726583445475672871500655006005928498748297302430118570579949151845700p -0.3
+ 3447675542184516931074416008762566207944477186165726583445475672871500655006005928498748297302430118570579949151845710p 0.9
+ 3447675542184516931074416008762566207944477186165726583445475672871500655006005928498748297302430118570579949151846400p 0.9
+ 3447675542184516931074416008762566207944477186165726583445475672871500655006005928498748297302430118570579949151846410p -0.3
+ \]
V_wl_381 (WordLine\\<381\\> gnd!) vsource type=pwl wave=\[
+ 0    -0.3
+ 6895351084369033862148832017525132415888954372331453166890951345743001310012011856997496594604860237141159898303692100p -0.3
+ 6895351084369033862148832017525132415888954372331453166890951345743001310012011856997496594604860237141159898303692110p 0.9
+ 6895351084369033862148832017525132415888954372331453166890951345743001310012011856997496594604860237141159898303692800p 0.9
+ 6895351084369033862148832017525132415888954372331453166890951345743001310012011856997496594604860237141159898303692810p -0.3
+ \]
V_wl_382 (WordLine\\<382\\> gnd!) vsource type=pwl wave=\[
+ 0    -0.3
+ 13790702168738067724297664035050264831777908744662906333781902691486002620024023713994993189209720474282319796607384900p -0.3
+ 13790702168738067724297664035050264831777908744662906333781902691486002620024023713994993189209720474282319796607384910p 0.9
+ 13790702168738067724297664035050264831777908744662906333781902691486002620024023713994993189209720474282319796607385600p 0.9
+ 13790702168738067724297664035050264831777908744662906333781902691486002620024023713994993189209720474282319796607385610p -0.3
+ \]
V_wl_383 (WordLine\\<383\\> gnd!) vsource type=pwl wave=\[
+ 0    -0.3
+ 27581404337476135448595328070100529663555817489325812667563805382972005240048047427989986378419440948564639593214770500p -0.3
+ 27581404337476135448595328070100529663555817489325812667563805382972005240048047427989986378419440948564639593214770510p 0.9
+ 27581404337476135448595328070100529663555817489325812667563805382972005240048047427989986378419440948564639593214771200p 0.9
+ 27581404337476135448595328070100529663555817489325812667563805382972005240048047427989986378419440948564639593214771210p -0.3
+ \]
V_wl_384 (WordLine\\<384\\> gnd!) vsource type=pwl wave=\[
+ 0    -0.3
+ 55162808674952270897190656140201059327111634978651625335127610765944010480096094855979972756838881897129279186429541700p -0.3
+ 55162808674952270897190656140201059327111634978651625335127610765944010480096094855979972756838881897129279186429541710p 0.9
+ 55162808674952270897190656140201059327111634978651625335127610765944010480096094855979972756838881897129279186429542400p 0.9
+ 55162808674952270897190656140201059327111634978651625335127610765944010480096094855979972756838881897129279186429542410p -0.3
+ \]
V_wl_385 (WordLine\\<385\\> gnd!) vsource type=pwl wave=\[
+ 0    -0.3
+ 110325617349904541794381312280402118654223269957303250670255221531888020960192189711959945513677763794258558372859084100p -0.3
+ 110325617349904541794381312280402118654223269957303250670255221531888020960192189711959945513677763794258558372859084110p 0.9
+ 110325617349904541794381312280402118654223269957303250670255221531888020960192189711959945513677763794258558372859084800p 0.9
+ 110325617349904541794381312280402118654223269957303250670255221531888020960192189711959945513677763794258558372859084810p -0.3
+ \]
V_wl_386 (WordLine\\<386\\> gnd!) vsource type=pwl wave=\[
+ 0    -0.3
+ 220651234699809083588762624560804237308446539914606501340510443063776041920384379423919891027355527588517116745718168900p -0.3
+ 220651234699809083588762624560804237308446539914606501340510443063776041920384379423919891027355527588517116745718168910p 0.9
+ 220651234699809083588762624560804237308446539914606501340510443063776041920384379423919891027355527588517116745718169600p 0.9
+ 220651234699809083588762624560804237308446539914606501340510443063776041920384379423919891027355527588517116745718169610p -0.3
+ \]
V_wl_387 (WordLine\\<387\\> gnd!) vsource type=pwl wave=\[
+ 0    -0.3
+ 441302469399618167177525249121608474616893079829213002681020886127552083840768758847839782054711055177034233491436338500p -0.3
+ 441302469399618167177525249121608474616893079829213002681020886127552083840768758847839782054711055177034233491436338510p 0.9
+ 441302469399618167177525249121608474616893079829213002681020886127552083840768758847839782054711055177034233491436339200p 0.9
+ 441302469399618167177525249121608474616893079829213002681020886127552083840768758847839782054711055177034233491436339210p -0.3
+ \]
V_wl_388 (WordLine\\<388\\> gnd!) vsource type=pwl wave=\[
+ 0    -0.3
+ 882604938799236334355050498243216949233786159658426005362041772255104167681537517695679564109422110354068466982872677700p -0.3
+ 882604938799236334355050498243216949233786159658426005362041772255104167681537517695679564109422110354068466982872677710p 0.9
+ 882604938799236334355050498243216949233786159658426005362041772255104167681537517695679564109422110354068466982872678400p 0.9
+ 882604938799236334355050498243216949233786159658426005362041772255104167681537517695679564109422110354068466982872678410p -0.3
+ \]
V_wl_389 (WordLine\\<389\\> gnd!) vsource type=pwl wave=\[
+ 0    -0.3
+ 1765209877598472668710100996486433898467572319316852010724083544510208335363075035391359128218844220708136933965745356100p -0.3
+ 1765209877598472668710100996486433898467572319316852010724083544510208335363075035391359128218844220708136933965745356110p 0.9
+ 1765209877598472668710100996486433898467572319316852010724083544510208335363075035391359128218844220708136933965745356800p 0.9
+ 1765209877598472668710100996486433898467572319316852010724083544510208335363075035391359128218844220708136933965745356810p -0.3
+ \]
V_wl_390 (WordLine\\<390\\> gnd!) vsource type=pwl wave=\[
+ 0    -0.3
+ 3530419755196945337420201992972867796935144638633704021448167089020416670726150070782718256437688441416273867931490712900p -0.3
+ 3530419755196945337420201992972867796935144638633704021448167089020416670726150070782718256437688441416273867931490712910p 0.9
+ 3530419755196945337420201992972867796935144638633704021448167089020416670726150070782718256437688441416273867931490713600p 0.9
+ 3530419755196945337420201992972867796935144638633704021448167089020416670726150070782718256437688441416273867931490713610p -0.3
+ \]
V_wl_391 (WordLine\\<391\\> gnd!) vsource type=pwl wave=\[
+ 0    -0.3
+ 7060839510393890674840403985945735593870289277267408042896334178040833341452300141565436512875376882832547735862981426500p -0.3
+ 7060839510393890674840403985945735593870289277267408042896334178040833341452300141565436512875376882832547735862981426510p 0.9
+ 7060839510393890674840403985945735593870289277267408042896334178040833341452300141565436512875376882832547735862981427200p 0.9
+ 7060839510393890674840403985945735593870289277267408042896334178040833341452300141565436512875376882832547735862981427210p -0.3
+ \]
V_wl_392 (WordLine\\<392\\> gnd!) vsource type=pwl wave=\[
+ 0    -0.3
+ 14121679020787781349680807971891471187740578554534816085792668356081666682904600283130873025750753765665095471725962853700p -0.3
+ 14121679020787781349680807971891471187740578554534816085792668356081666682904600283130873025750753765665095471725962853710p 0.9
+ 14121679020787781349680807971891471187740578554534816085792668356081666682904600283130873025750753765665095471725962854400p 0.9
+ 14121679020787781349680807971891471187740578554534816085792668356081666682904600283130873025750753765665095471725962854410p -0.3
+ \]
V_wl_393 (WordLine\\<393\\> gnd!) vsource type=pwl wave=\[
+ 0    -0.3
+ 28243358041575562699361615943782942375481157109069632171585336712163333365809200566261746051501507531330190943451925708100p -0.3
+ 28243358041575562699361615943782942375481157109069632171585336712163333365809200566261746051501507531330190943451925708110p 0.9
+ 28243358041575562699361615943782942375481157109069632171585336712163333365809200566261746051501507531330190943451925708800p 0.9
+ 28243358041575562699361615943782942375481157109069632171585336712163333365809200566261746051501507531330190943451925708810p -0.3
+ \]
V_wl_394 (WordLine\\<394\\> gnd!) vsource type=pwl wave=\[
+ 0    -0.3
+ 56486716083151125398723231887565884750962314218139264343170673424326666731618401132523492103003015062660381886903851416900p -0.3
+ 56486716083151125398723231887565884750962314218139264343170673424326666731618401132523492103003015062660381886903851416910p 0.9
+ 56486716083151125398723231887565884750962314218139264343170673424326666731618401132523492103003015062660381886903851417600p 0.9
+ 56486716083151125398723231887565884750962314218139264343170673424326666731618401132523492103003015062660381886903851417610p -0.3
+ \]
V_wl_395 (WordLine\\<395\\> gnd!) vsource type=pwl wave=\[
+ 0    -0.3
+ 112973432166302250797446463775131769501924628436278528686341346848653333463236802265046984206006030125320763773807702834500p -0.3
+ 112973432166302250797446463775131769501924628436278528686341346848653333463236802265046984206006030125320763773807702834510p 0.9
+ 112973432166302250797446463775131769501924628436278528686341346848653333463236802265046984206006030125320763773807702835200p 0.9
+ 112973432166302250797446463775131769501924628436278528686341346848653333463236802265046984206006030125320763773807702835210p -0.3
+ \]
V_wl_396 (WordLine\\<396\\> gnd!) vsource type=pwl wave=\[
+ 0    -0.3
+ 225946864332604501594892927550263539003849256872557057372682693697306666926473604530093968412012060250641527547615405669700p -0.3
+ 225946864332604501594892927550263539003849256872557057372682693697306666926473604530093968412012060250641527547615405669710p 0.9
+ 225946864332604501594892927550263539003849256872557057372682693697306666926473604530093968412012060250641527547615405670400p 0.9
+ 225946864332604501594892927550263539003849256872557057372682693697306666926473604530093968412012060250641527547615405670410p -0.3
+ \]
V_wl_397 (WordLine\\<397\\> gnd!) vsource type=pwl wave=\[
+ 0    -0.3
+ 451893728665209003189785855100527078007698513745114114745365387394613333852947209060187936824024120501283055095230811340100p -0.3
+ 451893728665209003189785855100527078007698513745114114745365387394613333852947209060187936824024120501283055095230811340110p 0.9
+ 451893728665209003189785855100527078007698513745114114745365387394613333852947209060187936824024120501283055095230811340800p 0.9
+ 451893728665209003189785855100527078007698513745114114745365387394613333852947209060187936824024120501283055095230811340810p -0.3
+ \]
V_wl_398 (WordLine\\<398\\> gnd!) vsource type=pwl wave=\[
+ 0    -0.3
+ 903787457330418006379571710201054156015397027490228229490730774789226667705894418120375873648048241002566110190461622680900p -0.3
+ 903787457330418006379571710201054156015397027490228229490730774789226667705894418120375873648048241002566110190461622680910p 0.9
+ 903787457330418006379571710201054156015397027490228229490730774789226667705894418120375873648048241002566110190461622681600p 0.9
+ 903787457330418006379571710201054156015397027490228229490730774789226667705894418120375873648048241002566110190461622681610p -0.3
+ \]
V_wl_399 (WordLine\\<399\\> gnd!) vsource type=pwl wave=\[
+ 0    -0.3
+ 1807574914660836012759143420402108312030794054980456458981461549578453335411788836240751747296096482005132220380923245362500p -0.3
+ 1807574914660836012759143420402108312030794054980456458981461549578453335411788836240751747296096482005132220380923245362510p 0.9
+ 1807574914660836012759143420402108312030794054980456458981461549578453335411788836240751747296096482005132220380923245363200p 0.9
+ 1807574914660836012759143420402108312030794054980456458981461549578453335411788836240751747296096482005132220380923245363210p -0.3
+ \]
V_wl_400 (WordLine\\<400\\> gnd!) vsource type=pwl wave=\[
+ 0    -0.3
+ 3615149829321672025518286840804216624061588109960912917962923099156906670823577672481503494592192964010264440761846490725700p -0.3
+ 3615149829321672025518286840804216624061588109960912917962923099156906670823577672481503494592192964010264440761846490725710p 0.9
+ 3615149829321672025518286840804216624061588109960912917962923099156906670823577672481503494592192964010264440761846490726400p 0.9
+ 3615149829321672025518286840804216624061588109960912917962923099156906670823577672481503494592192964010264440761846490726410p -0.3
+ \]
V_wl_401 (WordLine\\<401\\> gnd!) vsource type=pwl wave=\[
+ 0    -0.3
+ 7230299658643344051036573681608433248123176219921825835925846198313813341647155344963006989184385928020528881523692981452100p -0.3
+ 7230299658643344051036573681608433248123176219921825835925846198313813341647155344963006989184385928020528881523692981452110p 0.9
+ 7230299658643344051036573681608433248123176219921825835925846198313813341647155344963006989184385928020528881523692981452800p 0.9
+ 7230299658643344051036573681608433248123176219921825835925846198313813341647155344963006989184385928020528881523692981452810p -0.3
+ \]
V_wl_402 (WordLine\\<402\\> gnd!) vsource type=pwl wave=\[
+ 0    -0.3
+ 14460599317286688102073147363216866496246352439843651671851692396627626683294310689926013978368771856041057763047385962904900p -0.3
+ 14460599317286688102073147363216866496246352439843651671851692396627626683294310689926013978368771856041057763047385962904910p 0.9
+ 14460599317286688102073147363216866496246352439843651671851692396627626683294310689926013978368771856041057763047385962905600p 0.9
+ 14460599317286688102073147363216866496246352439843651671851692396627626683294310689926013978368771856041057763047385962905610p -0.3
+ \]
V_wl_403 (WordLine\\<403\\> gnd!) vsource type=pwl wave=\[
+ 0    -0.3
+ 28921198634573376204146294726433732992492704879687303343703384793255253366588621379852027956737543712082115526094771925810500p -0.3
+ 28921198634573376204146294726433732992492704879687303343703384793255253366588621379852027956737543712082115526094771925810510p 0.9
+ 28921198634573376204146294726433732992492704879687303343703384793255253366588621379852027956737543712082115526094771925811200p 0.9
+ 28921198634573376204146294726433732992492704879687303343703384793255253366588621379852027956737543712082115526094771925811210p -0.3
+ \]
V_wl_404 (WordLine\\<404\\> gnd!) vsource type=pwl wave=\[
+ 0    -0.3
+ 57842397269146752408292589452867465984985409759374606687406769586510506733177242759704055913475087424164231052189543851621700p -0.3
+ 57842397269146752408292589452867465984985409759374606687406769586510506733177242759704055913475087424164231052189543851621710p 0.9
+ 57842397269146752408292589452867465984985409759374606687406769586510506733177242759704055913475087424164231052189543851622400p 0.9
+ 57842397269146752408292589452867465984985409759374606687406769586510506733177242759704055913475087424164231052189543851622410p -0.3
+ \]
V_wl_405 (WordLine\\<405\\> gnd!) vsource type=pwl wave=\[
+ 0    -0.3
+ 115684794538293504816585178905734931969970819518749213374813539173021013466354485519408111826950174848328462104379087703244100p -0.3
+ 115684794538293504816585178905734931969970819518749213374813539173021013466354485519408111826950174848328462104379087703244110p 0.9
+ 115684794538293504816585178905734931969970819518749213374813539173021013466354485519408111826950174848328462104379087703244800p 0.9
+ 115684794538293504816585178905734931969970819518749213374813539173021013466354485519408111826950174848328462104379087703244810p -0.3
+ \]
V_wl_406 (WordLine\\<406\\> gnd!) vsource type=pwl wave=\[
+ 0    -0.3
+ 231369589076587009633170357811469863939941639037498426749627078346042026932708971038816223653900349696656924208758175406488900p -0.3
+ 231369589076587009633170357811469863939941639037498426749627078346042026932708971038816223653900349696656924208758175406488910p 0.9
+ 231369589076587009633170357811469863939941639037498426749627078346042026932708971038816223653900349696656924208758175406489600p 0.9
+ 231369589076587009633170357811469863939941639037498426749627078346042026932708971038816223653900349696656924208758175406489610p -0.3
+ \]
V_wl_407 (WordLine\\<407\\> gnd!) vsource type=pwl wave=\[
+ 0    -0.3
+ 462739178153174019266340715622939727879883278074996853499254156692084053865417942077632447307800699393313848417516350812978500p -0.3
+ 462739178153174019266340715622939727879883278074996853499254156692084053865417942077632447307800699393313848417516350812978510p 0.9
+ 462739178153174019266340715622939727879883278074996853499254156692084053865417942077632447307800699393313848417516350812979200p 0.9
+ 462739178153174019266340715622939727879883278074996853499254156692084053865417942077632447307800699393313848417516350812979210p -0.3
+ \]
V_wl_408 (WordLine\\<408\\> gnd!) vsource type=pwl wave=\[
+ 0    -0.3
+ 925478356306348038532681431245879455759766556149993706998508313384168107730835884155264894615601398786627696835032701625957700p -0.3
+ 925478356306348038532681431245879455759766556149993706998508313384168107730835884155264894615601398786627696835032701625957710p 0.9
+ 925478356306348038532681431245879455759766556149993706998508313384168107730835884155264894615601398786627696835032701625958400p 0.9
+ 925478356306348038532681431245879455759766556149993706998508313384168107730835884155264894615601398786627696835032701625958410p -0.3
+ \]
V_wl_409 (WordLine\\<409\\> gnd!) vsource type=pwl wave=\[
+ 0    -0.3
+ 1850956712612696077065362862491758911519533112299987413997016626768336215461671768310529789231202797573255393670065403251916100p -0.3
+ 1850956712612696077065362862491758911519533112299987413997016626768336215461671768310529789231202797573255393670065403251916110p 0.9
+ 1850956712612696077065362862491758911519533112299987413997016626768336215461671768310529789231202797573255393670065403251916800p 0.9
+ 1850956712612696077065362862491758911519533112299987413997016626768336215461671768310529789231202797573255393670065403251916810p -0.3
+ \]
V_wl_410 (WordLine\\<410\\> gnd!) vsource type=pwl wave=\[
+ 0    -0.3
+ 3701913425225392154130725724983517823039066224599974827994033253536672430923343536621059578462405595146510787340130806503832900p -0.3
+ 3701913425225392154130725724983517823039066224599974827994033253536672430923343536621059578462405595146510787340130806503832910p 0.9
+ 3701913425225392154130725724983517823039066224599974827994033253536672430923343536621059578462405595146510787340130806503833600p 0.9
+ 3701913425225392154130725724983517823039066224599974827994033253536672430923343536621059578462405595146510787340130806503833610p -0.3
+ \]
V_wl_411 (WordLine\\<411\\> gnd!) vsource type=pwl wave=\[
+ 0    -0.3
+ 7403826850450784308261451449967035646078132449199949655988066507073344861846687073242119156924811190293021574680261613007666500p -0.3
+ 7403826850450784308261451449967035646078132449199949655988066507073344861846687073242119156924811190293021574680261613007666510p 0.9
+ 7403826850450784308261451449967035646078132449199949655988066507073344861846687073242119156924811190293021574680261613007667200p 0.9
+ 7403826850450784308261451449967035646078132449199949655988066507073344861846687073242119156924811190293021574680261613007667210p -0.3
+ \]
V_wl_412 (WordLine\\<412\\> gnd!) vsource type=pwl wave=\[
+ 0    -0.3
+ 14807653700901568616522902899934071292156264898399899311976133014146689723693374146484238313849622380586043149360523226015333700p -0.3
+ 14807653700901568616522902899934071292156264898399899311976133014146689723693374146484238313849622380586043149360523226015333710p 0.9
+ 14807653700901568616522902899934071292156264898399899311976133014146689723693374146484238313849622380586043149360523226015334400p 0.9
+ 14807653700901568616522902899934071292156264898399899311976133014146689723693374146484238313849622380586043149360523226015334410p -0.3
+ \]
V_wl_413 (WordLine\\<413\\> gnd!) vsource type=pwl wave=\[
+ 0    -0.3
+ 29615307401803137233045805799868142584312529796799798623952266028293379447386748292968476627699244761172086298721046452030668100p -0.3
+ 29615307401803137233045805799868142584312529796799798623952266028293379447386748292968476627699244761172086298721046452030668110p 0.9
+ 29615307401803137233045805799868142584312529796799798623952266028293379447386748292968476627699244761172086298721046452030668800p 0.9
+ 29615307401803137233045805799868142584312529796799798623952266028293379447386748292968476627699244761172086298721046452030668810p -0.3
+ \]
V_wl_414 (WordLine\\<414\\> gnd!) vsource type=pwl wave=\[
+ 0    -0.3
+ 59230614803606274466091611599736285168625059593599597247904532056586758894773496585936953255398489522344172597442092904061336900p -0.3
+ 59230614803606274466091611599736285168625059593599597247904532056586758894773496585936953255398489522344172597442092904061336910p 0.9
+ 59230614803606274466091611599736285168625059593599597247904532056586758894773496585936953255398489522344172597442092904061337600p 0.9
+ 59230614803606274466091611599736285168625059593599597247904532056586758894773496585936953255398489522344172597442092904061337610p -0.3
+ \]
V_wl_415 (WordLine\\<415\\> gnd!) vsource type=pwl wave=\[
+ 0    -0.3
+ 118461229607212548932183223199472570337250119187199194495809064113173517789546993171873906510796979044688345194884185808122674500p -0.3
+ 118461229607212548932183223199472570337250119187199194495809064113173517789546993171873906510796979044688345194884185808122674510p 0.9
+ 118461229607212548932183223199472570337250119187199194495809064113173517789546993171873906510796979044688345194884185808122675200p 0.9
+ 118461229607212548932183223199472570337250119187199194495809064113173517789546993171873906510796979044688345194884185808122675210p -0.3
+ \]
V_wl_416 (WordLine\\<416\\> gnd!) vsource type=pwl wave=\[
+ 0    -0.3
+ 236922459214425097864366446398945140674500238374398388991618128226347035579093986343747813021593958089376690389768371616245349700p -0.3
+ 236922459214425097864366446398945140674500238374398388991618128226347035579093986343747813021593958089376690389768371616245349710p 0.9
+ 236922459214425097864366446398945140674500238374398388991618128226347035579093986343747813021593958089376690389768371616245350400p 0.9
+ 236922459214425097864366446398945140674500238374398388991618128226347035579093986343747813021593958089376690389768371616245350410p -0.3
+ \]
V_wl_417 (WordLine\\<417\\> gnd!) vsource type=pwl wave=\[
+ 0    -0.3
+ 473844918428850195728732892797890281349000476748796777983236256452694071158187972687495626043187916178753380779536743232490700100p -0.3
+ 473844918428850195728732892797890281349000476748796777983236256452694071158187972687495626043187916178753380779536743232490700110p 0.9
+ 473844918428850195728732892797890281349000476748796777983236256452694071158187972687495626043187916178753380779536743232490700800p 0.9
+ 473844918428850195728732892797890281349000476748796777983236256452694071158187972687495626043187916178753380779536743232490700810p -0.3
+ \]
V_wl_418 (WordLine\\<418\\> gnd!) vsource type=pwl wave=\[
+ 0    -0.3
+ 947689836857700391457465785595780562698000953497593555966472512905388142316375945374991252086375832357506761559073486464981400900p -0.3
+ 947689836857700391457465785595780562698000953497593555966472512905388142316375945374991252086375832357506761559073486464981400910p 0.9
+ 947689836857700391457465785595780562698000953497593555966472512905388142316375945374991252086375832357506761559073486464981401600p 0.9
+ 947689836857700391457465785595780562698000953497593555966472512905388142316375945374991252086375832357506761559073486464981401610p -0.3
+ \]
V_wl_419 (WordLine\\<419\\> gnd!) vsource type=pwl wave=\[
+ 0    -0.3
+ 1895379673715400782914931571191561125396001906995187111932945025810776284632751890749982504172751664715013523118146972929962802500p -0.3
+ 1895379673715400782914931571191561125396001906995187111932945025810776284632751890749982504172751664715013523118146972929962802510p 0.9
+ 1895379673715400782914931571191561125396001906995187111932945025810776284632751890749982504172751664715013523118146972929962803200p 0.9
+ 1895379673715400782914931571191561125396001906995187111932945025810776284632751890749982504172751664715013523118146972929962803210p -0.3
+ \]
V_wl_420 (WordLine\\<420\\> gnd!) vsource type=pwl wave=\[
+ 0    -0.3
+ 3790759347430801565829863142383122250792003813990374223865890051621552569265503781499965008345503329430027046236293945859925605700p -0.3
+ 3790759347430801565829863142383122250792003813990374223865890051621552569265503781499965008345503329430027046236293945859925605710p 0.9
+ 3790759347430801565829863142383122250792003813990374223865890051621552569265503781499965008345503329430027046236293945859925606400p 0.9
+ 3790759347430801565829863142383122250792003813990374223865890051621552569265503781499965008345503329430027046236293945859925606410p -0.3
+ \]
V_wl_421 (WordLine\\<421\\> gnd!) vsource type=pwl wave=\[
+ 0    -0.3
+ 7581518694861603131659726284766244501584007627980748447731780103243105138531007562999930016691006658860054092472587891719851212100p -0.3
+ 7581518694861603131659726284766244501584007627980748447731780103243105138531007562999930016691006658860054092472587891719851212110p 0.9
+ 7581518694861603131659726284766244501584007627980748447731780103243105138531007562999930016691006658860054092472587891719851212800p 0.9
+ 7581518694861603131659726284766244501584007627980748447731780103243105138531007562999930016691006658860054092472587891719851212810p -0.3
+ \]
V_wl_422 (WordLine\\<422\\> gnd!) vsource type=pwl wave=\[
+ 0    -0.3
+ 15163037389723206263319452569532489003168015255961496895463560206486210277062015125999860033382013317720108184945175783439702424900p -0.3
+ 15163037389723206263319452569532489003168015255961496895463560206486210277062015125999860033382013317720108184945175783439702424910p 0.9
+ 15163037389723206263319452569532489003168015255961496895463560206486210277062015125999860033382013317720108184945175783439702425600p 0.9
+ 15163037389723206263319452569532489003168015255961496895463560206486210277062015125999860033382013317720108184945175783439702425610p -0.3
+ \]
V_wl_423 (WordLine\\<423\\> gnd!) vsource type=pwl wave=\[
+ 0    -0.3
+ 30326074779446412526638905139064978006336030511922993790927120412972420554124030251999720066764026635440216369890351566879404850500p -0.3
+ 30326074779446412526638905139064978006336030511922993790927120412972420554124030251999720066764026635440216369890351566879404850510p 0.9
+ 30326074779446412526638905139064978006336030511922993790927120412972420554124030251999720066764026635440216369890351566879404851200p 0.9
+ 30326074779446412526638905139064978006336030511922993790927120412972420554124030251999720066764026635440216369890351566879404851210p -0.3
+ \]
V_wl_424 (WordLine\\<424\\> gnd!) vsource type=pwl wave=\[
+ 0    -0.3
+ 60652149558892825053277810278129956012672061023845987581854240825944841108248060503999440133528053270880432739780703133758809701700p -0.3
+ 60652149558892825053277810278129956012672061023845987581854240825944841108248060503999440133528053270880432739780703133758809701710p 0.9
+ 60652149558892825053277810278129956012672061023845987581854240825944841108248060503999440133528053270880432739780703133758809702400p 0.9
+ 60652149558892825053277810278129956012672061023845987581854240825944841108248060503999440133528053270880432739780703133758809702410p -0.3
+ \]
V_wl_425 (WordLine\\<425\\> gnd!) vsource type=pwl wave=\[
+ 0    -0.3
+ 121304299117785650106555620556259912025344122047691975163708481651889682216496121007998880267056106541760865479561406267517619404100p -0.3
+ 121304299117785650106555620556259912025344122047691975163708481651889682216496121007998880267056106541760865479561406267517619404110p 0.9
+ 121304299117785650106555620556259912025344122047691975163708481651889682216496121007998880267056106541760865479561406267517619404800p 0.9
+ 121304299117785650106555620556259912025344122047691975163708481651889682216496121007998880267056106541760865479561406267517619404810p -0.3
+ \]
V_wl_426 (WordLine\\<426\\> gnd!) vsource type=pwl wave=\[
+ 0    -0.3
+ 242608598235571300213111241112519824050688244095383950327416963303779364432992242015997760534112213083521730959122812535035238808900p -0.3
+ 242608598235571300213111241112519824050688244095383950327416963303779364432992242015997760534112213083521730959122812535035238808910p 0.9
+ 242608598235571300213111241112519824050688244095383950327416963303779364432992242015997760534112213083521730959122812535035238809600p 0.9
+ 242608598235571300213111241112519824050688244095383950327416963303779364432992242015997760534112213083521730959122812535035238809610p -0.3
+ \]
V_wl_427 (WordLine\\<427\\> gnd!) vsource type=pwl wave=\[
+ 0    -0.3
+ 485217196471142600426222482225039648101376488190767900654833926607558728865984484031995521068224426167043461918245625070070477618500p -0.3
+ 485217196471142600426222482225039648101376488190767900654833926607558728865984484031995521068224426167043461918245625070070477618510p 0.9
+ 485217196471142600426222482225039648101376488190767900654833926607558728865984484031995521068224426167043461918245625070070477619200p 0.9
+ 485217196471142600426222482225039648101376488190767900654833926607558728865984484031995521068224426167043461918245625070070477619210p -0.3
+ \]
V_wl_428 (WordLine\\<428\\> gnd!) vsource type=pwl wave=\[
+ 0    -0.3
+ 970434392942285200852444964450079296202752976381535801309667853215117457731968968063991042136448852334086923836491250140140955237700p -0.3
+ 970434392942285200852444964450079296202752976381535801309667853215117457731968968063991042136448852334086923836491250140140955237710p 0.9
+ 970434392942285200852444964450079296202752976381535801309667853215117457731968968063991042136448852334086923836491250140140955238400p 0.9
+ 970434392942285200852444964450079296202752976381535801309667853215117457731968968063991042136448852334086923836491250140140955238410p -0.3
+ \]
V_wl_429 (WordLine\\<429\\> gnd!) vsource type=pwl wave=\[
+ 0    -0.3
+ 1940868785884570401704889928900158592405505952763071602619335706430234915463937936127982084272897704668173847672982500280281910476100p -0.3
+ 1940868785884570401704889928900158592405505952763071602619335706430234915463937936127982084272897704668173847672982500280281910476110p 0.9
+ 1940868785884570401704889928900158592405505952763071602619335706430234915463937936127982084272897704668173847672982500280281910476800p 0.9
+ 1940868785884570401704889928900158592405505952763071602619335706430234915463937936127982084272897704668173847672982500280281910476810p -0.3
+ \]
V_wl_430 (WordLine\\<430\\> gnd!) vsource type=pwl wave=\[
+ 0    -0.3
+ 3881737571769140803409779857800317184811011905526143205238671412860469830927875872255964168545795409336347695345965000560563820952900p -0.3
+ 3881737571769140803409779857800317184811011905526143205238671412860469830927875872255964168545795409336347695345965000560563820952910p 0.9
+ 3881737571769140803409779857800317184811011905526143205238671412860469830927875872255964168545795409336347695345965000560563820953600p 0.9
+ 3881737571769140803409779857800317184811011905526143205238671412860469830927875872255964168545795409336347695345965000560563820953610p -0.3
+ \]
V_wl_431 (WordLine\\<431\\> gnd!) vsource type=pwl wave=\[
+ 0    -0.3
+ 7763475143538281606819559715600634369622023811052286410477342825720939661855751744511928337091590818672695390691930001121127641906500p -0.3
+ 7763475143538281606819559715600634369622023811052286410477342825720939661855751744511928337091590818672695390691930001121127641906510p 0.9
+ 7763475143538281606819559715600634369622023811052286410477342825720939661855751744511928337091590818672695390691930001121127641907200p 0.9
+ 7763475143538281606819559715600634369622023811052286410477342825720939661855751744511928337091590818672695390691930001121127641907210p -0.3
+ \]
V_wl_432 (WordLine\\<432\\> gnd!) vsource type=pwl wave=\[
+ 0    -0.3
+ 15526950287076563213639119431201268739244047622104572820954685651441879323711503489023856674183181637345390781383860002242255283813700p -0.3
+ 15526950287076563213639119431201268739244047622104572820954685651441879323711503489023856674183181637345390781383860002242255283813710p 0.9
+ 15526950287076563213639119431201268739244047622104572820954685651441879323711503489023856674183181637345390781383860002242255283814400p 0.9
+ 15526950287076563213639119431201268739244047622104572820954685651441879323711503489023856674183181637345390781383860002242255283814410p -0.3
+ \]
V_wl_433 (WordLine\\<433\\> gnd!) vsource type=pwl wave=\[
+ 0    -0.3
+ 31053900574153126427278238862402537478488095244209145641909371302883758647423006978047713348366363274690781562767720004484510567628100p -0.3
+ 31053900574153126427278238862402537478488095244209145641909371302883758647423006978047713348366363274690781562767720004484510567628110p 0.9
+ 31053900574153126427278238862402537478488095244209145641909371302883758647423006978047713348366363274690781562767720004484510567628800p 0.9
+ 31053900574153126427278238862402537478488095244209145641909371302883758647423006978047713348366363274690781562767720004484510567628810p -0.3
+ \]
V_wl_434 (WordLine\\<434\\> gnd!) vsource type=pwl wave=\[
+ 0    -0.3
+ 62107801148306252854556477724805074956976190488418291283818742605767517294846013956095426696732726549381563125535440008969021135256900p -0.3
+ 62107801148306252854556477724805074956976190488418291283818742605767517294846013956095426696732726549381563125535440008969021135256910p 0.9
+ 62107801148306252854556477724805074956976190488418291283818742605767517294846013956095426696732726549381563125535440008969021135257600p 0.9
+ 62107801148306252854556477724805074956976190488418291283818742605767517294846013956095426696732726549381563125535440008969021135257610p -0.3
+ \]
V_wl_435 (WordLine\\<435\\> gnd!) vsource type=pwl wave=\[
+ 0    -0.3
+ 124215602296612505709112955449610149913952380976836582567637485211535034589692027912190853393465453098763126251070880017938042270514500p -0.3
+ 124215602296612505709112955449610149913952380976836582567637485211535034589692027912190853393465453098763126251070880017938042270514510p 0.9
+ 124215602296612505709112955449610149913952380976836582567637485211535034589692027912190853393465453098763126251070880017938042270515200p 0.9
+ 124215602296612505709112955449610149913952380976836582567637485211535034589692027912190853393465453098763126251070880017938042270515210p -0.3
+ \]
V_wl_436 (WordLine\\<436\\> gnd!) vsource type=pwl wave=\[
+ 0    -0.3
+ 248431204593225011418225910899220299827904761953673165135274970423070069179384055824381706786930906197526252502141760035876084541029700p -0.3
+ 248431204593225011418225910899220299827904761953673165135274970423070069179384055824381706786930906197526252502141760035876084541029710p 0.9
+ 248431204593225011418225910899220299827904761953673165135274970423070069179384055824381706786930906197526252502141760035876084541030400p 0.9
+ 248431204593225011418225910899220299827904761953673165135274970423070069179384055824381706786930906197526252502141760035876084541030410p -0.3
+ \]
V_wl_437 (WordLine\\<437\\> gnd!) vsource type=pwl wave=\[
+ 0    -0.3
+ 496862409186450022836451821798440599655809523907346330270549940846140138358768111648763413573861812395052505004283520071752169082060100p -0.3
+ 496862409186450022836451821798440599655809523907346330270549940846140138358768111648763413573861812395052505004283520071752169082060110p 0.9
+ 496862409186450022836451821798440599655809523907346330270549940846140138358768111648763413573861812395052505004283520071752169082060800p 0.9
+ 496862409186450022836451821798440599655809523907346330270549940846140138358768111648763413573861812395052505004283520071752169082060810p -0.3
+ \]
V_wl_438 (WordLine\\<438\\> gnd!) vsource type=pwl wave=\[
+ 0    -0.3
+ 993724818372900045672903643596881199311619047814692660541099881692280276717536223297526827147723624790105010008567040143504338164120900p -0.3
+ 993724818372900045672903643596881199311619047814692660541099881692280276717536223297526827147723624790105010008567040143504338164120910p 0.9
+ 993724818372900045672903643596881199311619047814692660541099881692280276717536223297526827147723624790105010008567040143504338164121600p 0.9
+ 993724818372900045672903643596881199311619047814692660541099881692280276717536223297526827147723624790105010008567040143504338164121610p -0.3
+ \]
V_wl_439 (WordLine\\<439\\> gnd!) vsource type=pwl wave=\[
+ 0    -0.3
+ 1987449636745800091345807287193762398623238095629385321082199763384560553435072446595053654295447249580210020017134080287008676328242500p -0.3
+ 1987449636745800091345807287193762398623238095629385321082199763384560553435072446595053654295447249580210020017134080287008676328242510p 0.9
+ 1987449636745800091345807287193762398623238095629385321082199763384560553435072446595053654295447249580210020017134080287008676328243200p 0.9
+ 1987449636745800091345807287193762398623238095629385321082199763384560553435072446595053654295447249580210020017134080287008676328243210p -0.3
+ \]
V_wl_440 (WordLine\\<440\\> gnd!) vsource type=pwl wave=\[
+ 0    -0.3
+ 3974899273491600182691614574387524797246476191258770642164399526769121106870144893190107308590894499160420040034268160574017352656485700p -0.3
+ 3974899273491600182691614574387524797246476191258770642164399526769121106870144893190107308590894499160420040034268160574017352656485710p 0.9
+ 3974899273491600182691614574387524797246476191258770642164399526769121106870144893190107308590894499160420040034268160574017352656486400p 0.9
+ 3974899273491600182691614574387524797246476191258770642164399526769121106870144893190107308590894499160420040034268160574017352656486410p -0.3
+ \]
V_wl_441 (WordLine\\<441\\> gnd!) vsource type=pwl wave=\[
+ 0    -0.3
+ 7949798546983200365383229148775049594492952382517541284328799053538242213740289786380214617181788998320840080068536321148034705312972100p -0.3
+ 7949798546983200365383229148775049594492952382517541284328799053538242213740289786380214617181788998320840080068536321148034705312972110p 0.9
+ 7949798546983200365383229148775049594492952382517541284328799053538242213740289786380214617181788998320840080068536321148034705312972800p 0.9
+ 7949798546983200365383229148775049594492952382517541284328799053538242213740289786380214617181788998320840080068536321148034705312972810p -0.3
+ \]
V_wl_442 (WordLine\\<442\\> gnd!) vsource type=pwl wave=\[
+ 0    -0.3
+ 15899597093966400730766458297550099188985904765035082568657598107076484427480579572760429234363577996641680160137072642296069410625944900p -0.3
+ 15899597093966400730766458297550099188985904765035082568657598107076484427480579572760429234363577996641680160137072642296069410625944910p 0.9
+ 15899597093966400730766458297550099188985904765035082568657598107076484427480579572760429234363577996641680160137072642296069410625945600p 0.9
+ 15899597093966400730766458297550099188985904765035082568657598107076484427480579572760429234363577996641680160137072642296069410625945610p -0.3
+ \]
V_wl_443 (WordLine\\<443\\> gnd!) vsource type=pwl wave=\[
+ 0    -0.3
+ 31799194187932801461532916595100198377971809530070165137315196214152968854961159145520858468727155993283360320274145284592138821251890500p -0.3
+ 31799194187932801461532916595100198377971809530070165137315196214152968854961159145520858468727155993283360320274145284592138821251890510p 0.9
+ 31799194187932801461532916595100198377971809530070165137315196214152968854961159145520858468727155993283360320274145284592138821251891200p 0.9
+ 31799194187932801461532916595100198377971809530070165137315196214152968854961159145520858468727155993283360320274145284592138821251891210p -0.3
+ \]
V_wl_444 (WordLine\\<444\\> gnd!) vsource type=pwl wave=\[
+ 0    -0.3
+ 63598388375865602923065833190200396755943619060140330274630392428305937709922318291041716937454311986566720640548290569184277642503781700p -0.3
+ 63598388375865602923065833190200396755943619060140330274630392428305937709922318291041716937454311986566720640548290569184277642503781710p 0.9
+ 63598388375865602923065833190200396755943619060140330274630392428305937709922318291041716937454311986566720640548290569184277642503782400p 0.9
+ 63598388375865602923065833190200396755943619060140330274630392428305937709922318291041716937454311986566720640548290569184277642503782410p -0.3
+ \]
V_wl_445 (WordLine\\<445\\> gnd!) vsource type=pwl wave=\[
+ 0    -0.3
+ 127196776751731205846131666380400793511887238120280660549260784856611875419844636582083433874908623973133441281096581138368555285007564100p -0.3
+ 127196776751731205846131666380400793511887238120280660549260784856611875419844636582083433874908623973133441281096581138368555285007564110p 0.9
+ 127196776751731205846131666380400793511887238120280660549260784856611875419844636582083433874908623973133441281096581138368555285007564800p 0.9
+ 127196776751731205846131666380400793511887238120280660549260784856611875419844636582083433874908623973133441281096581138368555285007564810p -0.3
+ \]
V_wl_446 (WordLine\\<446\\> gnd!) vsource type=pwl wave=\[
+ 0    -0.3
+ 254393553503462411692263332760801587023774476240561321098521569713223750839689273164166867749817247946266882562193162276737110570015128900p -0.3
+ 254393553503462411692263332760801587023774476240561321098521569713223750839689273164166867749817247946266882562193162276737110570015128910p 0.9
+ 254393553503462411692263332760801587023774476240561321098521569713223750839689273164166867749817247946266882562193162276737110570015129600p 0.9
+ 254393553503462411692263332760801587023774476240561321098521569713223750839689273164166867749817247946266882562193162276737110570015129610p -0.3
+ \]
V_wl_447 (WordLine\\<447\\> gnd!) vsource type=pwl wave=\[
+ 0    -0.3
+ 508787107006924823384526665521603174047548952481122642197043139426447501679378546328333735499634495892533765124386324553474221140030258500p -0.3
+ 508787107006924823384526665521603174047548952481122642197043139426447501679378546328333735499634495892533765124386324553474221140030258510p 0.9
+ 508787107006924823384526665521603174047548952481122642197043139426447501679378546328333735499634495892533765124386324553474221140030259200p 0.9
+ 508787107006924823384526665521603174047548952481122642197043139426447501679378546328333735499634495892533765124386324553474221140030259210p -0.3
+ \]
V_wl_448 (WordLine\\<448\\> gnd!) vsource type=pwl wave=\[
+ 0    -0.3
+ 1017574214013849646769053331043206348095097904962245284394086278852895003358757092656667470999268991785067530248772649106948442280060517700p -0.3
+ 1017574214013849646769053331043206348095097904962245284394086278852895003358757092656667470999268991785067530248772649106948442280060517710p 0.9
+ 1017574214013849646769053331043206348095097904962245284394086278852895003358757092656667470999268991785067530248772649106948442280060518400p 0.9
+ 1017574214013849646769053331043206348095097904962245284394086278852895003358757092656667470999268991785067530248772649106948442280060518410p -0.3
+ \]
V_wl_449 (WordLine\\<449\\> gnd!) vsource type=pwl wave=\[
+ 0    -0.3
+ 2035148428027699293538106662086412696190195809924490568788172557705790006717514185313334941998537983570135060497545298213896884560121036100p -0.3
+ 2035148428027699293538106662086412696190195809924490568788172557705790006717514185313334941998537983570135060497545298213896884560121036110p 0.9
+ 2035148428027699293538106662086412696190195809924490568788172557705790006717514185313334941998537983570135060497545298213896884560121036800p 0.9
+ 2035148428027699293538106662086412696190195809924490568788172557705790006717514185313334941998537983570135060497545298213896884560121036810p -0.3
+ \]
V_wl_450 (WordLine\\<450\\> gnd!) vsource type=pwl wave=\[
+ 0    -0.3
+ 4070296856055398587076213324172825392380391619848981137576345115411580013435028370626669883997075967140270120995090596427793769120242072900p -0.3
+ 4070296856055398587076213324172825392380391619848981137576345115411580013435028370626669883997075967140270120995090596427793769120242072910p 0.9
+ 4070296856055398587076213324172825392380391619848981137576345115411580013435028370626669883997075967140270120995090596427793769120242073600p 0.9
+ 4070296856055398587076213324172825392380391619848981137576345115411580013435028370626669883997075967140270120995090596427793769120242073610p -0.3
+ \]
V_wl_451 (WordLine\\<451\\> gnd!) vsource type=pwl wave=\[
+ 0    -0.3
+ 8140593712110797174152426648345650784760783239697962275152690230823160026870056741253339767994151934280540241990181192855587538240484146500p -0.3
+ 8140593712110797174152426648345650784760783239697962275152690230823160026870056741253339767994151934280540241990181192855587538240484146510p 0.9
+ 8140593712110797174152426648345650784760783239697962275152690230823160026870056741253339767994151934280540241990181192855587538240484147200p 0.9
+ 8140593712110797174152426648345650784760783239697962275152690230823160026870056741253339767994151934280540241990181192855587538240484147210p -0.3
+ \]
V_wl_452 (WordLine\\<452\\> gnd!) vsource type=pwl wave=\[
+ 0    -0.3
+ 16281187424221594348304853296691301569521566479395924550305380461646320053740113482506679535988303868561080483980362385711175076480968293700p -0.3
+ 16281187424221594348304853296691301569521566479395924550305380461646320053740113482506679535988303868561080483980362385711175076480968293710p 0.9
+ 16281187424221594348304853296691301569521566479395924550305380461646320053740113482506679535988303868561080483980362385711175076480968294400p 0.9
+ 16281187424221594348304853296691301569521566479395924550305380461646320053740113482506679535988303868561080483980362385711175076480968294410p -0.3
+ \]
V_wl_453 (WordLine\\<453\\> gnd!) vsource type=pwl wave=\[
+ 0    -0.3
+ 32562374848443188696609706593382603139043132958791849100610760923292640107480226965013359071976607737122160967960724771422350152961936588100p -0.3
+ 32562374848443188696609706593382603139043132958791849100610760923292640107480226965013359071976607737122160967960724771422350152961936588110p 0.9
+ 32562374848443188696609706593382603139043132958791849100610760923292640107480226965013359071976607737122160967960724771422350152961936588800p 0.9
+ 32562374848443188696609706593382603139043132958791849100610760923292640107480226965013359071976607737122160967960724771422350152961936588810p -0.3
+ \]
V_wl_454 (WordLine\\<454\\> gnd!) vsource type=pwl wave=\[
+ 0    -0.3
+ 65124749696886377393219413186765206278086265917583698201221521846585280214960453930026718143953215474244321935921449542844700305923873176900p -0.3
+ 65124749696886377393219413186765206278086265917583698201221521846585280214960453930026718143953215474244321935921449542844700305923873176910p 0.9
+ 65124749696886377393219413186765206278086265917583698201221521846585280214960453930026718143953215474244321935921449542844700305923873177600p 0.9
+ 65124749696886377393219413186765206278086265917583698201221521846585280214960453930026718143953215474244321935921449542844700305923873177610p -0.3
+ \]
V_wl_455 (WordLine\\<455\\> gnd!) vsource type=pwl wave=\[
+ 0    -0.3
+ 130249499393772754786438826373530412556172531835167396402443043693170560429920907860053436287906430948488643871842899085689400611847746354500p -0.3
+ 130249499393772754786438826373530412556172531835167396402443043693170560429920907860053436287906430948488643871842899085689400611847746354510p 0.9
+ 130249499393772754786438826373530412556172531835167396402443043693170560429920907860053436287906430948488643871842899085689400611847746355200p 0.9
+ 130249499393772754786438826373530412556172531835167396402443043693170560429920907860053436287906430948488643871842899085689400611847746355210p -0.3
+ \]
V_wl_456 (WordLine\\<456\\> gnd!) vsource type=pwl wave=\[
+ 0    -0.3
+ 260498998787545509572877652747060825112345063670334792804886087386341120859841815720106872575812861896977287743685798171378801223695492709700p -0.3
+ 260498998787545509572877652747060825112345063670334792804886087386341120859841815720106872575812861896977287743685798171378801223695492709710p 0.9
+ 260498998787545509572877652747060825112345063670334792804886087386341120859841815720106872575812861896977287743685798171378801223695492710400p 0.9
+ 260498998787545509572877652747060825112345063670334792804886087386341120859841815720106872575812861896977287743685798171378801223695492710410p -0.3
+ \]
V_wl_457 (WordLine\\<457\\> gnd!) vsource type=pwl wave=\[
+ 0    -0.3
+ 520997997575091019145755305494121650224690127340669585609772174772682241719683631440213745151625723793954575487371596342757602447390985420100p -0.3
+ 520997997575091019145755305494121650224690127340669585609772174772682241719683631440213745151625723793954575487371596342757602447390985420110p 0.9
+ 520997997575091019145755305494121650224690127340669585609772174772682241719683631440213745151625723793954575487371596342757602447390985420800p 0.9
+ 520997997575091019145755305494121650224690127340669585609772174772682241719683631440213745151625723793954575487371596342757602447390985420810p -0.3
+ \]
V_wl_458 (WordLine\\<458\\> gnd!) vsource type=pwl wave=\[
+ 0    -0.3
+ 1041995995150182038291510610988243300449380254681339171219544349545364483439367262880427490303251447587909150974743192685515204894781970840900p -0.3
+ 1041995995150182038291510610988243300449380254681339171219544349545364483439367262880427490303251447587909150974743192685515204894781970840910p 0.9
+ 1041995995150182038291510610988243300449380254681339171219544349545364483439367262880427490303251447587909150974743192685515204894781970841600p 0.9
+ 1041995995150182038291510610988243300449380254681339171219544349545364483439367262880427490303251447587909150974743192685515204894781970841610p -0.3
+ \]
V_wl_459 (WordLine\\<459\\> gnd!) vsource type=pwl wave=\[
+ 0    -0.3
+ 2083991990300364076583021221976486600898760509362678342439088699090728966878734525760854980606502895175818301949486385371030409789563941682500p -0.3
+ 2083991990300364076583021221976486600898760509362678342439088699090728966878734525760854980606502895175818301949486385371030409789563941682510p 0.9
+ 2083991990300364076583021221976486600898760509362678342439088699090728966878734525760854980606502895175818301949486385371030409789563941683200p 0.9
+ 2083991990300364076583021221976486600898760509362678342439088699090728966878734525760854980606502895175818301949486385371030409789563941683210p -0.3
+ \]
V_wl_460 (WordLine\\<460\\> gnd!) vsource type=pwl wave=\[
+ 0    -0.3
+ 4167983980600728153166042443952973201797521018725356684878177398181457933757469051521709961213005790351636603898972770742060819579127883365700p -0.3
+ 4167983980600728153166042443952973201797521018725356684878177398181457933757469051521709961213005790351636603898972770742060819579127883365710p 0.9
+ 4167983980600728153166042443952973201797521018725356684878177398181457933757469051521709961213005790351636603898972770742060819579127883366400p 0.9
+ 4167983980600728153166042443952973201797521018725356684878177398181457933757469051521709961213005790351636603898972770742060819579127883366410p -0.3
+ \]
V_wl_461 (WordLine\\<461\\> gnd!) vsource type=pwl wave=\[
+ 0    -0.3
+ 8335967961201456306332084887905946403595042037450713369756354796362915867514938103043419922426011580703273207797945541484121639158255766732100p -0.3
+ 8335967961201456306332084887905946403595042037450713369756354796362915867514938103043419922426011580703273207797945541484121639158255766732110p 0.9
+ 8335967961201456306332084887905946403595042037450713369756354796362915867514938103043419922426011580703273207797945541484121639158255766732800p 0.9
+ 8335967961201456306332084887905946403595042037450713369756354796362915867514938103043419922426011580703273207797945541484121639158255766732810p -0.3
+ \]
V_wl_462 (WordLine\\<462\\> gnd!) vsource type=pwl wave=\[
+ 0    -0.3
+ 16671935922402912612664169775811892807190084074901426739512709592725831735029876206086839844852023161406546415595891082968243278316511533464900p -0.3
+ 16671935922402912612664169775811892807190084074901426739512709592725831735029876206086839844852023161406546415595891082968243278316511533464910p 0.9
+ 16671935922402912612664169775811892807190084074901426739512709592725831735029876206086839844852023161406546415595891082968243278316511533465600p 0.9
+ 16671935922402912612664169775811892807190084074901426739512709592725831735029876206086839844852023161406546415595891082968243278316511533465610p -0.3
+ \]
V_wl_463 (WordLine\\<463\\> gnd!) vsource type=pwl wave=\[
+ 0    -0.3
+ 33343871844805825225328339551623785614380168149802853479025419185451663470059752412173679689704046322813092831191782165936486556633023066930500p -0.3
+ 33343871844805825225328339551623785614380168149802853479025419185451663470059752412173679689704046322813092831191782165936486556633023066930510p 0.9
+ 33343871844805825225328339551623785614380168149802853479025419185451663470059752412173679689704046322813092831191782165936486556633023066931200p 0.9
+ 33343871844805825225328339551623785614380168149802853479025419185451663470059752412173679689704046322813092831191782165936486556633023066931210p -0.3
+ \]
V_wl_464 (WordLine\\<464\\> gnd!) vsource type=pwl wave=\[
+ 0    -0.3
+ 66687743689611650450656679103247571228760336299605706958050838370903326940119504824347359379408092645626185662383564331872973113266046133861700p -0.3
+ 66687743689611650450656679103247571228760336299605706958050838370903326940119504824347359379408092645626185662383564331872973113266046133861710p 0.9
+ 66687743689611650450656679103247571228760336299605706958050838370903326940119504824347359379408092645626185662383564331872973113266046133862400p 0.9
+ 66687743689611650450656679103247571228760336299605706958050838370903326940119504824347359379408092645626185662383564331872973113266046133862410p -0.3
+ \]
V_wl_465 (WordLine\\<465\\> gnd!) vsource type=pwl wave=\[
+ 0    -0.3
+ 133375487379223300901313358206495142457520672599211413916101676741806653880239009648694718758816185291252371324767128663745946226532092267724100p -0.3
+ 133375487379223300901313358206495142457520672599211413916101676741806653880239009648694718758816185291252371324767128663745946226532092267724110p 0.9
+ 133375487379223300901313358206495142457520672599211413916101676741806653880239009648694718758816185291252371324767128663745946226532092267724800p 0.9
+ 133375487379223300901313358206495142457520672599211413916101676741806653880239009648694718758816185291252371324767128663745946226532092267724810p -0.3
+ \]
V_wl_466 (WordLine\\<466\\> gnd!) vsource type=pwl wave=\[
+ 0    -0.3
+ 266750974758446601802626716412990284915041345198422827832203353483613307760478019297389437517632370582504742649534257327491892453064184535448900p -0.3
+ 266750974758446601802626716412990284915041345198422827832203353483613307760478019297389437517632370582504742649534257327491892453064184535448910p 0.9
+ 266750974758446601802626716412990284915041345198422827832203353483613307760478019297389437517632370582504742649534257327491892453064184535449600p 0.9
+ 266750974758446601802626716412990284915041345198422827832203353483613307760478019297389437517632370582504742649534257327491892453064184535449610p -0.3
+ \]
V_wl_467 (WordLine\\<467\\> gnd!) vsource type=pwl wave=\[
+ 0    -0.3
+ 533501949516893203605253432825980569830082690396845655664406706967226615520956038594778875035264741165009485299068514654983784906128369070898500p -0.3
+ 533501949516893203605253432825980569830082690396845655664406706967226615520956038594778875035264741165009485299068514654983784906128369070898510p 0.9
+ 533501949516893203605253432825980569830082690396845655664406706967226615520956038594778875035264741165009485299068514654983784906128369070899200p 0.9
+ 533501949516893203605253432825980569830082690396845655664406706967226615520956038594778875035264741165009485299068514654983784906128369070899210p -0.3
+ \]
V_wl_468 (WordLine\\<468\\> gnd!) vsource type=pwl wave=\[
+ 0    -0.3
+ 1067003899033786407210506865651961139660165380793691311328813413934453231041912077189557750070529482330018970598137029309967569812256738141797700p -0.3
+ 1067003899033786407210506865651961139660165380793691311328813413934453231041912077189557750070529482330018970598137029309967569812256738141797710p 0.9
+ 1067003899033786407210506865651961139660165380793691311328813413934453231041912077189557750070529482330018970598137029309967569812256738141798400p 0.9
+ 1067003899033786407210506865651961139660165380793691311328813413934453231041912077189557750070529482330018970598137029309967569812256738141798410p -0.3
+ \]
V_wl_469 (WordLine\\<469\\> gnd!) vsource type=pwl wave=\[
+ 0    -0.3
+ 2134007798067572814421013731303922279320330761587382622657626827868906462083824154379115500141058964660037941196274058619935139624513476283596100p -0.3
+ 2134007798067572814421013731303922279320330761587382622657626827868906462083824154379115500141058964660037941196274058619935139624513476283596110p 0.9
+ 2134007798067572814421013731303922279320330761587382622657626827868906462083824154379115500141058964660037941196274058619935139624513476283596800p 0.9
+ 2134007798067572814421013731303922279320330761587382622657626827868906462083824154379115500141058964660037941196274058619935139624513476283596810p -0.3
+ \]
V_wl_470 (WordLine\\<470\\> gnd!) vsource type=pwl wave=\[
+ 0    -0.3
+ 4268015596135145628842027462607844558640661523174765245315253655737812924167648308758231000282117929320075882392548117239870279249026952567192900p -0.3
+ 4268015596135145628842027462607844558640661523174765245315253655737812924167648308758231000282117929320075882392548117239870279249026952567192910p 0.9
+ 4268015596135145628842027462607844558640661523174765245315253655737812924167648308758231000282117929320075882392548117239870279249026952567193600p 0.9
+ 4268015596135145628842027462607844558640661523174765245315253655737812924167648308758231000282117929320075882392548117239870279249026952567193610p -0.3
+ \]
V_wl_471 (WordLine\\<471\\> gnd!) vsource type=pwl wave=\[
+ 0    -0.3
+ 8536031192270291257684054925215689117281323046349530490630507311475625848335296617516462000564235858640151764785096234479740558498053905134386500p -0.3
+ 8536031192270291257684054925215689117281323046349530490630507311475625848335296617516462000564235858640151764785096234479740558498053905134386510p 0.9
+ 8536031192270291257684054925215689117281323046349530490630507311475625848335296617516462000564235858640151764785096234479740558498053905134387200p 0.9
+ 8536031192270291257684054925215689117281323046349530490630507311475625848335296617516462000564235858640151764785096234479740558498053905134387210p -0.3
+ \]
V_wl_472 (WordLine\\<472\\> gnd!) vsource type=pwl wave=\[
+ 0    -0.3
+ 17072062384540582515368109850431378234562646092699060981261014622951251696670593235032924001128471717280303529570192468959481116996107810268773700p -0.3
+ 17072062384540582515368109850431378234562646092699060981261014622951251696670593235032924001128471717280303529570192468959481116996107810268773710p 0.9
+ 17072062384540582515368109850431378234562646092699060981261014622951251696670593235032924001128471717280303529570192468959481116996107810268774400p 0.9
+ 17072062384540582515368109850431378234562646092699060981261014622951251696670593235032924001128471717280303529570192468959481116996107810268774410p -0.3
+ \]
V_wl_473 (WordLine\\<473\\> gnd!) vsource type=pwl wave=\[
+ 0    -0.3
+ 34144124769081165030736219700862756469125292185398121962522029245902503393341186470065848002256943434560607059140384937918962233992215620537548100p -0.3
+ 34144124769081165030736219700862756469125292185398121962522029245902503393341186470065848002256943434560607059140384937918962233992215620537548110p 0.9
+ 34144124769081165030736219700862756469125292185398121962522029245902503393341186470065848002256943434560607059140384937918962233992215620537548800p 0.9
+ 34144124769081165030736219700862756469125292185398121962522029245902503393341186470065848002256943434560607059140384937918962233992215620537548810p -0.3
+ \]
V_wl_474 (WordLine\\<474\\> gnd!) vsource type=pwl wave=\[
+ 0    -0.3
+ 68288249538162330061472439401725512938250584370796243925044058491805006786682372940131696004513886869121214118280769875837924467984431241075096900p -0.3
+ 68288249538162330061472439401725512938250584370796243925044058491805006786682372940131696004513886869121214118280769875837924467984431241075096910p 0.9
+ 68288249538162330061472439401725512938250584370796243925044058491805006786682372940131696004513886869121214118280769875837924467984431241075097600p 0.9
+ 68288249538162330061472439401725512938250584370796243925044058491805006786682372940131696004513886869121214118280769875837924467984431241075097610p -0.3
+ \]
V_wl_475 (WordLine\\<475\\> gnd!) vsource type=pwl wave=\[
+ 0    -0.3
+ 136576499076324660122944878803451025876501168741592487850088116983610013573364745880263392009027773738242428236561539751675848935968862482150194500p -0.3
+ 136576499076324660122944878803451025876501168741592487850088116983610013573364745880263392009027773738242428236561539751675848935968862482150194510p 0.9
+ 136576499076324660122944878803451025876501168741592487850088116983610013573364745880263392009027773738242428236561539751675848935968862482150195200p 0.9
+ 136576499076324660122944878803451025876501168741592487850088116983610013573364745880263392009027773738242428236561539751675848935968862482150195210p -0.3
+ \]
V_wl_476 (WordLine\\<476\\> gnd!) vsource type=pwl wave=\[
+ 0    -0.3
+ 273152998152649320245889757606902051753002337483184975700176233967220027146729491760526784018055547476484856473123079503351697871937724964300389700p -0.3
+ 273152998152649320245889757606902051753002337483184975700176233967220027146729491760526784018055547476484856473123079503351697871937724964300389710p 0.9
+ 273152998152649320245889757606902051753002337483184975700176233967220027146729491760526784018055547476484856473123079503351697871937724964300390400p 0.9
+ 273152998152649320245889757606902051753002337483184975700176233967220027146729491760526784018055547476484856473123079503351697871937724964300390410p -0.3
+ \]
V_wl_477 (WordLine\\<477\\> gnd!) vsource type=pwl wave=\[
+ 0    -0.3
+ 546305996305298640491779515213804103506004674966369951400352467934440054293458983521053568036111094952969712946246159006703395743875449928600780100p -0.3
+ 546305996305298640491779515213804103506004674966369951400352467934440054293458983521053568036111094952969712946246159006703395743875449928600780110p 0.9
+ 546305996305298640491779515213804103506004674966369951400352467934440054293458983521053568036111094952969712946246159006703395743875449928600780800p 0.9
+ 546305996305298640491779515213804103506004674966369951400352467934440054293458983521053568036111094952969712946246159006703395743875449928600780810p -0.3
+ \]
V_wl_478 (WordLine\\<478\\> gnd!) vsource type=pwl wave=\[
+ 0    -0.3
+ 1092611992610597280983559030427608207012009349932739902800704935868880108586917967042107136072222189905939425892492318013406791487750899857201560900p -0.3
+ 1092611992610597280983559030427608207012009349932739902800704935868880108586917967042107136072222189905939425892492318013406791487750899857201560910p 0.9
+ 1092611992610597280983559030427608207012009349932739902800704935868880108586917967042107136072222189905939425892492318013406791487750899857201561600p 0.9
+ 1092611992610597280983559030427608207012009349932739902800704935868880108586917967042107136072222189905939425892492318013406791487750899857201561610p -0.3
+ \]
V_wl_479 (WordLine\\<479\\> gnd!) vsource type=pwl wave=\[
+ 0    -0.3
+ 2185223985221194561967118060855216414024018699865479805601409871737760217173835934084214272144444379811878851784984636026813582975501799714403122500p -0.3
+ 2185223985221194561967118060855216414024018699865479805601409871737760217173835934084214272144444379811878851784984636026813582975501799714403122510p 0.9
+ 2185223985221194561967118060855216414024018699865479805601409871737760217173835934084214272144444379811878851784984636026813582975501799714403123200p 0.9
+ 2185223985221194561967118060855216414024018699865479805601409871737760217173835934084214272144444379811878851784984636026813582975501799714403123210p -0.3
+ \]
V_wl_480 (WordLine\\<480\\> gnd!) vsource type=pwl wave=\[
+ 0    -0.3
+ 4370447970442389123934236121710432828048037399730959611202819743475520434347671868168428544288888759623757703569969272053627165951003599428806245700p -0.3
+ 4370447970442389123934236121710432828048037399730959611202819743475520434347671868168428544288888759623757703569969272053627165951003599428806245710p 0.9
+ 4370447970442389123934236121710432828048037399730959611202819743475520434347671868168428544288888759623757703569969272053627165951003599428806246400p 0.9
+ 4370447970442389123934236121710432828048037399730959611202819743475520434347671868168428544288888759623757703569969272053627165951003599428806246410p -0.3
+ \]
V_wl_481 (WordLine\\<481\\> gnd!) vsource type=pwl wave=\[
+ 0    -0.3
+ 8740895940884778247868472243420865656096074799461919222405639486951040868695343736336857088577777519247515407139938544107254331902007198857612492100p -0.3
+ 8740895940884778247868472243420865656096074799461919222405639486951040868695343736336857088577777519247515407139938544107254331902007198857612492110p 0.9
+ 8740895940884778247868472243420865656096074799461919222405639486951040868695343736336857088577777519247515407139938544107254331902007198857612492800p 0.9
+ 8740895940884778247868472243420865656096074799461919222405639486951040868695343736336857088577777519247515407139938544107254331902007198857612492810p -0.3
+ \]
V_wl_482 (WordLine\\<482\\> gnd!) vsource type=pwl wave=\[
+ 0    -0.3
+ 17481791881769556495736944486841731312192149598923838444811278973902081737390687472673714177155555038495030814279877088214508663804014397715224984900p -0.3
+ 17481791881769556495736944486841731312192149598923838444811278973902081737390687472673714177155555038495030814279877088214508663804014397715224984910p 0.9
+ 17481791881769556495736944486841731312192149598923838444811278973902081737390687472673714177155555038495030814279877088214508663804014397715224985600p 0.9
+ 17481791881769556495736944486841731312192149598923838444811278973902081737390687472673714177155555038495030814279877088214508663804014397715224985610p -0.3
+ \]
V_wl_483 (WordLine\\<483\\> gnd!) vsource type=pwl wave=\[
+ 0    -0.3
+ 34963583763539112991473888973683462624384299197847676889622557947804163474781374945347428354311110076990061628559754176429017327608028795430449970500p -0.3
+ 34963583763539112991473888973683462624384299197847676889622557947804163474781374945347428354311110076990061628559754176429017327608028795430449970510p 0.9
+ 34963583763539112991473888973683462624384299197847676889622557947804163474781374945347428354311110076990061628559754176429017327608028795430449971200p 0.9
+ 34963583763539112991473888973683462624384299197847676889622557947804163474781374945347428354311110076990061628559754176429017327608028795430449971210p -0.3
+ \]
V_wl_484 (WordLine\\<484\\> gnd!) vsource type=pwl wave=\[
+ 0    -0.3
+ 69927167527078225982947777947366925248768598395695353779245115895608326949562749890694856708622220153980123257119508352858034655216057590860899941700p -0.3
+ 69927167527078225982947777947366925248768598395695353779245115895608326949562749890694856708622220153980123257119508352858034655216057590860899941710p 0.9
+ 69927167527078225982947777947366925248768598395695353779245115895608326949562749890694856708622220153980123257119508352858034655216057590860899942400p 0.9
+ 69927167527078225982947777947366925248768598395695353779245115895608326949562749890694856708622220153980123257119508352858034655216057590860899942410p -0.3
+ \]
V_wl_485 (WordLine\\<485\\> gnd!) vsource type=pwl wave=\[
+ 0    -0.3
+ 139854335054156451965895555894733850497537196791390707558490231791216653899125499781389713417244440307960246514239016705716069310432115181721799884100p -0.3
+ 139854335054156451965895555894733850497537196791390707558490231791216653899125499781389713417244440307960246514239016705716069310432115181721799884110p 0.9
+ 139854335054156451965895555894733850497537196791390707558490231791216653899125499781389713417244440307960246514239016705716069310432115181721799884800p 0.9
+ 139854335054156451965895555894733850497537196791390707558490231791216653899125499781389713417244440307960246514239016705716069310432115181721799884810p -0.3
+ \]
V_wl_486 (WordLine\\<486\\> gnd!) vsource type=pwl wave=\[
+ 0    -0.3
+ 279708670108312903931791111789467700995074393582781415116980463582433307798250999562779426834488880615920493028478033411432138620864230363443599768900p -0.3
+ 279708670108312903931791111789467700995074393582781415116980463582433307798250999562779426834488880615920493028478033411432138620864230363443599768910p 0.9
+ 279708670108312903931791111789467700995074393582781415116980463582433307798250999562779426834488880615920493028478033411432138620864230363443599769600p 0.9
+ 279708670108312903931791111789467700995074393582781415116980463582433307798250999562779426834488880615920493028478033411432138620864230363443599769610p -0.3
+ \]
V_wl_487 (WordLine\\<487\\> gnd!) vsource type=pwl wave=\[
+ 0    -0.3
+ 559417340216625807863582223578935401990148787165562830233960927164866615596501999125558853668977761231840986056956066822864277241728460726887199538500p -0.3
+ 559417340216625807863582223578935401990148787165562830233960927164866615596501999125558853668977761231840986056956066822864277241728460726887199538510p 0.9
+ 559417340216625807863582223578935401990148787165562830233960927164866615596501999125558853668977761231840986056956066822864277241728460726887199539200p 0.9
+ 559417340216625807863582223578935401990148787165562830233960927164866615596501999125558853668977761231840986056956066822864277241728460726887199539210p -0.3
+ \]
V_wl_488 (WordLine\\<488\\> gnd!) vsource type=pwl wave=\[
+ 0    -0.3
+ 1118834680433251615727164447157870803980297574331125660467921854329733231193003998251117707337955522463681972113912133645728554483456921453774399077700p -0.3
+ 1118834680433251615727164447157870803980297574331125660467921854329733231193003998251117707337955522463681972113912133645728554483456921453774399077710p 0.9
+ 1118834680433251615727164447157870803980297574331125660467921854329733231193003998251117707337955522463681972113912133645728554483456921453774399078400p 0.9
+ 1118834680433251615727164447157870803980297574331125660467921854329733231193003998251117707337955522463681972113912133645728554483456921453774399078410p -0.3
+ \]
V_wl_489 (WordLine\\<489\\> gnd!) vsource type=pwl wave=\[
+ 0    -0.3
+ 2237669360866503231454328894315741607960595148662251320935843708659466462386007996502235414675911044927363944227824267291457108966913842907548798156100p -0.3
+ 2237669360866503231454328894315741607960595148662251320935843708659466462386007996502235414675911044927363944227824267291457108966913842907548798156110p 0.9
+ 2237669360866503231454328894315741607960595148662251320935843708659466462386007996502235414675911044927363944227824267291457108966913842907548798156800p 0.9
+ 2237669360866503231454328894315741607960595148662251320935843708659466462386007996502235414675911044927363944227824267291457108966913842907548798156810p -0.3
+ \]
V_wl_490 (WordLine\\<490\\> gnd!) vsource type=pwl wave=\[
+ 0    -0.3
+ 4475338721733006462908657788631483215921190297324502641871687417318932924772015993004470829351822089854727888455648534582914217933827685815097596312900p -0.3
+ 4475338721733006462908657788631483215921190297324502641871687417318932924772015993004470829351822089854727888455648534582914217933827685815097596312910p 0.9
+ 4475338721733006462908657788631483215921190297324502641871687417318932924772015993004470829351822089854727888455648534582914217933827685815097596313600p 0.9
+ 4475338721733006462908657788631483215921190297324502641871687417318932924772015993004470829351822089854727888455648534582914217933827685815097596313610p -0.3
+ \]
V_wl_491 (WordLine\\<491\\> gnd!) vsource type=pwl wave=\[
+ 0    -0.3
+ 8950677443466012925817315577262966431842380594649005283743374834637865849544031986008941658703644179709455776911297069165828435867655371630195192626500p -0.3
+ 8950677443466012925817315577262966431842380594649005283743374834637865849544031986008941658703644179709455776911297069165828435867655371630195192626510p 0.9
+ 8950677443466012925817315577262966431842380594649005283743374834637865849544031986008941658703644179709455776911297069165828435867655371630195192627200p 0.9
+ 8950677443466012925817315577262966431842380594649005283743374834637865849544031986008941658703644179709455776911297069165828435867655371630195192627210p -0.3
+ \]
V_wl_492 (WordLine\\<492\\> gnd!) vsource type=pwl wave=\[
+ 0    -0.3
+ 17901354886932025851634631154525932863684761189298010567486749669275731699088063972017883317407288359418911553822594138331656871735310743260390385253700p -0.3
+ 17901354886932025851634631154525932863684761189298010567486749669275731699088063972017883317407288359418911553822594138331656871735310743260390385253710p 0.9
+ 17901354886932025851634631154525932863684761189298010567486749669275731699088063972017883317407288359418911553822594138331656871735310743260390385254400p 0.9
+ 17901354886932025851634631154525932863684761189298010567486749669275731699088063972017883317407288359418911553822594138331656871735310743260390385254410p -0.3
+ \]
V_wl_493 (WordLine\\<493\\> gnd!) vsource type=pwl wave=\[
+ 0    -0.3
+ 35802709773864051703269262309051865727369522378596021134973499338551463398176127944035766634814576718837823107645188276663313743470621486520780770508100p -0.3
+ 35802709773864051703269262309051865727369522378596021134973499338551463398176127944035766634814576718837823107645188276663313743470621486520780770508110p 0.9
+ 35802709773864051703269262309051865727369522378596021134973499338551463398176127944035766634814576718837823107645188276663313743470621486520780770508800p 0.9
+ 35802709773864051703269262309051865727369522378596021134973499338551463398176127944035766634814576718837823107645188276663313743470621486520780770508810p -0.3
+ \]
V_wl_494 (WordLine\\<494\\> gnd!) vsource type=pwl wave=\[
+ 0    -0.3
+ 71605419547728103406538524618103731454739044757192042269946998677102926796352255888071533269629153437675646215290376553326627486941242973041561541016900p -0.3
+ 71605419547728103406538524618103731454739044757192042269946998677102926796352255888071533269629153437675646215290376553326627486941242973041561541016910p 0.9
+ 71605419547728103406538524618103731454739044757192042269946998677102926796352255888071533269629153437675646215290376553326627486941242973041561541017600p 0.9
+ 71605419547728103406538524618103731454739044757192042269946998677102926796352255888071533269629153437675646215290376553326627486941242973041561541017610p -0.3
+ \]
V_wl_495 (WordLine\\<495\\> gnd!) vsource type=pwl wave=\[
+ 0    -0.3
+ 143210839095456206813077049236207462909478089514384084539893997354205853592704511776143066539258306875351292430580753106653254973882485946083123082034500p -0.3
+ 143210839095456206813077049236207462909478089514384084539893997354205853592704511776143066539258306875351292430580753106653254973882485946083123082034510p 0.9
+ 143210839095456206813077049236207462909478089514384084539893997354205853592704511776143066539258306875351292430580753106653254973882485946083123082035200p 0.9
+ 143210839095456206813077049236207462909478089514384084539893997354205853592704511776143066539258306875351292430580753106653254973882485946083123082035210p -0.3
+ \]
V_wl_496 (WordLine\\<496\\> gnd!) vsource type=pwl wave=\[
+ 0    -0.3
+ 286421678190912413626154098472414925818956179028768169079787994708411707185409023552286133078516613750702584861161506213306509947764971892166246164069700p -0.3
+ 286421678190912413626154098472414925818956179028768169079787994708411707185409023552286133078516613750702584861161506213306509947764971892166246164069710p 0.9
+ 286421678190912413626154098472414925818956179028768169079787994708411707185409023552286133078516613750702584861161506213306509947764971892166246164070400p 0.9
+ 286421678190912413626154098472414925818956179028768169079787994708411707185409023552286133078516613750702584861161506213306509947764971892166246164070410p -0.3
+ \]
V_wl_497 (WordLine\\<497\\> gnd!) vsource type=pwl wave=\[
+ 0    -0.3
+ 572843356381824827252308196944829851637912358057536338159575989416823414370818047104572266157033227501405169722323012426613019895529943784332492328140100p -0.3
+ 572843356381824827252308196944829851637912358057536338159575989416823414370818047104572266157033227501405169722323012426613019895529943784332492328140110p 0.9
+ 572843356381824827252308196944829851637912358057536338159575989416823414370818047104572266157033227501405169722323012426613019895529943784332492328140800p 0.9
+ 572843356381824827252308196944829851637912358057536338159575989416823414370818047104572266157033227501405169722323012426613019895529943784332492328140810p -0.3
+ \]
V_wl_498 (WordLine\\<498\\> gnd!) vsource type=pwl wave=\[
+ 0    -0.3
+ 1145686712763649654504616393889659703275824716115072676319151978833646828741636094209144532314066455002810339444646024853226039791059887568664984656280900p -0.3
+ 1145686712763649654504616393889659703275824716115072676319151978833646828741636094209144532314066455002810339444646024853226039791059887568664984656280910p 0.9
+ 1145686712763649654504616393889659703275824716115072676319151978833646828741636094209144532314066455002810339444646024853226039791059887568664984656281600p 0.9
+ 1145686712763649654504616393889659703275824716115072676319151978833646828741636094209144532314066455002810339444646024853226039791059887568664984656281610p -0.3
+ \]
V_wl_499 (WordLine\\<499\\> gnd!) vsource type=pwl wave=\[
+ 0    -0.3
+ 2291373425527299309009232787779319406551649432230145352638303957667293657483272188418289064628132910005620678889292049706452079582119775137329969312562500p -0.3
+ 2291373425527299309009232787779319406551649432230145352638303957667293657483272188418289064628132910005620678889292049706452079582119775137329969312562510p 0.9
+ 2291373425527299309009232787779319406551649432230145352638303957667293657483272188418289064628132910005620678889292049706452079582119775137329969312563200p 0.9
+ 2291373425527299309009232787779319406551649432230145352638303957667293657483272188418289064628132910005620678889292049706452079582119775137329969312563210p -0.3
+ \]
V_wl_500 (WordLine\\<500\\> gnd!) vsource type=pwl wave=\[
+ 0    -0.3
+ 4582746851054598618018465575558638813103298864460290705276607915334587314966544376836578129256265820011241357778584099412904159164239550274659938625125700p -0.3
+ 4582746851054598618018465575558638813103298864460290705276607915334587314966544376836578129256265820011241357778584099412904159164239550274659938625125710p 0.9
+ 4582746851054598618018465575558638813103298864460290705276607915334587314966544376836578129256265820011241357778584099412904159164239550274659938625126400p 0.9
+ 4582746851054598618018465575558638813103298864460290705276607915334587314966544376836578129256265820011241357778584099412904159164239550274659938625126410p -0.3
+ \]
V_wl_501 (WordLine\\<501\\> gnd!) vsource type=pwl wave=\[
+ 0    -0.3
+ 9165493702109197236036931151117277626206597728920581410553215830669174629933088753673156258512531640022482715557168198825808318328479100549319877250252100p -0.3
+ 9165493702109197236036931151117277626206597728920581410553215830669174629933088753673156258512531640022482715557168198825808318328479100549319877250252110p 0.9
+ 9165493702109197236036931151117277626206597728920581410553215830669174629933088753673156258512531640022482715557168198825808318328479100549319877250252800p 0.9
+ 9165493702109197236036931151117277626206597728920581410553215830669174629933088753673156258512531640022482715557168198825808318328479100549319877250252810p -0.3
+ \]
V_wl_502 (WordLine\\<502\\> gnd!) vsource type=pwl wave=\[
+ 0    -0.3
+ 18330987404218394472073862302234555252413195457841162821106431661338349259866177507346312517025063280044965431114336397651616636656958201098639754500504900p -0.3
+ 18330987404218394472073862302234555252413195457841162821106431661338349259866177507346312517025063280044965431114336397651616636656958201098639754500504910p 0.9
+ 18330987404218394472073862302234555252413195457841162821106431661338349259866177507346312517025063280044965431114336397651616636656958201098639754500505600p 0.9
+ 18330987404218394472073862302234555252413195457841162821106431661338349259866177507346312517025063280044965431114336397651616636656958201098639754500505610p -0.3
+ \]
V_wl_503 (WordLine\\<503\\> gnd!) vsource type=pwl wave=\[
+ 0    -0.3
+ 36661974808436788944147724604469110504826390915682325642212863322676698519732355014692625034050126560089930862228672795303233273313916402197279509001010500p -0.3
+ 36661974808436788944147724604469110504826390915682325642212863322676698519732355014692625034050126560089930862228672795303233273313916402197279509001010510p 0.9
+ 36661974808436788944147724604469110504826390915682325642212863322676698519732355014692625034050126560089930862228672795303233273313916402197279509001011200p 0.9
+ 36661974808436788944147724604469110504826390915682325642212863322676698519732355014692625034050126560089930862228672795303233273313916402197279509001011210p -0.3
+ \]
V_wl_504 (WordLine\\<504\\> gnd!) vsource type=pwl wave=\[
+ 0    -0.3
+ 73323949616873577888295449208938221009652781831364651284425726645353397039464710029385250068100253120179861724457345590606466546627832804394559018002021700p -0.3
+ 73323949616873577888295449208938221009652781831364651284425726645353397039464710029385250068100253120179861724457345590606466546627832804394559018002021710p 0.9
+ 73323949616873577888295449208938221009652781831364651284425726645353397039464710029385250068100253120179861724457345590606466546627832804394559018002022400p 0.9
+ 73323949616873577888295449208938221009652781831364651284425726645353397039464710029385250068100253120179861724457345590606466546627832804394559018002022410p -0.3
+ \]
V_wl_505 (WordLine\\<505\\> gnd!) vsource type=pwl wave=\[
+ 0    -0.3
+ 146647899233747155776590898417876442019305563662729302568851453290706794078929420058770500136200506240359723448914691181212933093255665608789118036004044100p -0.3
+ 146647899233747155776590898417876442019305563662729302568851453290706794078929420058770500136200506240359723448914691181212933093255665608789118036004044110p 0.9
+ 146647899233747155776590898417876442019305563662729302568851453290706794078929420058770500136200506240359723448914691181212933093255665608789118036004044800p 0.9
+ 146647899233747155776590898417876442019305563662729302568851453290706794078929420058770500136200506240359723448914691181212933093255665608789118036004044810p -0.3
+ \]
V_wl_506 (WordLine\\<506\\> gnd!) vsource type=pwl wave=\[
+ 0    -0.3
+ 293295798467494311553181796835752884038611127325458605137702906581413588157858840117541000272401012480719446897829382362425866186511331217578236072008088900p -0.3
+ 293295798467494311553181796835752884038611127325458605137702906581413588157858840117541000272401012480719446897829382362425866186511331217578236072008088910p 0.9
+ 293295798467494311553181796835752884038611127325458605137702906581413588157858840117541000272401012480719446897829382362425866186511331217578236072008089600p 0.9
+ 293295798467494311553181796835752884038611127325458605137702906581413588157858840117541000272401012480719446897829382362425866186511331217578236072008089610p -0.3
+ \]
V_wl_507 (WordLine\\<507\\> gnd!) vsource type=pwl wave=\[
+ 0    -0.3
+ 586591596934988623106363593671505768077222254650917210275405813162827176315717680235082000544802024961438893795658764724851732373022662435156472144016178500p -0.3
+ 586591596934988623106363593671505768077222254650917210275405813162827176315717680235082000544802024961438893795658764724851732373022662435156472144016178510p 0.9
+ 586591596934988623106363593671505768077222254650917210275405813162827176315717680235082000544802024961438893795658764724851732373022662435156472144016179200p 0.9
+ 586591596934988623106363593671505768077222254650917210275405813162827176315717680235082000544802024961438893795658764724851732373022662435156472144016179210p -0.3
+ \]
V_wl_508 (WordLine\\<508\\> gnd!) vsource type=pwl wave=\[
+ 0    -0.3
+ 1173183193869977246212727187343011536154444509301834420550811626325654352631435360470164001089604049922877787591317529449703464746045324870312944288032357700p -0.3
+ 1173183193869977246212727187343011536154444509301834420550811626325654352631435360470164001089604049922877787591317529449703464746045324870312944288032357710p 0.9
+ 1173183193869977246212727187343011536154444509301834420550811626325654352631435360470164001089604049922877787591317529449703464746045324870312944288032358400p 0.9
+ 1173183193869977246212727187343011536154444509301834420550811626325654352631435360470164001089604049922877787591317529449703464746045324870312944288032358410p -0.3
+ \]
V_wl_509 (WordLine\\<509\\> gnd!) vsource type=pwl wave=\[
+ 0    -0.3
+ 2346366387739954492425454374686023072308889018603668841101623252651308705262870720940328002179208099845755575182635058899406929492090649740625888576064716100p -0.3
+ 2346366387739954492425454374686023072308889018603668841101623252651308705262870720940328002179208099845755575182635058899406929492090649740625888576064716110p 0.9
+ 2346366387739954492425454374686023072308889018603668841101623252651308705262870720940328002179208099845755575182635058899406929492090649740625888576064716800p 0.9
+ 2346366387739954492425454374686023072308889018603668841101623252651308705262870720940328002179208099845755575182635058899406929492090649740625888576064716810p -0.3
+ \]
V_wl_510 (WordLine\\<510\\> gnd!) vsource type=pwl wave=\[
+ 0    -0.3
+ 4692732775479908984850908749372046144617778037207337682203246505302617410525741441880656004358416199691511150365270117798813858984181299481251777152129432900p -0.3
+ 4692732775479908984850908749372046144617778037207337682203246505302617410525741441880656004358416199691511150365270117798813858984181299481251777152129432910p 0.9
+ 4692732775479908984850908749372046144617778037207337682203246505302617410525741441880656004358416199691511150365270117798813858984181299481251777152129433600p 0.9
+ 4692732775479908984850908749372046144617778037207337682203246505302617410525741441880656004358416199691511150365270117798813858984181299481251777152129433610p -0.3
+ \]
V_wl_511 (WordLine\\<511\\> gnd!) vsource type=pwl wave=\[
+ 0    -0.3
+ 9385465550959817969701817498744092289235556074414675364406493010605234821051482883761312008716832399383022300730540235597627717968362598962503554304258866500p -0.3
+ 9385465550959817969701817498744092289235556074414675364406493010605234821051482883761312008716832399383022300730540235597627717968362598962503554304258866510p 0.9
+ 9385465550959817969701817498744092289235556074414675364406493010605234821051482883761312008716832399383022300730540235597627717968362598962503554304258867200p 0.9
+ 9385465550959817969701817498744092289235556074414675364406493010605234821051482883761312008716832399383022300730540235597627717968362598962503554304258867210p -0.3
+ \]
V_wl_512 (WordLine\\<512\\> gnd!) vsource type=pwl wave=\[
+ 0    -0.3
+ 18770931101919635939403634997488184578471112148829350728812986021210469642102965767522624017433664798766044601461080471195255435936725197925007108608517733700p -0.3
+ 18770931101919635939403634997488184578471112148829350728812986021210469642102965767522624017433664798766044601461080471195255435936725197925007108608517733710p 0.9
+ 18770931101919635939403634997488184578471112148829350728812986021210469642102965767522624017433664798766044601461080471195255435936725197925007108608517734400p 0.9
+ 18770931101919635939403634997488184578471112148829350728812986021210469642102965767522624017433664798766044601461080471195255435936725197925007108608517734410p -0.3
+ \]
V_wl_513 (WordLine\\<513\\> gnd!) vsource type=pwl wave=\[
+ 0    -0.3
+ 37541862203839271878807269994976369156942224297658701457625972042420939284205931535045248034867329597532089202922160942390510871873450395850014217217035468100p -0.3
+ 37541862203839271878807269994976369156942224297658701457625972042420939284205931535045248034867329597532089202922160942390510871873450395850014217217035468110p 0.9
+ 37541862203839271878807269994976369156942224297658701457625972042420939284205931535045248034867329597532089202922160942390510871873450395850014217217035468800p 0.9
+ 37541862203839271878807269994976369156942224297658701457625972042420939284205931535045248034867329597532089202922160942390510871873450395850014217217035468810p -0.3
+ \]
V_wl_514 (WordLine\\<514\\> gnd!) vsource type=pwl wave=\[
+ 0    -0.3
+ 75083724407678543757614539989952738313884448595317402915251944084841878568411863070090496069734659195064178405844321884781021743746900791700028434434070936900p -0.3
+ 75083724407678543757614539989952738313884448595317402915251944084841878568411863070090496069734659195064178405844321884781021743746900791700028434434070936910p 0.9
+ 75083724407678543757614539989952738313884448595317402915251944084841878568411863070090496069734659195064178405844321884781021743746900791700028434434070937600p 0.9
+ 75083724407678543757614539989952738313884448595317402915251944084841878568411863070090496069734659195064178405844321884781021743746900791700028434434070937610p -0.3
+ \]
V_wl_515 (WordLine\\<515\\> gnd!) vsource type=pwl wave=\[
+ 0    -0.3
+ 150167448815357087515229079979905476627768897190634805830503888169683757136823726140180992139469318390128356811688643769562043487493801583400056868868141874500p -0.3
+ 150167448815357087515229079979905476627768897190634805830503888169683757136823726140180992139469318390128356811688643769562043487493801583400056868868141874510p 0.9
+ 150167448815357087515229079979905476627768897190634805830503888169683757136823726140180992139469318390128356811688643769562043487493801583400056868868141875200p 0.9
+ 150167448815357087515229079979905476627768897190634805830503888169683757136823726140180992139469318390128356811688643769562043487493801583400056868868141875210p -0.3
+ \]
V_wl_516 (WordLine\\<516\\> gnd!) vsource type=pwl wave=\[
+ 0    -0.3
+ 300334897630714175030458159959810953255537794381269611661007776339367514273647452280361984278938636780256713623377287539124086974987603166800113737736283749700p -0.3
+ 300334897630714175030458159959810953255537794381269611661007776339367514273647452280361984278938636780256713623377287539124086974987603166800113737736283749710p 0.9
+ 300334897630714175030458159959810953255537794381269611661007776339367514273647452280361984278938636780256713623377287539124086974987603166800113737736283750400p 0.9
+ 300334897630714175030458159959810953255537794381269611661007776339367514273647452280361984278938636780256713623377287539124086974987603166800113737736283750410p -0.3
+ \]
V_wl_517 (WordLine\\<517\\> gnd!) vsource type=pwl wave=\[
+ 0    -0.3
+ 600669795261428350060916319919621906511075588762539223322015552678735028547294904560723968557877273560513427246754575078248173949975206333600227475472567500100p -0.3
+ 600669795261428350060916319919621906511075588762539223322015552678735028547294904560723968557877273560513427246754575078248173949975206333600227475472567500110p 0.9
+ 600669795261428350060916319919621906511075588762539223322015552678735028547294904560723968557877273560513427246754575078248173949975206333600227475472567500800p 0.9
+ 600669795261428350060916319919621906511075588762539223322015552678735028547294904560723968557877273560513427246754575078248173949975206333600227475472567500810p -0.3
+ \]
V_wl_518 (WordLine\\<518\\> gnd!) vsource type=pwl wave=\[
+ 0    -0.3
+ 1201339590522856700121832639839243813022151177525078446644031105357470057094589809121447937115754547121026854493509150156496347899950412667200454950945135000900p -0.3
+ 1201339590522856700121832639839243813022151177525078446644031105357470057094589809121447937115754547121026854493509150156496347899950412667200454950945135000910p 0.9
+ 1201339590522856700121832639839243813022151177525078446644031105357470057094589809121447937115754547121026854493509150156496347899950412667200454950945135001600p 0.9
+ 1201339590522856700121832639839243813022151177525078446644031105357470057094589809121447937115754547121026854493509150156496347899950412667200454950945135001610p -0.3
+ \]
V_wl_519 (WordLine\\<519\\> gnd!) vsource type=pwl wave=\[
+ 0    -0.3
+ 2402679181045713400243665279678487626044302355050156893288062210714940114189179618242895874231509094242053708987018300312992695799900825334400909901890270002500p -0.3
+ 2402679181045713400243665279678487626044302355050156893288062210714940114189179618242895874231509094242053708987018300312992695799900825334400909901890270002510p 0.9
+ 2402679181045713400243665279678487626044302355050156893288062210714940114189179618242895874231509094242053708987018300312992695799900825334400909901890270003200p 0.9
+ 2402679181045713400243665279678487626044302355050156893288062210714940114189179618242895874231509094242053708987018300312992695799900825334400909901890270003210p -0.3
+ \]
V_wl_520 (WordLine\\<520\\> gnd!) vsource type=pwl wave=\[
+ 0    -0.3
+ 4805358362091426800487330559356975252088604710100313786576124421429880228378359236485791748463018188484107417974036600625985391599801650668801819803780540005700p -0.3
+ 4805358362091426800487330559356975252088604710100313786576124421429880228378359236485791748463018188484107417974036600625985391599801650668801819803780540005710p 0.9
+ 4805358362091426800487330559356975252088604710100313786576124421429880228378359236485791748463018188484107417974036600625985391599801650668801819803780540006400p 0.9
+ 4805358362091426800487330559356975252088604710100313786576124421429880228378359236485791748463018188484107417974036600625985391599801650668801819803780540006410p -0.3
+ \]
V_wl_521 (WordLine\\<521\\> gnd!) vsource type=pwl wave=\[
+ 0    -0.3
+ 9610716724182853600974661118713950504177209420200627573152248842859760456756718472971583496926036376968214835948073201251970783199603301337603639607561080012100p -0.3
+ 9610716724182853600974661118713950504177209420200627573152248842859760456756718472971583496926036376968214835948073201251970783199603301337603639607561080012110p 0.9
+ 9610716724182853600974661118713950504177209420200627573152248842859760456756718472971583496926036376968214835948073201251970783199603301337603639607561080012800p 0.9
+ 9610716724182853600974661118713950504177209420200627573152248842859760456756718472971583496926036376968214835948073201251970783199603301337603639607561080012810p -0.3
+ \]
V_wl_522 (WordLine\\<522\\> gnd!) vsource type=pwl wave=\[
+ 0    -0.3
+ 19221433448365707201949322237427901008354418840401255146304497685719520913513436945943166993852072753936429671896146402503941566399206602675207279215122160024900p -0.3
+ 19221433448365707201949322237427901008354418840401255146304497685719520913513436945943166993852072753936429671896146402503941566399206602675207279215122160024910p 0.9
+ 19221433448365707201949322237427901008354418840401255146304497685719520913513436945943166993852072753936429671896146402503941566399206602675207279215122160025600p 0.9
+ 19221433448365707201949322237427901008354418840401255146304497685719520913513436945943166993852072753936429671896146402503941566399206602675207279215122160025610p -0.3
+ \]
V_wl_523 (WordLine\\<523\\> gnd!) vsource type=pwl wave=\[
+ 0    -0.3
+ 38442866896731414403898644474855802016708837680802510292608995371439041827026873891886333987704145507872859343792292805007883132798413205350414558430244320050500p -0.3
+ 38442866896731414403898644474855802016708837680802510292608995371439041827026873891886333987704145507872859343792292805007883132798413205350414558430244320050510p 0.9
+ 38442866896731414403898644474855802016708837680802510292608995371439041827026873891886333987704145507872859343792292805007883132798413205350414558430244320051200p 0.9
+ 38442866896731414403898644474855802016708837680802510292608995371439041827026873891886333987704145507872859343792292805007883132798413205350414558430244320051210p -0.3
+ \]
V_wl_524 (WordLine\\<524\\> gnd!) vsource type=pwl wave=\[
+ 0    -0.3
+ 76885733793462828807797288949711604033417675361605020585217990742878083654053747783772667975408291015745718687584585610015766265596826410700829116860488640101700p -0.3
+ 76885733793462828807797288949711604033417675361605020585217990742878083654053747783772667975408291015745718687584585610015766265596826410700829116860488640101710p 0.9
+ 76885733793462828807797288949711604033417675361605020585217990742878083654053747783772667975408291015745718687584585610015766265596826410700829116860488640102400p 0.9
+ 76885733793462828807797288949711604033417675361605020585217990742878083654053747783772667975408291015745718687584585610015766265596826410700829116860488640102410p -0.3
+ \]
V_wl_525 (WordLine\\<525\\> gnd!) vsource type=pwl wave=\[
+ 0    -0.3
+ 153771467586925657615594577899423208066835350723210041170435981485756167308107495567545335950816582031491437375169171220031532531193652821401658233720977280204100p -0.3
+ 153771467586925657615594577899423208066835350723210041170435981485756167308107495567545335950816582031491437375169171220031532531193652821401658233720977280204110p 0.9
+ 153771467586925657615594577899423208066835350723210041170435981485756167308107495567545335950816582031491437375169171220031532531193652821401658233720977280204800p 0.9
+ 153771467586925657615594577899423208066835350723210041170435981485756167308107495567545335950816582031491437375169171220031532531193652821401658233720977280204810p -0.3
+ \]
V_wl_526 (WordLine\\<526\\> gnd!) vsource type=pwl wave=\[
+ 0    -0.3
+ 307542935173851315231189155798846416133670701446420082340871962971512334616214991135090671901633164062982874750338342440063065062387305642803316467441954560408900p -0.3
+ 307542935173851315231189155798846416133670701446420082340871962971512334616214991135090671901633164062982874750338342440063065062387305642803316467441954560408910p 0.9
+ 307542935173851315231189155798846416133670701446420082340871962971512334616214991135090671901633164062982874750338342440063065062387305642803316467441954560409600p 0.9
+ 307542935173851315231189155798846416133670701446420082340871962971512334616214991135090671901633164062982874750338342440063065062387305642803316467441954560409610p -0.3
+ \]
V_wl_527 (WordLine\\<527\\> gnd!) vsource type=pwl wave=\[
+ 0    -0.3
+ 615085870347702630462378311597692832267341402892840164681743925943024669232429982270181343803266328125965749500676684880126130124774611285606632934883909120818500p -0.3
+ 615085870347702630462378311597692832267341402892840164681743925943024669232429982270181343803266328125965749500676684880126130124774611285606632934883909120818510p 0.9
+ 615085870347702630462378311597692832267341402892840164681743925943024669232429982270181343803266328125965749500676684880126130124774611285606632934883909120819200p 0.9
+ 615085870347702630462378311597692832267341402892840164681743925943024669232429982270181343803266328125965749500676684880126130124774611285606632934883909120819210p -0.3
+ \]
V_wl_528 (WordLine\\<528\\> gnd!) vsource type=pwl wave=\[
+ 0    -0.3
+ 1230171740695405260924756623195385664534682805785680329363487851886049338464859964540362687606532656251931499001353369760252260249549222571213265869767818241637700p -0.3
+ 1230171740695405260924756623195385664534682805785680329363487851886049338464859964540362687606532656251931499001353369760252260249549222571213265869767818241637710p 0.9
+ 1230171740695405260924756623195385664534682805785680329363487851886049338464859964540362687606532656251931499001353369760252260249549222571213265869767818241638400p 0.9
+ 1230171740695405260924756623195385664534682805785680329363487851886049338464859964540362687606532656251931499001353369760252260249549222571213265869767818241638410p -0.3
+ \]
V_wl_529 (WordLine\\<529\\> gnd!) vsource type=pwl wave=\[
+ 0    -0.3
+ 2460343481390810521849513246390771329069365611571360658726975703772098676929719929080725375213065312503862998002706739520504520499098445142426531739535636483276100p -0.3
+ 2460343481390810521849513246390771329069365611571360658726975703772098676929719929080725375213065312503862998002706739520504520499098445142426531739535636483276110p 0.9
+ 2460343481390810521849513246390771329069365611571360658726975703772098676929719929080725375213065312503862998002706739520504520499098445142426531739535636483276800p 0.9
+ 2460343481390810521849513246390771329069365611571360658726975703772098676929719929080725375213065312503862998002706739520504520499098445142426531739535636483276810p -0.3
+ \]
V_wl_530 (WordLine\\<530\\> gnd!) vsource type=pwl wave=\[
+ 0    -0.3
+ 4920686962781621043699026492781542658138731223142721317453951407544197353859439858161450750426130625007725996005413479041009040998196890284853063479071272966552900p -0.3
+ 4920686962781621043699026492781542658138731223142721317453951407544197353859439858161450750426130625007725996005413479041009040998196890284853063479071272966552910p 0.9
+ 4920686962781621043699026492781542658138731223142721317453951407544197353859439858161450750426130625007725996005413479041009040998196890284853063479071272966553600p 0.9
+ 4920686962781621043699026492781542658138731223142721317453951407544197353859439858161450750426130625007725996005413479041009040998196890284853063479071272966553610p -0.3
+ \]
V_wl_531 (WordLine\\<531\\> gnd!) vsource type=pwl wave=\[
+ 0    -0.3
+ 9841373925563242087398052985563085316277462446285442634907902815088394707718879716322901500852261250015451992010826958082018081996393780569706126958142545933106500p -0.3
+ 9841373925563242087398052985563085316277462446285442634907902815088394707718879716322901500852261250015451992010826958082018081996393780569706126958142545933106510p 0.9
+ 9841373925563242087398052985563085316277462446285442634907902815088394707718879716322901500852261250015451992010826958082018081996393780569706126958142545933107200p 0.9
+ 9841373925563242087398052985563085316277462446285442634907902815088394707718879716322901500852261250015451992010826958082018081996393780569706126958142545933107210p -0.3
+ \]
V_wl_532 (WordLine\\<532\\> gnd!) vsource type=pwl wave=\[
+ 0    -0.3
+ 19682747851126484174796105971126170632554924892570885269815805630176789415437759432645803001704522500030903984021653916164036163992787561139412253916285091866213700p -0.3
+ 19682747851126484174796105971126170632554924892570885269815805630176789415437759432645803001704522500030903984021653916164036163992787561139412253916285091866213710p 0.9
+ 19682747851126484174796105971126170632554924892570885269815805630176789415437759432645803001704522500030903984021653916164036163992787561139412253916285091866214400p 0.9
+ 19682747851126484174796105971126170632554924892570885269815805630176789415437759432645803001704522500030903984021653916164036163992787561139412253916285091866214410p -0.3
+ \]
V_wl_533 (WordLine\\<533\\> gnd!) vsource type=pwl wave=\[
+ 0    -0.3
+ 39365495702252968349592211942252341265109849785141770539631611260353578830875518865291606003409045000061807968043307832328072327985575122278824507832570183732428100p -0.3
+ 39365495702252968349592211942252341265109849785141770539631611260353578830875518865291606003409045000061807968043307832328072327985575122278824507832570183732428110p 0.9
+ 39365495702252968349592211942252341265109849785141770539631611260353578830875518865291606003409045000061807968043307832328072327985575122278824507832570183732428800p 0.9
+ 39365495702252968349592211942252341265109849785141770539631611260353578830875518865291606003409045000061807968043307832328072327985575122278824507832570183732428810p -0.3
+ \]
V_wl_534 (WordLine\\<534\\> gnd!) vsource type=pwl wave=\[
+ 0    -0.3
+ 78730991404505936699184423884504682530219699570283541079263222520707157661751037730583212006818090000123615936086615664656144655971150244557649015665140367464856900p -0.3
+ 78730991404505936699184423884504682530219699570283541079263222520707157661751037730583212006818090000123615936086615664656144655971150244557649015665140367464856910p 0.9
+ 78730991404505936699184423884504682530219699570283541079263222520707157661751037730583212006818090000123615936086615664656144655971150244557649015665140367464857600p 0.9
+ 78730991404505936699184423884504682530219699570283541079263222520707157661751037730583212006818090000123615936086615664656144655971150244557649015665140367464857610p -0.3
+ \]
V_wl_535 (WordLine\\<535\\> gnd!) vsource type=pwl wave=\[
+ 0    -0.3
+ 157461982809011873398368847769009365060439399140567082158526445041414315323502075461166424013636180000247231872173231329312289311942300489115298031330280734929714500p -0.3
+ 157461982809011873398368847769009365060439399140567082158526445041414315323502075461166424013636180000247231872173231329312289311942300489115298031330280734929714510p 0.9
+ 157461982809011873398368847769009365060439399140567082158526445041414315323502075461166424013636180000247231872173231329312289311942300489115298031330280734929715200p 0.9
+ 157461982809011873398368847769009365060439399140567082158526445041414315323502075461166424013636180000247231872173231329312289311942300489115298031330280734929715210p -0.3
+ \]
V_wl_536 (WordLine\\<536\\> gnd!) vsource type=pwl wave=\[
+ 0    -0.3
+ 314923965618023746796737695538018730120878798281134164317052890082828630647004150922332848027272360000494463744346462658624578623884600978230596062660561469859429700p -0.3
+ 314923965618023746796737695538018730120878798281134164317052890082828630647004150922332848027272360000494463744346462658624578623884600978230596062660561469859429710p 0.9
+ 314923965618023746796737695538018730120878798281134164317052890082828630647004150922332848027272360000494463744346462658624578623884600978230596062660561469859430400p 0.9
+ 314923965618023746796737695538018730120878798281134164317052890082828630647004150922332848027272360000494463744346462658624578623884600978230596062660561469859430410p -0.3
+ \]
V_wl_537 (WordLine\\<537\\> gnd!) vsource type=pwl wave=\[
+ 0    -0.3
+ 629847931236047493593475391076037460241757596562268328634105780165657261294008301844665696054544720000988927488692925317249157247769201956461192125321122939718860100p -0.3
+ 629847931236047493593475391076037460241757596562268328634105780165657261294008301844665696054544720000988927488692925317249157247769201956461192125321122939718860110p 0.9
+ 629847931236047493593475391076037460241757596562268328634105780165657261294008301844665696054544720000988927488692925317249157247769201956461192125321122939718860800p 0.9
+ 629847931236047493593475391076037460241757596562268328634105780165657261294008301844665696054544720000988927488692925317249157247769201956461192125321122939718860810p -0.3
+ \]
V_wl_538 (WordLine\\<538\\> gnd!) vsource type=pwl wave=\[
+ 0    -0.3
+ 1259695862472094987186950782152074920483515193124536657268211560331314522588016603689331392109089440001977854977385850634498314495538403912922384250642245879437720900p -0.3
+ 1259695862472094987186950782152074920483515193124536657268211560331314522588016603689331392109089440001977854977385850634498314495538403912922384250642245879437720910p 0.9
+ 1259695862472094987186950782152074920483515193124536657268211560331314522588016603689331392109089440001977854977385850634498314495538403912922384250642245879437721600p 0.9
+ 1259695862472094987186950782152074920483515193124536657268211560331314522588016603689331392109089440001977854977385850634498314495538403912922384250642245879437721610p -0.3
+ \]
V_wl_539 (WordLine\\<539\\> gnd!) vsource type=pwl wave=\[
+ 0    -0.3
+ 2519391724944189974373901564304149840967030386249073314536423120662629045176033207378662784218178880003955709954771701268996628991076807825844768501284491758875442500p -0.3
+ 2519391724944189974373901564304149840967030386249073314536423120662629045176033207378662784218178880003955709954771701268996628991076807825844768501284491758875442510p 0.9
+ 2519391724944189974373901564304149840967030386249073314536423120662629045176033207378662784218178880003955709954771701268996628991076807825844768501284491758875443200p 0.9
+ 2519391724944189974373901564304149840967030386249073314536423120662629045176033207378662784218178880003955709954771701268996628991076807825844768501284491758875443210p -0.3
+ \]
V_wl_540 (WordLine\\<540\\> gnd!) vsource type=pwl wave=\[
+ 0    -0.3
+ 5038783449888379948747803128608299681934060772498146629072846241325258090352066414757325568436357760007911419909543402537993257982153615651689537002568983517750885700p -0.3
+ 5038783449888379948747803128608299681934060772498146629072846241325258090352066414757325568436357760007911419909543402537993257982153615651689537002568983517750885710p 0.9
+ 5038783449888379948747803128608299681934060772498146629072846241325258090352066414757325568436357760007911419909543402537993257982153615651689537002568983517750886400p 0.9
+ 5038783449888379948747803128608299681934060772498146629072846241325258090352066414757325568436357760007911419909543402537993257982153615651689537002568983517750886410p -0.3
+ \]
V_wl_541 (WordLine\\<541\\> gnd!) vsource type=pwl wave=\[
+ 0    -0.3
+ 10077566899776759897495606257216599363868121544996293258145692482650516180704132829514651136872715520015822839819086805075986515964307231303379074005137967035501772100p -0.3
+ 10077566899776759897495606257216599363868121544996293258145692482650516180704132829514651136872715520015822839819086805075986515964307231303379074005137967035501772110p 0.9
+ 10077566899776759897495606257216599363868121544996293258145692482650516180704132829514651136872715520015822839819086805075986515964307231303379074005137967035501772800p 0.9
+ 10077566899776759897495606257216599363868121544996293258145692482650516180704132829514651136872715520015822839819086805075986515964307231303379074005137967035501772810p -0.3
+ \]
V_wl_542 (WordLine\\<542\\> gnd!) vsource type=pwl wave=\[
+ 0    -0.3
+ 20155133799553519794991212514433198727736243089992586516291384965301032361408265659029302273745431040031645679638173610151973031928614462606758148010275934071003544900p -0.3
+ 20155133799553519794991212514433198727736243089992586516291384965301032361408265659029302273745431040031645679638173610151973031928614462606758148010275934071003544910p 0.9
+ 20155133799553519794991212514433198727736243089992586516291384965301032361408265659029302273745431040031645679638173610151973031928614462606758148010275934071003545600p 0.9
+ 20155133799553519794991212514433198727736243089992586516291384965301032361408265659029302273745431040031645679638173610151973031928614462606758148010275934071003545610p -0.3
+ \]
V_wl_543 (WordLine\\<543\\> gnd!) vsource type=pwl wave=\[
+ 0    -0.3
+ 40310267599107039589982425028866397455472486179985173032582769930602064722816531318058604547490862080063291359276347220303946063857228925213516296020551868142007090500p -0.3
+ 40310267599107039589982425028866397455472486179985173032582769930602064722816531318058604547490862080063291359276347220303946063857228925213516296020551868142007090510p 0.9
+ 40310267599107039589982425028866397455472486179985173032582769930602064722816531318058604547490862080063291359276347220303946063857228925213516296020551868142007091200p 0.9
+ 40310267599107039589982425028866397455472486179985173032582769930602064722816531318058604547490862080063291359276347220303946063857228925213516296020551868142007091210p -0.3
+ \]
V_wl_544 (WordLine\\<544\\> gnd!) vsource type=pwl wave=\[
+ 0    -0.3
+ 80620535198214079179964850057732794910944972359970346065165539861204129445633062636117209094981724160126582718552694440607892127714457850427032592041103736284014181700p -0.3
+ 80620535198214079179964850057732794910944972359970346065165539861204129445633062636117209094981724160126582718552694440607892127714457850427032592041103736284014181710p 0.9
+ 80620535198214079179964850057732794910944972359970346065165539861204129445633062636117209094981724160126582718552694440607892127714457850427032592041103736284014182400p 0.9
+ 80620535198214079179964850057732794910944972359970346065165539861204129445633062636117209094981724160126582718552694440607892127714457850427032592041103736284014182410p -0.3
+ \]
V_wl_545 (WordLine\\<545\\> gnd!) vsource type=pwl wave=\[
+ 0    -0.3
+ 161241070396428158359929700115465589821889944719940692130331079722408258891266125272234418189963448320253165437105388881215784255428915700854065184082207472568028364100p -0.3
+ 161241070396428158359929700115465589821889944719940692130331079722408258891266125272234418189963448320253165437105388881215784255428915700854065184082207472568028364110p 0.9
+ 161241070396428158359929700115465589821889944719940692130331079722408258891266125272234418189963448320253165437105388881215784255428915700854065184082207472568028364800p 0.9
+ 161241070396428158359929700115465589821889944719940692130331079722408258891266125272234418189963448320253165437105388881215784255428915700854065184082207472568028364810p -0.3
+ \]
V_wl_546 (WordLine\\<546\\> gnd!) vsource type=pwl wave=\[
+ 0    -0.3
+ 322482140792856316719859400230931179643779889439881384260662159444816517782532250544468836379926896640506330874210777762431568510857831401708130368164414945136056728900p -0.3
+ 322482140792856316719859400230931179643779889439881384260662159444816517782532250544468836379926896640506330874210777762431568510857831401708130368164414945136056728910p 0.9
+ 322482140792856316719859400230931179643779889439881384260662159444816517782532250544468836379926896640506330874210777762431568510857831401708130368164414945136056729600p 0.9
+ 322482140792856316719859400230931179643779889439881384260662159444816517782532250544468836379926896640506330874210777762431568510857831401708130368164414945136056729610p -0.3
+ \]
V_wl_547 (WordLine\\<547\\> gnd!) vsource type=pwl wave=\[
+ 0    -0.3
+ 644964281585712633439718800461862359287559778879762768521324318889633035565064501088937672759853793281012661748421555524863137021715662803416260736328829890272113458500p -0.3
+ 644964281585712633439718800461862359287559778879762768521324318889633035565064501088937672759853793281012661748421555524863137021715662803416260736328829890272113458510p 0.9
+ 644964281585712633439718800461862359287559778879762768521324318889633035565064501088937672759853793281012661748421555524863137021715662803416260736328829890272113459200p 0.9
+ 644964281585712633439718800461862359287559778879762768521324318889633035565064501088937672759853793281012661748421555524863137021715662803416260736328829890272113459210p -0.3
+ \]
V_wl_548 (WordLine\\<548\\> gnd!) vsource type=pwl wave=\[
+ 0    -0.3
+ 1289928563171425266879437600923724718575119557759525537042648637779266071130129002177875345519707586562025323496843111049726274043431325606832521472657659780544226917700p -0.3
+ 1289928563171425266879437600923724718575119557759525537042648637779266071130129002177875345519707586562025323496843111049726274043431325606832521472657659780544226917710p 0.9
+ 1289928563171425266879437600923724718575119557759525537042648637779266071130129002177875345519707586562025323496843111049726274043431325606832521472657659780544226918400p 0.9
+ 1289928563171425266879437600923724718575119557759525537042648637779266071130129002177875345519707586562025323496843111049726274043431325606832521472657659780544226918410p -0.3
+ \]
V_wl_549 (WordLine\\<549\\> gnd!) vsource type=pwl wave=\[
+ 0    -0.3
+ 2579857126342850533758875201847449437150239115519051074085297275558532142260258004355750691039415173124050646993686222099452548086862651213665042945315319561088453836100p -0.3
+ 2579857126342850533758875201847449437150239115519051074085297275558532142260258004355750691039415173124050646993686222099452548086862651213665042945315319561088453836110p 0.9
+ 2579857126342850533758875201847449437150239115519051074085297275558532142260258004355750691039415173124050646993686222099452548086862651213665042945315319561088453836800p 0.9
+ 2579857126342850533758875201847449437150239115519051074085297275558532142260258004355750691039415173124050646993686222099452548086862651213665042945315319561088453836810p -0.3
+ \]
V_wl_550 (WordLine\\<550\\> gnd!) vsource type=pwl wave=\[
+ 0    -0.3
+ 5159714252685701067517750403694898874300478231038102148170594551117064284520516008711501382078830346248101293987372444198905096173725302427330085890630639122176907672900p -0.3
+ 5159714252685701067517750403694898874300478231038102148170594551117064284520516008711501382078830346248101293987372444198905096173725302427330085890630639122176907672910p 0.9
+ 5159714252685701067517750403694898874300478231038102148170594551117064284520516008711501382078830346248101293987372444198905096173725302427330085890630639122176907673600p 0.9
+ 5159714252685701067517750403694898874300478231038102148170594551117064284520516008711501382078830346248101293987372444198905096173725302427330085890630639122176907673610p -0.3
+ \]
V_wl_551 (WordLine\\<551\\> gnd!) vsource type=pwl wave=\[
+ 0    -0.3
+ 10319428505371402135035500807389797748600956462076204296341189102234128569041032017423002764157660692496202587974744888397810192347450604854660171781261278244353815346500p -0.3
+ 10319428505371402135035500807389797748600956462076204296341189102234128569041032017423002764157660692496202587974744888397810192347450604854660171781261278244353815346510p 0.9
+ 10319428505371402135035500807389797748600956462076204296341189102234128569041032017423002764157660692496202587974744888397810192347450604854660171781261278244353815347200p 0.9
+ 10319428505371402135035500807389797748600956462076204296341189102234128569041032017423002764157660692496202587974744888397810192347450604854660171781261278244353815347210p -0.3
+ \]
V_wl_552 (WordLine\\<552\\> gnd!) vsource type=pwl wave=\[
+ 0    -0.3
+ 20638857010742804270071001614779595497201912924152408592682378204468257138082064034846005528315321384992405175949489776795620384694901209709320343562522556488707630693700p -0.3
+ 20638857010742804270071001614779595497201912924152408592682378204468257138082064034846005528315321384992405175949489776795620384694901209709320343562522556488707630693710p 0.9
+ 20638857010742804270071001614779595497201912924152408592682378204468257138082064034846005528315321384992405175949489776795620384694901209709320343562522556488707630694400p 0.9
+ 20638857010742804270071001614779595497201912924152408592682378204468257138082064034846005528315321384992405175949489776795620384694901209709320343562522556488707630694410p -0.3
+ \]
V_wl_553 (WordLine\\<553\\> gnd!) vsource type=pwl wave=\[
+ 0    -0.3
+ 41277714021485608540142003229559190994403825848304817185364756408936514276164128069692011056630642769984810351898979553591240769389802419418640687125045112977415261388100p -0.3
+ 41277714021485608540142003229559190994403825848304817185364756408936514276164128069692011056630642769984810351898979553591240769389802419418640687125045112977415261388110p 0.9
+ 41277714021485608540142003229559190994403825848304817185364756408936514276164128069692011056630642769984810351898979553591240769389802419418640687125045112977415261388800p 0.9
+ 41277714021485608540142003229559190994403825848304817185364756408936514276164128069692011056630642769984810351898979553591240769389802419418640687125045112977415261388810p -0.3
+ \]
V_wl_554 (WordLine\\<554\\> gnd!) vsource type=pwl wave=\[
+ 0    -0.3
+ 82555428042971217080284006459118381988807651696609634370729512817873028552328256139384022113261285539969620703797959107182481538779604838837281374250090225954830522776900p -0.3
+ 82555428042971217080284006459118381988807651696609634370729512817873028552328256139384022113261285539969620703797959107182481538779604838837281374250090225954830522776910p 0.9
+ 82555428042971217080284006459118381988807651696609634370729512817873028552328256139384022113261285539969620703797959107182481538779604838837281374250090225954830522777600p 0.9
+ 82555428042971217080284006459118381988807651696609634370729512817873028552328256139384022113261285539969620703797959107182481538779604838837281374250090225954830522777610p -0.3
+ \]
V_wl_555 (WordLine\\<555\\> gnd!) vsource type=pwl wave=\[
+ 0    -0.3
+ 165110856085942434160568012918236763977615303393219268741459025635746057104656512278768044226522571079939241407595918214364963077559209677674562748500180451909661045554500p -0.3
+ 165110856085942434160568012918236763977615303393219268741459025635746057104656512278768044226522571079939241407595918214364963077559209677674562748500180451909661045554510p 0.9
+ 165110856085942434160568012918236763977615303393219268741459025635746057104656512278768044226522571079939241407595918214364963077559209677674562748500180451909661045555200p 0.9
+ 165110856085942434160568012918236763977615303393219268741459025635746057104656512278768044226522571079939241407595918214364963077559209677674562748500180451909661045555210p -0.3
+ \]
V_wl_556 (WordLine\\<556\\> gnd!) vsource type=pwl wave=\[
+ 0    -0.3
+ 330221712171884868321136025836473527955230606786438537482918051271492114209313024557536088453045142159878482815191836428729926155118419355349125497000360903819322091109700p -0.3
+ 330221712171884868321136025836473527955230606786438537482918051271492114209313024557536088453045142159878482815191836428729926155118419355349125497000360903819322091109710p 0.9
+ 330221712171884868321136025836473527955230606786438537482918051271492114209313024557536088453045142159878482815191836428729926155118419355349125497000360903819322091110400p 0.9
+ 330221712171884868321136025836473527955230606786438537482918051271492114209313024557536088453045142159878482815191836428729926155118419355349125497000360903819322091110410p -0.3
+ \]
V_wl_557 (WordLine\\<557\\> gnd!) vsource type=pwl wave=\[
+ 0    -0.3
+ 660443424343769736642272051672947055910461213572877074965836102542984228418626049115072176906090284319756965630383672857459852310236838710698250994000721807638644182220100p -0.3
+ 660443424343769736642272051672947055910461213572877074965836102542984228418626049115072176906090284319756965630383672857459852310236838710698250994000721807638644182220110p 0.9
+ 660443424343769736642272051672947055910461213572877074965836102542984228418626049115072176906090284319756965630383672857459852310236838710698250994000721807638644182220800p 0.9
+ 660443424343769736642272051672947055910461213572877074965836102542984228418626049115072176906090284319756965630383672857459852310236838710698250994000721807638644182220810p -0.3
+ \]
V_wl_558 (WordLine\\<558\\> gnd!) vsource type=pwl wave=\[
+ 0    -0.3
+ 1320886848687539473284544103345894111820922427145754149931672205085968456837252098230144353812180568639513931260767345714919704620473677421396501988001443615277288364440900p -0.3
+ 1320886848687539473284544103345894111820922427145754149931672205085968456837252098230144353812180568639513931260767345714919704620473677421396501988001443615277288364440910p 0.9
+ 1320886848687539473284544103345894111820922427145754149931672205085968456837252098230144353812180568639513931260767345714919704620473677421396501988001443615277288364441600p 0.9
+ 1320886848687539473284544103345894111820922427145754149931672205085968456837252098230144353812180568639513931260767345714919704620473677421396501988001443615277288364441610p -0.3
+ \]
V_wl_559 (WordLine\\<559\\> gnd!) vsource type=pwl wave=\[
+ 0    -0.3
+ 2641773697375078946569088206691788223641844854291508299863344410171936913674504196460288707624361137279027862521534691429839409240947354842793003976002887230554576728882500p -0.3
+ 2641773697375078946569088206691788223641844854291508299863344410171936913674504196460288707624361137279027862521534691429839409240947354842793003976002887230554576728882510p 0.9
+ 2641773697375078946569088206691788223641844854291508299863344410171936913674504196460288707624361137279027862521534691429839409240947354842793003976002887230554576728883200p 0.9
+ 2641773697375078946569088206691788223641844854291508299863344410171936913674504196460288707624361137279027862521534691429839409240947354842793003976002887230554576728883210p -0.3
+ \]
V_wl_560 (WordLine\\<560\\> gnd!) vsource type=pwl wave=\[
+ 0    -0.3
+ 5283547394750157893138176413383576447283689708583016599726688820343873827349008392920577415248722274558055725043069382859678818481894709685586007952005774461109153457765700p -0.3
+ 5283547394750157893138176413383576447283689708583016599726688820343873827349008392920577415248722274558055725043069382859678818481894709685586007952005774461109153457765710p 0.9
+ 5283547394750157893138176413383576447283689708583016599726688820343873827349008392920577415248722274558055725043069382859678818481894709685586007952005774461109153457766400p 0.9
+ 5283547394750157893138176413383576447283689708583016599726688820343873827349008392920577415248722274558055725043069382859678818481894709685586007952005774461109153457766410p -0.3
+ \]
V_wl_561 (WordLine\\<561\\> gnd!) vsource type=pwl wave=\[
+ 0    -0.3
+ 10567094789500315786276352826767152894567379417166033199453377640687747654698016785841154830497444549116111450086138765719357636963789419371172015904011548922218306915532100p -0.3
+ 10567094789500315786276352826767152894567379417166033199453377640687747654698016785841154830497444549116111450086138765719357636963789419371172015904011548922218306915532110p 0.9
+ 10567094789500315786276352826767152894567379417166033199453377640687747654698016785841154830497444549116111450086138765719357636963789419371172015904011548922218306915532800p 0.9
+ 10567094789500315786276352826767152894567379417166033199453377640687747654698016785841154830497444549116111450086138765719357636963789419371172015904011548922218306915532810p -0.3
+ \]
V_wl_562 (WordLine\\<562\\> gnd!) vsource type=pwl wave=\[
+ 0    -0.3
+ 21134189579000631572552705653534305789134758834332066398906755281375495309396033571682309660994889098232222900172277531438715273927578838742344031808023097844436613831064900p -0.3
+ 21134189579000631572552705653534305789134758834332066398906755281375495309396033571682309660994889098232222900172277531438715273927578838742344031808023097844436613831064910p 0.9
+ 21134189579000631572552705653534305789134758834332066398906755281375495309396033571682309660994889098232222900172277531438715273927578838742344031808023097844436613831065600p 0.9
+ 21134189579000631572552705653534305789134758834332066398906755281375495309396033571682309660994889098232222900172277531438715273927578838742344031808023097844436613831065610p -0.3
+ \]
V_wl_563 (WordLine\\<563\\> gnd!) vsource type=pwl wave=\[
+ 0    -0.3
+ 42268379158001263145105411307068611578269517668664132797813510562750990618792067143364619321989778196464445800344555062877430547855157677484688063616046195688873227662130500p -0.3
+ 42268379158001263145105411307068611578269517668664132797813510562750990618792067143364619321989778196464445800344555062877430547855157677484688063616046195688873227662130510p 0.9
+ 42268379158001263145105411307068611578269517668664132797813510562750990618792067143364619321989778196464445800344555062877430547855157677484688063616046195688873227662131200p 0.9
+ 42268379158001263145105411307068611578269517668664132797813510562750990618792067143364619321989778196464445800344555062877430547855157677484688063616046195688873227662131210p -0.3
+ \]
V_wl_564 (WordLine\\<564\\> gnd!) vsource type=pwl wave=\[
+ 0    -0.3
+ 84536758316002526290210822614137223156539035337328265595627021125501981237584134286729238643979556392928891600689110125754861095710315354969376127232092391377746455324261700p -0.3
+ 84536758316002526290210822614137223156539035337328265595627021125501981237584134286729238643979556392928891600689110125754861095710315354969376127232092391377746455324261710p 0.9
+ 84536758316002526290210822614137223156539035337328265595627021125501981237584134286729238643979556392928891600689110125754861095710315354969376127232092391377746455324262400p 0.9
+ 84536758316002526290210822614137223156539035337328265595627021125501981237584134286729238643979556392928891600689110125754861095710315354969376127232092391377746455324262410p -0.3
+ \]
V_wl_565 (WordLine\\<565\\> gnd!) vsource type=pwl wave=\[
+ 0    -0.3
+ 169073516632005052580421645228274446313078070674656531191254042251003962475168268573458477287959112785857783201378220251509722191420630709938752254464184782755492910648524100p -0.3
+ 169073516632005052580421645228274446313078070674656531191254042251003962475168268573458477287959112785857783201378220251509722191420630709938752254464184782755492910648524110p 0.9
+ 169073516632005052580421645228274446313078070674656531191254042251003962475168268573458477287959112785857783201378220251509722191420630709938752254464184782755492910648524800p 0.9
+ 169073516632005052580421645228274446313078070674656531191254042251003962475168268573458477287959112785857783201378220251509722191420630709938752254464184782755492910648524810p -0.3
+ \]
V_wl_566 (WordLine\\<566\\> gnd!) vsource type=pwl wave=\[
+ 0    -0.3
+ 338147033264010105160843290456548892626156141349313062382508084502007924950336537146916954575918225571715566402756440503019444382841261419877504508928369565510985821297048900p -0.3
+ 338147033264010105160843290456548892626156141349313062382508084502007924950336537146916954575918225571715566402756440503019444382841261419877504508928369565510985821297048910p 0.9
+ 338147033264010105160843290456548892626156141349313062382508084502007924950336537146916954575918225571715566402756440503019444382841261419877504508928369565510985821297049600p 0.9
+ 338147033264010105160843290456548892626156141349313062382508084502007924950336537146916954575918225571715566402756440503019444382841261419877504508928369565510985821297049610p -0.3
+ \]
V_wl_567 (WordLine\\<567\\> gnd!) vsource type=pwl wave=\[
+ 0    -0.3
+ 676294066528020210321686580913097785252312282698626124765016169004015849900673074293833909151836451143431132805512881006038888765682522839755009017856739131021971642594098500p -0.3
+ 676294066528020210321686580913097785252312282698626124765016169004015849900673074293833909151836451143431132805512881006038888765682522839755009017856739131021971642594098510p 0.9
+ 676294066528020210321686580913097785252312282698626124765016169004015849900673074293833909151836451143431132805512881006038888765682522839755009017856739131021971642594099200p 0.9
+ 676294066528020210321686580913097785252312282698626124765016169004015849900673074293833909151836451143431132805512881006038888765682522839755009017856739131021971642594099210p -0.3
+ \]
V_wl_568 (WordLine\\<568\\> gnd!) vsource type=pwl wave=\[
+ 0    -0.3
+ 1352588133056040420643373161826195570504624565397252249530032338008031699801346148587667818303672902286862265611025762012077777531365045679510018035713478262043943285188197700p -0.3
+ 1352588133056040420643373161826195570504624565397252249530032338008031699801346148587667818303672902286862265611025762012077777531365045679510018035713478262043943285188197710p 0.9
+ 1352588133056040420643373161826195570504624565397252249530032338008031699801346148587667818303672902286862265611025762012077777531365045679510018035713478262043943285188198400p 0.9
+ 1352588133056040420643373161826195570504624565397252249530032338008031699801346148587667818303672902286862265611025762012077777531365045679510018035713478262043943285188198410p -0.3
+ \]
V_wl_569 (WordLine\\<569\\> gnd!) vsource type=pwl wave=\[
+ 0    -0.3
+ 2705176266112080841286746323652391141009249130794504499060064676016063399602692297175335636607345804573724531222051524024155555062730091359020036071426956524087886570376396100p -0.3
+ 2705176266112080841286746323652391141009249130794504499060064676016063399602692297175335636607345804573724531222051524024155555062730091359020036071426956524087886570376396110p 0.9
+ 2705176266112080841286746323652391141009249130794504499060064676016063399602692297175335636607345804573724531222051524024155555062730091359020036071426956524087886570376396800p 0.9
+ 2705176266112080841286746323652391141009249130794504499060064676016063399602692297175335636607345804573724531222051524024155555062730091359020036071426956524087886570376396810p -0.3
+ \]
V_wl_570 (WordLine\\<570\\> gnd!) vsource type=pwl wave=\[
+ 0    -0.3
+ 5410352532224161682573492647304782282018498261589008998120129352032126799205384594350671273214691609147449062444103048048311110125460182718040072142853913048175773140752792900p -0.3
+ 5410352532224161682573492647304782282018498261589008998120129352032126799205384594350671273214691609147449062444103048048311110125460182718040072142853913048175773140752792910p 0.9
+ 5410352532224161682573492647304782282018498261589008998120129352032126799205384594350671273214691609147449062444103048048311110125460182718040072142853913048175773140752793600p 0.9
+ 5410352532224161682573492647304782282018498261589008998120129352032126799205384594350671273214691609147449062444103048048311110125460182718040072142853913048175773140752793610p -0.3
+ \]
V_wl_571 (WordLine\\<571\\> gnd!) vsource type=pwl wave=\[
+ 0    -0.3
+ 10820705064448323365146985294609564564036996523178017996240258704064253598410769188701342546429383218294898124888206096096622220250920365436080144285707826096351546281505586500p -0.3
+ 10820705064448323365146985294609564564036996523178017996240258704064253598410769188701342546429383218294898124888206096096622220250920365436080144285707826096351546281505586510p 0.9
+ 10820705064448323365146985294609564564036996523178017996240258704064253598410769188701342546429383218294898124888206096096622220250920365436080144285707826096351546281505587200p 0.9
+ 10820705064448323365146985294609564564036996523178017996240258704064253598410769188701342546429383218294898124888206096096622220250920365436080144285707826096351546281505587210p -0.3
+ \]
V_wl_572 (WordLine\\<572\\> gnd!) vsource type=pwl wave=\[
+ 0    -0.3
+ 21641410128896646730293970589219129128073993046356035992480517408128507196821538377402685092858766436589796249776412192193244440501840730872160288571415652192703092563011173700p -0.3
+ 21641410128896646730293970589219129128073993046356035992480517408128507196821538377402685092858766436589796249776412192193244440501840730872160288571415652192703092563011173710p 0.9
+ 21641410128896646730293970589219129128073993046356035992480517408128507196821538377402685092858766436589796249776412192193244440501840730872160288571415652192703092563011174400p 0.9
+ 21641410128896646730293970589219129128073993046356035992480517408128507196821538377402685092858766436589796249776412192193244440501840730872160288571415652192703092563011174410p -0.3
+ \]
V_wl_573 (WordLine\\<573\\> gnd!) vsource type=pwl wave=\[
+ 0    -0.3
+ 43282820257793293460587941178438258256147986092712071984961034816257014393643076754805370185717532873179592499552824384386488881003681461744320577142831304385406185126022348100p -0.3
+ 43282820257793293460587941178438258256147986092712071984961034816257014393643076754805370185717532873179592499552824384386488881003681461744320577142831304385406185126022348110p 0.9
+ 43282820257793293460587941178438258256147986092712071984961034816257014393643076754805370185717532873179592499552824384386488881003681461744320577142831304385406185126022348800p 0.9
+ 43282820257793293460587941178438258256147986092712071984961034816257014393643076754805370185717532873179592499552824384386488881003681461744320577142831304385406185126022348810p -0.3
+ \]
V_wl_574 (WordLine\\<574\\> gnd!) vsource type=pwl wave=\[
+ 0    -0.3
+ 86565640515586586921175882356876516512295972185424143969922069632514028787286153509610740371435065746359184999105648768772977762007362923488641154285662608770812370252044696900p -0.3
+ 86565640515586586921175882356876516512295972185424143969922069632514028787286153509610740371435065746359184999105648768772977762007362923488641154285662608770812370252044696910p 0.9
+ 86565640515586586921175882356876516512295972185424143969922069632514028787286153509610740371435065746359184999105648768772977762007362923488641154285662608770812370252044697600p 0.9
+ 86565640515586586921175882356876516512295972185424143969922069632514028787286153509610740371435065746359184999105648768772977762007362923488641154285662608770812370252044697610p -0.3
+ \]
V_wl_575 (WordLine\\<575\\> gnd!) vsource type=pwl wave=\[
+ 0    -0.3
+ 173131281031173173842351764713753033024591944370848287939844139265028057574572307019221480742870131492718369998211297537545955524014725846977282308571325217541624740504089394500p -0.3
+ 173131281031173173842351764713753033024591944370848287939844139265028057574572307019221480742870131492718369998211297537545955524014725846977282308571325217541624740504089394510p 0.9
+ 173131281031173173842351764713753033024591944370848287939844139265028057574572307019221480742870131492718369998211297537545955524014725846977282308571325217541624740504089395200p 0.9
+ 173131281031173173842351764713753033024591944370848287939844139265028057574572307019221480742870131492718369998211297537545955524014725846977282308571325217541624740504089395210p -0.3
+ \]
V_wl_576 (WordLine\\<576\\> gnd!) vsource type=pwl wave=\[
+ 0    -0.3
+ 346262562062346347684703529427506066049183888741696575879688278530056115149144614038442961485740262985436739996422595075091911048029451693954564617142650435083249481008178789700p -0.3
+ 346262562062346347684703529427506066049183888741696575879688278530056115149144614038442961485740262985436739996422595075091911048029451693954564617142650435083249481008178789710p 0.9
+ 346262562062346347684703529427506066049183888741696575879688278530056115149144614038442961485740262985436739996422595075091911048029451693954564617142650435083249481008178790400p 0.9
+ 346262562062346347684703529427506066049183888741696575879688278530056115149144614038442961485740262985436739996422595075091911048029451693954564617142650435083249481008178790410p -0.3
+ \]
V_wl_577 (WordLine\\<577\\> gnd!) vsource type=pwl wave=\[
+ 0    -0.3
+ 692525124124692695369407058855012132098367777483393151759376557060112230298289228076885922971480525970873479992845190150183822096058903387909129234285300870166498962016357580100p -0.3
+ 692525124124692695369407058855012132098367777483393151759376557060112230298289228076885922971480525970873479992845190150183822096058903387909129234285300870166498962016357580110p 0.9
+ 692525124124692695369407058855012132098367777483393151759376557060112230298289228076885922971480525970873479992845190150183822096058903387909129234285300870166498962016357580800p 0.9
+ 692525124124692695369407058855012132098367777483393151759376557060112230298289228076885922971480525970873479992845190150183822096058903387909129234285300870166498962016357580810p -0.3
+ \]
V_wl_578 (WordLine\\<578\\> gnd!) vsource type=pwl wave=\[
+ 0    -0.3
+ 1385050248249385390738814117710024264196735554966786303518753114120224460596578456153771845942961051941746959985690380300367644192117806775818258468570601740332997924032715160900p -0.3
+ 1385050248249385390738814117710024264196735554966786303518753114120224460596578456153771845942961051941746959985690380300367644192117806775818258468570601740332997924032715160910p 0.9
+ 1385050248249385390738814117710024264196735554966786303518753114120224460596578456153771845942961051941746959985690380300367644192117806775818258468570601740332997924032715161600p 0.9
+ 1385050248249385390738814117710024264196735554966786303518753114120224460596578456153771845942961051941746959985690380300367644192117806775818258468570601740332997924032715161610p -0.3
+ \]
V_wl_579 (WordLine\\<579\\> gnd!) vsource type=pwl wave=\[
+ 0    -0.3
+ 2770100496498770781477628235420048528393471109933572607037506228240448921193156912307543691885922103883493919971380760600735288384235613551636516937141203480665995848065430322500p -0.3
+ 2770100496498770781477628235420048528393471109933572607037506228240448921193156912307543691885922103883493919971380760600735288384235613551636516937141203480665995848065430322510p 0.9
+ 2770100496498770781477628235420048528393471109933572607037506228240448921193156912307543691885922103883493919971380760600735288384235613551636516937141203480665995848065430323200p 0.9
+ 2770100496498770781477628235420048528393471109933572607037506228240448921193156912307543691885922103883493919971380760600735288384235613551636516937141203480665995848065430323210p -0.3
+ \]
V_wl_580 (WordLine\\<580\\> gnd!) vsource type=pwl wave=\[
+ 0    -0.3
+ 5540200992997541562955256470840097056786942219867145214075012456480897842386313824615087383771844207766987839942761521201470576768471227103273033874282406961331991696130860645700p -0.3
+ 5540200992997541562955256470840097056786942219867145214075012456480897842386313824615087383771844207766987839942761521201470576768471227103273033874282406961331991696130860645710p 0.9
+ 5540200992997541562955256470840097056786942219867145214075012456480897842386313824615087383771844207766987839942761521201470576768471227103273033874282406961331991696130860646400p 0.9
+ 5540200992997541562955256470840097056786942219867145214075012456480897842386313824615087383771844207766987839942761521201470576768471227103273033874282406961331991696130860646410p -0.3
+ \]
V_wl_581 (WordLine\\<581\\> gnd!) vsource type=pwl wave=\[
+ 0    -0.3
+ 11080401985995083125910512941680194113573884439734290428150024912961795684772627649230174767543688415533975679885523042402941153536942454206546067748564813922663983392261721292100p -0.3
+ 11080401985995083125910512941680194113573884439734290428150024912961795684772627649230174767543688415533975679885523042402941153536942454206546067748564813922663983392261721292110p 0.9
+ 11080401985995083125910512941680194113573884439734290428150024912961795684772627649230174767543688415533975679885523042402941153536942454206546067748564813922663983392261721292800p 0.9
+ 11080401985995083125910512941680194113573884439734290428150024912961795684772627649230174767543688415533975679885523042402941153536942454206546067748564813922663983392261721292810p -0.3
+ \]
V_wl_582 (WordLine\\<582\\> gnd!) vsource type=pwl wave=\[
+ 0    -0.3
+ 22160803971990166251821025883360388227147768879468580856300049825923591369545255298460349535087376831067951359771046084805882307073884908413092135497129627845327966784523442584900p -0.3
+ 22160803971990166251821025883360388227147768879468580856300049825923591369545255298460349535087376831067951359771046084805882307073884908413092135497129627845327966784523442584910p 0.9
+ 22160803971990166251821025883360388227147768879468580856300049825923591369545255298460349535087376831067951359771046084805882307073884908413092135497129627845327966784523442585600p 0.9
+ 22160803971990166251821025883360388227147768879468580856300049825923591369545255298460349535087376831067951359771046084805882307073884908413092135497129627845327966784523442585610p -0.3
+ \]
V_wl_583 (WordLine\\<583\\> gnd!) vsource type=pwl wave=\[
+ 0    -0.3
+ 44321607943980332503642051766720776454295537758937161712600099651847182739090510596920699070174753662135902719542092169611764614147769816826184270994259255690655933569046885170500p -0.3
+ 44321607943980332503642051766720776454295537758937161712600099651847182739090510596920699070174753662135902719542092169611764614147769816826184270994259255690655933569046885170510p 0.9
+ 44321607943980332503642051766720776454295537758937161712600099651847182739090510596920699070174753662135902719542092169611764614147769816826184270994259255690655933569046885171200p 0.9
+ 44321607943980332503642051766720776454295537758937161712600099651847182739090510596920699070174753662135902719542092169611764614147769816826184270994259255690655933569046885171210p -0.3
+ \]
V_wl_584 (WordLine\\<584\\> gnd!) vsource type=pwl wave=\[
+ 0    -0.3
+ 88643215887960665007284103533441552908591075517874323425200199303694365478181021193841398140349507324271805439084184339223529228295539633652368541988518511381311867138093770341700p -0.3
+ 88643215887960665007284103533441552908591075517874323425200199303694365478181021193841398140349507324271805439084184339223529228295539633652368541988518511381311867138093770341710p 0.9
+ 88643215887960665007284103533441552908591075517874323425200199303694365478181021193841398140349507324271805439084184339223529228295539633652368541988518511381311867138093770342400p 0.9
+ 88643215887960665007284103533441552908591075517874323425200199303694365478181021193841398140349507324271805439084184339223529228295539633652368541988518511381311867138093770342410p -0.3
+ \]
V_wl_585 (WordLine\\<585\\> gnd!) vsource type=pwl wave=\[
+ 0    -0.3
+ 177286431775921330014568207066883105817182151035748646850400398607388730956362042387682796280699014648543610878168368678447058456591079267304737083977037022762623734276187540684100p -0.3
+ 177286431775921330014568207066883105817182151035748646850400398607388730956362042387682796280699014648543610878168368678447058456591079267304737083977037022762623734276187540684110p 0.9
+ 177286431775921330014568207066883105817182151035748646850400398607388730956362042387682796280699014648543610878168368678447058456591079267304737083977037022762623734276187540684800p 0.9
+ 177286431775921330014568207066883105817182151035748646850400398607388730956362042387682796280699014648543610878168368678447058456591079267304737083977037022762623734276187540684810p -0.3
+ \]
V_wl_586 (WordLine\\<586\\> gnd!) vsource type=pwl wave=\[
+ 0    -0.3
+ 354572863551842660029136414133766211634364302071497293700800797214777461912724084775365592561398029297087221756336737356894116913182158534609474167954074045525247468552375081368900p -0.3
+ 354572863551842660029136414133766211634364302071497293700800797214777461912724084775365592561398029297087221756336737356894116913182158534609474167954074045525247468552375081368910p 0.9
+ 354572863551842660029136414133766211634364302071497293700800797214777461912724084775365592561398029297087221756336737356894116913182158534609474167954074045525247468552375081369600p 0.9
+ 354572863551842660029136414133766211634364302071497293700800797214777461912724084775365592561398029297087221756336737356894116913182158534609474167954074045525247468552375081369610p -0.3
+ \]
V_wl_587 (WordLine\\<587\\> gnd!) vsource type=pwl wave=\[
+ 0    -0.3
+ 709145727103685320058272828267532423268728604142994587401601594429554923825448169550731185122796058594174443512673474713788233826364317069218948335908148091050494937104750162738500p -0.3
+ 709145727103685320058272828267532423268728604142994587401601594429554923825448169550731185122796058594174443512673474713788233826364317069218948335908148091050494937104750162738510p 0.9
+ 709145727103685320058272828267532423268728604142994587401601594429554923825448169550731185122796058594174443512673474713788233826364317069218948335908148091050494937104750162739200p 0.9
+ 709145727103685320058272828267532423268728604142994587401601594429554923825448169550731185122796058594174443512673474713788233826364317069218948335908148091050494937104750162739210p -0.3
+ \]
V_wl_588 (WordLine\\<588\\> gnd!) vsource type=pwl wave=\[
+ 0    -0.3
+ 1418291454207370640116545656535064846537457208285989174803203188859109847650896339101462370245592117188348887025346949427576467652728634138437896671816296182100989874209500325477700p -0.3
+ 1418291454207370640116545656535064846537457208285989174803203188859109847650896339101462370245592117188348887025346949427576467652728634138437896671816296182100989874209500325477710p 0.9
+ 1418291454207370640116545656535064846537457208285989174803203188859109847650896339101462370245592117188348887025346949427576467652728634138437896671816296182100989874209500325478400p 0.9
+ 1418291454207370640116545656535064846537457208285989174803203188859109847650896339101462370245592117188348887025346949427576467652728634138437896671816296182100989874209500325478410p -0.3
+ \]
V_wl_589 (WordLine\\<589\\> gnd!) vsource type=pwl wave=\[
+ 0    -0.3
+ 2836582908414741280233091313070129693074914416571978349606406377718219695301792678202924740491184234376697774050693898855152935305457268276875793343632592364201979748419000650956100p -0.3
+ 2836582908414741280233091313070129693074914416571978349606406377718219695301792678202924740491184234376697774050693898855152935305457268276875793343632592364201979748419000650956110p 0.9
+ 2836582908414741280233091313070129693074914416571978349606406377718219695301792678202924740491184234376697774050693898855152935305457268276875793343632592364201979748419000650956800p 0.9
+ 2836582908414741280233091313070129693074914416571978349606406377718219695301792678202924740491184234376697774050693898855152935305457268276875793343632592364201979748419000650956810p -0.3
+ \]
V_wl_590 (WordLine\\<590\\> gnd!) vsource type=pwl wave=\[
+ 0    -0.3
+ 5673165816829482560466182626140259386149828833143956699212812755436439390603585356405849480982368468753395548101387797710305870610914536553751586687265184728403959496838001301912900p -0.3
+ 5673165816829482560466182626140259386149828833143956699212812755436439390603585356405849480982368468753395548101387797710305870610914536553751586687265184728403959496838001301912910p 0.9
+ 5673165816829482560466182626140259386149828833143956699212812755436439390603585356405849480982368468753395548101387797710305870610914536553751586687265184728403959496838001301913600p 0.9
+ 5673165816829482560466182626140259386149828833143956699212812755436439390603585356405849480982368468753395548101387797710305870610914536553751586687265184728403959496838001301913610p -0.3
+ \]
V_wl_591 (WordLine\\<591\\> gnd!) vsource type=pwl wave=\[
+ 0    -0.3
+ 11346331633658965120932365252280518772299657666287913398425625510872878781207170712811698961964736937506791096202775595420611741221829073107503173374530369456807918993676002603826500p -0.3
+ 11346331633658965120932365252280518772299657666287913398425625510872878781207170712811698961964736937506791096202775595420611741221829073107503173374530369456807918993676002603826510p 0.9
+ 11346331633658965120932365252280518772299657666287913398425625510872878781207170712811698961964736937506791096202775595420611741221829073107503173374530369456807918993676002603827200p 0.9
+ 11346331633658965120932365252280518772299657666287913398425625510872878781207170712811698961964736937506791096202775595420611741221829073107503173374530369456807918993676002603827210p -0.3
+ \]
V_wl_592 (WordLine\\<592\\> gnd!) vsource type=pwl wave=\[
+ 0    -0.3
+ 22692663267317930241864730504561037544599315332575826796851251021745757562414341425623397923929473875013582192405551190841223482443658146215006346749060738913615837987352005207653700p -0.3
+ 22692663267317930241864730504561037544599315332575826796851251021745757562414341425623397923929473875013582192405551190841223482443658146215006346749060738913615837987352005207653710p 0.9
+ 22692663267317930241864730504561037544599315332575826796851251021745757562414341425623397923929473875013582192405551190841223482443658146215006346749060738913615837987352005207654400p 0.9
+ 22692663267317930241864730504561037544599315332575826796851251021745757562414341425623397923929473875013582192405551190841223482443658146215006346749060738913615837987352005207654410p -0.3
+ \]
V_wl_593 (WordLine\\<593\\> gnd!) vsource type=pwl wave=\[
+ 0    -0.3
+ 45385326534635860483729461009122075089198630665151653593702502043491515124828682851246795847858947750027164384811102381682446964887316292430012693498121477827231675974704010415308100p -0.3
+ 45385326534635860483729461009122075089198630665151653593702502043491515124828682851246795847858947750027164384811102381682446964887316292430012693498121477827231675974704010415308110p 0.9
+ 45385326534635860483729461009122075089198630665151653593702502043491515124828682851246795847858947750027164384811102381682446964887316292430012693498121477827231675974704010415308800p 0.9
+ 45385326534635860483729461009122075089198630665151653593702502043491515124828682851246795847858947750027164384811102381682446964887316292430012693498121477827231675974704010415308810p -0.3
+ \]
V_wl_594 (WordLine\\<594\\> gnd!) vsource type=pwl wave=\[
+ 0    -0.3
+ 90770653069271720967458922018244150178397261330303307187405004086983030249657365702493591695717895500054328769622204763364893929774632584860025386996242955654463351949408020830616900p -0.3
+ 90770653069271720967458922018244150178397261330303307187405004086983030249657365702493591695717895500054328769622204763364893929774632584860025386996242955654463351949408020830616910p 0.9
+ 90770653069271720967458922018244150178397261330303307187405004086983030249657365702493591695717895500054328769622204763364893929774632584860025386996242955654463351949408020830617600p 0.9
+ 90770653069271720967458922018244150178397261330303307187405004086983030249657365702493591695717895500054328769622204763364893929774632584860025386996242955654463351949408020830617610p -0.3
+ \]
V_wl_595 (WordLine\\<595\\> gnd!) vsource type=pwl wave=\[
+ 0    -0.3
+ 181541306138543441934917844036488300356794522660606614374810008173966060499314731404987183391435791000108657539244409526729787859549265169720050773992485911308926703898816041661234500p -0.3
+ 181541306138543441934917844036488300356794522660606614374810008173966060499314731404987183391435791000108657539244409526729787859549265169720050773992485911308926703898816041661234510p 0.9
+ 181541306138543441934917844036488300356794522660606614374810008173966060499314731404987183391435791000108657539244409526729787859549265169720050773992485911308926703898816041661235200p 0.9
+ 181541306138543441934917844036488300356794522660606614374810008173966060499314731404987183391435791000108657539244409526729787859549265169720050773992485911308926703898816041661235210p -0.3
+ \]
V_wl_596 (WordLine\\<596\\> gnd!) vsource type=pwl wave=\[
+ 0    -0.3
+ 363082612277086883869835688072976600713589045321213228749620016347932120998629462809974366782871582000217315078488819053459575719098530339440101547984971822617853407797632083322469700p -0.3
+ 363082612277086883869835688072976600713589045321213228749620016347932120998629462809974366782871582000217315078488819053459575719098530339440101547984971822617853407797632083322469710p 0.9
+ 363082612277086883869835688072976600713589045321213228749620016347932120998629462809974366782871582000217315078488819053459575719098530339440101547984971822617853407797632083322470400p 0.9
+ 363082612277086883869835688072976600713589045321213228749620016347932120998629462809974366782871582000217315078488819053459575719098530339440101547984971822617853407797632083322470410p -0.3
+ \]
V_wl_597 (WordLine\\<597\\> gnd!) vsource type=pwl wave=\[
+ 0    -0.3
+ 726165224554173767739671376145953201427178090642426457499240032695864241997258925619948733565743164000434630156977638106919151438197060678880203095969943645235706815595264166644940100p -0.3
+ 726165224554173767739671376145953201427178090642426457499240032695864241997258925619948733565743164000434630156977638106919151438197060678880203095969943645235706815595264166644940110p 0.9
+ 726165224554173767739671376145953201427178090642426457499240032695864241997258925619948733565743164000434630156977638106919151438197060678880203095969943645235706815595264166644940800p 0.9
+ 726165224554173767739671376145953201427178090642426457499240032695864241997258925619948733565743164000434630156977638106919151438197060678880203095969943645235706815595264166644940810p -0.3
+ \]
V_wl_598 (WordLine\\<598\\> gnd!) vsource type=pwl wave=\[
+ 0    -0.3
+ 1452330449108347535479342752291906402854356181284852914998480065391728483994517851239897467131486328000869260313955276213838302876394121357760406191939887290471413631190528333289880900p -0.3
+ 1452330449108347535479342752291906402854356181284852914998480065391728483994517851239897467131486328000869260313955276213838302876394121357760406191939887290471413631190528333289880910p 0.9
+ 1452330449108347535479342752291906402854356181284852914998480065391728483994517851239897467131486328000869260313955276213838302876394121357760406191939887290471413631190528333289881600p 0.9
+ 1452330449108347535479342752291906402854356181284852914998480065391728483994517851239897467131486328000869260313955276213838302876394121357760406191939887290471413631190528333289881610p -0.3
+ \]
V_wl_599 (WordLine\\<599\\> gnd!) vsource type=pwl wave=\[
+ 0    -0.3
+ 2904660898216695070958685504583812805708712362569705829996960130783456967989035702479794934262972656001738520627910552427676605752788242715520812383879774580942827262381056666579762500p -0.3
+ 2904660898216695070958685504583812805708712362569705829996960130783456967989035702479794934262972656001738520627910552427676605752788242715520812383879774580942827262381056666579762510p 0.9
+ 2904660898216695070958685504583812805708712362569705829996960130783456967989035702479794934262972656001738520627910552427676605752788242715520812383879774580942827262381056666579763200p 0.9
+ 2904660898216695070958685504583812805708712362569705829996960130783456967989035702479794934262972656001738520627910552427676605752788242715520812383879774580942827262381056666579763210p -0.3
+ \]
V_wl_600 (WordLine\\<600\\> gnd!) vsource type=pwl wave=\[
+ 0    -0.3
+ 5809321796433390141917371009167625611417424725139411659993920261566913935978071404959589868525945312003477041255821104855353211505576485431041624767759549161885654524762113333159525700p -0.3
+ 5809321796433390141917371009167625611417424725139411659993920261566913935978071404959589868525945312003477041255821104855353211505576485431041624767759549161885654524762113333159525710p 0.9
+ 5809321796433390141917371009167625611417424725139411659993920261566913935978071404959589868525945312003477041255821104855353211505576485431041624767759549161885654524762113333159526400p 0.9
+ 5809321796433390141917371009167625611417424725139411659993920261566913935978071404959589868525945312003477041255821104855353211505576485431041624767759549161885654524762113333159526410p -0.3
+ \]
V_wl_601 (WordLine\\<601\\> gnd!) vsource type=pwl wave=\[
+ 0    -0.3
+ 11618643592866780283834742018335251222834849450278823319987840523133827871956142809919179737051890624006954082511642209710706423011152970862083249535519098323771309049524226666319052100p -0.3
+ 11618643592866780283834742018335251222834849450278823319987840523133827871956142809919179737051890624006954082511642209710706423011152970862083249535519098323771309049524226666319052110p 0.9
+ 11618643592866780283834742018335251222834849450278823319987840523133827871956142809919179737051890624006954082511642209710706423011152970862083249535519098323771309049524226666319052800p 0.9
+ 11618643592866780283834742018335251222834849450278823319987840523133827871956142809919179737051890624006954082511642209710706423011152970862083249535519098323771309049524226666319052810p -0.3
+ \]
V_wl_602 (WordLine\\<602\\> gnd!) vsource type=pwl wave=\[
+ 0    -0.3
+ 23237287185733560567669484036670502445669698900557646639975681046267655743912285619838359474103781248013908165023284419421412846022305941724166499071038196647542618099048453332638104900p -0.3
+ 23237287185733560567669484036670502445669698900557646639975681046267655743912285619838359474103781248013908165023284419421412846022305941724166499071038196647542618099048453332638104910p 0.9
+ 23237287185733560567669484036670502445669698900557646639975681046267655743912285619838359474103781248013908165023284419421412846022305941724166499071038196647542618099048453332638105600p 0.9
+ 23237287185733560567669484036670502445669698900557646639975681046267655743912285619838359474103781248013908165023284419421412846022305941724166499071038196647542618099048453332638105610p -0.3
+ \]
V_wl_603 (WordLine\\<603\\> gnd!) vsource type=pwl wave=\[
+ 0    -0.3
+ 46474574371467121135338968073341004891339397801115293279951362092535311487824571239676718948207562496027816330046568838842825692044611883448332998142076393295085236198096906665276210500p -0.3
+ 46474574371467121135338968073341004891339397801115293279951362092535311487824571239676718948207562496027816330046568838842825692044611883448332998142076393295085236198096906665276210510p 0.9
+ 46474574371467121135338968073341004891339397801115293279951362092535311487824571239676718948207562496027816330046568838842825692044611883448332998142076393295085236198096906665276211200p 0.9
+ 46474574371467121135338968073341004891339397801115293279951362092535311487824571239676718948207562496027816330046568838842825692044611883448332998142076393295085236198096906665276211210p -0.3
+ \]
V_wl_604 (WordLine\\<604\\> gnd!) vsource type=pwl wave=\[
+ 0    -0.3
+ 92949148742934242270677936146682009782678795602230586559902724185070622975649142479353437896415124992055632660093137677685651384089223766896665996284152786590170472396193813330552421700p -0.3
+ 92949148742934242270677936146682009782678795602230586559902724185070622975649142479353437896415124992055632660093137677685651384089223766896665996284152786590170472396193813330552421710p 0.9
+ 92949148742934242270677936146682009782678795602230586559902724185070622975649142479353437896415124992055632660093137677685651384089223766896665996284152786590170472396193813330552422400p 0.9
+ 92949148742934242270677936146682009782678795602230586559902724185070622975649142479353437896415124992055632660093137677685651384089223766896665996284152786590170472396193813330552422410p -0.3
+ \]
V_wl_605 (WordLine\\<605\\> gnd!) vsource type=pwl wave=\[
+ 0    -0.3
+ 185898297485868484541355872293364019565357591204461173119805448370141245951298284958706875792830249984111265320186275355371302768178447533793331992568305573180340944792387626661104844100p -0.3
+ 185898297485868484541355872293364019565357591204461173119805448370141245951298284958706875792830249984111265320186275355371302768178447533793331992568305573180340944792387626661104844110p 0.9
+ 185898297485868484541355872293364019565357591204461173119805448370141245951298284958706875792830249984111265320186275355371302768178447533793331992568305573180340944792387626661104844800p 0.9
+ 185898297485868484541355872293364019565357591204461173119805448370141245951298284958706875792830249984111265320186275355371302768178447533793331992568305573180340944792387626661104844810p -0.3
+ \]
V_wl_606 (WordLine\\<606\\> gnd!) vsource type=pwl wave=\[
+ 0    -0.3
+ 371796594971736969082711744586728039130715182408922346239610896740282491902596569917413751585660499968222530640372550710742605536356895067586663985136611146360681889584775253322209688900p -0.3
+ 371796594971736969082711744586728039130715182408922346239610896740282491902596569917413751585660499968222530640372550710742605536356895067586663985136611146360681889584775253322209688910p 0.9
+ 371796594971736969082711744586728039130715182408922346239610896740282491902596569917413751585660499968222530640372550710742605536356895067586663985136611146360681889584775253322209689600p 0.9
+ 371796594971736969082711744586728039130715182408922346239610896740282491902596569917413751585660499968222530640372550710742605536356895067586663985136611146360681889584775253322209689610p -0.3
+ \]
V_wl_607 (WordLine\\<607\\> gnd!) vsource type=pwl wave=\[
+ 0    -0.3
+ 743593189943473938165423489173456078261430364817844692479221793480564983805193139834827503171320999936445061280745101421485211072713790135173327970273222292721363779169550506644419378500p -0.3
+ 743593189943473938165423489173456078261430364817844692479221793480564983805193139834827503171320999936445061280745101421485211072713790135173327970273222292721363779169550506644419378510p 0.9
+ 743593189943473938165423489173456078261430364817844692479221793480564983805193139834827503171320999936445061280745101421485211072713790135173327970273222292721363779169550506644419379200p 0.9
+ 743593189943473938165423489173456078261430364817844692479221793480564983805193139834827503171320999936445061280745101421485211072713790135173327970273222292721363779169550506644419379210p -0.3
+ \]
V_wl_608 (WordLine\\<608\\> gnd!) vsource type=pwl wave=\[
+ 0    -0.3
+ 1487186379886947876330846978346912156522860729635689384958443586961129967610386279669655006342641999872890122561490202842970422145427580270346655940546444585442727558339101013288838757700p -0.3
+ 1487186379886947876330846978346912156522860729635689384958443586961129967610386279669655006342641999872890122561490202842970422145427580270346655940546444585442727558339101013288838757710p 0.9
+ 1487186379886947876330846978346912156522860729635689384958443586961129967610386279669655006342641999872890122561490202842970422145427580270346655940546444585442727558339101013288838758400p 0.9
+ 1487186379886947876330846978346912156522860729635689384958443586961129967610386279669655006342641999872890122561490202842970422145427580270346655940546444585442727558339101013288838758410p -0.3
+ \]
V_wl_609 (WordLine\\<609\\> gnd!) vsource type=pwl wave=\[
+ 0    -0.3
+ 2974372759773895752661693956693824313045721459271378769916887173922259935220772559339310012685283999745780245122980405685940844290855160540693311881092889170885455116678202026577677516100p -0.3
+ 2974372759773895752661693956693824313045721459271378769916887173922259935220772559339310012685283999745780245122980405685940844290855160540693311881092889170885455116678202026577677516110p 0.9
+ 2974372759773895752661693956693824313045721459271378769916887173922259935220772559339310012685283999745780245122980405685940844290855160540693311881092889170885455116678202026577677516800p 0.9
+ 2974372759773895752661693956693824313045721459271378769916887173922259935220772559339310012685283999745780245122980405685940844290855160540693311881092889170885455116678202026577677516810p -0.3
+ \]
V_wl_610 (WordLine\\<610\\> gnd!) vsource type=pwl wave=\[
+ 0    -0.3
+ 5948745519547791505323387913387648626091442918542757539833774347844519870441545118678620025370567999491560490245960811371881688581710321081386623762185778341770910233356404053155355032900p -0.3
+ 5948745519547791505323387913387648626091442918542757539833774347844519870441545118678620025370567999491560490245960811371881688581710321081386623762185778341770910233356404053155355032910p 0.9
+ 5948745519547791505323387913387648626091442918542757539833774347844519870441545118678620025370567999491560490245960811371881688581710321081386623762185778341770910233356404053155355033600p 0.9
+ 5948745519547791505323387913387648626091442918542757539833774347844519870441545118678620025370567999491560490245960811371881688581710321081386623762185778341770910233356404053155355033610p -0.3
+ \]
V_wl_611 (WordLine\\<611\\> gnd!) vsource type=pwl wave=\[
+ 0    -0.3
+ 11897491039095583010646775826775297252182885837085515079667548695689039740883090237357240050741135998983120980491921622743763377163420642162773247524371556683541820466712808106310710066500p -0.3
+ 11897491039095583010646775826775297252182885837085515079667548695689039740883090237357240050741135998983120980491921622743763377163420642162773247524371556683541820466712808106310710066510p 0.9
+ 11897491039095583010646775826775297252182885837085515079667548695689039740883090237357240050741135998983120980491921622743763377163420642162773247524371556683541820466712808106310710067200p 0.9
+ 11897491039095583010646775826775297252182885837085515079667548695689039740883090237357240050741135998983120980491921622743763377163420642162773247524371556683541820466712808106310710067210p -0.3
+ \]
V_wl_612 (WordLine\\<612\\> gnd!) vsource type=pwl wave=\[
+ 0    -0.3
+ 23794982078191166021293551653550594504365771674171030159335097391378079481766180474714480101482271997966241960983843245487526754326841284325546495048743113367083640933425616212621420133700p -0.3
+ 23794982078191166021293551653550594504365771674171030159335097391378079481766180474714480101482271997966241960983843245487526754326841284325546495048743113367083640933425616212621420133710p 0.9
+ 23794982078191166021293551653550594504365771674171030159335097391378079481766180474714480101482271997966241960983843245487526754326841284325546495048743113367083640933425616212621420134400p 0.9
+ 23794982078191166021293551653550594504365771674171030159335097391378079481766180474714480101482271997966241960983843245487526754326841284325546495048743113367083640933425616212621420134410p -0.3
+ \]
V_wl_613 (WordLine\\<613\\> gnd!) vsource type=pwl wave=\[
+ 0    -0.3
+ 47589964156382332042587103307101189008731543348342060318670194782756158963532360949428960202964543995932483921967686490975053508653682568651092990097486226734167281866851232425242840268100p -0.3
+ 47589964156382332042587103307101189008731543348342060318670194782756158963532360949428960202964543995932483921967686490975053508653682568651092990097486226734167281866851232425242840268110p 0.9
+ 47589964156382332042587103307101189008731543348342060318670194782756158963532360949428960202964543995932483921967686490975053508653682568651092990097486226734167281866851232425242840268800p 0.9
+ 47589964156382332042587103307101189008731543348342060318670194782756158963532360949428960202964543995932483921967686490975053508653682568651092990097486226734167281866851232425242840268810p -0.3
+ \]
V_wl_614 (WordLine\\<614\\> gnd!) vsource type=pwl wave=\[
+ 0    -0.3
+ 95179928312764664085174206614202378017463086696684120637340389565512317927064721898857920405929087991864967843935372981950107017307365137302185980194972453468334563733702464850485680536900p -0.3
+ 95179928312764664085174206614202378017463086696684120637340389565512317927064721898857920405929087991864967843935372981950107017307365137302185980194972453468334563733702464850485680536910p 0.9
+ 95179928312764664085174206614202378017463086696684120637340389565512317927064721898857920405929087991864967843935372981950107017307365137302185980194972453468334563733702464850485680537600p 0.9
+ 95179928312764664085174206614202378017463086696684120637340389565512317927064721898857920405929087991864967843935372981950107017307365137302185980194972453468334563733702464850485680537610p -0.3
+ \]
V_wl_615 (WordLine\\<615\\> gnd!) vsource type=pwl wave=\[
+ 0    -0.3
+ 190359856625529328170348413228404756034926173393368241274680779131024635854129443797715840811858175983729935687870745963900214034614730274604371960389944906936669127467404929700971361074500p -0.3
+ 190359856625529328170348413228404756034926173393368241274680779131024635854129443797715840811858175983729935687870745963900214034614730274604371960389944906936669127467404929700971361074510p 0.9
+ 190359856625529328170348413228404756034926173393368241274680779131024635854129443797715840811858175983729935687870745963900214034614730274604371960389944906936669127467404929700971361075200p 0.9
+ 190359856625529328170348413228404756034926173393368241274680779131024635854129443797715840811858175983729935687870745963900214034614730274604371960389944906936669127467404929700971361075210p -0.3
+ \]
V_wl_616 (WordLine\\<616\\> gnd!) vsource type=pwl wave=\[
+ 0    -0.3
+ 380719713251058656340696826456809512069852346786736482549361558262049271708258887595431681623716351967459871375741491927800428069229460549208743920779889813873338254934809859401942722149700p -0.3
+ 380719713251058656340696826456809512069852346786736482549361558262049271708258887595431681623716351967459871375741491927800428069229460549208743920779889813873338254934809859401942722149710p 0.9
+ 380719713251058656340696826456809512069852346786736482549361558262049271708258887595431681623716351967459871375741491927800428069229460549208743920779889813873338254934809859401942722150400p 0.9
+ 380719713251058656340696826456809512069852346786736482549361558262049271708258887595431681623716351967459871375741491927800428069229460549208743920779889813873338254934809859401942722150410p -0.3
+ \]
V_wl_617 (WordLine\\<617\\> gnd!) vsource type=pwl wave=\[
+ 0    -0.3
+ 761439426502117312681393652913619024139704693573472965098723116524098543416517775190863363247432703934919742751482983855600856138458921098417487841559779627746676509869619718803885444300100p -0.3
+ 761439426502117312681393652913619024139704693573472965098723116524098543416517775190863363247432703934919742751482983855600856138458921098417487841559779627746676509869619718803885444300110p 0.9
+ 761439426502117312681393652913619024139704693573472965098723116524098543416517775190863363247432703934919742751482983855600856138458921098417487841559779627746676509869619718803885444300800p 0.9
+ 761439426502117312681393652913619024139704693573472965098723116524098543416517775190863363247432703934919742751482983855600856138458921098417487841559779627746676509869619718803885444300810p -0.3
+ \]
V_wl_618 (WordLine\\<618\\> gnd!) vsource type=pwl wave=\[
+ 0    -0.3
+ 1522878853004234625362787305827238048279409387146945930197446233048197086833035550381726726494865407869839485502965967711201712276917842196834975683119559255493353019739239437607770888600900p -0.3
+ 1522878853004234625362787305827238048279409387146945930197446233048197086833035550381726726494865407869839485502965967711201712276917842196834975683119559255493353019739239437607770888600910p 0.9
+ 1522878853004234625362787305827238048279409387146945930197446233048197086833035550381726726494865407869839485502965967711201712276917842196834975683119559255493353019739239437607770888601600p 0.9
+ 1522878853004234625362787305827238048279409387146945930197446233048197086833035550381726726494865407869839485502965967711201712276917842196834975683119559255493353019739239437607770888601610p -0.3
+ \]
V_wl_619 (WordLine\\<619\\> gnd!) vsource type=pwl wave=\[
+ 0    -0.3
+ 3045757706008469250725574611654476096558818774293891860394892466096394173666071100763453452989730815739678971005931935422403424553835684393669951366239118510986706039478478875215541777202500p -0.3
+ 3045757706008469250725574611654476096558818774293891860394892466096394173666071100763453452989730815739678971005931935422403424553835684393669951366239118510986706039478478875215541777202510p 0.9
+ 3045757706008469250725574611654476096558818774293891860394892466096394173666071100763453452989730815739678971005931935422403424553835684393669951366239118510986706039478478875215541777203200p 0.9
+ 3045757706008469250725574611654476096558818774293891860394892466096394173666071100763453452989730815739678971005931935422403424553835684393669951366239118510986706039478478875215541777203210p -0.3
+ \]
V_wl_620 (WordLine\\<620\\> gnd!) vsource type=pwl wave=\[
+ 0    -0.3
+ 6091515412016938501451149223308952193117637548587783720789784932192788347332142201526906905979461631479357942011863870844806849107671368787339902732478237021973412078956957750431083554405700p -0.3
+ 6091515412016938501451149223308952193117637548587783720789784932192788347332142201526906905979461631479357942011863870844806849107671368787339902732478237021973412078956957750431083554405710p 0.9
+ 6091515412016938501451149223308952193117637548587783720789784932192788347332142201526906905979461631479357942011863870844806849107671368787339902732478237021973412078956957750431083554406400p 0.9
+ 6091515412016938501451149223308952193117637548587783720789784932192788347332142201526906905979461631479357942011863870844806849107671368787339902732478237021973412078956957750431083554406410p -0.3
+ \]
V_wl_621 (WordLine\\<621\\> gnd!) vsource type=pwl wave=\[
+ 0    -0.3
+ 12183030824033877002902298446617904386235275097175567441579569864385576694664284403053813811958923262958715884023727741689613698215342737574679805464956474043946824157913915500862167108812100p -0.3
+ 12183030824033877002902298446617904386235275097175567441579569864385576694664284403053813811958923262958715884023727741689613698215342737574679805464956474043946824157913915500862167108812110p 0.9
+ 12183030824033877002902298446617904386235275097175567441579569864385576694664284403053813811958923262958715884023727741689613698215342737574679805464956474043946824157913915500862167108812800p 0.9
+ 12183030824033877002902298446617904386235275097175567441579569864385576694664284403053813811958923262958715884023727741689613698215342737574679805464956474043946824157913915500862167108812810p -0.3
+ \]
V_wl_622 (WordLine\\<622\\> gnd!) vsource type=pwl wave=\[
+ 0    -0.3
+ 24366061648067754005804596893235808772470550194351134883159139728771153389328568806107627623917846525917431768047455483379227396430685475149359610929912948087893648315827831001724334217624900p -0.3
+ 24366061648067754005804596893235808772470550194351134883159139728771153389328568806107627623917846525917431768047455483379227396430685475149359610929912948087893648315827831001724334217624910p 0.9
+ 24366061648067754005804596893235808772470550194351134883159139728771153389328568806107627623917846525917431768047455483379227396430685475149359610929912948087893648315827831001724334217625600p 0.9
+ 24366061648067754005804596893235808772470550194351134883159139728771153389328568806107627623917846525917431768047455483379227396430685475149359610929912948087893648315827831001724334217625610p -0.3
+ \]
V_wl_623 (WordLine\\<623\\> gnd!) vsource type=pwl wave=\[
+ 0    -0.3
+ 48732123296135508011609193786471617544941100388702269766318279457542306778657137612215255247835693051834863536094910966758454792861370950298719221859825896175787296631655662003448668435250500p -0.3
+ 48732123296135508011609193786471617544941100388702269766318279457542306778657137612215255247835693051834863536094910966758454792861370950298719221859825896175787296631655662003448668435250510p 0.9
+ 48732123296135508011609193786471617544941100388702269766318279457542306778657137612215255247835693051834863536094910966758454792861370950298719221859825896175787296631655662003448668435251200p 0.9
+ 48732123296135508011609193786471617544941100388702269766318279457542306778657137612215255247835693051834863536094910966758454792861370950298719221859825896175787296631655662003448668435251210p -0.3
+ \]
V_wl_624 (WordLine\\<624\\> gnd!) vsource type=pwl wave=\[
+ 0    -0.3
+ 97464246592271016023218387572943235089882200777404539532636558915084613557314275224430510495671386103669727072189821933516909585722741900597438443719651792351574593263311324006897336870501700p -0.3
+ 97464246592271016023218387572943235089882200777404539532636558915084613557314275224430510495671386103669727072189821933516909585722741900597438443719651792351574593263311324006897336870501710p 0.9
+ 97464246592271016023218387572943235089882200777404539532636558915084613557314275224430510495671386103669727072189821933516909585722741900597438443719651792351574593263311324006897336870502400p 0.9
+ 97464246592271016023218387572943235089882200777404539532636558915084613557314275224430510495671386103669727072189821933516909585722741900597438443719651792351574593263311324006897336870502410p -0.3
+ \]
V_wl_625 (WordLine\\<625\\> gnd!) vsource type=pwl wave=\[
+ 0    -0.3
+ 194928493184542032046436775145886470179764401554809079065273117830169227114628550448861020991342772207339454144379643867033819171445483801194876887439303584703149186526622648013794673741004100p -0.3
+ 194928493184542032046436775145886470179764401554809079065273117830169227114628550448861020991342772207339454144379643867033819171445483801194876887439303584703149186526622648013794673741004110p 0.9
+ 194928493184542032046436775145886470179764401554809079065273117830169227114628550448861020991342772207339454144379643867033819171445483801194876887439303584703149186526622648013794673741004800p 0.9
+ 194928493184542032046436775145886470179764401554809079065273117830169227114628550448861020991342772207339454144379643867033819171445483801194876887439303584703149186526622648013794673741004810p -0.3
+ \]
V_wl_626 (WordLine\\<626\\> gnd!) vsource type=pwl wave=\[
+ 0    -0.3
+ 389856986369084064092873550291772940359528803109618158130546235660338454229257100897722041982685544414678908288759287734067638342890967602389753774878607169406298373053245296027589347482008900p -0.3
+ 389856986369084064092873550291772940359528803109618158130546235660338454229257100897722041982685544414678908288759287734067638342890967602389753774878607169406298373053245296027589347482008910p 0.9
+ 389856986369084064092873550291772940359528803109618158130546235660338454229257100897722041982685544414678908288759287734067638342890967602389753774878607169406298373053245296027589347482009600p 0.9
+ 389856986369084064092873550291772940359528803109618158130546235660338454229257100897722041982685544414678908288759287734067638342890967602389753774878607169406298373053245296027589347482009610p -0.3
+ \]
V_wl_627 (WordLine\\<627\\> gnd!) vsource type=pwl wave=\[
+ 0    -0.3
+ 779713972738168128185747100583545880719057606219236316261092471320676908458514201795444083965371088829357816577518575468135276685781935204779507549757214338812596746106490592055178694964018500p -0.3
+ 779713972738168128185747100583545880719057606219236316261092471320676908458514201795444083965371088829357816577518575468135276685781935204779507549757214338812596746106490592055178694964018510p 0.9
+ 779713972738168128185747100583545880719057606219236316261092471320676908458514201795444083965371088829357816577518575468135276685781935204779507549757214338812596746106490592055178694964019200p 0.9
+ 779713972738168128185747100583545880719057606219236316261092471320676908458514201795444083965371088829357816577518575468135276685781935204779507549757214338812596746106490592055178694964019210p -0.3
+ \]
V_wl_628 (WordLine\\<628\\> gnd!) vsource type=pwl wave=\[
+ 0    -0.3
+ 1559427945476336256371494201167091761438115212438472632522184942641353816917028403590888167930742177658715633155037150936270553371563870409559015099514428677625193492212981184110357389928037700p -0.3
+ 1559427945476336256371494201167091761438115212438472632522184942641353816917028403590888167930742177658715633155037150936270553371563870409559015099514428677625193492212981184110357389928037710p 0.9
+ 1559427945476336256371494201167091761438115212438472632522184942641353816917028403590888167930742177658715633155037150936270553371563870409559015099514428677625193492212981184110357389928038400p 0.9
+ 1559427945476336256371494201167091761438115212438472632522184942641353816917028403590888167930742177658715633155037150936270553371563870409559015099514428677625193492212981184110357389928038410p -0.3
+ \]
V_wl_629 (WordLine\\<629\\> gnd!) vsource type=pwl wave=\[
+ 0    -0.3
+ 3118855890952672512742988402334183522876230424876945265044369885282707633834056807181776335861484355317431266310074301872541106743127740819118030199028857355250386984425962368220714779856076100p -0.3
+ 3118855890952672512742988402334183522876230424876945265044369885282707633834056807181776335861484355317431266310074301872541106743127740819118030199028857355250386984425962368220714779856076110p 0.9
+ 3118855890952672512742988402334183522876230424876945265044369885282707633834056807181776335861484355317431266310074301872541106743127740819118030199028857355250386984425962368220714779856076800p 0.9
+ 3118855890952672512742988402334183522876230424876945265044369885282707633834056807181776335861484355317431266310074301872541106743127740819118030199028857355250386984425962368220714779856076810p -0.3
+ \]
V_wl_630 (WordLine\\<630\\> gnd!) vsource type=pwl wave=\[
+ 0    -0.3
+ 6237711781905345025485976804668367045752460849753890530088739770565415267668113614363552671722968710634862532620148603745082213486255481638236060398057714710500773968851924736441429559712152900p -0.3
+ 6237711781905345025485976804668367045752460849753890530088739770565415267668113614363552671722968710634862532620148603745082213486255481638236060398057714710500773968851924736441429559712152910p 0.9
+ 6237711781905345025485976804668367045752460849753890530088739770565415267668113614363552671722968710634862532620148603745082213486255481638236060398057714710500773968851924736441429559712153600p 0.9
+ 6237711781905345025485976804668367045752460849753890530088739770565415267668113614363552671722968710634862532620148603745082213486255481638236060398057714710500773968851924736441429559712153610p -0.3
+ \]
V_wl_631 (WordLine\\<631\\> gnd!) vsource type=pwl wave=\[
+ 0    -0.3
+ 12475423563810690050971953609336734091504921699507781060177479541130830535336227228727105343445937421269725065240297207490164426972510963276472120796115429421001547937703849472882859119424306500p -0.3
+ 12475423563810690050971953609336734091504921699507781060177479541130830535336227228727105343445937421269725065240297207490164426972510963276472120796115429421001547937703849472882859119424306510p 0.9
+ 12475423563810690050971953609336734091504921699507781060177479541130830535336227228727105343445937421269725065240297207490164426972510963276472120796115429421001547937703849472882859119424307200p 0.9
+ 12475423563810690050971953609336734091504921699507781060177479541130830535336227228727105343445937421269725065240297207490164426972510963276472120796115429421001547937703849472882859119424307210p -0.3
+ \]
V_wl_632 (WordLine\\<632\\> gnd!) vsource type=pwl wave=\[
+ 0    -0.3
+ 24950847127621380101943907218673468183009843399015562120354959082261661070672454457454210686891874842539450130480594414980328853945021926552944241592230858842003095875407698945765718238848613700p -0.3
+ 24950847127621380101943907218673468183009843399015562120354959082261661070672454457454210686891874842539450130480594414980328853945021926552944241592230858842003095875407698945765718238848613710p 0.9
+ 24950847127621380101943907218673468183009843399015562120354959082261661070672454457454210686891874842539450130480594414980328853945021926552944241592230858842003095875407698945765718238848614400p 0.9
+ 24950847127621380101943907218673468183009843399015562120354959082261661070672454457454210686891874842539450130480594414980328853945021926552944241592230858842003095875407698945765718238848614410p -0.3
+ \]
V_wl_633 (WordLine\\<633\\> gnd!) vsource type=pwl wave=\[
+ 0    -0.3
+ 49901694255242760203887814437346936366019686798031124240709918164523322141344908914908421373783749685078900260961188829960657707890043853105888483184461717684006191750815397891531436477697228100p -0.3
+ 49901694255242760203887814437346936366019686798031124240709918164523322141344908914908421373783749685078900260961188829960657707890043853105888483184461717684006191750815397891531436477697228110p 0.9
+ 49901694255242760203887814437346936366019686798031124240709918164523322141344908914908421373783749685078900260961188829960657707890043853105888483184461717684006191750815397891531436477697228800p 0.9
+ 49901694255242760203887814437346936366019686798031124240709918164523322141344908914908421373783749685078900260961188829960657707890043853105888483184461717684006191750815397891531436477697228810p -0.3
+ \]
V_wl_634 (WordLine\\<634\\> gnd!) vsource type=pwl wave=\[
+ 0    -0.3
+ 99803388510485520407775628874693872732039373596062248481419836329046644282689817829816842747567499370157800521922377659921315415780087706211776966368923435368012383501630795783062872955394456900p -0.3
+ 99803388510485520407775628874693872732039373596062248481419836329046644282689817829816842747567499370157800521922377659921315415780087706211776966368923435368012383501630795783062872955394456910p 0.9
+ 99803388510485520407775628874693872732039373596062248481419836329046644282689817829816842747567499370157800521922377659921315415780087706211776966368923435368012383501630795783062872955394457600p 0.9
+ 99803388510485520407775628874693872732039373596062248481419836329046644282689817829816842747567499370157800521922377659921315415780087706211776966368923435368012383501630795783062872955394457610p -0.3
+ \]
V_wl_635 (WordLine\\<635\\> gnd!) vsource type=pwl wave=\[
+ 0    -0.3
+ 199606777020971040815551257749387745464078747192124496962839672658093288565379635659633685495134998740315601043844755319842630831560175412423553932737846870736024767003261591566125745910788914500p -0.3
+ 199606777020971040815551257749387745464078747192124496962839672658093288565379635659633685495134998740315601043844755319842630831560175412423553932737846870736024767003261591566125745910788914510p 0.9
+ 199606777020971040815551257749387745464078747192124496962839672658093288565379635659633685495134998740315601043844755319842630831560175412423553932737846870736024767003261591566125745910788915200p 0.9
+ 199606777020971040815551257749387745464078747192124496962839672658093288565379635659633685495134998740315601043844755319842630831560175412423553932737846870736024767003261591566125745910788915210p -0.3
+ \]
V_wl_636 (WordLine\\<636\\> gnd!) vsource type=pwl wave=\[
+ 0    -0.3
+ 399213554041942081631102515498775490928157494384248993925679345316186577130759271319267370990269997480631202087689510639685261663120350824847107865475693741472049534006523183132251491821577829700p -0.3
+ 399213554041942081631102515498775490928157494384248993925679345316186577130759271319267370990269997480631202087689510639685261663120350824847107865475693741472049534006523183132251491821577829710p 0.9
+ 399213554041942081631102515498775490928157494384248993925679345316186577130759271319267370990269997480631202087689510639685261663120350824847107865475693741472049534006523183132251491821577830400p 0.9
+ 399213554041942081631102515498775490928157494384248993925679345316186577130759271319267370990269997480631202087689510639685261663120350824847107865475693741472049534006523183132251491821577830410p -0.3
+ \]
V_wl_637 (WordLine\\<637\\> gnd!) vsource type=pwl wave=\[
+ 0    -0.3
+ 798427108083884163262205030997550981856314988768497987851358690632373154261518542638534741980539994961262404175379021279370523326240701649694215730951387482944099068013046366264502983643155660100p -0.3
+ 798427108083884163262205030997550981856314988768497987851358690632373154261518542638534741980539994961262404175379021279370523326240701649694215730951387482944099068013046366264502983643155660110p 0.9
+ 798427108083884163262205030997550981856314988768497987851358690632373154261518542638534741980539994961262404175379021279370523326240701649694215730951387482944099068013046366264502983643155660800p 0.9
+ 798427108083884163262205030997550981856314988768497987851358690632373154261518542638534741980539994961262404175379021279370523326240701649694215730951387482944099068013046366264502983643155660810p -0.3
+ \]
V_wl_638 (WordLine\\<638\\> gnd!) vsource type=pwl wave=\[
+ 0    -0.3
+ 1596854216167768326524410061995101963712629977536995975702717381264746308523037085277069483961079989922524808350758042558741046652481403299388431461902774965888198136026092732529005967286311320900p -0.3
+ 1596854216167768326524410061995101963712629977536995975702717381264746308523037085277069483961079989922524808350758042558741046652481403299388431461902774965888198136026092732529005967286311320910p 0.9
+ 1596854216167768326524410061995101963712629977536995975702717381264746308523037085277069483961079989922524808350758042558741046652481403299388431461902774965888198136026092732529005967286311321600p 0.9
+ 1596854216167768326524410061995101963712629977536995975702717381264746308523037085277069483961079989922524808350758042558741046652481403299388431461902774965888198136026092732529005967286311321610p -0.3
+ \]
V_wl_639 (WordLine\\<639\\> gnd!) vsource type=pwl wave=\[
+ 0    -0.3
+ 3193708432335536653048820123990203927425259955073991951405434762529492617046074170554138967922159979845049616701516085117482093304962806598776862923805549931776396272052185465058011934572622642500p -0.3
+ 3193708432335536653048820123990203927425259955073991951405434762529492617046074170554138967922159979845049616701516085117482093304962806598776862923805549931776396272052185465058011934572622642510p 0.9
+ 3193708432335536653048820123990203927425259955073991951405434762529492617046074170554138967922159979845049616701516085117482093304962806598776862923805549931776396272052185465058011934572622643200p 0.9
+ 3193708432335536653048820123990203927425259955073991951405434762529492617046074170554138967922159979845049616701516085117482093304962806598776862923805549931776396272052185465058011934572622643210p -0.3
+ \]
V_wl_640 (WordLine\\<640\\> gnd!) vsource type=pwl wave=\[
+ 0    -0.3
+ 6387416864671073306097640247980407854850519910147983902810869525058985234092148341108277935844319959690099233403032170234964186609925613197553725847611099863552792544104370930116023869145245285700p -0.3
+ 6387416864671073306097640247980407854850519910147983902810869525058985234092148341108277935844319959690099233403032170234964186609925613197553725847611099863552792544104370930116023869145245285710p 0.9
+ 6387416864671073306097640247980407854850519910147983902810869525058985234092148341108277935844319959690099233403032170234964186609925613197553725847611099863552792544104370930116023869145245286400p 0.9
+ 6387416864671073306097640247980407854850519910147983902810869525058985234092148341108277935844319959690099233403032170234964186609925613197553725847611099863552792544104370930116023869145245286410p -0.3
+ \]
V_wl_641 (WordLine\\<641\\> gnd!) vsource type=pwl wave=\[
+ 0    -0.3
+ 12774833729342146612195280495960815709701039820295967805621739050117970468184296682216555871688639919380198466806064340469928373219851226395107451695222199727105585088208741860232047738290490572100p -0.3
+ 12774833729342146612195280495960815709701039820295967805621739050117970468184296682216555871688639919380198466806064340469928373219851226395107451695222199727105585088208741860232047738290490572110p 0.9
+ 12774833729342146612195280495960815709701039820295967805621739050117970468184296682216555871688639919380198466806064340469928373219851226395107451695222199727105585088208741860232047738290490572800p 0.9
+ 12774833729342146612195280495960815709701039820295967805621739050117970468184296682216555871688639919380198466806064340469928373219851226395107451695222199727105585088208741860232047738290490572810p -0.3
+ \]
V_wl_642 (WordLine\\<642\\> gnd!) vsource type=pwl wave=\[
+ 0    -0.3
+ 25549667458684293224390560991921631419402079640591935611243478100235940936368593364433111743377279838760396933612128680939856746439702452790214903390444399454211170176417483720464095476580981144900p -0.3
+ 25549667458684293224390560991921631419402079640591935611243478100235940936368593364433111743377279838760396933612128680939856746439702452790214903390444399454211170176417483720464095476580981144910p 0.9
+ 25549667458684293224390560991921631419402079640591935611243478100235940936368593364433111743377279838760396933612128680939856746439702452790214903390444399454211170176417483720464095476580981145600p 0.9
+ 25549667458684293224390560991921631419402079640591935611243478100235940936368593364433111743377279838760396933612128680939856746439702452790214903390444399454211170176417483720464095476580981145610p -0.3
+ \]
V_wl_643 (WordLine\\<643\\> gnd!) vsource type=pwl wave=\[
+ 0    -0.3
+ 51099334917368586448781121983843262838804159281183871222486956200471881872737186728866223486754559677520793867224257361879713492879404905580429806780888798908422340352834967440928190953161962290500p -0.3
+ 51099334917368586448781121983843262838804159281183871222486956200471881872737186728866223486754559677520793867224257361879713492879404905580429806780888798908422340352834967440928190953161962290510p 0.9
+ 51099334917368586448781121983843262838804159281183871222486956200471881872737186728866223486754559677520793867224257361879713492879404905580429806780888798908422340352834967440928190953161962291200p 0.9
+ 51099334917368586448781121983843262838804159281183871222486956200471881872737186728866223486754559677520793867224257361879713492879404905580429806780888798908422340352834967440928190953161962291210p -0.3
+ \]
V_wl_644 (WordLine\\<644\\> gnd!) vsource type=pwl wave=\[
+ 0    -0.3
+ 102198669834737172897562243967686525677608318562367742444973912400943763745474373457732446973509119355041587734448514723759426985758809811160859613561777597816844680705669934881856381906323924581700p -0.3
+ 102198669834737172897562243967686525677608318562367742444973912400943763745474373457732446973509119355041587734448514723759426985758809811160859613561777597816844680705669934881856381906323924581710p 0.9
+ 102198669834737172897562243967686525677608318562367742444973912400943763745474373457732446973509119355041587734448514723759426985758809811160859613561777597816844680705669934881856381906323924582400p 0.9
+ 102198669834737172897562243967686525677608318562367742444973912400943763745474373457732446973509119355041587734448514723759426985758809811160859613561777597816844680705669934881856381906323924582410p -0.3
+ \]
V_wl_645 (WordLine\\<645\\> gnd!) vsource type=pwl wave=\[
+ 0    -0.3
+ 204397339669474345795124487935373051355216637124735484889947824801887527490948746915464893947018238710083175468897029447518853971517619622321719227123555195633689361411339869763712763812647849164100p -0.3
+ 204397339669474345795124487935373051355216637124735484889947824801887527490948746915464893947018238710083175468897029447518853971517619622321719227123555195633689361411339869763712763812647849164110p 0.9
+ 204397339669474345795124487935373051355216637124735484889947824801887527490948746915464893947018238710083175468897029447518853971517619622321719227123555195633689361411339869763712763812647849164800p 0.9
+ 204397339669474345795124487935373051355216637124735484889947824801887527490948746915464893947018238710083175468897029447518853971517619622321719227123555195633689361411339869763712763812647849164810p -0.3
+ \]
V_wl_646 (WordLine\\<646\\> gnd!) vsource type=pwl wave=\[
+ 0    -0.3
+ 408794679338948691590248975870746102710433274249470969779895649603775054981897493830929787894036477420166350937794058895037707943035239244643438454247110391267378722822679739527425527625295698328900p -0.3
+ 408794679338948691590248975870746102710433274249470969779895649603775054981897493830929787894036477420166350937794058895037707943035239244643438454247110391267378722822679739527425527625295698328910p 0.9
+ 408794679338948691590248975870746102710433274249470969779895649603775054981897493830929787894036477420166350937794058895037707943035239244643438454247110391267378722822679739527425527625295698329600p 0.9
+ 408794679338948691590248975870746102710433274249470969779895649603775054981897493830929787894036477420166350937794058895037707943035239244643438454247110391267378722822679739527425527625295698329610p -0.3
+ \]
V_wl_647 (WordLine\\<647\\> gnd!) vsource type=pwl wave=\[
+ 0    -0.3
+ 817589358677897383180497951741492205420866548498941939559791299207550109963794987661859575788072954840332701875588117790075415886070478489286876908494220782534757445645359479054851055250591396658500p -0.3
+ 817589358677897383180497951741492205420866548498941939559791299207550109963794987661859575788072954840332701875588117790075415886070478489286876908494220782534757445645359479054851055250591396658510p 0.9
+ 817589358677897383180497951741492205420866548498941939559791299207550109963794987661859575788072954840332701875588117790075415886070478489286876908494220782534757445645359479054851055250591396659200p 0.9
+ 817589358677897383180497951741492205420866548498941939559791299207550109963794987661859575788072954840332701875588117790075415886070478489286876908494220782534757445645359479054851055250591396659210p -0.3
+ \]
V_wl_648 (WordLine\\<648\\> gnd!) vsource type=pwl wave=\[
+ 0    -0.3
+ 1635178717355794766360995903482984410841733096997883879119582598415100219927589975323719151576145909680665403751176235580150831772140956978573753816988441565069514891290718958109702110501182793317700p -0.3
+ 1635178717355794766360995903482984410841733096997883879119582598415100219927589975323719151576145909680665403751176235580150831772140956978573753816988441565069514891290718958109702110501182793317710p 0.9
+ 1635178717355794766360995903482984410841733096997883879119582598415100219927589975323719151576145909680665403751176235580150831772140956978573753816988441565069514891290718958109702110501182793318400p 0.9
+ 1635178717355794766360995903482984410841733096997883879119582598415100219927589975323719151576145909680665403751176235580150831772140956978573753816988441565069514891290718958109702110501182793318410p -0.3
+ \]
V_wl_649 (WordLine\\<649\\> gnd!) vsource type=pwl wave=\[
+ 0    -0.3
+ 3270357434711589532721991806965968821683466193995767758239165196830200439855179950647438303152291819361330807502352471160301663544281913957147507633976883130139029782581437916219404221002365586636100p -0.3
+ 3270357434711589532721991806965968821683466193995767758239165196830200439855179950647438303152291819361330807502352471160301663544281913957147507633976883130139029782581437916219404221002365586636110p 0.9
+ 3270357434711589532721991806965968821683466193995767758239165196830200439855179950647438303152291819361330807502352471160301663544281913957147507633976883130139029782581437916219404221002365586636800p 0.9
+ 3270357434711589532721991806965968821683466193995767758239165196830200439855179950647438303152291819361330807502352471160301663544281913957147507633976883130139029782581437916219404221002365586636810p -0.3
+ \]
V_wl_650 (WordLine\\<650\\> gnd!) vsource type=pwl wave=\[
+ 0    -0.3
+ 6540714869423179065443983613931937643366932387991535516478330393660400879710359901294876606304583638722661615004704942320603327088563827914295015267953766260278059565162875832438808442004731173272900p -0.3
+ 6540714869423179065443983613931937643366932387991535516478330393660400879710359901294876606304583638722661615004704942320603327088563827914295015267953766260278059565162875832438808442004731173272910p 0.9
+ 6540714869423179065443983613931937643366932387991535516478330393660400879710359901294876606304583638722661615004704942320603327088563827914295015267953766260278059565162875832438808442004731173273600p 0.9
+ 6540714869423179065443983613931937643366932387991535516478330393660400879710359901294876606304583638722661615004704942320603327088563827914295015267953766260278059565162875832438808442004731173273610p -0.3
+ \]
V_wl_651 (WordLine\\<651\\> gnd!) vsource type=pwl wave=\[
+ 0    -0.3
+ 13081429738846358130887967227863875286733864775983071032956660787320801759420719802589753212609167277445323230009409884641206654177127655828590030535907532520556119130325751664877616884009462346546500p -0.3
+ 13081429738846358130887967227863875286733864775983071032956660787320801759420719802589753212609167277445323230009409884641206654177127655828590030535907532520556119130325751664877616884009462346546510p 0.9
+ 13081429738846358130887967227863875286733864775983071032956660787320801759420719802589753212609167277445323230009409884641206654177127655828590030535907532520556119130325751664877616884009462346547200p 0.9
+ 13081429738846358130887967227863875286733864775983071032956660787320801759420719802589753212609167277445323230009409884641206654177127655828590030535907532520556119130325751664877616884009462346547210p -0.3
+ \]
V_wl_652 (WordLine\\<652\\> gnd!) vsource type=pwl wave=\[
+ 0    -0.3
+ 26162859477692716261775934455727750573467729551966142065913321574641603518841439605179506425218334554890646460018819769282413308354255311657180061071815065041112238260651503329755233768018924693093700p -0.3
+ 26162859477692716261775934455727750573467729551966142065913321574641603518841439605179506425218334554890646460018819769282413308354255311657180061071815065041112238260651503329755233768018924693093710p 0.9
+ 26162859477692716261775934455727750573467729551966142065913321574641603518841439605179506425218334554890646460018819769282413308354255311657180061071815065041112238260651503329755233768018924693094400p 0.9
+ 26162859477692716261775934455727750573467729551966142065913321574641603518841439605179506425218334554890646460018819769282413308354255311657180061071815065041112238260651503329755233768018924693094410p -0.3
+ \]
V_wl_653 (WordLine\\<653\\> gnd!) vsource type=pwl wave=\[
+ 0    -0.3
+ 52325718955385432523551868911455501146935459103932284131826643149283207037682879210359012850436669109781292920037639538564826616708510623314360122143630130082224476521303006659510467536037849386188100p -0.3
+ 52325718955385432523551868911455501146935459103932284131826643149283207037682879210359012850436669109781292920037639538564826616708510623314360122143630130082224476521303006659510467536037849386188110p 0.9
+ 52325718955385432523551868911455501146935459103932284131826643149283207037682879210359012850436669109781292920037639538564826616708510623314360122143630130082224476521303006659510467536037849386188800p 0.9
+ 52325718955385432523551868911455501146935459103932284131826643149283207037682879210359012850436669109781292920037639538564826616708510623314360122143630130082224476521303006659510467536037849386188810p -0.3
+ \]
V_wl_654 (WordLine\\<654\\> gnd!) vsource type=pwl wave=\[
+ 0    -0.3
+ 104651437910770865047103737822911002293870918207864568263653286298566414075365758420718025700873338219562585840075279077129653233417021246628720244287260260164448953042606013319020935072075698772376900p -0.3
+ 104651437910770865047103737822911002293870918207864568263653286298566414075365758420718025700873338219562585840075279077129653233417021246628720244287260260164448953042606013319020935072075698772376910p 0.9
+ 104651437910770865047103737822911002293870918207864568263653286298566414075365758420718025700873338219562585840075279077129653233417021246628720244287260260164448953042606013319020935072075698772377600p 0.9
+ 104651437910770865047103737822911002293870918207864568263653286298566414075365758420718025700873338219562585840075279077129653233417021246628720244287260260164448953042606013319020935072075698772377610p -0.3
+ \]
V_wl_655 (WordLine\\<655\\> gnd!) vsource type=pwl wave=\[
+ 0    -0.3
+ 209302875821541730094207475645822004587741836415729136527306572597132828150731516841436051401746676439125171680150558154259306466834042493257440488574520520328897906085212026638041870144151397544754500p -0.3
+ 209302875821541730094207475645822004587741836415729136527306572597132828150731516841436051401746676439125171680150558154259306466834042493257440488574520520328897906085212026638041870144151397544754510p 0.9
+ 209302875821541730094207475645822004587741836415729136527306572597132828150731516841436051401746676439125171680150558154259306466834042493257440488574520520328897906085212026638041870144151397544755200p 0.9
+ 209302875821541730094207475645822004587741836415729136527306572597132828150731516841436051401746676439125171680150558154259306466834042493257440488574520520328897906085212026638041870144151397544755210p -0.3
+ \]
V_wl_656 (WordLine\\<656\\> gnd!) vsource type=pwl wave=\[
+ 0    -0.3
+ 418605751643083460188414951291644009175483672831458273054613145194265656301463033682872102803493352878250343360301116308518612933668084986514880977149041040657795812170424053276083740288302795089509700p -0.3
+ 418605751643083460188414951291644009175483672831458273054613145194265656301463033682872102803493352878250343360301116308518612933668084986514880977149041040657795812170424053276083740288302795089509710p 0.9
+ 418605751643083460188414951291644009175483672831458273054613145194265656301463033682872102803493352878250343360301116308518612933668084986514880977149041040657795812170424053276083740288302795089510400p 0.9
+ 418605751643083460188414951291644009175483672831458273054613145194265656301463033682872102803493352878250343360301116308518612933668084986514880977149041040657795812170424053276083740288302795089510410p -0.3
+ \]
V_wl_657 (WordLine\\<657\\> gnd!) vsource type=pwl wave=\[
+ 0    -0.3
+ 837211503286166920376829902583288018350967345662916546109226290388531312602926067365744205606986705756500686720602232617037225867336169973029761954298082081315591624340848106552167480576605590179020100p -0.3
+ 837211503286166920376829902583288018350967345662916546109226290388531312602926067365744205606986705756500686720602232617037225867336169973029761954298082081315591624340848106552167480576605590179020110p 0.9
+ 837211503286166920376829902583288018350967345662916546109226290388531312602926067365744205606986705756500686720602232617037225867336169973029761954298082081315591624340848106552167480576605590179020800p 0.9
+ 837211503286166920376829902583288018350967345662916546109226290388531312602926067365744205606986705756500686720602232617037225867336169973029761954298082081315591624340848106552167480576605590179020810p -0.3
+ \]
V_wl_658 (WordLine\\<658\\> gnd!) vsource type=pwl wave=\[
+ 0    -0.3
+ 1674423006572333840753659805166576036701934691325833092218452580777062625205852134731488411213973411513001373441204465234074451734672339946059523908596164162631183248681696213104334961153211180358040900p -0.3
+ 1674423006572333840753659805166576036701934691325833092218452580777062625205852134731488411213973411513001373441204465234074451734672339946059523908596164162631183248681696213104334961153211180358040910p 0.9
+ 1674423006572333840753659805166576036701934691325833092218452580777062625205852134731488411213973411513001373441204465234074451734672339946059523908596164162631183248681696213104334961153211180358041600p 0.9
+ 1674423006572333840753659805166576036701934691325833092218452580777062625205852134731488411213973411513001373441204465234074451734672339946059523908596164162631183248681696213104334961153211180358041610p -0.3
+ \]
V_wl_659 (WordLine\\<659\\> gnd!) vsource type=pwl wave=\[
+ 0    -0.3
+ 3348846013144667681507319610333152073403869382651666184436905161554125250411704269462976822427946823026002746882408930468148903469344679892119047817192328325262366497363392426208669922306422360716082500p -0.3
+ 3348846013144667681507319610333152073403869382651666184436905161554125250411704269462976822427946823026002746882408930468148903469344679892119047817192328325262366497363392426208669922306422360716082510p 0.9
+ 3348846013144667681507319610333152073403869382651666184436905161554125250411704269462976822427946823026002746882408930468148903469344679892119047817192328325262366497363392426208669922306422360716083200p 0.9
+ 3348846013144667681507319610333152073403869382651666184436905161554125250411704269462976822427946823026002746882408930468148903469344679892119047817192328325262366497363392426208669922306422360716083210p -0.3
+ \]
V_wl_660 (WordLine\\<660\\> gnd!) vsource type=pwl wave=\[
+ 0    -0.3
+ 6697692026289335363014639220666304146807738765303332368873810323108250500823408538925953644855893646052005493764817860936297806938689359784238095634384656650524732994726784852417339844612844721432165700p -0.3
+ 6697692026289335363014639220666304146807738765303332368873810323108250500823408538925953644855893646052005493764817860936297806938689359784238095634384656650524732994726784852417339844612844721432165710p 0.9
+ 6697692026289335363014639220666304146807738765303332368873810323108250500823408538925953644855893646052005493764817860936297806938689359784238095634384656650524732994726784852417339844612844721432166400p 0.9
+ 6697692026289335363014639220666304146807738765303332368873810323108250500823408538925953644855893646052005493764817860936297806938689359784238095634384656650524732994726784852417339844612844721432166410p -0.3
+ \]
V_wl_661 (WordLine\\<661\\> gnd!) vsource type=pwl wave=\[
+ 0    -0.3
+ 13395384052578670726029278441332608293615477530606664737747620646216501001646817077851907289711787292104010987529635721872595613877378719568476191268769313301049465989453569704834679689225689442864332100p -0.3
+ 13395384052578670726029278441332608293615477530606664737747620646216501001646817077851907289711787292104010987529635721872595613877378719568476191268769313301049465989453569704834679689225689442864332110p 0.9
+ 13395384052578670726029278441332608293615477530606664737747620646216501001646817077851907289711787292104010987529635721872595613877378719568476191268769313301049465989453569704834679689225689442864332800p 0.9
+ 13395384052578670726029278441332608293615477530606664737747620646216501001646817077851907289711787292104010987529635721872595613877378719568476191268769313301049465989453569704834679689225689442864332810p -0.3
+ \]
V_wl_662 (WordLine\\<662\\> gnd!) vsource type=pwl wave=\[
+ 0    -0.3
+ 26790768105157341452058556882665216587230955061213329475495241292433002003293634155703814579423574584208021975059271443745191227754757439136952382537538626602098931978907139409669359378451378885728664900p -0.3
+ 26790768105157341452058556882665216587230955061213329475495241292433002003293634155703814579423574584208021975059271443745191227754757439136952382537538626602098931978907139409669359378451378885728664910p 0.9
+ 26790768105157341452058556882665216587230955061213329475495241292433002003293634155703814579423574584208021975059271443745191227754757439136952382537538626602098931978907139409669359378451378885728665600p 0.9
+ 26790768105157341452058556882665216587230955061213329475495241292433002003293634155703814579423574584208021975059271443745191227754757439136952382537538626602098931978907139409669359378451378885728665610p -0.3
+ \]
V_wl_663 (WordLine\\<663\\> gnd!) vsource type=pwl wave=\[
+ 0    -0.3
+ 53581536210314682904117113765330433174461910122426658950990482584866004006587268311407629158847149168416043950118542887490382455509514878273904765075077253204197863957814278819338718756902757771457330500p -0.3
+ 53581536210314682904117113765330433174461910122426658950990482584866004006587268311407629158847149168416043950118542887490382455509514878273904765075077253204197863957814278819338718756902757771457330510p 0.9
+ 53581536210314682904117113765330433174461910122426658950990482584866004006587268311407629158847149168416043950118542887490382455509514878273904765075077253204197863957814278819338718756902757771457331200p 0.9
+ 53581536210314682904117113765330433174461910122426658950990482584866004006587268311407629158847149168416043950118542887490382455509514878273904765075077253204197863957814278819338718756902757771457331210p -0.3
+ \]
V_wl_664 (WordLine\\<664\\> gnd!) vsource type=pwl wave=\[
+ 0    -0.3
+ 107163072420629365808234227530660866348923820244853317901980965169732008013174536622815258317694298336832087900237085774980764911019029756547809530150154506408395727915628557638677437513805515542914661700p -0.3
+ 107163072420629365808234227530660866348923820244853317901980965169732008013174536622815258317694298336832087900237085774980764911019029756547809530150154506408395727915628557638677437513805515542914661710p 0.9
+ 107163072420629365808234227530660866348923820244853317901980965169732008013174536622815258317694298336832087900237085774980764911019029756547809530150154506408395727915628557638677437513805515542914662400p 0.9
+ 107163072420629365808234227530660866348923820244853317901980965169732008013174536622815258317694298336832087900237085774980764911019029756547809530150154506408395727915628557638677437513805515542914662410p -0.3
+ \]
V_wl_665 (WordLine\\<665\\> gnd!) vsource type=pwl wave=\[
+ 0    -0.3
+ 214326144841258731616468455061321732697847640489706635803961930339464016026349073245630516635388596673664175800474171549961529822038059513095619060300309012816791455831257115277354875027611031085829324100p -0.3
+ 214326144841258731616468455061321732697847640489706635803961930339464016026349073245630516635388596673664175800474171549961529822038059513095619060300309012816791455831257115277354875027611031085829324110p 0.9
+ 214326144841258731616468455061321732697847640489706635803961930339464016026349073245630516635388596673664175800474171549961529822038059513095619060300309012816791455831257115277354875027611031085829324800p 0.9
+ 214326144841258731616468455061321732697847640489706635803961930339464016026349073245630516635388596673664175800474171549961529822038059513095619060300309012816791455831257115277354875027611031085829324810p -0.3
+ \]
V_wl_666 (WordLine\\<666\\> gnd!) vsource type=pwl wave=\[
+ 0    -0.3
+ 428652289682517463232936910122643465395695280979413271607923860678928032052698146491261033270777193347328351600948343099923059644076119026191238120600618025633582911662514230554709750055222062171658648900p -0.3
+ 428652289682517463232936910122643465395695280979413271607923860678928032052698146491261033270777193347328351600948343099923059644076119026191238120600618025633582911662514230554709750055222062171658648910p 0.9
+ 428652289682517463232936910122643465395695280979413271607923860678928032052698146491261033270777193347328351600948343099923059644076119026191238120600618025633582911662514230554709750055222062171658649600p 0.9
+ 428652289682517463232936910122643465395695280979413271607923860678928032052698146491261033270777193347328351600948343099923059644076119026191238120600618025633582911662514230554709750055222062171658649610p -0.3
+ \]
V_wl_667 (WordLine\\<667\\> gnd!) vsource type=pwl wave=\[
+ 0    -0.3
+ 857304579365034926465873820245286930791390561958826543215847721357856064105396292982522066541554386694656703201896686199846119288152238052382476241201236051267165823325028461109419500110444124343317298500p -0.3
+ 857304579365034926465873820245286930791390561958826543215847721357856064105396292982522066541554386694656703201896686199846119288152238052382476241201236051267165823325028461109419500110444124343317298510p 0.9
+ 857304579365034926465873820245286930791390561958826543215847721357856064105396292982522066541554386694656703201896686199846119288152238052382476241201236051267165823325028461109419500110444124343317299200p 0.9
+ 857304579365034926465873820245286930791390561958826543215847721357856064105396292982522066541554386694656703201896686199846119288152238052382476241201236051267165823325028461109419500110444124343317299210p -0.3
+ \]
V_wl_668 (WordLine\\<668\\> gnd!) vsource type=pwl wave=\[
+ 0    -0.3
+ 1714609158730069852931747640490573861582781123917653086431695442715712128210792585965044133083108773389313406403793372399692238576304476104764952482402472102534331646650056922218839000220888248686634597700p -0.3
+ 1714609158730069852931747640490573861582781123917653086431695442715712128210792585965044133083108773389313406403793372399692238576304476104764952482402472102534331646650056922218839000220888248686634597710p 0.9
+ 1714609158730069852931747640490573861582781123917653086431695442715712128210792585965044133083108773389313406403793372399692238576304476104764952482402472102534331646650056922218839000220888248686634598400p 0.9
+ 1714609158730069852931747640490573861582781123917653086431695442715712128210792585965044133083108773389313406403793372399692238576304476104764952482402472102534331646650056922218839000220888248686634598410p -0.3
+ \]
V_wl_669 (WordLine\\<669\\> gnd!) vsource type=pwl wave=\[
+ 0    -0.3
+ 3429218317460139705863495280981147723165562247835306172863390885431424256421585171930088266166217546778626812807586744799384477152608952209529904964804944205068663293300113844437678000441776497373269196100p -0.3
+ 3429218317460139705863495280981147723165562247835306172863390885431424256421585171930088266166217546778626812807586744799384477152608952209529904964804944205068663293300113844437678000441776497373269196110p 0.9
+ 3429218317460139705863495280981147723165562247835306172863390885431424256421585171930088266166217546778626812807586744799384477152608952209529904964804944205068663293300113844437678000441776497373269196800p 0.9
+ 3429218317460139705863495280981147723165562247835306172863390885431424256421585171930088266166217546778626812807586744799384477152608952209529904964804944205068663293300113844437678000441776497373269196810p -0.3
+ \]
V_wl_670 (WordLine\\<670\\> gnd!) vsource type=pwl wave=\[
+ 0    -0.3
+ 6858436634920279411726990561962295446331124495670612345726781770862848512843170343860176532332435093557253625615173489598768954305217904419059809929609888410137326586600227688875356000883552994746538392900p -0.3
+ 6858436634920279411726990561962295446331124495670612345726781770862848512843170343860176532332435093557253625615173489598768954305217904419059809929609888410137326586600227688875356000883552994746538392910p 0.9
+ 6858436634920279411726990561962295446331124495670612345726781770862848512843170343860176532332435093557253625615173489598768954305217904419059809929609888410137326586600227688875356000883552994746538393600p 0.9
+ 6858436634920279411726990561962295446331124495670612345726781770862848512843170343860176532332435093557253625615173489598768954305217904419059809929609888410137326586600227688875356000883552994746538393610p -0.3
+ \]
V_wl_671 (WordLine\\<671\\> gnd!) vsource type=pwl wave=\[
+ 0    -0.3
+ 13716873269840558823453981123924590892662248991341224691453563541725697025686340687720353064664870187114507251230346979197537908610435808838119619859219776820274653173200455377750712001767105989493076786500p -0.3
+ 13716873269840558823453981123924590892662248991341224691453563541725697025686340687720353064664870187114507251230346979197537908610435808838119619859219776820274653173200455377750712001767105989493076786510p 0.9
+ 13716873269840558823453981123924590892662248991341224691453563541725697025686340687720353064664870187114507251230346979197537908610435808838119619859219776820274653173200455377750712001767105989493076787200p 0.9
+ 13716873269840558823453981123924590892662248991341224691453563541725697025686340687720353064664870187114507251230346979197537908610435808838119619859219776820274653173200455377750712001767105989493076787210p -0.3
+ \]
V_wl_672 (WordLine\\<672\\> gnd!) vsource type=pwl wave=\[
+ 0    -0.3
+ 27433746539681117646907962247849181785324497982682449382907127083451394051372681375440706129329740374229014502460693958395075817220871617676239239718439553640549306346400910755501424003534211978986153573700p -0.3
+ 27433746539681117646907962247849181785324497982682449382907127083451394051372681375440706129329740374229014502460693958395075817220871617676239239718439553640549306346400910755501424003534211978986153573710p 0.9
+ 27433746539681117646907962247849181785324497982682449382907127083451394051372681375440706129329740374229014502460693958395075817220871617676239239718439553640549306346400910755501424003534211978986153574400p 0.9
+ 27433746539681117646907962247849181785324497982682449382907127083451394051372681375440706129329740374229014502460693958395075817220871617676239239718439553640549306346400910755501424003534211978986153574410p -0.3
+ \]
V_wl_673 (WordLine\\<673\\> gnd!) vsource type=pwl wave=\[
+ 0    -0.3
+ 54867493079362235293815924495698363570648995965364898765814254166902788102745362750881412258659480748458029004921387916790151634441743235352478479436879107281098612692801821511002848007068423957972307148100p -0.3
+ 54867493079362235293815924495698363570648995965364898765814254166902788102745362750881412258659480748458029004921387916790151634441743235352478479436879107281098612692801821511002848007068423957972307148110p 0.9
+ 54867493079362235293815924495698363570648995965364898765814254166902788102745362750881412258659480748458029004921387916790151634441743235352478479436879107281098612692801821511002848007068423957972307148800p 0.9
+ 54867493079362235293815924495698363570648995965364898765814254166902788102745362750881412258659480748458029004921387916790151634441743235352478479436879107281098612692801821511002848007068423957972307148810p -0.3
+ \]
V_wl_674 (WordLine\\<674\\> gnd!) vsource type=pwl wave=\[
+ 0    -0.3
+ 109734986158724470587631848991396727141297991930729797531628508333805576205490725501762824517318961496916058009842775833580303268883486470704956958873758214562197225385603643022005696014136847915944614296900p -0.3
+ 109734986158724470587631848991396727141297991930729797531628508333805576205490725501762824517318961496916058009842775833580303268883486470704956958873758214562197225385603643022005696014136847915944614296910p 0.9
+ 109734986158724470587631848991396727141297991930729797531628508333805576205490725501762824517318961496916058009842775833580303268883486470704956958873758214562197225385603643022005696014136847915944614297600p 0.9
+ 109734986158724470587631848991396727141297991930729797531628508333805576205490725501762824517318961496916058009842775833580303268883486470704956958873758214562197225385603643022005696014136847915944614297610p -0.3
+ \]
V_wl_675 (WordLine\\<675\\> gnd!) vsource type=pwl wave=\[
+ 0    -0.3
+ 219469972317448941175263697982793454282595983861459595063257016667611152410981451003525649034637922993832116019685551667160606537766972941409913917747516429124394450771207286044011392028273695831889228594500p -0.3
+ 219469972317448941175263697982793454282595983861459595063257016667611152410981451003525649034637922993832116019685551667160606537766972941409913917747516429124394450771207286044011392028273695831889228594510p 0.9
+ 219469972317448941175263697982793454282595983861459595063257016667611152410981451003525649034637922993832116019685551667160606537766972941409913917747516429124394450771207286044011392028273695831889228595200p 0.9
+ 219469972317448941175263697982793454282595983861459595063257016667611152410981451003525649034637922993832116019685551667160606537766972941409913917747516429124394450771207286044011392028273695831889228595210p -0.3
+ \]
V_wl_676 (WordLine\\<676\\> gnd!) vsource type=pwl wave=\[
+ 0    -0.3
+ 438939944634897882350527395965586908565191967722919190126514033335222304821962902007051298069275845987664232039371103334321213075533945882819827835495032858248788901542414572088022784056547391663778457189700p -0.3
+ 438939944634897882350527395965586908565191967722919190126514033335222304821962902007051298069275845987664232039371103334321213075533945882819827835495032858248788901542414572088022784056547391663778457189710p 0.9
+ 438939944634897882350527395965586908565191967722919190126514033335222304821962902007051298069275845987664232039371103334321213075533945882819827835495032858248788901542414572088022784056547391663778457190400p 0.9
+ 438939944634897882350527395965586908565191967722919190126514033335222304821962902007051298069275845987664232039371103334321213075533945882819827835495032858248788901542414572088022784056547391663778457190410p -0.3
+ \]
V_wl_677 (WordLine\\<677\\> gnd!) vsource type=pwl wave=\[
+ 0    -0.3
+ 877879889269795764701054791931173817130383935445838380253028066670444609643925804014102596138551691975328464078742206668642426151067891765639655670990065716497577803084829144176045568113094783327556914380100p -0.3
+ 877879889269795764701054791931173817130383935445838380253028066670444609643925804014102596138551691975328464078742206668642426151067891765639655670990065716497577803084829144176045568113094783327556914380110p 0.9
+ 877879889269795764701054791931173817130383935445838380253028066670444609643925804014102596138551691975328464078742206668642426151067891765639655670990065716497577803084829144176045568113094783327556914380800p 0.9
+ 877879889269795764701054791931173817130383935445838380253028066670444609643925804014102596138551691975328464078742206668642426151067891765639655670990065716497577803084829144176045568113094783327556914380810p -0.3
+ \]
V_wl_678 (WordLine\\<678\\> gnd!) vsource type=pwl wave=\[
+ 0    -0.3
+ 1755759778539591529402109583862347634260767870891676760506056133340889219287851608028205192277103383950656928157484413337284852302135783531279311341980131432995155606169658288352091136226189566655113828760900p -0.3
+ 1755759778539591529402109583862347634260767870891676760506056133340889219287851608028205192277103383950656928157484413337284852302135783531279311341980131432995155606169658288352091136226189566655113828760910p 0.9
+ 1755759778539591529402109583862347634260767870891676760506056133340889219287851608028205192277103383950656928157484413337284852302135783531279311341980131432995155606169658288352091136226189566655113828761600p 0.9
+ 1755759778539591529402109583862347634260767870891676760506056133340889219287851608028205192277103383950656928157484413337284852302135783531279311341980131432995155606169658288352091136226189566655113828761610p -0.3
+ \]
V_wl_679 (WordLine\\<679\\> gnd!) vsource type=pwl wave=\[
+ 0    -0.3
+ 3511519557079183058804219167724695268521535741783353521012112266681778438575703216056410384554206767901313856314968826674569704604271567062558622683960262865990311212339316576704182272452379133310227657522500p -0.3
+ 3511519557079183058804219167724695268521535741783353521012112266681778438575703216056410384554206767901313856314968826674569704604271567062558622683960262865990311212339316576704182272452379133310227657522510p 0.9
+ 3511519557079183058804219167724695268521535741783353521012112266681778438575703216056410384554206767901313856314968826674569704604271567062558622683960262865990311212339316576704182272452379133310227657523200p 0.9
+ 3511519557079183058804219167724695268521535741783353521012112266681778438575703216056410384554206767901313856314968826674569704604271567062558622683960262865990311212339316576704182272452379133310227657523210p -0.3
+ \]
V_wl_680 (WordLine\\<680\\> gnd!) vsource type=pwl wave=\[
+ 0    -0.3
+ 7023039114158366117608438335449390537043071483566707042024224533363556877151406432112820769108413535802627712629937653349139409208543134125117245367920525731980622424678633153408364544904758266620455315045700p -0.3
+ 7023039114158366117608438335449390537043071483566707042024224533363556877151406432112820769108413535802627712629937653349139409208543134125117245367920525731980622424678633153408364544904758266620455315045710p 0.9
+ 7023039114158366117608438335449390537043071483566707042024224533363556877151406432112820769108413535802627712629937653349139409208543134125117245367920525731980622424678633153408364544904758266620455315046400p 0.9
+ 7023039114158366117608438335449390537043071483566707042024224533363556877151406432112820769108413535802627712629937653349139409208543134125117245367920525731980622424678633153408364544904758266620455315046410p -0.3
+ \]
V_wl_681 (WordLine\\<681\\> gnd!) vsource type=pwl wave=\[
+ 0    -0.3
+ 14046078228316732235216876670898781074086142967133414084048449066727113754302812864225641538216827071605255425259875306698278818417086268250234490735841051463961244849357266306816729089809516533240910630092100p -0.3
+ 14046078228316732235216876670898781074086142967133414084048449066727113754302812864225641538216827071605255425259875306698278818417086268250234490735841051463961244849357266306816729089809516533240910630092110p 0.9
+ 14046078228316732235216876670898781074086142967133414084048449066727113754302812864225641538216827071605255425259875306698278818417086268250234490735841051463961244849357266306816729089809516533240910630092800p 0.9
+ 14046078228316732235216876670898781074086142967133414084048449066727113754302812864225641538216827071605255425259875306698278818417086268250234490735841051463961244849357266306816729089809516533240910630092810p -0.3
+ \]
V_wl_682 (WordLine\\<682\\> gnd!) vsource type=pwl wave=\[
+ 0    -0.3
+ 28092156456633464470433753341797562148172285934266828168096898133454227508605625728451283076433654143210510850519750613396557636834172536500468981471682102927922489698714532613633458179619033066481821260184900p -0.3
+ 28092156456633464470433753341797562148172285934266828168096898133454227508605625728451283076433654143210510850519750613396557636834172536500468981471682102927922489698714532613633458179619033066481821260184910p 0.9
+ 28092156456633464470433753341797562148172285934266828168096898133454227508605625728451283076433654143210510850519750613396557636834172536500468981471682102927922489698714532613633458179619033066481821260185600p 0.9
+ 28092156456633464470433753341797562148172285934266828168096898133454227508605625728451283076433654143210510850519750613396557636834172536500468981471682102927922489698714532613633458179619033066481821260185610p -0.3
+ \]
V_wl_683 (WordLine\\<683\\> gnd!) vsource type=pwl wave=\[
+ 0    -0.3
+ 56184312913266928940867506683595124296344571868533656336193796266908455017211251456902566152867308286421021701039501226793115273668345073000937962943364205855844979397429065227266916359238066132963642520370500p -0.3
+ 56184312913266928940867506683595124296344571868533656336193796266908455017211251456902566152867308286421021701039501226793115273668345073000937962943364205855844979397429065227266916359238066132963642520370510p 0.9
+ 56184312913266928940867506683595124296344571868533656336193796266908455017211251456902566152867308286421021701039501226793115273668345073000937962943364205855844979397429065227266916359238066132963642520371200p 0.9
+ 56184312913266928940867506683595124296344571868533656336193796266908455017211251456902566152867308286421021701039501226793115273668345073000937962943364205855844979397429065227266916359238066132963642520371210p -0.3
+ \]
V_wl_684 (WordLine\\<684\\> gnd!) vsource type=pwl wave=\[
+ 0    -0.3
+ 112368625826533857881735013367190248592689143737067312672387592533816910034422502913805132305734616572842043402079002453586230547336690146001875925886728411711689958794858130454533832718476132265927285040741700p -0.3
+ 112368625826533857881735013367190248592689143737067312672387592533816910034422502913805132305734616572842043402079002453586230547336690146001875925886728411711689958794858130454533832718476132265927285040741710p 0.9
+ 112368625826533857881735013367190248592689143737067312672387592533816910034422502913805132305734616572842043402079002453586230547336690146001875925886728411711689958794858130454533832718476132265927285040742400p 0.9
+ 112368625826533857881735013367190248592689143737067312672387592533816910034422502913805132305734616572842043402079002453586230547336690146001875925886728411711689958794858130454533832718476132265927285040742410p -0.3
+ \]
V_wl_685 (WordLine\\<685\\> gnd!) vsource type=pwl wave=\[
+ 0    -0.3
+ 224737251653067715763470026734380497185378287474134625344775185067633820068845005827610264611469233145684086804158004907172461094673380292003751851773456823423379917589716260909067665436952264531854570081484100p -0.3
+ 224737251653067715763470026734380497185378287474134625344775185067633820068845005827610264611469233145684086804158004907172461094673380292003751851773456823423379917589716260909067665436952264531854570081484110p 0.9
+ 224737251653067715763470026734380497185378287474134625344775185067633820068845005827610264611469233145684086804158004907172461094673380292003751851773456823423379917589716260909067665436952264531854570081484800p 0.9
+ 224737251653067715763470026734380497185378287474134625344775185067633820068845005827610264611469233145684086804158004907172461094673380292003751851773456823423379917589716260909067665436952264531854570081484810p -0.3
+ \]
V_wl_686 (WordLine\\<686\\> gnd!) vsource type=pwl wave=\[
+ 0    -0.3
+ 449474503306135431526940053468760994370756574948269250689550370135267640137690011655220529222938466291368173608316009814344922189346760584007503703546913646846759835179432521818135330873904529063709140162968900p -0.3
+ 449474503306135431526940053468760994370756574948269250689550370135267640137690011655220529222938466291368173608316009814344922189346760584007503703546913646846759835179432521818135330873904529063709140162968910p 0.9
+ 449474503306135431526940053468760994370756574948269250689550370135267640137690011655220529222938466291368173608316009814344922189346760584007503703546913646846759835179432521818135330873904529063709140162969600p 0.9
+ 449474503306135431526940053468760994370756574948269250689550370135267640137690011655220529222938466291368173608316009814344922189346760584007503703546913646846759835179432521818135330873904529063709140162969610p -0.3
+ \]
V_wl_687 (WordLine\\<687\\> gnd!) vsource type=pwl wave=\[
+ 0    -0.3
+ 898949006612270863053880106937521988741513149896538501379100740270535280275380023310441058445876932582736347216632019628689844378693521168015007407093827293693519670358865043636270661747809058127418280325938500p -0.3
+ 898949006612270863053880106937521988741513149896538501379100740270535280275380023310441058445876932582736347216632019628689844378693521168015007407093827293693519670358865043636270661747809058127418280325938510p 0.9
+ 898949006612270863053880106937521988741513149896538501379100740270535280275380023310441058445876932582736347216632019628689844378693521168015007407093827293693519670358865043636270661747809058127418280325939200p 0.9
+ 898949006612270863053880106937521988741513149896538501379100740270535280275380023310441058445876932582736347216632019628689844378693521168015007407093827293693519670358865043636270661747809058127418280325939210p -0.3
+ \]
V_wl_688 (WordLine\\<688\\> gnd!) vsource type=pwl wave=\[
+ 0    -0.3
+ 1797898013224541726107760213875043977483026299793077002758201480541070560550760046620882116891753865165472694433264039257379688757387042336030014814187654587387039340717730087272541323495618116254836560651877700p -0.3
+ 1797898013224541726107760213875043977483026299793077002758201480541070560550760046620882116891753865165472694433264039257379688757387042336030014814187654587387039340717730087272541323495618116254836560651877710p 0.9
+ 1797898013224541726107760213875043977483026299793077002758201480541070560550760046620882116891753865165472694433264039257379688757387042336030014814187654587387039340717730087272541323495618116254836560651878400p 0.9
+ 1797898013224541726107760213875043977483026299793077002758201480541070560550760046620882116891753865165472694433264039257379688757387042336030014814187654587387039340717730087272541323495618116254836560651878410p -0.3
+ \]
V_wl_689 (WordLine\\<689\\> gnd!) vsource type=pwl wave=\[
+ 0    -0.3
+ 3595796026449083452215520427750087954966052599586154005516402961082141121101520093241764233783507730330945388866528078514759377514774084672060029628375309174774078681435460174545082646991236232509673121303756100p -0.3
+ 3595796026449083452215520427750087954966052599586154005516402961082141121101520093241764233783507730330945388866528078514759377514774084672060029628375309174774078681435460174545082646991236232509673121303756110p 0.9
+ 3595796026449083452215520427750087954966052599586154005516402961082141121101520093241764233783507730330945388866528078514759377514774084672060029628375309174774078681435460174545082646991236232509673121303756800p 0.9
+ 3595796026449083452215520427750087954966052599586154005516402961082141121101520093241764233783507730330945388866528078514759377514774084672060029628375309174774078681435460174545082646991236232509673121303756810p -0.3
+ \]
V_wl_690 (WordLine\\<690\\> gnd!) vsource type=pwl wave=\[
+ 0    -0.3
+ 7191592052898166904431040855500175909932105199172308011032805922164282242203040186483528467567015460661890777733056157029518755029548169344120059256750618349548157362870920349090165293982472465019346242607512900p -0.3
+ 7191592052898166904431040855500175909932105199172308011032805922164282242203040186483528467567015460661890777733056157029518755029548169344120059256750618349548157362870920349090165293982472465019346242607512910p 0.9
+ 7191592052898166904431040855500175909932105199172308011032805922164282242203040186483528467567015460661890777733056157029518755029548169344120059256750618349548157362870920349090165293982472465019346242607513600p 0.9
+ 7191592052898166904431040855500175909932105199172308011032805922164282242203040186483528467567015460661890777733056157029518755029548169344120059256750618349548157362870920349090165293982472465019346242607513610p -0.3
+ \]
V_wl_691 (WordLine\\<691\\> gnd!) vsource type=pwl wave=\[
+ 0    -0.3
+ 14383184105796333808862081711000351819864210398344616022065611844328564484406080372967056935134030921323781555466112314059037510059096338688240118513501236699096314725741840698180330587964944930038692485215026500p -0.3
+ 14383184105796333808862081711000351819864210398344616022065611844328564484406080372967056935134030921323781555466112314059037510059096338688240118513501236699096314725741840698180330587964944930038692485215026510p 0.9
+ 14383184105796333808862081711000351819864210398344616022065611844328564484406080372967056935134030921323781555466112314059037510059096338688240118513501236699096314725741840698180330587964944930038692485215027200p 0.9
+ 14383184105796333808862081711000351819864210398344616022065611844328564484406080372967056935134030921323781555466112314059037510059096338688240118513501236699096314725741840698180330587964944930038692485215027210p -0.3
+ \]
V_wl_692 (WordLine\\<692\\> gnd!) vsource type=pwl wave=\[
+ 0    -0.3
+ 28766368211592667617724163422000703639728420796689232044131223688657128968812160745934113870268061842647563110932224628118075020118192677376480237027002473398192629451483681396360661175929889860077384970430053700p -0.3
+ 28766368211592667617724163422000703639728420796689232044131223688657128968812160745934113870268061842647563110932224628118075020118192677376480237027002473398192629451483681396360661175929889860077384970430053710p 0.9
+ 28766368211592667617724163422000703639728420796689232044131223688657128968812160745934113870268061842647563110932224628118075020118192677376480237027002473398192629451483681396360661175929889860077384970430054400p 0.9
+ 28766368211592667617724163422000703639728420796689232044131223688657128968812160745934113870268061842647563110932224628118075020118192677376480237027002473398192629451483681396360661175929889860077384970430054410p -0.3
+ \]
V_wl_693 (WordLine\\<693\\> gnd!) vsource type=pwl wave=\[
+ 0    -0.3
+ 57532736423185335235448326844001407279456841593378464088262447377314257937624321491868227740536123685295126221864449256236150040236385354752960474054004946796385258902967362792721322351859779720154769940860108100p -0.3
+ 57532736423185335235448326844001407279456841593378464088262447377314257937624321491868227740536123685295126221864449256236150040236385354752960474054004946796385258902967362792721322351859779720154769940860108110p 0.9
+ 57532736423185335235448326844001407279456841593378464088262447377314257937624321491868227740536123685295126221864449256236150040236385354752960474054004946796385258902967362792721322351859779720154769940860108800p 0.9
+ 57532736423185335235448326844001407279456841593378464088262447377314257937624321491868227740536123685295126221864449256236150040236385354752960474054004946796385258902967362792721322351859779720154769940860108810p -0.3
+ \]
V_wl_694 (WordLine\\<694\\> gnd!) vsource type=pwl wave=\[
+ 0    -0.3
+ 115065472846370670470896653688002814558913683186756928176524894754628515875248642983736455481072247370590252443728898512472300080472770709505920948108009893592770517805934725585442644703719559440309539881720216900p -0.3
+ 115065472846370670470896653688002814558913683186756928176524894754628515875248642983736455481072247370590252443728898512472300080472770709505920948108009893592770517805934725585442644703719559440309539881720216910p 0.9
+ 115065472846370670470896653688002814558913683186756928176524894754628515875248642983736455481072247370590252443728898512472300080472770709505920948108009893592770517805934725585442644703719559440309539881720217600p 0.9
+ 115065472846370670470896653688002814558913683186756928176524894754628515875248642983736455481072247370590252443728898512472300080472770709505920948108009893592770517805934725585442644703719559440309539881720217610p -0.3
+ \]
V_wl_695 (WordLine\\<695\\> gnd!) vsource type=pwl wave=\[
+ 0    -0.3
+ 230130945692741340941793307376005629117827366373513856353049789509257031750497285967472910962144494741180504887457797024944600160945541419011841896216019787185541035611869451170885289407439118880619079763440434500p -0.3
+ 230130945692741340941793307376005629117827366373513856353049789509257031750497285967472910962144494741180504887457797024944600160945541419011841896216019787185541035611869451170885289407439118880619079763440434510p 0.9
+ 230130945692741340941793307376005629117827366373513856353049789509257031750497285967472910962144494741180504887457797024944600160945541419011841896216019787185541035611869451170885289407439118880619079763440435200p 0.9
+ 230130945692741340941793307376005629117827366373513856353049789509257031750497285967472910962144494741180504887457797024944600160945541419011841896216019787185541035611869451170885289407439118880619079763440435210p -0.3
+ \]
V_wl_696 (WordLine\\<696\\> gnd!) vsource type=pwl wave=\[
+ 0    -0.3
+ 460261891385482681883586614752011258235654732747027712706099579018514063500994571934945821924288989482361009774915594049889200321891082838023683792432039574371082071223738902341770578814878237761238159526880869700p -0.3
+ 460261891385482681883586614752011258235654732747027712706099579018514063500994571934945821924288989482361009774915594049889200321891082838023683792432039574371082071223738902341770578814878237761238159526880869710p 0.9
+ 460261891385482681883586614752011258235654732747027712706099579018514063500994571934945821924288989482361009774915594049889200321891082838023683792432039574371082071223738902341770578814878237761238159526880870400p 0.9
+ 460261891385482681883586614752011258235654732747027712706099579018514063500994571934945821924288989482361009774915594049889200321891082838023683792432039574371082071223738902341770578814878237761238159526880870410p -0.3
+ \]
V_wl_697 (WordLine\\<697\\> gnd!) vsource type=pwl wave=\[
+ 0    -0.3
+ 920523782770965363767173229504022516471309465494055425412199158037028127001989143869891643848577978964722019549831188099778400643782165676047367584864079148742164142447477804683541157629756475522476319053761740100p -0.3
+ 920523782770965363767173229504022516471309465494055425412199158037028127001989143869891643848577978964722019549831188099778400643782165676047367584864079148742164142447477804683541157629756475522476319053761740110p 0.9
+ 920523782770965363767173229504022516471309465494055425412199158037028127001989143869891643848577978964722019549831188099778400643782165676047367584864079148742164142447477804683541157629756475522476319053761740800p 0.9
+ 920523782770965363767173229504022516471309465494055425412199158037028127001989143869891643848577978964722019549831188099778400643782165676047367584864079148742164142447477804683541157629756475522476319053761740810p -0.3
+ \]
V_wl_698 (WordLine\\<698\\> gnd!) vsource type=pwl wave=\[
+ 0    -0.3
+ 1841047565541930727534346459008045032942618930988110850824398316074056254003978287739783287697155957929444039099662376199556801287564331352094735169728158297484328284894955609367082315259512951044952638107523480900p -0.3
+ 1841047565541930727534346459008045032942618930988110850824398316074056254003978287739783287697155957929444039099662376199556801287564331352094735169728158297484328284894955609367082315259512951044952638107523480910p 0.9
+ 1841047565541930727534346459008045032942618930988110850824398316074056254003978287739783287697155957929444039099662376199556801287564331352094735169728158297484328284894955609367082315259512951044952638107523481600p 0.9
+ 1841047565541930727534346459008045032942618930988110850824398316074056254003978287739783287697155957929444039099662376199556801287564331352094735169728158297484328284894955609367082315259512951044952638107523481610p -0.3
+ \]
V_wl_699 (WordLine\\<699\\> gnd!) vsource type=pwl wave=\[
+ 0    -0.3
+ 3682095131083861455068692918016090065885237861976221701648796632148112508007956575479566575394311915858888078199324752399113602575128662704189470339456316594968656569789911218734164630519025902089905276215046962500p -0.3
+ 3682095131083861455068692918016090065885237861976221701648796632148112508007956575479566575394311915858888078199324752399113602575128662704189470339456316594968656569789911218734164630519025902089905276215046962510p 0.9
+ 3682095131083861455068692918016090065885237861976221701648796632148112508007956575479566575394311915858888078199324752399113602575128662704189470339456316594968656569789911218734164630519025902089905276215046963200p 0.9
+ 3682095131083861455068692918016090065885237861976221701648796632148112508007956575479566575394311915858888078199324752399113602575128662704189470339456316594968656569789911218734164630519025902089905276215046963210p -0.3
+ \]
V_wl_700 (WordLine\\<700\\> gnd!) vsource type=pwl wave=\[
+ 0    -0.3
+ 7364190262167722910137385836032180131770475723952443403297593264296225016015913150959133150788623831717776156398649504798227205150257325408378940678912633189937313139579822437468329261038051804179810552430093925700p -0.3
+ 7364190262167722910137385836032180131770475723952443403297593264296225016015913150959133150788623831717776156398649504798227205150257325408378940678912633189937313139579822437468329261038051804179810552430093925710p 0.9
+ 7364190262167722910137385836032180131770475723952443403297593264296225016015913150959133150788623831717776156398649504798227205150257325408378940678912633189937313139579822437468329261038051804179810552430093926400p 0.9
+ 7364190262167722910137385836032180131770475723952443403297593264296225016015913150959133150788623831717776156398649504798227205150257325408378940678912633189937313139579822437468329261038051804179810552430093926410p -0.3
+ \]
V_wl_701 (WordLine\\<701\\> gnd!) vsource type=pwl wave=\[
+ 0    -0.3
+ 14728380524335445820274771672064360263540951447904886806595186528592450032031826301918266301577247663435552312797299009596454410300514650816757881357825266379874626279159644874936658522076103608359621104860187852100p -0.3
+ 14728380524335445820274771672064360263540951447904886806595186528592450032031826301918266301577247663435552312797299009596454410300514650816757881357825266379874626279159644874936658522076103608359621104860187852110p 0.9
+ 14728380524335445820274771672064360263540951447904886806595186528592450032031826301918266301577247663435552312797299009596454410300514650816757881357825266379874626279159644874936658522076103608359621104860187852800p 0.9
+ 14728380524335445820274771672064360263540951447904886806595186528592450032031826301918266301577247663435552312797299009596454410300514650816757881357825266379874626279159644874936658522076103608359621104860187852810p -0.3
+ \]
V_wl_702 (WordLine\\<702\\> gnd!) vsource type=pwl wave=\[
+ 0    -0.3
+ 29456761048670891640549543344128720527081902895809773613190373057184900064063652603836532603154495326871104625594598019192908820601029301633515762715650532759749252558319289749873317044152207216719242209720375704900p -0.3
+ 29456761048670891640549543344128720527081902895809773613190373057184900064063652603836532603154495326871104625594598019192908820601029301633515762715650532759749252558319289749873317044152207216719242209720375704910p 0.9
+ 29456761048670891640549543344128720527081902895809773613190373057184900064063652603836532603154495326871104625594598019192908820601029301633515762715650532759749252558319289749873317044152207216719242209720375705600p 0.9
+ 29456761048670891640549543344128720527081902895809773613190373057184900064063652603836532603154495326871104625594598019192908820601029301633515762715650532759749252558319289749873317044152207216719242209720375705610p -0.3
+ \]
V_wl_703 (WordLine\\<703\\> gnd!) vsource type=pwl wave=\[
+ 0    -0.3
+ 58913522097341783281099086688257441054163805791619547226380746114369800128127305207673065206308990653742209251189196038385817641202058603267031525431301065519498505116638579499746634088304414433438484419440751410500p -0.3
+ 58913522097341783281099086688257441054163805791619547226380746114369800128127305207673065206308990653742209251189196038385817641202058603267031525431301065519498505116638579499746634088304414433438484419440751410510p 0.9
+ 58913522097341783281099086688257441054163805791619547226380746114369800128127305207673065206308990653742209251189196038385817641202058603267031525431301065519498505116638579499746634088304414433438484419440751411200p 0.9
+ 58913522097341783281099086688257441054163805791619547226380746114369800128127305207673065206308990653742209251189196038385817641202058603267031525431301065519498505116638579499746634088304414433438484419440751411210p -0.3
+ \]
V_wl_704 (WordLine\\<704\\> gnd!) vsource type=pwl wave=\[
+ 0    -0.3
+ 117827044194683566562198173376514882108327611583239094452761492228739600256254610415346130412617981307484418502378392076771635282404117206534063050862602131038997010233277158999493268176608828866876968838881502821700p -0.3
+ 117827044194683566562198173376514882108327611583239094452761492228739600256254610415346130412617981307484418502378392076771635282404117206534063050862602131038997010233277158999493268176608828866876968838881502821710p 0.9
+ 117827044194683566562198173376514882108327611583239094452761492228739600256254610415346130412617981307484418502378392076771635282404117206534063050862602131038997010233277158999493268176608828866876968838881502822400p 0.9
+ 117827044194683566562198173376514882108327611583239094452761492228739600256254610415346130412617981307484418502378392076771635282404117206534063050862602131038997010233277158999493268176608828866876968838881502822410p -0.3
+ \]
V_wl_705 (WordLine\\<705\\> gnd!) vsource type=pwl wave=\[
+ 0    -0.3
+ 235654088389367133124396346753029764216655223166478188905522984457479200512509220830692260825235962614968837004756784153543270564808234413068126101725204262077994020466554317998986536353217657733753937677763005644100p -0.3
+ 235654088389367133124396346753029764216655223166478188905522984457479200512509220830692260825235962614968837004756784153543270564808234413068126101725204262077994020466554317998986536353217657733753937677763005644110p 0.9
+ 235654088389367133124396346753029764216655223166478188905522984457479200512509220830692260825235962614968837004756784153543270564808234413068126101725204262077994020466554317998986536353217657733753937677763005644800p 0.9
+ 235654088389367133124396346753029764216655223166478188905522984457479200512509220830692260825235962614968837004756784153543270564808234413068126101725204262077994020466554317998986536353217657733753937677763005644810p -0.3
+ \]
V_wl_706 (WordLine\\<706\\> gnd!) vsource type=pwl wave=\[
+ 0    -0.3
+ 471308176778734266248792693506059528433310446332956377811045968914958401025018441661384521650471925229937674009513568307086541129616468826136252203450408524155988040933108635997973072706435315467507875355526011288900p -0.3
+ 471308176778734266248792693506059528433310446332956377811045968914958401025018441661384521650471925229937674009513568307086541129616468826136252203450408524155988040933108635997973072706435315467507875355526011288910p 0.9
+ 471308176778734266248792693506059528433310446332956377811045968914958401025018441661384521650471925229937674009513568307086541129616468826136252203450408524155988040933108635997973072706435315467507875355526011289600p 0.9
+ 471308176778734266248792693506059528433310446332956377811045968914958401025018441661384521650471925229937674009513568307086541129616468826136252203450408524155988040933108635997973072706435315467507875355526011289610p -0.3
+ \]
V_wl_707 (WordLine\\<707\\> gnd!) vsource type=pwl wave=\[
+ 0    -0.3
+ 942616353557468532497585387012119056866620892665912755622091937829916802050036883322769043300943850459875348019027136614173082259232937652272504406900817048311976081866217271995946145412870630935015750711052022578500p -0.3
+ 942616353557468532497585387012119056866620892665912755622091937829916802050036883322769043300943850459875348019027136614173082259232937652272504406900817048311976081866217271995946145412870630935015750711052022578510p 0.9
+ 942616353557468532497585387012119056866620892665912755622091937829916802050036883322769043300943850459875348019027136614173082259232937652272504406900817048311976081866217271995946145412870630935015750711052022579200p 0.9
+ 942616353557468532497585387012119056866620892665912755622091937829916802050036883322769043300943850459875348019027136614173082259232937652272504406900817048311976081866217271995946145412870630935015750711052022579210p -0.3
+ \]
V_wl_708 (WordLine\\<708\\> gnd!) vsource type=pwl wave=\[
+ 0    -0.3
+ 1885232707114937064995170774024238113733241785331825511244183875659833604100073766645538086601887700919750696038054273228346164518465875304545008813801634096623952163732434543991892290825741261870031501422104045157700p -0.3
+ 1885232707114937064995170774024238113733241785331825511244183875659833604100073766645538086601887700919750696038054273228346164518465875304545008813801634096623952163732434543991892290825741261870031501422104045157710p 0.9
+ 1885232707114937064995170774024238113733241785331825511244183875659833604100073766645538086601887700919750696038054273228346164518465875304545008813801634096623952163732434543991892290825741261870031501422104045158400p 0.9
+ 1885232707114937064995170774024238113733241785331825511244183875659833604100073766645538086601887700919750696038054273228346164518465875304545008813801634096623952163732434543991892290825741261870031501422104045158410p -0.3
+ \]
V_wl_709 (WordLine\\<709\\> gnd!) vsource type=pwl wave=\[
+ 0    -0.3
+ 3770465414229874129990341548048476227466483570663651022488367751319667208200147533291076173203775401839501392076108546456692329036931750609090017627603268193247904327464869087983784581651482523740063002844208090316100p -0.3
+ 3770465414229874129990341548048476227466483570663651022488367751319667208200147533291076173203775401839501392076108546456692329036931750609090017627603268193247904327464869087983784581651482523740063002844208090316110p 0.9
+ 3770465414229874129990341548048476227466483570663651022488367751319667208200147533291076173203775401839501392076108546456692329036931750609090017627603268193247904327464869087983784581651482523740063002844208090316800p 0.9
+ 3770465414229874129990341548048476227466483570663651022488367751319667208200147533291076173203775401839501392076108546456692329036931750609090017627603268193247904327464869087983784581651482523740063002844208090316810p -0.3
+ \]
V_wl_710 (WordLine\\<710\\> gnd!) vsource type=pwl wave=\[
+ 0    -0.3
+ 7540930828459748259980683096096952454932967141327302044976735502639334416400295066582152346407550803679002784152217092913384658073863501218180035255206536386495808654929738175967569163302965047480126005688416180632900p -0.3
+ 7540930828459748259980683096096952454932967141327302044976735502639334416400295066582152346407550803679002784152217092913384658073863501218180035255206536386495808654929738175967569163302965047480126005688416180632910p 0.9
+ 7540930828459748259980683096096952454932967141327302044976735502639334416400295066582152346407550803679002784152217092913384658073863501218180035255206536386495808654929738175967569163302965047480126005688416180633600p 0.9
+ 7540930828459748259980683096096952454932967141327302044976735502639334416400295066582152346407550803679002784152217092913384658073863501218180035255206536386495808654929738175967569163302965047480126005688416180633610p -0.3
+ \]
V_wl_711 (WordLine\\<711\\> gnd!) vsource type=pwl wave=\[
+ 0    -0.3
+ 15081861656919496519961366192193904909865934282654604089953471005278668832800590133164304692815101607358005568304434185826769316147727002436360070510413072772991617309859476351935138326605930094960252011376832361266500p -0.3
+ 15081861656919496519961366192193904909865934282654604089953471005278668832800590133164304692815101607358005568304434185826769316147727002436360070510413072772991617309859476351935138326605930094960252011376832361266510p 0.9
+ 15081861656919496519961366192193904909865934282654604089953471005278668832800590133164304692815101607358005568304434185826769316147727002436360070510413072772991617309859476351935138326605930094960252011376832361267200p 0.9
+ 15081861656919496519961366192193904909865934282654604089953471005278668832800590133164304692815101607358005568304434185826769316147727002436360070510413072772991617309859476351935138326605930094960252011376832361267210p -0.3
+ \]
V_wl_712 (WordLine\\<712\\> gnd!) vsource type=pwl wave=\[
+ 0    -0.3
+ 30163723313838993039922732384387809819731868565309208179906942010557337665601180266328609385630203214716011136608868371653538632295454004872720141020826145545983234619718952703870276653211860189920504022753664722533700p -0.3
+ 30163723313838993039922732384387809819731868565309208179906942010557337665601180266328609385630203214716011136608868371653538632295454004872720141020826145545983234619718952703870276653211860189920504022753664722533710p 0.9
+ 30163723313838993039922732384387809819731868565309208179906942010557337665601180266328609385630203214716011136608868371653538632295454004872720141020826145545983234619718952703870276653211860189920504022753664722534400p 0.9
+ 30163723313838993039922732384387809819731868565309208179906942010557337665601180266328609385630203214716011136608868371653538632295454004872720141020826145545983234619718952703870276653211860189920504022753664722534410p -0.3
+ \]
V_wl_713 (WordLine\\<713\\> gnd!) vsource type=pwl wave=\[
+ 0    -0.3
+ 60327446627677986079845464768775619639463737130618416359813884021114675331202360532657218771260406429432022273217736743307077264590908009745440282041652291091966469239437905407740553306423720379841008045507329445068100p -0.3
+ 60327446627677986079845464768775619639463737130618416359813884021114675331202360532657218771260406429432022273217736743307077264590908009745440282041652291091966469239437905407740553306423720379841008045507329445068110p 0.9
+ 60327446627677986079845464768775619639463737130618416359813884021114675331202360532657218771260406429432022273217736743307077264590908009745440282041652291091966469239437905407740553306423720379841008045507329445068800p 0.9
+ 60327446627677986079845464768775619639463737130618416359813884021114675331202360532657218771260406429432022273217736743307077264590908009745440282041652291091966469239437905407740553306423720379841008045507329445068810p -0.3
+ \]
V_wl_714 (WordLine\\<714\\> gnd!) vsource type=pwl wave=\[
+ 0    -0.3
+ 120654893255355972159690929537551239278927474261236832719627768042229350662404721065314437542520812858864044546435473486614154529181816019490880564083304582183932938478875810815481106612847440759682016091014658890136900p -0.3
+ 120654893255355972159690929537551239278927474261236832719627768042229350662404721065314437542520812858864044546435473486614154529181816019490880564083304582183932938478875810815481106612847440759682016091014658890136910p 0.9
+ 120654893255355972159690929537551239278927474261236832719627768042229350662404721065314437542520812858864044546435473486614154529181816019490880564083304582183932938478875810815481106612847440759682016091014658890137600p 0.9
+ 120654893255355972159690929537551239278927474261236832719627768042229350662404721065314437542520812858864044546435473486614154529181816019490880564083304582183932938478875810815481106612847440759682016091014658890137610p -0.3
+ \]
V_wl_715 (WordLine\\<715\\> gnd!) vsource type=pwl wave=\[
+ 0    -0.3
+ 241309786510711944319381859075102478557854948522473665439255536084458701324809442130628875085041625717728089092870946973228309058363632038981761128166609164367865876957751621630962213225694881519364032182029317780274500p -0.3
+ 241309786510711944319381859075102478557854948522473665439255536084458701324809442130628875085041625717728089092870946973228309058363632038981761128166609164367865876957751621630962213225694881519364032182029317780274510p 0.9
+ 241309786510711944319381859075102478557854948522473665439255536084458701324809442130628875085041625717728089092870946973228309058363632038981761128166609164367865876957751621630962213225694881519364032182029317780275200p 0.9
+ 241309786510711944319381859075102478557854948522473665439255536084458701324809442130628875085041625717728089092870946973228309058363632038981761128166609164367865876957751621630962213225694881519364032182029317780275210p -0.3
+ \]
V_wl_716 (WordLine\\<716\\> gnd!) vsource type=pwl wave=\[
+ 0    -0.3
+ 482619573021423888638763718150204957115709897044947330878511072168917402649618884261257750170083251435456178185741893946456618116727264077963522256333218328735731753915503243261924426451389763038728064364058635560549700p -0.3
+ 482619573021423888638763718150204957115709897044947330878511072168917402649618884261257750170083251435456178185741893946456618116727264077963522256333218328735731753915503243261924426451389763038728064364058635560549710p 0.9
+ 482619573021423888638763718150204957115709897044947330878511072168917402649618884261257750170083251435456178185741893946456618116727264077963522256333218328735731753915503243261924426451389763038728064364058635560550400p 0.9
+ 482619573021423888638763718150204957115709897044947330878511072168917402649618884261257750170083251435456178185741893946456618116727264077963522256333218328735731753915503243261924426451389763038728064364058635560550410p -0.3
+ \]
V_wl_717 (WordLine\\<717\\> gnd!) vsource type=pwl wave=\[
+ 0    -0.3
+ 965239146042847777277527436300409914231419794089894661757022144337834805299237768522515500340166502870912356371483787892913236233454528155927044512666436657471463507831006486523848852902779526077456128728117271121100100p -0.3
+ 965239146042847777277527436300409914231419794089894661757022144337834805299237768522515500340166502870912356371483787892913236233454528155927044512666436657471463507831006486523848852902779526077456128728117271121100110p 0.9
+ 965239146042847777277527436300409914231419794089894661757022144337834805299237768522515500340166502870912356371483787892913236233454528155927044512666436657471463507831006486523848852902779526077456128728117271121100800p 0.9
+ 965239146042847777277527436300409914231419794089894661757022144337834805299237768522515500340166502870912356371483787892913236233454528155927044512666436657471463507831006486523848852902779526077456128728117271121100810p -0.3
+ \]
V_wl_718 (WordLine\\<718\\> gnd!) vsource type=pwl wave=\[
+ 0    -0.3
+ 1930478292085695554555054872600819828462839588179789323514044288675669610598475537045031000680333005741824712742967575785826472466909056311854089025332873314942927015662012973047697705805559052154912257456234542242200900p -0.3
+ 1930478292085695554555054872600819828462839588179789323514044288675669610598475537045031000680333005741824712742967575785826472466909056311854089025332873314942927015662012973047697705805559052154912257456234542242200910p 0.9
+ 1930478292085695554555054872600819828462839588179789323514044288675669610598475537045031000680333005741824712742967575785826472466909056311854089025332873314942927015662012973047697705805559052154912257456234542242201600p 0.9
+ 1930478292085695554555054872600819828462839588179789323514044288675669610598475537045031000680333005741824712742967575785826472466909056311854089025332873314942927015662012973047697705805559052154912257456234542242201610p -0.3
+ \]
V_wl_719 (WordLine\\<719\\> gnd!) vsource type=pwl wave=\[
+ 0    -0.3
+ 3860956584171391109110109745201639656925679176359578647028088577351339221196951074090062001360666011483649425485935151571652944933818112623708178050665746629885854031324025946095395411611118104309824514912469084484402500p -0.3
+ 3860956584171391109110109745201639656925679176359578647028088577351339221196951074090062001360666011483649425485935151571652944933818112623708178050665746629885854031324025946095395411611118104309824514912469084484402510p 0.9
+ 3860956584171391109110109745201639656925679176359578647028088577351339221196951074090062001360666011483649425485935151571652944933818112623708178050665746629885854031324025946095395411611118104309824514912469084484403200p 0.9
+ 3860956584171391109110109745201639656925679176359578647028088577351339221196951074090062001360666011483649425485935151571652944933818112623708178050665746629885854031324025946095395411611118104309824514912469084484403210p -0.3
+ \]
V_wl_720 (WordLine\\<720\\> gnd!) vsource type=pwl wave=\[
+ 0    -0.3
+ 7721913168342782218220219490403279313851358352719157294056177154702678442393902148180124002721332022967298850971870303143305889867636225247416356101331493259771708062648051892190790823222236208619649029824938168968805700p -0.3
+ 7721913168342782218220219490403279313851358352719157294056177154702678442393902148180124002721332022967298850971870303143305889867636225247416356101331493259771708062648051892190790823222236208619649029824938168968805710p 0.9
+ 7721913168342782218220219490403279313851358352719157294056177154702678442393902148180124002721332022967298850971870303143305889867636225247416356101331493259771708062648051892190790823222236208619649029824938168968806400p 0.9
+ 7721913168342782218220219490403279313851358352719157294056177154702678442393902148180124002721332022967298850971870303143305889867636225247416356101331493259771708062648051892190790823222236208619649029824938168968806410p -0.3
+ \]
V_wl_721 (WordLine\\<721\\> gnd!) vsource type=pwl wave=\[
+ 0    -0.3
+ 15443826336685564436440438980806558627702716705438314588112354309405356884787804296360248005442664045934597701943740606286611779735272450494832712202662986519543416125296103784381581646444472417239298059649876337937612100p -0.3
+ 15443826336685564436440438980806558627702716705438314588112354309405356884787804296360248005442664045934597701943740606286611779735272450494832712202662986519543416125296103784381581646444472417239298059649876337937612110p 0.9
+ 15443826336685564436440438980806558627702716705438314588112354309405356884787804296360248005442664045934597701943740606286611779735272450494832712202662986519543416125296103784381581646444472417239298059649876337937612800p 0.9
+ 15443826336685564436440438980806558627702716705438314588112354309405356884787804296360248005442664045934597701943740606286611779735272450494832712202662986519543416125296103784381581646444472417239298059649876337937612810p -0.3
+ \]
V_wl_722 (WordLine\\<722\\> gnd!) vsource type=pwl wave=\[
+ 0    -0.3
+ 30887652673371128872880877961613117255405433410876629176224708618810713769575608592720496010885328091869195403887481212573223559470544900989665424405325973039086832250592207568763163292888944834478596119299752675875224900p -0.3
+ 30887652673371128872880877961613117255405433410876629176224708618810713769575608592720496010885328091869195403887481212573223559470544900989665424405325973039086832250592207568763163292888944834478596119299752675875224910p 0.9
+ 30887652673371128872880877961613117255405433410876629176224708618810713769575608592720496010885328091869195403887481212573223559470544900989665424405325973039086832250592207568763163292888944834478596119299752675875225600p 0.9
+ 30887652673371128872880877961613117255405433410876629176224708618810713769575608592720496010885328091869195403887481212573223559470544900989665424405325973039086832250592207568763163292888944834478596119299752675875225610p -0.3
+ \]
V_wl_723 (WordLine\\<723\\> gnd!) vsource type=pwl wave=\[
+ 0    -0.3
+ 61775305346742257745761755923226234510810866821753258352449417237621427539151217185440992021770656183738390807774962425146447118941089801979330848810651946078173664501184415137526326585777889668957192238599505351750450500p -0.3
+ 61775305346742257745761755923226234510810866821753258352449417237621427539151217185440992021770656183738390807774962425146447118941089801979330848810651946078173664501184415137526326585777889668957192238599505351750450510p 0.9
+ 61775305346742257745761755923226234510810866821753258352449417237621427539151217185440992021770656183738390807774962425146447118941089801979330848810651946078173664501184415137526326585777889668957192238599505351750451200p 0.9
+ 61775305346742257745761755923226234510810866821753258352449417237621427539151217185440992021770656183738390807774962425146447118941089801979330848810651946078173664501184415137526326585777889668957192238599505351750451210p -0.3
+ \]
V_wl_724 (WordLine\\<724\\> gnd!) vsource type=pwl wave=\[
+ 0    -0.3
+ 123550610693484515491523511846452469021621733643506516704898834475242855078302434370881984043541312367476781615549924850292894237882179603958661697621303892156347329002368830275052653171555779337914384477199010703500901700p -0.3
+ 123550610693484515491523511846452469021621733643506516704898834475242855078302434370881984043541312367476781615549924850292894237882179603958661697621303892156347329002368830275052653171555779337914384477199010703500901710p 0.9
+ 123550610693484515491523511846452469021621733643506516704898834475242855078302434370881984043541312367476781615549924850292894237882179603958661697621303892156347329002368830275052653171555779337914384477199010703500902400p 0.9
+ 123550610693484515491523511846452469021621733643506516704898834475242855078302434370881984043541312367476781615549924850292894237882179603958661697621303892156347329002368830275052653171555779337914384477199010703500902410p -0.3
+ \]
V_wl_725 (WordLine\\<725\\> gnd!) vsource type=pwl wave=\[
+ 0    -0.3
+ 247101221386969030983047023692904938043243467287013033409797668950485710156604868741763968087082624734953563231099849700585788475764359207917323395242607784312694658004737660550105306343111558675828768954398021407001804100p -0.3
+ 247101221386969030983047023692904938043243467287013033409797668950485710156604868741763968087082624734953563231099849700585788475764359207917323395242607784312694658004737660550105306343111558675828768954398021407001804110p 0.9
+ 247101221386969030983047023692904938043243467287013033409797668950485710156604868741763968087082624734953563231099849700585788475764359207917323395242607784312694658004737660550105306343111558675828768954398021407001804800p 0.9
+ 247101221386969030983047023692904938043243467287013033409797668950485710156604868741763968087082624734953563231099849700585788475764359207917323395242607784312694658004737660550105306343111558675828768954398021407001804810p -0.3
+ \]
V_wl_726 (WordLine\\<726\\> gnd!) vsource type=pwl wave=\[
+ 0    -0.3
+ 494202442773938061966094047385809876086486934574026066819595337900971420313209737483527936174165249469907126462199699401171576951528718415834646790485215568625389316009475321100210612686223117351657537908796042814003608900p -0.3
+ 494202442773938061966094047385809876086486934574026066819595337900971420313209737483527936174165249469907126462199699401171576951528718415834646790485215568625389316009475321100210612686223117351657537908796042814003608910p 0.9
+ 494202442773938061966094047385809876086486934574026066819595337900971420313209737483527936174165249469907126462199699401171576951528718415834646790485215568625389316009475321100210612686223117351657537908796042814003609600p 0.9
+ 494202442773938061966094047385809876086486934574026066819595337900971420313209737483527936174165249469907126462199699401171576951528718415834646790485215568625389316009475321100210612686223117351657537908796042814003609610p -0.3
+ \]
V_wl_727 (WordLine\\<727\\> gnd!) vsource type=pwl wave=\[
+ 0    -0.3
+ 988404885547876123932188094771619752172973869148052133639190675801942840626419474967055872348330498939814252924399398802343153903057436831669293580970431137250778632018950642200421225372446234703315075817592085628007218500p -0.3
+ 988404885547876123932188094771619752172973869148052133639190675801942840626419474967055872348330498939814252924399398802343153903057436831669293580970431137250778632018950642200421225372446234703315075817592085628007218510p 0.9
+ 988404885547876123932188094771619752172973869148052133639190675801942840626419474967055872348330498939814252924399398802343153903057436831669293580970431137250778632018950642200421225372446234703315075817592085628007219200p 0.9
+ 988404885547876123932188094771619752172973869148052133639190675801942840626419474967055872348330498939814252924399398802343153903057436831669293580970431137250778632018950642200421225372446234703315075817592085628007219210p -0.3
+ \]
V_wl_728 (WordLine\\<728\\> gnd!) vsource type=pwl wave=\[
+ 0    -0.3
+ 1976809771095752247864376189543239504345947738296104267278381351603885681252838949934111744696660997879628505848798797604686307806114873663338587161940862274501557264037901284400842450744892469406630151635184171256014437700p -0.3
+ 1976809771095752247864376189543239504345947738296104267278381351603885681252838949934111744696660997879628505848798797604686307806114873663338587161940862274501557264037901284400842450744892469406630151635184171256014437710p 0.9
+ 1976809771095752247864376189543239504345947738296104267278381351603885681252838949934111744696660997879628505848798797604686307806114873663338587161940862274501557264037901284400842450744892469406630151635184171256014438400p 0.9
+ 1976809771095752247864376189543239504345947738296104267278381351603885681252838949934111744696660997879628505848798797604686307806114873663338587161940862274501557264037901284400842450744892469406630151635184171256014438410p -0.3
+ \]
V_wl_729 (WordLine\\<729\\> gnd!) vsource type=pwl wave=\[
+ 0    -0.3
+ 3953619542191504495728752379086479008691895476592208534556762703207771362505677899868223489393321995759257011697597595209372615612229747326677174323881724549003114528075802568801684901489784938813260303270368342512028876100p -0.3
+ 3953619542191504495728752379086479008691895476592208534556762703207771362505677899868223489393321995759257011697597595209372615612229747326677174323881724549003114528075802568801684901489784938813260303270368342512028876110p 0.9
+ 3953619542191504495728752379086479008691895476592208534556762703207771362505677899868223489393321995759257011697597595209372615612229747326677174323881724549003114528075802568801684901489784938813260303270368342512028876800p 0.9
+ 3953619542191504495728752379086479008691895476592208534556762703207771362505677899868223489393321995759257011697597595209372615612229747326677174323881724549003114528075802568801684901489784938813260303270368342512028876810p -0.3
+ \]
V_wl_730 (WordLine\\<730\\> gnd!) vsource type=pwl wave=\[
+ 0    -0.3
+ 7907239084383008991457504758172958017383790953184417069113525406415542725011355799736446978786643991518514023395195190418745231224459494653354348647763449098006229056151605137603369802979569877626520606540736685024057752900p -0.3
+ 7907239084383008991457504758172958017383790953184417069113525406415542725011355799736446978786643991518514023395195190418745231224459494653354348647763449098006229056151605137603369802979569877626520606540736685024057752910p 0.9
+ 7907239084383008991457504758172958017383790953184417069113525406415542725011355799736446978786643991518514023395195190418745231224459494653354348647763449098006229056151605137603369802979569877626520606540736685024057753600p 0.9
+ 7907239084383008991457504758172958017383790953184417069113525406415542725011355799736446978786643991518514023395195190418745231224459494653354348647763449098006229056151605137603369802979569877626520606540736685024057753610p -0.3
+ \]
V_wl_731 (WordLine\\<731\\> gnd!) vsource type=pwl wave=\[
+ 0    -0.3
+ 15814478168766017982915009516345916034767581906368834138227050812831085450022711599472893957573287983037028046790390380837490462448918989306708697295526898196012458112303210275206739605959139755253041213081473370048115506500p -0.3
+ 15814478168766017982915009516345916034767581906368834138227050812831085450022711599472893957573287983037028046790390380837490462448918989306708697295526898196012458112303210275206739605959139755253041213081473370048115506510p 0.9
+ 15814478168766017982915009516345916034767581906368834138227050812831085450022711599472893957573287983037028046790390380837490462448918989306708697295526898196012458112303210275206739605959139755253041213081473370048115507200p 0.9
+ 15814478168766017982915009516345916034767581906368834138227050812831085450022711599472893957573287983037028046790390380837490462448918989306708697295526898196012458112303210275206739605959139755253041213081473370048115507210p -0.3
+ \]
V_wl_732 (WordLine\\<732\\> gnd!) vsource type=pwl wave=\[
+ 0    -0.3
+ 31628956337532035965830019032691832069535163812737668276454101625662170900045423198945787915146575966074056093580780761674980924897837978613417394591053796392024916224606420550413479211918279510506082426162946740096231013700p -0.3
+ 31628956337532035965830019032691832069535163812737668276454101625662170900045423198945787915146575966074056093580780761674980924897837978613417394591053796392024916224606420550413479211918279510506082426162946740096231013710p 0.9
+ 31628956337532035965830019032691832069535163812737668276454101625662170900045423198945787915146575966074056093580780761674980924897837978613417394591053796392024916224606420550413479211918279510506082426162946740096231014400p 0.9
+ 31628956337532035965830019032691832069535163812737668276454101625662170900045423198945787915146575966074056093580780761674980924897837978613417394591053796392024916224606420550413479211918279510506082426162946740096231014410p -0.3
+ \]
V_wl_733 (WordLine\\<733\\> gnd!) vsource type=pwl wave=\[
+ 0    -0.3
+ 63257912675064071931660038065383664139070327625475336552908203251324341800090846397891575830293151932148112187161561523349961849795675957226834789182107592784049832449212841100826958423836559021012164852325893480192462028100p -0.3
+ 63257912675064071931660038065383664139070327625475336552908203251324341800090846397891575830293151932148112187161561523349961849795675957226834789182107592784049832449212841100826958423836559021012164852325893480192462028110p 0.9
+ 63257912675064071931660038065383664139070327625475336552908203251324341800090846397891575830293151932148112187161561523349961849795675957226834789182107592784049832449212841100826958423836559021012164852325893480192462028800p 0.9
+ 63257912675064071931660038065383664139070327625475336552908203251324341800090846397891575830293151932148112187161561523349961849795675957226834789182107592784049832449212841100826958423836559021012164852325893480192462028810p -0.3
+ \]
V_wl_734 (WordLine\\<734\\> gnd!) vsource type=pwl wave=\[
+ 0    -0.3
+ 126515825350128143863320076130767328278140655250950673105816406502648683600181692795783151660586303864296224374323123046699923699591351914453669578364215185568099664898425682201653916847673118042024329704651786960384924056900p -0.3
+ 126515825350128143863320076130767328278140655250950673105816406502648683600181692795783151660586303864296224374323123046699923699591351914453669578364215185568099664898425682201653916847673118042024329704651786960384924056910p 0.9
+ 126515825350128143863320076130767328278140655250950673105816406502648683600181692795783151660586303864296224374323123046699923699591351914453669578364215185568099664898425682201653916847673118042024329704651786960384924057600p 0.9
+ 126515825350128143863320076130767328278140655250950673105816406502648683600181692795783151660586303864296224374323123046699923699591351914453669578364215185568099664898425682201653916847673118042024329704651786960384924057610p -0.3
+ \]
V_wl_735 (WordLine\\<735\\> gnd!) vsource type=pwl wave=\[
+ 0    -0.3
+ 253031650700256287726640152261534656556281310501901346211632813005297367200363385591566303321172607728592448748646246093399847399182703828907339156728430371136199329796851364403307833695346236084048659409303573920769848114500p -0.3
+ 253031650700256287726640152261534656556281310501901346211632813005297367200363385591566303321172607728592448748646246093399847399182703828907339156728430371136199329796851364403307833695346236084048659409303573920769848114510p 0.9
+ 253031650700256287726640152261534656556281310501901346211632813005297367200363385591566303321172607728592448748646246093399847399182703828907339156728430371136199329796851364403307833695346236084048659409303573920769848115200p 0.9
+ 253031650700256287726640152261534656556281310501901346211632813005297367200363385591566303321172607728592448748646246093399847399182703828907339156728430371136199329796851364403307833695346236084048659409303573920769848115210p -0.3
+ \]
V_wl_736 (WordLine\\<736\\> gnd!) vsource type=pwl wave=\[
+ 0    -0.3
+ 506063301400512575453280304523069313112562621003802692423265626010594734400726771183132606642345215457184897497292492186799694798365407657814678313456860742272398659593702728806615667390692472168097318818607147841539696229700p -0.3
+ 506063301400512575453280304523069313112562621003802692423265626010594734400726771183132606642345215457184897497292492186799694798365407657814678313456860742272398659593702728806615667390692472168097318818607147841539696229710p 0.9
+ 506063301400512575453280304523069313112562621003802692423265626010594734400726771183132606642345215457184897497292492186799694798365407657814678313456860742272398659593702728806615667390692472168097318818607147841539696230400p 0.9
+ 506063301400512575453280304523069313112562621003802692423265626010594734400726771183132606642345215457184897497292492186799694798365407657814678313456860742272398659593702728806615667390692472168097318818607147841539696230410p -0.3
+ \]
V_wl_737 (WordLine\\<737\\> gnd!) vsource type=pwl wave=\[
+ 0    -0.3
+ 1012126602801025150906560609046138626225125242007605384846531252021189468801453542366265213284690430914369794994584984373599389596730815315629356626913721484544797319187405457613231334781384944336194637637214295683079392460100p -0.3
+ 1012126602801025150906560609046138626225125242007605384846531252021189468801453542366265213284690430914369794994584984373599389596730815315629356626913721484544797319187405457613231334781384944336194637637214295683079392460110p 0.9
+ 1012126602801025150906560609046138626225125242007605384846531252021189468801453542366265213284690430914369794994584984373599389596730815315629356626913721484544797319187405457613231334781384944336194637637214295683079392460800p 0.9
+ 1012126602801025150906560609046138626225125242007605384846531252021189468801453542366265213284690430914369794994584984373599389596730815315629356626913721484544797319187405457613231334781384944336194637637214295683079392460810p -0.3
+ \]
V_wl_738 (WordLine\\<738\\> gnd!) vsource type=pwl wave=\[
+ 0    -0.3
+ 2024253205602050301813121218092277252450250484015210769693062504042378937602907084732530426569380861828739589989169968747198779193461630631258713253827442969089594638374810915226462669562769888672389275274428591366158784920900p -0.3
+ 2024253205602050301813121218092277252450250484015210769693062504042378937602907084732530426569380861828739589989169968747198779193461630631258713253827442969089594638374810915226462669562769888672389275274428591366158784920910p 0.9
+ 2024253205602050301813121218092277252450250484015210769693062504042378937602907084732530426569380861828739589989169968747198779193461630631258713253827442969089594638374810915226462669562769888672389275274428591366158784921600p 0.9
+ 2024253205602050301813121218092277252450250484015210769693062504042378937602907084732530426569380861828739589989169968747198779193461630631258713253827442969089594638374810915226462669562769888672389275274428591366158784921610p -0.3
+ \]
V_wl_739 (WordLine\\<739\\> gnd!) vsource type=pwl wave=\[
+ 0    -0.3
+ 4048506411204100603626242436184554504900500968030421539386125008084757875205814169465060853138761723657479179978339937494397558386923261262517426507654885938179189276749621830452925339125539777344778550548857182732317569842500p -0.3
+ 4048506411204100603626242436184554504900500968030421539386125008084757875205814169465060853138761723657479179978339937494397558386923261262517426507654885938179189276749621830452925339125539777344778550548857182732317569842510p 0.9
+ 4048506411204100603626242436184554504900500968030421539386125008084757875205814169465060853138761723657479179978339937494397558386923261262517426507654885938179189276749621830452925339125539777344778550548857182732317569843200p 0.9
+ 4048506411204100603626242436184554504900500968030421539386125008084757875205814169465060853138761723657479179978339937494397558386923261262517426507654885938179189276749621830452925339125539777344778550548857182732317569843210p -0.3
+ \]
V_wl_740 (WordLine\\<740\\> gnd!) vsource type=pwl wave=\[
+ 0    -0.3
+ 8097012822408201207252484872369109009801001936060843078772250016169515750411628338930121706277523447314958359956679874988795116773846522525034853015309771876358378553499243660905850678251079554689557101097714365464635139685700p -0.3
+ 8097012822408201207252484872369109009801001936060843078772250016169515750411628338930121706277523447314958359956679874988795116773846522525034853015309771876358378553499243660905850678251079554689557101097714365464635139685710p 0.9
+ 8097012822408201207252484872369109009801001936060843078772250016169515750411628338930121706277523447314958359956679874988795116773846522525034853015309771876358378553499243660905850678251079554689557101097714365464635139686400p 0.9
+ 8097012822408201207252484872369109009801001936060843078772250016169515750411628338930121706277523447314958359956679874988795116773846522525034853015309771876358378553499243660905850678251079554689557101097714365464635139686410p -0.3
+ \]
V_wl_741 (WordLine\\<741\\> gnd!) vsource type=pwl wave=\[
+ 0    -0.3
+ 16194025644816402414504969744738218019602003872121686157544500032339031500823256677860243412555046894629916719913359749977590233547693045050069706030619543752716757106998487321811701356502159109379114202195428730929270279372100p -0.3
+ 16194025644816402414504969744738218019602003872121686157544500032339031500823256677860243412555046894629916719913359749977590233547693045050069706030619543752716757106998487321811701356502159109379114202195428730929270279372110p 0.9
+ 16194025644816402414504969744738218019602003872121686157544500032339031500823256677860243412555046894629916719913359749977590233547693045050069706030619543752716757106998487321811701356502159109379114202195428730929270279372800p 0.9
+ 16194025644816402414504969744738218019602003872121686157544500032339031500823256677860243412555046894629916719913359749977590233547693045050069706030619543752716757106998487321811701356502159109379114202195428730929270279372810p -0.3
+ \]
V_wl_742 (WordLine\\<742\\> gnd!) vsource type=pwl wave=\[
+ 0    -0.3
+ 32388051289632804829009939489476436039204007744243372315089000064678063001646513355720486825110093789259833439826719499955180467095386090100139412061239087505433514213996974643623402713004318218758228404390857461858540558744900p -0.3
+ 32388051289632804829009939489476436039204007744243372315089000064678063001646513355720486825110093789259833439826719499955180467095386090100139412061239087505433514213996974643623402713004318218758228404390857461858540558744910p 0.9
+ 32388051289632804829009939489476436039204007744243372315089000064678063001646513355720486825110093789259833439826719499955180467095386090100139412061239087505433514213996974643623402713004318218758228404390857461858540558745600p 0.9
+ 32388051289632804829009939489476436039204007744243372315089000064678063001646513355720486825110093789259833439826719499955180467095386090100139412061239087505433514213996974643623402713004318218758228404390857461858540558745610p -0.3
+ \]
V_wl_743 (WordLine\\<743\\> gnd!) vsource type=pwl wave=\[
+ 0    -0.3
+ 64776102579265609658019878978952872078408015488486744630178000129356126003293026711440973650220187578519666879653438999910360934190772180200278824122478175010867028427993949287246805426008636437516456808781714923717081117490500p -0.3
+ 64776102579265609658019878978952872078408015488486744630178000129356126003293026711440973650220187578519666879653438999910360934190772180200278824122478175010867028427993949287246805426008636437516456808781714923717081117490510p 0.9
+ 64776102579265609658019878978952872078408015488486744630178000129356126003293026711440973650220187578519666879653438999910360934190772180200278824122478175010867028427993949287246805426008636437516456808781714923717081117491200p 0.9
+ 64776102579265609658019878978952872078408015488486744630178000129356126003293026711440973650220187578519666879653438999910360934190772180200278824122478175010867028427993949287246805426008636437516456808781714923717081117491210p -0.3
+ \]
V_wl_744 (WordLine\\<744\\> gnd!) vsource type=pwl wave=\[
+ 0    -0.3
+ 129552205158531219316039757957905744156816030976973489260356000258712252006586053422881947300440375157039333759306877999820721868381544360400557648244956350021734056855987898574493610852017272875032913617563429847434162234981700p -0.3
+ 129552205158531219316039757957905744156816030976973489260356000258712252006586053422881947300440375157039333759306877999820721868381544360400557648244956350021734056855987898574493610852017272875032913617563429847434162234981710p 0.9
+ 129552205158531219316039757957905744156816030976973489260356000258712252006586053422881947300440375157039333759306877999820721868381544360400557648244956350021734056855987898574493610852017272875032913617563429847434162234982400p 0.9
+ 129552205158531219316039757957905744156816030976973489260356000258712252006586053422881947300440375157039333759306877999820721868381544360400557648244956350021734056855987898574493610852017272875032913617563429847434162234982410p -0.3
+ \]
V_wl_745 (WordLine\\<745\\> gnd!) vsource type=pwl wave=\[
+ 0    -0.3
+ 259104410317062438632079515915811488313632061953946978520712000517424504013172106845763894600880750314078667518613755999641443736763088720801115296489912700043468113711975797148987221704034545750065827235126859694868324469964100p -0.3
+ 259104410317062438632079515915811488313632061953946978520712000517424504013172106845763894600880750314078667518613755999641443736763088720801115296489912700043468113711975797148987221704034545750065827235126859694868324469964110p 0.9
+ 259104410317062438632079515915811488313632061953946978520712000517424504013172106845763894600880750314078667518613755999641443736763088720801115296489912700043468113711975797148987221704034545750065827235126859694868324469964800p 0.9
+ 259104410317062438632079515915811488313632061953946978520712000517424504013172106845763894600880750314078667518613755999641443736763088720801115296489912700043468113711975797148987221704034545750065827235126859694868324469964810p -0.3
+ \]
V_wl_746 (WordLine\\<746\\> gnd!) vsource type=pwl wave=\[
+ 0    -0.3
+ 518208820634124877264159031831622976627264123907893957041424001034849008026344213691527789201761500628157335037227511999282887473526177441602230592979825400086936227423951594297974443408069091500131654470253719389736648939928900p -0.3
+ 518208820634124877264159031831622976627264123907893957041424001034849008026344213691527789201761500628157335037227511999282887473526177441602230592979825400086936227423951594297974443408069091500131654470253719389736648939928910p 0.9
+ 518208820634124877264159031831622976627264123907893957041424001034849008026344213691527789201761500628157335037227511999282887473526177441602230592979825400086936227423951594297974443408069091500131654470253719389736648939929600p 0.9
+ 518208820634124877264159031831622976627264123907893957041424001034849008026344213691527789201761500628157335037227511999282887473526177441602230592979825400086936227423951594297974443408069091500131654470253719389736648939929610p -0.3
+ \]
V_wl_747 (WordLine\\<747\\> gnd!) vsource type=pwl wave=\[
+ 0    -0.3
+ 1036417641268249754528318063663245953254528247815787914082848002069698016052688427383055578403523001256314670074455023998565774947052354883204461185959650800173872454847903188595948886816138183000263308940507438779473297879858500p -0.3
+ 1036417641268249754528318063663245953254528247815787914082848002069698016052688427383055578403523001256314670074455023998565774947052354883204461185959650800173872454847903188595948886816138183000263308940507438779473297879858510p 0.9
+ 1036417641268249754528318063663245953254528247815787914082848002069698016052688427383055578403523001256314670074455023998565774947052354883204461185959650800173872454847903188595948886816138183000263308940507438779473297879859200p 0.9
+ 1036417641268249754528318063663245953254528247815787914082848002069698016052688427383055578403523001256314670074455023998565774947052354883204461185959650800173872454847903188595948886816138183000263308940507438779473297879859210p -0.3
+ \]
V_wl_748 (WordLine\\<748\\> gnd!) vsource type=pwl wave=\[
+ 0    -0.3
+ 2072835282536499509056636127326491906509056495631575828165696004139396032105376854766111156807046002512629340148910047997131549894104709766408922371919301600347744909695806377191897773632276366000526617881014877558946595759717700p -0.3
+ 2072835282536499509056636127326491906509056495631575828165696004139396032105376854766111156807046002512629340148910047997131549894104709766408922371919301600347744909695806377191897773632276366000526617881014877558946595759717710p 0.9
+ 2072835282536499509056636127326491906509056495631575828165696004139396032105376854766111156807046002512629340148910047997131549894104709766408922371919301600347744909695806377191897773632276366000526617881014877558946595759718400p 0.9
+ 2072835282536499509056636127326491906509056495631575828165696004139396032105376854766111156807046002512629340148910047997131549894104709766408922371919301600347744909695806377191897773632276366000526617881014877558946595759718410p -0.3
+ \]
V_wl_749 (WordLine\\<749\\> gnd!) vsource type=pwl wave=\[
+ 0    -0.3
+ 4145670565072999018113272254652983813018112991263151656331392008278792064210753709532222313614092005025258680297820095994263099788209419532817844743838603200695489819391612754383795547264552732001053235762029755117893191519436100p -0.3
+ 4145670565072999018113272254652983813018112991263151656331392008278792064210753709532222313614092005025258680297820095994263099788209419532817844743838603200695489819391612754383795547264552732001053235762029755117893191519436110p 0.9
+ 4145670565072999018113272254652983813018112991263151656331392008278792064210753709532222313614092005025258680297820095994263099788209419532817844743838603200695489819391612754383795547264552732001053235762029755117893191519436800p 0.9
+ 4145670565072999018113272254652983813018112991263151656331392008278792064210753709532222313614092005025258680297820095994263099788209419532817844743838603200695489819391612754383795547264552732001053235762029755117893191519436810p -0.3
+ \]
V_wl_750 (WordLine\\<750\\> gnd!) vsource type=pwl wave=\[
+ 0    -0.3
+ 8291341130145998036226544509305967626036225982526303312662784016557584128421507419064444627228184010050517360595640191988526199576418839065635689487677206401390979638783225508767591094529105464002106471524059510235786383038872900p -0.3
+ 8291341130145998036226544509305967626036225982526303312662784016557584128421507419064444627228184010050517360595640191988526199576418839065635689487677206401390979638783225508767591094529105464002106471524059510235786383038872910p 0.9
+ 8291341130145998036226544509305967626036225982526303312662784016557584128421507419064444627228184010050517360595640191988526199576418839065635689487677206401390979638783225508767591094529105464002106471524059510235786383038873600p 0.9
+ 8291341130145998036226544509305967626036225982526303312662784016557584128421507419064444627228184010050517360595640191988526199576418839065635689487677206401390979638783225508767591094529105464002106471524059510235786383038873610p -0.3
+ \]
V_wl_751 (WordLine\\<751\\> gnd!) vsource type=pwl wave=\[
+ 0    -0.3
+ 16582682260291996072453089018611935252072451965052606625325568033115168256843014838128889254456368020101034721191280383977052399152837678131271378975354412802781959277566451017535182189058210928004212943048119020471572766077746500p -0.3
+ 16582682260291996072453089018611935252072451965052606625325568033115168256843014838128889254456368020101034721191280383977052399152837678131271378975354412802781959277566451017535182189058210928004212943048119020471572766077746510p 0.9
+ 16582682260291996072453089018611935252072451965052606625325568033115168256843014838128889254456368020101034721191280383977052399152837678131271378975354412802781959277566451017535182189058210928004212943048119020471572766077747200p 0.9
+ 16582682260291996072453089018611935252072451965052606625325568033115168256843014838128889254456368020101034721191280383977052399152837678131271378975354412802781959277566451017535182189058210928004212943048119020471572766077747210p -0.3
+ \]
V_wl_752 (WordLine\\<752\\> gnd!) vsource type=pwl wave=\[
+ 0    -0.3
+ 33165364520583992144906178037223870504144903930105213250651136066230336513686029676257778508912736040202069442382560767954104798305675356262542757950708825605563918555132902035070364378116421856008425886096238040943145532155493700p -0.3
+ 33165364520583992144906178037223870504144903930105213250651136066230336513686029676257778508912736040202069442382560767954104798305675356262542757950708825605563918555132902035070364378116421856008425886096238040943145532155493710p 0.9
+ 33165364520583992144906178037223870504144903930105213250651136066230336513686029676257778508912736040202069442382560767954104798305675356262542757950708825605563918555132902035070364378116421856008425886096238040943145532155494400p 0.9
+ 33165364520583992144906178037223870504144903930105213250651136066230336513686029676257778508912736040202069442382560767954104798305675356262542757950708825605563918555132902035070364378116421856008425886096238040943145532155494410p -0.3
+ \]
V_wl_753 (WordLine\\<753\\> gnd!) vsource type=pwl wave=\[
+ 0    -0.3
+ 66330729041167984289812356074447741008289807860210426501302272132460673027372059352515557017825472080404138884765121535908209596611350712525085515901417651211127837110265804070140728756232843712016851772192476081886291064310988100p -0.3
+ 66330729041167984289812356074447741008289807860210426501302272132460673027372059352515557017825472080404138884765121535908209596611350712525085515901417651211127837110265804070140728756232843712016851772192476081886291064310988110p 0.9
+ 66330729041167984289812356074447741008289807860210426501302272132460673027372059352515557017825472080404138884765121535908209596611350712525085515901417651211127837110265804070140728756232843712016851772192476081886291064310988800p 0.9
+ 66330729041167984289812356074447741008289807860210426501302272132460673027372059352515557017825472080404138884765121535908209596611350712525085515901417651211127837110265804070140728756232843712016851772192476081886291064310988810p -0.3
+ \]
V_wl_754 (WordLine\\<754\\> gnd!) vsource type=pwl wave=\[
+ 0    -0.3
+ 132661458082335968579624712148895482016579615720420853002604544264921346054744118705031114035650944160808277769530243071816419193222701425050171031802835302422255674220531608140281457512465687424033703544384952163772582128621976900p -0.3
+ 132661458082335968579624712148895482016579615720420853002604544264921346054744118705031114035650944160808277769530243071816419193222701425050171031802835302422255674220531608140281457512465687424033703544384952163772582128621976910p 0.9
+ 132661458082335968579624712148895482016579615720420853002604544264921346054744118705031114035650944160808277769530243071816419193222701425050171031802835302422255674220531608140281457512465687424033703544384952163772582128621977600p 0.9
+ 132661458082335968579624712148895482016579615720420853002604544264921346054744118705031114035650944160808277769530243071816419193222701425050171031802835302422255674220531608140281457512465687424033703544384952163772582128621977610p -0.3
+ \]
V_wl_755 (WordLine\\<755\\> gnd!) vsource type=pwl wave=\[
+ 0    -0.3
+ 265322916164671937159249424297790964033159231440841706005209088529842692109488237410062228071301888321616555539060486143632838386445402850100342063605670604844511348441063216280562915024931374848067407088769904327545164257243954500p -0.3
+ 265322916164671937159249424297790964033159231440841706005209088529842692109488237410062228071301888321616555539060486143632838386445402850100342063605670604844511348441063216280562915024931374848067407088769904327545164257243954510p 0.9
+ 265322916164671937159249424297790964033159231440841706005209088529842692109488237410062228071301888321616555539060486143632838386445402850100342063605670604844511348441063216280562915024931374848067407088769904327545164257243955200p 0.9
+ 265322916164671937159249424297790964033159231440841706005209088529842692109488237410062228071301888321616555539060486143632838386445402850100342063605670604844511348441063216280562915024931374848067407088769904327545164257243955210p -0.3
+ \]
V_wl_756 (WordLine\\<756\\> gnd!) vsource type=pwl wave=\[
+ 0    -0.3
+ 530645832329343874318498848595581928066318462881683412010418177059685384218976474820124456142603776643233111078120972287265676772890805700200684127211341209689022696882126432561125830049862749696134814177539808655090328514487909700p -0.3
+ 530645832329343874318498848595581928066318462881683412010418177059685384218976474820124456142603776643233111078120972287265676772890805700200684127211341209689022696882126432561125830049862749696134814177539808655090328514487909710p 0.9
+ 530645832329343874318498848595581928066318462881683412010418177059685384218976474820124456142603776643233111078120972287265676772890805700200684127211341209689022696882126432561125830049862749696134814177539808655090328514487910400p 0.9
+ 530645832329343874318498848595581928066318462881683412010418177059685384218976474820124456142603776643233111078120972287265676772890805700200684127211341209689022696882126432561125830049862749696134814177539808655090328514487910410p -0.3
+ \]
V_wl_757 (WordLine\\<757\\> gnd!) vsource type=pwl wave=\[
+ 0    -0.3
+ 1061291664658687748636997697191163856132636925763366824020836354119370768437952949640248912285207553286466222156241944574531353545781611400401368254422682419378045393764252865122251660099725499392269628355079617310180657028975820100p -0.3
+ 1061291664658687748636997697191163856132636925763366824020836354119370768437952949640248912285207553286466222156241944574531353545781611400401368254422682419378045393764252865122251660099725499392269628355079617310180657028975820110p 0.9
+ 1061291664658687748636997697191163856132636925763366824020836354119370768437952949640248912285207553286466222156241944574531353545781611400401368254422682419378045393764252865122251660099725499392269628355079617310180657028975820800p 0.9
+ 1061291664658687748636997697191163856132636925763366824020836354119370768437952949640248912285207553286466222156241944574531353545781611400401368254422682419378045393764252865122251660099725499392269628355079617310180657028975820810p -0.3
+ \]
V_wl_758 (WordLine\\<758\\> gnd!) vsource type=pwl wave=\[
+ 0    -0.3
+ 2122583329317375497273995394382327712265273851526733648041672708238741536875905899280497824570415106572932444312483889149062707091563222800802736508845364838756090787528505730244503320199450998784539256710159234620361314057951640900p -0.3
+ 2122583329317375497273995394382327712265273851526733648041672708238741536875905899280497824570415106572932444312483889149062707091563222800802736508845364838756090787528505730244503320199450998784539256710159234620361314057951640910p 0.9
+ 2122583329317375497273995394382327712265273851526733648041672708238741536875905899280497824570415106572932444312483889149062707091563222800802736508845364838756090787528505730244503320199450998784539256710159234620361314057951641600p 0.9
+ 2122583329317375497273995394382327712265273851526733648041672708238741536875905899280497824570415106572932444312483889149062707091563222800802736508845364838756090787528505730244503320199450998784539256710159234620361314057951641610p -0.3
+ \]
V_wl_759 (WordLine\\<759\\> gnd!) vsource type=pwl wave=\[
+ 0    -0.3
+ 4245166658634750994547990788764655424530547703053467296083345416477483073751811798560995649140830213145864888624967778298125414183126445601605473017690729677512181575057011460489006640398901997569078513420318469240722628115903282500p -0.3
+ 4245166658634750994547990788764655424530547703053467296083345416477483073751811798560995649140830213145864888624967778298125414183126445601605473017690729677512181575057011460489006640398901997569078513420318469240722628115903282510p 0.9
+ 4245166658634750994547990788764655424530547703053467296083345416477483073751811798560995649140830213145864888624967778298125414183126445601605473017690729677512181575057011460489006640398901997569078513420318469240722628115903283200p 0.9
+ 4245166658634750994547990788764655424530547703053467296083345416477483073751811798560995649140830213145864888624967778298125414183126445601605473017690729677512181575057011460489006640398901997569078513420318469240722628115903283210p -0.3
+ \]
V_wl_760 (WordLine\\<760\\> gnd!) vsource type=pwl wave=\[
+ 0    -0.3
+ 8490333317269501989095981577529310849061095406106934592166690832954966147503623597121991298281660426291729777249935556596250828366252891203210946035381459355024363150114022920978013280797803995138157026840636938481445256231806565700p -0.3
+ 8490333317269501989095981577529310849061095406106934592166690832954966147503623597121991298281660426291729777249935556596250828366252891203210946035381459355024363150114022920978013280797803995138157026840636938481445256231806565710p 0.9
+ 8490333317269501989095981577529310849061095406106934592166690832954966147503623597121991298281660426291729777249935556596250828366252891203210946035381459355024363150114022920978013280797803995138157026840636938481445256231806566400p 0.9
+ 8490333317269501989095981577529310849061095406106934592166690832954966147503623597121991298281660426291729777249935556596250828366252891203210946035381459355024363150114022920978013280797803995138157026840636938481445256231806566410p -0.3
+ \]
V_wl_761 (WordLine\\<761\\> gnd!) vsource type=pwl wave=\[
+ 0    -0.3
+ 16980666634539003978191963155058621698122190812213869184333381665909932295007247194243982596563320852583459554499871113192501656732505782406421892070762918710048726300228045841956026561595607990276314053681273876962890512463613132100p -0.3
+ 16980666634539003978191963155058621698122190812213869184333381665909932295007247194243982596563320852583459554499871113192501656732505782406421892070762918710048726300228045841956026561595607990276314053681273876962890512463613132110p 0.9
+ 16980666634539003978191963155058621698122190812213869184333381665909932295007247194243982596563320852583459554499871113192501656732505782406421892070762918710048726300228045841956026561595607990276314053681273876962890512463613132800p 0.9
+ 16980666634539003978191963155058621698122190812213869184333381665909932295007247194243982596563320852583459554499871113192501656732505782406421892070762918710048726300228045841956026561595607990276314053681273876962890512463613132810p -0.3
+ \]
V_wl_762 (WordLine\\<762\\> gnd!) vsource type=pwl wave=\[
+ 0    -0.3
+ 33961333269078007956383926310117243396244381624427738368666763331819864590014494388487965193126641705166919108999742226385003313465011564812843784141525837420097452600456091683912053123191215980552628107362547753925781024927226264900p -0.3
+ 33961333269078007956383926310117243396244381624427738368666763331819864590014494388487965193126641705166919108999742226385003313465011564812843784141525837420097452600456091683912053123191215980552628107362547753925781024927226264910p 0.9
+ 33961333269078007956383926310117243396244381624427738368666763331819864590014494388487965193126641705166919108999742226385003313465011564812843784141525837420097452600456091683912053123191215980552628107362547753925781024927226265600p 0.9
+ 33961333269078007956383926310117243396244381624427738368666763331819864590014494388487965193126641705166919108999742226385003313465011564812843784141525837420097452600456091683912053123191215980552628107362547753925781024927226265610p -0.3
+ \]
V_wl_763 (WordLine\\<763\\> gnd!) vsource type=pwl wave=\[
+ 0    -0.3
+ 67922666538156015912767852620234486792488763248855476737333526663639729180028988776975930386253283410333838217999484452770006626930023129625687568283051674840194905200912183367824106246382431961105256214725095507851562049854452530500p -0.3
+ 67922666538156015912767852620234486792488763248855476737333526663639729180028988776975930386253283410333838217999484452770006626930023129625687568283051674840194905200912183367824106246382431961105256214725095507851562049854452530510p 0.9
+ 67922666538156015912767852620234486792488763248855476737333526663639729180028988776975930386253283410333838217999484452770006626930023129625687568283051674840194905200912183367824106246382431961105256214725095507851562049854452531200p 0.9
+ 67922666538156015912767852620234486792488763248855476737333526663639729180028988776975930386253283410333838217999484452770006626930023129625687568283051674840194905200912183367824106246382431961105256214725095507851562049854452531210p -0.3
+ \]
V_wl_764 (WordLine\\<764\\> gnd!) vsource type=pwl wave=\[
+ 0    -0.3
+ 135845333076312031825535705240468973584977526497710953474667053327279458360057977553951860772506566820667676435998968905540013253860046259251375136566103349680389810401824366735648212492764863922210512429450191015703124099708905061700p -0.3
+ 135845333076312031825535705240468973584977526497710953474667053327279458360057977553951860772506566820667676435998968905540013253860046259251375136566103349680389810401824366735648212492764863922210512429450191015703124099708905061710p 0.9
+ 135845333076312031825535705240468973584977526497710953474667053327279458360057977553951860772506566820667676435998968905540013253860046259251375136566103349680389810401824366735648212492764863922210512429450191015703124099708905062400p 0.9
+ 135845333076312031825535705240468973584977526497710953474667053327279458360057977553951860772506566820667676435998968905540013253860046259251375136566103349680389810401824366735648212492764863922210512429450191015703124099708905062410p -0.3
+ \]
V_wl_765 (WordLine\\<765\\> gnd!) vsource type=pwl wave=\[
+ 0    -0.3
+ 271690666152624063651071410480937947169955052995421906949334106654558916720115955107903721545013133641335352871997937811080026507720092518502750273132206699360779620803648733471296424985529727844421024858900382031406248199417810124100p -0.3
+ 271690666152624063651071410480937947169955052995421906949334106654558916720115955107903721545013133641335352871997937811080026507720092518502750273132206699360779620803648733471296424985529727844421024858900382031406248199417810124110p 0.9
+ 271690666152624063651071410480937947169955052995421906949334106654558916720115955107903721545013133641335352871997937811080026507720092518502750273132206699360779620803648733471296424985529727844421024858900382031406248199417810124800p 0.9
+ 271690666152624063651071410480937947169955052995421906949334106654558916720115955107903721545013133641335352871997937811080026507720092518502750273132206699360779620803648733471296424985529727844421024858900382031406248199417810124810p -0.3
+ \]
V_wl_766 (WordLine\\<766\\> gnd!) vsource type=pwl wave=\[
+ 0    -0.3
+ 543381332305248127302142820961875894339910105990843813898668213309117833440231910215807443090026267282670705743995875622160053015440185037005500546264413398721559241607297466942592849971059455688842049717800764062812496398835620248900p -0.3
+ 543381332305248127302142820961875894339910105990843813898668213309117833440231910215807443090026267282670705743995875622160053015440185037005500546264413398721559241607297466942592849971059455688842049717800764062812496398835620248910p 0.9
+ 543381332305248127302142820961875894339910105990843813898668213309117833440231910215807443090026267282670705743995875622160053015440185037005500546264413398721559241607297466942592849971059455688842049717800764062812496398835620249600p 0.9
+ 543381332305248127302142820961875894339910105990843813898668213309117833440231910215807443090026267282670705743995875622160053015440185037005500546264413398721559241607297466942592849971059455688842049717800764062812496398835620249610p -0.3
+ \]
V_wl_767 (WordLine\\<767\\> gnd!) vsource type=pwl wave=\[
+ 0    -0.3
+ 1086762664610496254604285641923751788679820211981687627797336426618235666880463820431614886180052534565341411487991751244320106030880370074011001092528826797443118483214594933885185699942118911377684099435601528125624992797671240498500p -0.3
+ 1086762664610496254604285641923751788679820211981687627797336426618235666880463820431614886180052534565341411487991751244320106030880370074011001092528826797443118483214594933885185699942118911377684099435601528125624992797671240498510p 0.9
+ 1086762664610496254604285641923751788679820211981687627797336426618235666880463820431614886180052534565341411487991751244320106030880370074011001092528826797443118483214594933885185699942118911377684099435601528125624992797671240499200p 0.9
+ 1086762664610496254604285641923751788679820211981687627797336426618235666880463820431614886180052534565341411487991751244320106030880370074011001092528826797443118483214594933885185699942118911377684099435601528125624992797671240499210p -0.3
+ \]
V_wl_768 (WordLine\\<768\\> gnd!) vsource type=pwl wave=\[
+ 0    -0.3
+ 2173525329220992509208571283847503577359640423963375255594672853236471333760927640863229772360105069130682822975983502488640212061760740148022002185057653594886236966429189867770371399884237822755368198871203056251249985595342480997700p -0.3
+ 2173525329220992509208571283847503577359640423963375255594672853236471333760927640863229772360105069130682822975983502488640212061760740148022002185057653594886236966429189867770371399884237822755368198871203056251249985595342480997710p 0.9
+ 2173525329220992509208571283847503577359640423963375255594672853236471333760927640863229772360105069130682822975983502488640212061760740148022002185057653594886236966429189867770371399884237822755368198871203056251249985595342480998400p 0.9
+ 2173525329220992509208571283847503577359640423963375255594672853236471333760927640863229772360105069130682822975983502488640212061760740148022002185057653594886236966429189867770371399884237822755368198871203056251249985595342480998410p -0.3
+ \]
V_wl_769 (WordLine\\<769\\> gnd!) vsource type=pwl wave=\[
+ 0    -0.3
+ 4347050658441985018417142567695007154719280847926750511189345706472942667521855281726459544720210138261365645951967004977280424123521480296044004370115307189772473932858379735540742799768475645510736397742406112502499971190684961996100p -0.3
+ 4347050658441985018417142567695007154719280847926750511189345706472942667521855281726459544720210138261365645951967004977280424123521480296044004370115307189772473932858379735540742799768475645510736397742406112502499971190684961996110p 0.9
+ 4347050658441985018417142567695007154719280847926750511189345706472942667521855281726459544720210138261365645951967004977280424123521480296044004370115307189772473932858379735540742799768475645510736397742406112502499971190684961996800p 0.9
+ 4347050658441985018417142567695007154719280847926750511189345706472942667521855281726459544720210138261365645951967004977280424123521480296044004370115307189772473932858379735540742799768475645510736397742406112502499971190684961996810p -0.3
+ \]
V_wl_770 (WordLine\\<770\\> gnd!) vsource type=pwl wave=\[
+ 0    -0.3
+ 8694101316883970036834285135390014309438561695853501022378691412945885335043710563452919089440420276522731291903934009954560848247042960592088008740230614379544947865716759471081485599536951291021472795484812225004999942381369923992900p -0.3
+ 8694101316883970036834285135390014309438561695853501022378691412945885335043710563452919089440420276522731291903934009954560848247042960592088008740230614379544947865716759471081485599536951291021472795484812225004999942381369923992910p 0.9
+ 8694101316883970036834285135390014309438561695853501022378691412945885335043710563452919089440420276522731291903934009954560848247042960592088008740230614379544947865716759471081485599536951291021472795484812225004999942381369923993600p 0.9
+ 8694101316883970036834285135390014309438561695853501022378691412945885335043710563452919089440420276522731291903934009954560848247042960592088008740230614379544947865716759471081485599536951291021472795484812225004999942381369923993610p -0.3
+ \]
V_wl_771 (WordLine\\<771\\> gnd!) vsource type=pwl wave=\[
+ 0    -0.3
+ 17388202633767940073668570270780028618877123391707002044757382825891770670087421126905838178880840553045462583807868019909121696494085921184176017480461228759089895731433518942162971199073902582042945590969624450009999884762739847986500p -0.3
+ 17388202633767940073668570270780028618877123391707002044757382825891770670087421126905838178880840553045462583807868019909121696494085921184176017480461228759089895731433518942162971199073902582042945590969624450009999884762739847986510p 0.9
+ 17388202633767940073668570270780028618877123391707002044757382825891770670087421126905838178880840553045462583807868019909121696494085921184176017480461228759089895731433518942162971199073902582042945590969624450009999884762739847987200p 0.9
+ 17388202633767940073668570270780028618877123391707002044757382825891770670087421126905838178880840553045462583807868019909121696494085921184176017480461228759089895731433518942162971199073902582042945590969624450009999884762739847987210p -0.3
+ \]
V_wl_772 (WordLine\\<772\\> gnd!) vsource type=pwl wave=\[
+ 0    -0.3
+ 34776405267535880147337140541560057237754246783414004089514765651783541340174842253811676357761681106090925167615736039818243392988171842368352034960922457518179791462867037884325942398147805164085891181939248900019999769525479695973700p -0.3
+ 34776405267535880147337140541560057237754246783414004089514765651783541340174842253811676357761681106090925167615736039818243392988171842368352034960922457518179791462867037884325942398147805164085891181939248900019999769525479695973710p 0.9
+ 34776405267535880147337140541560057237754246783414004089514765651783541340174842253811676357761681106090925167615736039818243392988171842368352034960922457518179791462867037884325942398147805164085891181939248900019999769525479695974400p 0.9
+ 34776405267535880147337140541560057237754246783414004089514765651783541340174842253811676357761681106090925167615736039818243392988171842368352034960922457518179791462867037884325942398147805164085891181939248900019999769525479695974410p -0.3
+ \]
V_wl_773 (WordLine\\<773\\> gnd!) vsource type=pwl wave=\[
+ 0    -0.3
+ 69552810535071760294674281083120114475508493566828008179029531303567082680349684507623352715523362212181850335231472079636486785976343684736704069921844915036359582925734075768651884796295610328171782363878497800039999539050959391948100p -0.3
+ 69552810535071760294674281083120114475508493566828008179029531303567082680349684507623352715523362212181850335231472079636486785976343684736704069921844915036359582925734075768651884796295610328171782363878497800039999539050959391948110p 0.9
+ 69552810535071760294674281083120114475508493566828008179029531303567082680349684507623352715523362212181850335231472079636486785976343684736704069921844915036359582925734075768651884796295610328171782363878497800039999539050959391948800p 0.9
+ 69552810535071760294674281083120114475508493566828008179029531303567082680349684507623352715523362212181850335231472079636486785976343684736704069921844915036359582925734075768651884796295610328171782363878497800039999539050959391948810p -0.3
+ \]
V_wl_774 (WordLine\\<774\\> gnd!) vsource type=pwl wave=\[
+ 0    -0.3
+ 139105621070143520589348562166240228951016987133656016358059062607134165360699369015246705431046724424363700670462944159272973571952687369473408139843689830072719165851468151537303769592591220656343564727756995600079999078101918783896900p -0.3
+ 139105621070143520589348562166240228951016987133656016358059062607134165360699369015246705431046724424363700670462944159272973571952687369473408139843689830072719165851468151537303769592591220656343564727756995600079999078101918783896910p 0.9
+ 139105621070143520589348562166240228951016987133656016358059062607134165360699369015246705431046724424363700670462944159272973571952687369473408139843689830072719165851468151537303769592591220656343564727756995600079999078101918783897600p 0.9
+ 139105621070143520589348562166240228951016987133656016358059062607134165360699369015246705431046724424363700670462944159272973571952687369473408139843689830072719165851468151537303769592591220656343564727756995600079999078101918783897610p -0.3
+ \]
V_wl_775 (WordLine\\<775\\> gnd!) vsource type=pwl wave=\[
+ 0    -0.3
+ 278211242140287041178697124332480457902033974267312032716118125214268330721398738030493410862093448848727401340925888318545947143905374738946816279687379660145438331702936303074607539185182441312687129455513991200159998156203837567794500p -0.3
+ 278211242140287041178697124332480457902033974267312032716118125214268330721398738030493410862093448848727401340925888318545947143905374738946816279687379660145438331702936303074607539185182441312687129455513991200159998156203837567794510p 0.9
+ 278211242140287041178697124332480457902033974267312032716118125214268330721398738030493410862093448848727401340925888318545947143905374738946816279687379660145438331702936303074607539185182441312687129455513991200159998156203837567795200p 0.9
+ 278211242140287041178697124332480457902033974267312032716118125214268330721398738030493410862093448848727401340925888318545947143905374738946816279687379660145438331702936303074607539185182441312687129455513991200159998156203837567795210p -0.3
+ \]
V_wl_776 (WordLine\\<776\\> gnd!) vsource type=pwl wave=\[
+ 0    -0.3
+ 556422484280574082357394248664960915804067948534624065432236250428536661442797476060986821724186897697454802681851776637091894287810749477893632559374759320290876663405872606149215078370364882625374258911027982400319996312407675135589700p -0.3
+ 556422484280574082357394248664960915804067948534624065432236250428536661442797476060986821724186897697454802681851776637091894287810749477893632559374759320290876663405872606149215078370364882625374258911027982400319996312407675135589710p 0.9
+ 556422484280574082357394248664960915804067948534624065432236250428536661442797476060986821724186897697454802681851776637091894287810749477893632559374759320290876663405872606149215078370364882625374258911027982400319996312407675135590400p 0.9
+ 556422484280574082357394248664960915804067948534624065432236250428536661442797476060986821724186897697454802681851776637091894287810749477893632559374759320290876663405872606149215078370364882625374258911027982400319996312407675135590410p -0.3
+ \]
V_wl_777 (WordLine\\<777\\> gnd!) vsource type=pwl wave=\[
+ 0    -0.3
+ 1112844968561148164714788497329921831608135897069248130864472500857073322885594952121973643448373795394909605363703553274183788575621498955787265118749518640581753326811745212298430156740729765250748517822055964800639992624815350271180100p -0.3
+ 1112844968561148164714788497329921831608135897069248130864472500857073322885594952121973643448373795394909605363703553274183788575621498955787265118749518640581753326811745212298430156740729765250748517822055964800639992624815350271180110p 0.9
+ 1112844968561148164714788497329921831608135897069248130864472500857073322885594952121973643448373795394909605363703553274183788575621498955787265118749518640581753326811745212298430156740729765250748517822055964800639992624815350271180800p 0.9
+ 1112844968561148164714788497329921831608135897069248130864472500857073322885594952121973643448373795394909605363703553274183788575621498955787265118749518640581753326811745212298430156740729765250748517822055964800639992624815350271180810p -0.3
+ \]
V_wl_778 (WordLine\\<778\\> gnd!) vsource type=pwl wave=\[
+ 0    -0.3
+ 2225689937122296329429576994659843663216271794138496261728945001714146645771189904243947286896747590789819210727407106548367577151242997911574530237499037281163506653623490424596860313481459530501497035644111929601279985249630700542360900p -0.3
+ 2225689937122296329429576994659843663216271794138496261728945001714146645771189904243947286896747590789819210727407106548367577151242997911574530237499037281163506653623490424596860313481459530501497035644111929601279985249630700542360910p 0.9
+ 2225689937122296329429576994659843663216271794138496261728945001714146645771189904243947286896747590789819210727407106548367577151242997911574530237499037281163506653623490424596860313481459530501497035644111929601279985249630700542361600p 0.9
+ 2225689937122296329429576994659843663216271794138496261728945001714146645771189904243947286896747590789819210727407106548367577151242997911574530237499037281163506653623490424596860313481459530501497035644111929601279985249630700542361610p -0.3
+ \]
V_wl_779 (WordLine\\<779\\> gnd!) vsource type=pwl wave=\[
+ 0    -0.3
+ 4451379874244592658859153989319687326432543588276992523457890003428293291542379808487894573793495181579638421454814213096735154302485995823149060474998074562327013307246980849193720626962919061002994071288223859202559970499261401084722500p -0.3
+ 4451379874244592658859153989319687326432543588276992523457890003428293291542379808487894573793495181579638421454814213096735154302485995823149060474998074562327013307246980849193720626962919061002994071288223859202559970499261401084722510p 0.9
+ 4451379874244592658859153989319687326432543588276992523457890003428293291542379808487894573793495181579638421454814213096735154302485995823149060474998074562327013307246980849193720626962919061002994071288223859202559970499261401084723200p 0.9
+ 4451379874244592658859153989319687326432543588276992523457890003428293291542379808487894573793495181579638421454814213096735154302485995823149060474998074562327013307246980849193720626962919061002994071288223859202559970499261401084723210p -0.3
+ \]
V_wl_780 (WordLine\\<780\\> gnd!) vsource type=pwl wave=\[
+ 0    -0.3
+ 8902759748489185317718307978639374652865087176553985046915780006856586583084759616975789147586990363159276842909628426193470308604971991646298120949996149124654026614493961698387441253925838122005988142576447718405119940998522802169445700p -0.3
+ 8902759748489185317718307978639374652865087176553985046915780006856586583084759616975789147586990363159276842909628426193470308604971991646298120949996149124654026614493961698387441253925838122005988142576447718405119940998522802169445710p 0.9
+ 8902759748489185317718307978639374652865087176553985046915780006856586583084759616975789147586990363159276842909628426193470308604971991646298120949996149124654026614493961698387441253925838122005988142576447718405119940998522802169446400p 0.9
+ 8902759748489185317718307978639374652865087176553985046915780006856586583084759616975789147586990363159276842909628426193470308604971991646298120949996149124654026614493961698387441253925838122005988142576447718405119940998522802169446410p -0.3
+ \]
V_wl_781 (WordLine\\<781\\> gnd!) vsource type=pwl wave=\[
+ 0    -0.3
+ 17805519496978370635436615957278749305730174353107970093831560013713173166169519233951578295173980726318553685819256852386940617209943983292596241899992298249308053228987923396774882507851676244011976285152895436810239881997045604338892100p -0.3
+ 17805519496978370635436615957278749305730174353107970093831560013713173166169519233951578295173980726318553685819256852386940617209943983292596241899992298249308053228987923396774882507851676244011976285152895436810239881997045604338892110p 0.9
+ 17805519496978370635436615957278749305730174353107970093831560013713173166169519233951578295173980726318553685819256852386940617209943983292596241899992298249308053228987923396774882507851676244011976285152895436810239881997045604338892800p 0.9
+ 17805519496978370635436615957278749305730174353107970093831560013713173166169519233951578295173980726318553685819256852386940617209943983292596241899992298249308053228987923396774882507851676244011976285152895436810239881997045604338892810p -0.3
+ \]
V_wl_782 (WordLine\\<782\\> gnd!) vsource type=pwl wave=\[
+ 0    -0.3
+ 35611038993956741270873231914557498611460348706215940187663120027426346332339038467903156590347961452637107371638513704773881234419887966585192483799984596498616106457975846793549765015703352488023952570305790873620479763994091208677784900p -0.3
+ 35611038993956741270873231914557498611460348706215940187663120027426346332339038467903156590347961452637107371638513704773881234419887966585192483799984596498616106457975846793549765015703352488023952570305790873620479763994091208677784910p 0.9
+ 35611038993956741270873231914557498611460348706215940187663120027426346332339038467903156590347961452637107371638513704773881234419887966585192483799984596498616106457975846793549765015703352488023952570305790873620479763994091208677785600p 0.9
+ 35611038993956741270873231914557498611460348706215940187663120027426346332339038467903156590347961452637107371638513704773881234419887966585192483799984596498616106457975846793549765015703352488023952570305790873620479763994091208677785610p -0.3
+ \]
V_wl_783 (WordLine\\<783\\> gnd!) vsource type=pwl wave=\[
+ 0    -0.3
+ 71222077987913482541746463829114997222920697412431880375326240054852692664678076935806313180695922905274214743277027409547762468839775933170384967599969192997232212915951693587099530031406704976047905140611581747240959527988182417355570500p -0.3
+ 71222077987913482541746463829114997222920697412431880375326240054852692664678076935806313180695922905274214743277027409547762468839775933170384967599969192997232212915951693587099530031406704976047905140611581747240959527988182417355570510p 0.9
+ 71222077987913482541746463829114997222920697412431880375326240054852692664678076935806313180695922905274214743277027409547762468839775933170384967599969192997232212915951693587099530031406704976047905140611581747240959527988182417355571200p 0.9
+ 71222077987913482541746463829114997222920697412431880375326240054852692664678076935806313180695922905274214743277027409547762468839775933170384967599969192997232212915951693587099530031406704976047905140611581747240959527988182417355571210p -0.3
+ \]
V_wl_784 (WordLine\\<784\\> gnd!) vsource type=pwl wave=\[
+ 0    -0.3
+ 142444155975826965083492927658229994445841394824863760750652480109705385329356153871612626361391845810548429486554054819095524937679551866340769935199938385994464425831903387174199060062813409952095810281223163494481919055976364834711141700p -0.3
+ 142444155975826965083492927658229994445841394824863760750652480109705385329356153871612626361391845810548429486554054819095524937679551866340769935199938385994464425831903387174199060062813409952095810281223163494481919055976364834711141710p 0.9
+ 142444155975826965083492927658229994445841394824863760750652480109705385329356153871612626361391845810548429486554054819095524937679551866340769935199938385994464425831903387174199060062813409952095810281223163494481919055976364834711142400p 0.9
+ 142444155975826965083492927658229994445841394824863760750652480109705385329356153871612626361391845810548429486554054819095524937679551866340769935199938385994464425831903387174199060062813409952095810281223163494481919055976364834711142410p -0.3
+ \]
V_wl_785 (WordLine\\<785\\> gnd!) vsource type=pwl wave=\[
+ 0    -0.3
+ 284888311951653930166985855316459988891682789649727521501304960219410770658712307743225252722783691621096858973108109638191049875359103732681539870399876771988928851663806774348398120125626819904191620562446326988963838111952729669422284100p -0.3
+ 284888311951653930166985855316459988891682789649727521501304960219410770658712307743225252722783691621096858973108109638191049875359103732681539870399876771988928851663806774348398120125626819904191620562446326988963838111952729669422284110p 0.9
+ 284888311951653930166985855316459988891682789649727521501304960219410770658712307743225252722783691621096858973108109638191049875359103732681539870399876771988928851663806774348398120125626819904191620562446326988963838111952729669422284800p 0.9
+ 284888311951653930166985855316459988891682789649727521501304960219410770658712307743225252722783691621096858973108109638191049875359103732681539870399876771988928851663806774348398120125626819904191620562446326988963838111952729669422284810p -0.3
+ \]
V_wl_786 (WordLine\\<786\\> gnd!) vsource type=pwl wave=\[
+ 0    -0.3
+ 569776623903307860333971710632919977783365579299455043002609920438821541317424615486450505445567383242193717946216219276382099750718207465363079740799753543977857703327613548696796240251253639808383241124892653977927676223905459338844568900p -0.3
+ 569776623903307860333971710632919977783365579299455043002609920438821541317424615486450505445567383242193717946216219276382099750718207465363079740799753543977857703327613548696796240251253639808383241124892653977927676223905459338844568910p 0.9
+ 569776623903307860333971710632919977783365579299455043002609920438821541317424615486450505445567383242193717946216219276382099750718207465363079740799753543977857703327613548696796240251253639808383241124892653977927676223905459338844569600p 0.9
+ 569776623903307860333971710632919977783365579299455043002609920438821541317424615486450505445567383242193717946216219276382099750718207465363079740799753543977857703327613548696796240251253639808383241124892653977927676223905459338844569610p -0.3
+ \]
V_wl_787 (WordLine\\<787\\> gnd!) vsource type=pwl wave=\[
+ 0    -0.3
+ 1139553247806615720667943421265839955566731158598910086005219840877643082634849230972901010891134766484387435892432438552764199501436414930726159481599507087955715406655227097393592480502507279616766482249785307955855352447810918677689138500p -0.3
+ 1139553247806615720667943421265839955566731158598910086005219840877643082634849230972901010891134766484387435892432438552764199501436414930726159481599507087955715406655227097393592480502507279616766482249785307955855352447810918677689138510p 0.9
+ 1139553247806615720667943421265839955566731158598910086005219840877643082634849230972901010891134766484387435892432438552764199501436414930726159481599507087955715406655227097393592480502507279616766482249785307955855352447810918677689139200p 0.9
+ 1139553247806615720667943421265839955566731158598910086005219840877643082634849230972901010891134766484387435892432438552764199501436414930726159481599507087955715406655227097393592480502507279616766482249785307955855352447810918677689139210p -0.3
+ \]
V_wl_788 (WordLine\\<788\\> gnd!) vsource type=pwl wave=\[
+ 0    -0.3
+ 2279106495613231441335886842531679911133462317197820172010439681755286165269698461945802021782269532968774871784864877105528399002872829861452318963199014175911430813310454194787184961005014559233532964499570615911710704895621837355378277700p -0.3
+ 2279106495613231441335886842531679911133462317197820172010439681755286165269698461945802021782269532968774871784864877105528399002872829861452318963199014175911430813310454194787184961005014559233532964499570615911710704895621837355378277710p 0.9
+ 2279106495613231441335886842531679911133462317197820172010439681755286165269698461945802021782269532968774871784864877105528399002872829861452318963199014175911430813310454194787184961005014559233532964499570615911710704895621837355378278400p 0.9
+ 2279106495613231441335886842531679911133462317197820172010439681755286165269698461945802021782269532968774871784864877105528399002872829861452318963199014175911430813310454194787184961005014559233532964499570615911710704895621837355378278410p -0.3
+ \]
V_wl_789 (WordLine\\<789\\> gnd!) vsource type=pwl wave=\[
+ 0    -0.3
+ 4558212991226462882671773685063359822266924634395640344020879363510572330539396923891604043564539065937549743569729754211056798005745659722904637926398028351822861626620908389574369922010029118467065928999141231823421409791243674710756556100p -0.3
+ 4558212991226462882671773685063359822266924634395640344020879363510572330539396923891604043564539065937549743569729754211056798005745659722904637926398028351822861626620908389574369922010029118467065928999141231823421409791243674710756556110p 0.9
+ 4558212991226462882671773685063359822266924634395640344020879363510572330539396923891604043564539065937549743569729754211056798005745659722904637926398028351822861626620908389574369922010029118467065928999141231823421409791243674710756556800p 0.9
+ 4558212991226462882671773685063359822266924634395640344020879363510572330539396923891604043564539065937549743569729754211056798005745659722904637926398028351822861626620908389574369922010029118467065928999141231823421409791243674710756556810p -0.3
+ \]
V_wl_790 (WordLine\\<790\\> gnd!) vsource type=pwl wave=\[
+ 0    -0.3
+ 9116425982452925765343547370126719644533849268791280688041758727021144661078793847783208087129078131875099487139459508422113596011491319445809275852796056703645723253241816779148739844020058236934131857998282463646842819582487349421513112900p -0.3
+ 9116425982452925765343547370126719644533849268791280688041758727021144661078793847783208087129078131875099487139459508422113596011491319445809275852796056703645723253241816779148739844020058236934131857998282463646842819582487349421513112910p 0.9
+ 9116425982452925765343547370126719644533849268791280688041758727021144661078793847783208087129078131875099487139459508422113596011491319445809275852796056703645723253241816779148739844020058236934131857998282463646842819582487349421513113600p 0.9
+ 9116425982452925765343547370126719644533849268791280688041758727021144661078793847783208087129078131875099487139459508422113596011491319445809275852796056703645723253241816779148739844020058236934131857998282463646842819582487349421513113610p -0.3
+ \]
V_wl_791 (WordLine\\<791\\> gnd!) vsource type=pwl wave=\[
+ 0    -0.3
+ 18232851964905851530687094740253439289067698537582561376083517454042289322157587695566416174258156263750198974278919016844227192022982638891618551705592113407291446506483633558297479688040116473868263715996564927293685639164974698843026226500p -0.3
+ 18232851964905851530687094740253439289067698537582561376083517454042289322157587695566416174258156263750198974278919016844227192022982638891618551705592113407291446506483633558297479688040116473868263715996564927293685639164974698843026226510p 0.9
+ 18232851964905851530687094740253439289067698537582561376083517454042289322157587695566416174258156263750198974278919016844227192022982638891618551705592113407291446506483633558297479688040116473868263715996564927293685639164974698843026227200p 0.9
+ 18232851964905851530687094740253439289067698537582561376083517454042289322157587695566416174258156263750198974278919016844227192022982638891618551705592113407291446506483633558297479688040116473868263715996564927293685639164974698843026227210p -0.3
+ \]
V_wl_792 (WordLine\\<792\\> gnd!) vsource type=pwl wave=\[
+ 0    -0.3
+ 36465703929811703061374189480506878578135397075165122752167034908084578644315175391132832348516312527500397948557838033688454384045965277783237103411184226814582893012967267116594959376080232947736527431993129854587371278329949397686052453700p -0.3
+ 36465703929811703061374189480506878578135397075165122752167034908084578644315175391132832348516312527500397948557838033688454384045965277783237103411184226814582893012967267116594959376080232947736527431993129854587371278329949397686052453710p 0.9
+ 36465703929811703061374189480506878578135397075165122752167034908084578644315175391132832348516312527500397948557838033688454384045965277783237103411184226814582893012967267116594959376080232947736527431993129854587371278329949397686052454400p 0.9
+ 36465703929811703061374189480506878578135397075165122752167034908084578644315175391132832348516312527500397948557838033688454384045965277783237103411184226814582893012967267116594959376080232947736527431993129854587371278329949397686052454410p -0.3
+ \]
V_wl_793 (WordLine\\<793\\> gnd!) vsource type=pwl wave=\[
+ 0    -0.3
+ 72931407859623406122748378961013757156270794150330245504334069816169157288630350782265664697032625055000795897115676067376908768091930555566474206822368453629165786025934534233189918752160465895473054863986259709174742556659898795372104908100p -0.3
+ 72931407859623406122748378961013757156270794150330245504334069816169157288630350782265664697032625055000795897115676067376908768091930555566474206822368453629165786025934534233189918752160465895473054863986259709174742556659898795372104908110p 0.9
+ 72931407859623406122748378961013757156270794150330245504334069816169157288630350782265664697032625055000795897115676067376908768091930555566474206822368453629165786025934534233189918752160465895473054863986259709174742556659898795372104908800p 0.9
+ 72931407859623406122748378961013757156270794150330245504334069816169157288630350782265664697032625055000795897115676067376908768091930555566474206822368453629165786025934534233189918752160465895473054863986259709174742556659898795372104908810p -0.3
+ \]
V_wl_794 (WordLine\\<794\\> gnd!) vsource type=pwl wave=\[
+ 0    -0.3
+ 145862815719246812245496757922027514312541588300660491008668139632338314577260701564531329394065250110001591794231352134753817536183861111132948413644736907258331572051869068466379837504320931790946109727972519418349485113319797590744209816900p -0.3
+ 145862815719246812245496757922027514312541588300660491008668139632338314577260701564531329394065250110001591794231352134753817536183861111132948413644736907258331572051869068466379837504320931790946109727972519418349485113319797590744209816910p 0.9
+ 145862815719246812245496757922027514312541588300660491008668139632338314577260701564531329394065250110001591794231352134753817536183861111132948413644736907258331572051869068466379837504320931790946109727972519418349485113319797590744209817600p 0.9
+ 145862815719246812245496757922027514312541588300660491008668139632338314577260701564531329394065250110001591794231352134753817536183861111132948413644736907258331572051869068466379837504320931790946109727972519418349485113319797590744209817610p -0.3
+ \]
V_wl_795 (WordLine\\<795\\> gnd!) vsource type=pwl wave=\[
+ 0    -0.3
+ 291725631438493624490993515844055028625083176601320982017336279264676629154521403129062658788130500220003183588462704269507635072367722222265896827289473814516663144103738136932759675008641863581892219455945038836698970226639595181488419634500p -0.3
+ 291725631438493624490993515844055028625083176601320982017336279264676629154521403129062658788130500220003183588462704269507635072367722222265896827289473814516663144103738136932759675008641863581892219455945038836698970226639595181488419634510p 0.9
+ 291725631438493624490993515844055028625083176601320982017336279264676629154521403129062658788130500220003183588462704269507635072367722222265896827289473814516663144103738136932759675008641863581892219455945038836698970226639595181488419635200p 0.9
+ 291725631438493624490993515844055028625083176601320982017336279264676629154521403129062658788130500220003183588462704269507635072367722222265896827289473814516663144103738136932759675008641863581892219455945038836698970226639595181488419635210p -0.3
+ \]
V_wl_796 (WordLine\\<796\\> gnd!) vsource type=pwl wave=\[
+ 0    -0.3
+ 583451262876987248981987031688110057250166353202641964034672558529353258309042806258125317576261000440006367176925408539015270144735444444531793654578947629033326288207476273865519350017283727163784438911890077673397940453279190362976839269700p -0.3
+ 583451262876987248981987031688110057250166353202641964034672558529353258309042806258125317576261000440006367176925408539015270144735444444531793654578947629033326288207476273865519350017283727163784438911890077673397940453279190362976839269710p 0.9
+ 583451262876987248981987031688110057250166353202641964034672558529353258309042806258125317576261000440006367176925408539015270144735444444531793654578947629033326288207476273865519350017283727163784438911890077673397940453279190362976839270400p 0.9
+ 583451262876987248981987031688110057250166353202641964034672558529353258309042806258125317576261000440006367176925408539015270144735444444531793654578947629033326288207476273865519350017283727163784438911890077673397940453279190362976839270410p -0.3
+ \]
V_wl_797 (WordLine\\<797\\> gnd!) vsource type=pwl wave=\[
+ 0    -0.3
+ 1166902525753974497963974063376220114500332706405283928069345117058706516618085612516250635152522000880012734353850817078030540289470888889063587309157895258066652576414952547731038700034567454327568877823780155346795880906558380725953678540100p -0.3
+ 1166902525753974497963974063376220114500332706405283928069345117058706516618085612516250635152522000880012734353850817078030540289470888889063587309157895258066652576414952547731038700034567454327568877823780155346795880906558380725953678540110p 0.9
+ 1166902525753974497963974063376220114500332706405283928069345117058706516618085612516250635152522000880012734353850817078030540289470888889063587309157895258066652576414952547731038700034567454327568877823780155346795880906558380725953678540800p 0.9
+ 1166902525753974497963974063376220114500332706405283928069345117058706516618085612516250635152522000880012734353850817078030540289470888889063587309157895258066652576414952547731038700034567454327568877823780155346795880906558380725953678540810p -0.3
+ \]
V_wl_798 (WordLine\\<798\\> gnd!) vsource type=pwl wave=\[
+ 0    -0.3
+ 2333805051507948995927948126752440229000665412810567856138690234117413033236171225032501270305044001760025468707701634156061080578941777778127174618315790516133305152829905095462077400069134908655137755647560310693591761813116761451907357080900p -0.3
+ 2333805051507948995927948126752440229000665412810567856138690234117413033236171225032501270305044001760025468707701634156061080578941777778127174618315790516133305152829905095462077400069134908655137755647560310693591761813116761451907357080910p 0.9
+ 2333805051507948995927948126752440229000665412810567856138690234117413033236171225032501270305044001760025468707701634156061080578941777778127174618315790516133305152829905095462077400069134908655137755647560310693591761813116761451907357081600p 0.9
+ 2333805051507948995927948126752440229000665412810567856138690234117413033236171225032501270305044001760025468707701634156061080578941777778127174618315790516133305152829905095462077400069134908655137755647560310693591761813116761451907357081610p -0.3
+ \]
V_wl_799 (WordLine\\<799\\> gnd!) vsource type=pwl wave=\[
+ 0    -0.3
+ 4667610103015897991855896253504880458001330825621135712277380468234826066472342450065002540610088003520050937415403268312122161157883555556254349236631581032266610305659810190924154800138269817310275511295120621387183523626233522903814714162500p -0.3
+ 4667610103015897991855896253504880458001330825621135712277380468234826066472342450065002540610088003520050937415403268312122161157883555556254349236631581032266610305659810190924154800138269817310275511295120621387183523626233522903814714162510p 0.9
+ 4667610103015897991855896253504880458001330825621135712277380468234826066472342450065002540610088003520050937415403268312122161157883555556254349236631581032266610305659810190924154800138269817310275511295120621387183523626233522903814714163200p 0.9
+ 4667610103015897991855896253504880458001330825621135712277380468234826066472342450065002540610088003520050937415403268312122161157883555556254349236631581032266610305659810190924154800138269817310275511295120621387183523626233522903814714163210p -0.3
+ \]
V_wl_800 (WordLine\\<800\\> gnd!) vsource type=pwl wave=\[
+ 0    -0.3
+ 9335220206031795983711792507009760916002661651242271424554760936469652132944684900130005081220176007040101874830806536624244322315767111112508698473263162064533220611319620381848309600276539634620551022590241242774367047252467045807629428325700p -0.3
+ 9335220206031795983711792507009760916002661651242271424554760936469652132944684900130005081220176007040101874830806536624244322315767111112508698473263162064533220611319620381848309600276539634620551022590241242774367047252467045807629428325710p 0.9
+ 9335220206031795983711792507009760916002661651242271424554760936469652132944684900130005081220176007040101874830806536624244322315767111112508698473263162064533220611319620381848309600276539634620551022590241242774367047252467045807629428326400p 0.9
+ 9335220206031795983711792507009760916002661651242271424554760936469652132944684900130005081220176007040101874830806536624244322315767111112508698473263162064533220611319620381848309600276539634620551022590241242774367047252467045807629428326410p -0.3
+ \]
V_wl_801 (WordLine\\<801\\> gnd!) vsource type=pwl wave=\[
+ 0    -0.3
+ 18670440412063591967423585014019521832005323302484542849109521872939304265889369800260010162440352014080203749661613073248488644631534222225017396946526324129066441222639240763696619200553079269241102045180482485548734094504934091615258856652100p -0.3
+ 18670440412063591967423585014019521832005323302484542849109521872939304265889369800260010162440352014080203749661613073248488644631534222225017396946526324129066441222639240763696619200553079269241102045180482485548734094504934091615258856652110p 0.9
+ 18670440412063591967423585014019521832005323302484542849109521872939304265889369800260010162440352014080203749661613073248488644631534222225017396946526324129066441222639240763696619200553079269241102045180482485548734094504934091615258856652800p 0.9
+ 18670440412063591967423585014019521832005323302484542849109521872939304265889369800260010162440352014080203749661613073248488644631534222225017396946526324129066441222639240763696619200553079269241102045180482485548734094504934091615258856652810p -0.3
+ \]
V_wl_802 (WordLine\\<802\\> gnd!) vsource type=pwl wave=\[
+ 0    -0.3
+ 37340880824127183934847170028039043664010646604969085698219043745878608531778739600520020324880704028160407499323226146496977289263068444450034793893052648258132882445278481527393238401106158538482204090360964971097468189009868183230517713304900p -0.3
+ 37340880824127183934847170028039043664010646604969085698219043745878608531778739600520020324880704028160407499323226146496977289263068444450034793893052648258132882445278481527393238401106158538482204090360964971097468189009868183230517713304910p 0.9
+ 37340880824127183934847170028039043664010646604969085698219043745878608531778739600520020324880704028160407499323226146496977289263068444450034793893052648258132882445278481527393238401106158538482204090360964971097468189009868183230517713305600p 0.9
+ 37340880824127183934847170028039043664010646604969085698219043745878608531778739600520020324880704028160407499323226146496977289263068444450034793893052648258132882445278481527393238401106158538482204090360964971097468189009868183230517713305610p -0.3
+ \]
V_wl_803 (WordLine\\<803\\> gnd!) vsource type=pwl wave=\[
+ 0    -0.3
+ 74681761648254367869694340056078087328021293209938171396438087491757217063557479201040040649761408056320814998646452292993954578526136888900069587786105296516265764890556963054786476802212317076964408180721929942194936378019736366461035426610500p -0.3
+ 74681761648254367869694340056078087328021293209938171396438087491757217063557479201040040649761408056320814998646452292993954578526136888900069587786105296516265764890556963054786476802212317076964408180721929942194936378019736366461035426610510p 0.9
+ 74681761648254367869694340056078087328021293209938171396438087491757217063557479201040040649761408056320814998646452292993954578526136888900069587786105296516265764890556963054786476802212317076964408180721929942194936378019736366461035426611200p 0.9
+ 74681761648254367869694340056078087328021293209938171396438087491757217063557479201040040649761408056320814998646452292993954578526136888900069587786105296516265764890556963054786476802212317076964408180721929942194936378019736366461035426611210p -0.3
+ \]
V_wl_804 (WordLine\\<804\\> gnd!) vsource type=pwl wave=\[
+ 0    -0.3
+ 149363523296508735739388680112156174656042586419876342792876174983514434127114958402080081299522816112641629997292904585987909157052273777800139175572210593032531529781113926109572953604424634153928816361443859884389872756039472732922070853221700p -0.3
+ 149363523296508735739388680112156174656042586419876342792876174983514434127114958402080081299522816112641629997292904585987909157052273777800139175572210593032531529781113926109572953604424634153928816361443859884389872756039472732922070853221710p 0.9
+ 149363523296508735739388680112156174656042586419876342792876174983514434127114958402080081299522816112641629997292904585987909157052273777800139175572210593032531529781113926109572953604424634153928816361443859884389872756039472732922070853222400p 0.9
+ 149363523296508735739388680112156174656042586419876342792876174983514434127114958402080081299522816112641629997292904585987909157052273777800139175572210593032531529781113926109572953604424634153928816361443859884389872756039472732922070853222410p -0.3
+ \]
V_wl_805 (WordLine\\<805\\> gnd!) vsource type=pwl wave=\[
+ 0    -0.3
+ 298727046593017471478777360224312349312085172839752685585752349967028868254229916804160162599045632225283259994585809171975818314104547555600278351144421186065063059562227852219145907208849268307857632722887719768779745512078945465844141706444100p -0.3
+ 298727046593017471478777360224312349312085172839752685585752349967028868254229916804160162599045632225283259994585809171975818314104547555600278351144421186065063059562227852219145907208849268307857632722887719768779745512078945465844141706444110p 0.9
+ 298727046593017471478777360224312349312085172839752685585752349967028868254229916804160162599045632225283259994585809171975818314104547555600278351144421186065063059562227852219145907208849268307857632722887719768779745512078945465844141706444800p 0.9
+ 298727046593017471478777360224312349312085172839752685585752349967028868254229916804160162599045632225283259994585809171975818314104547555600278351144421186065063059562227852219145907208849268307857632722887719768779745512078945465844141706444810p -0.3
+ \]
V_wl_806 (WordLine\\<806\\> gnd!) vsource type=pwl wave=\[
+ 0    -0.3
+ 597454093186034942957554720448624698624170345679505371171504699934057736508459833608320325198091264450566519989171618343951636628209095111200556702288842372130126119124455704438291814417698536615715265445775439537559491024157890931688283412888900p -0.3
+ 597454093186034942957554720448624698624170345679505371171504699934057736508459833608320325198091264450566519989171618343951636628209095111200556702288842372130126119124455704438291814417698536615715265445775439537559491024157890931688283412888910p 0.9
+ 597454093186034942957554720448624698624170345679505371171504699934057736508459833608320325198091264450566519989171618343951636628209095111200556702288842372130126119124455704438291814417698536615715265445775439537559491024157890931688283412889600p 0.9
+ 597454093186034942957554720448624698624170345679505371171504699934057736508459833608320325198091264450566519989171618343951636628209095111200556702288842372130126119124455704438291814417698536615715265445775439537559491024157890931688283412889610p -0.3
+ \]
V_wl_807 (WordLine\\<807\\> gnd!) vsource type=pwl wave=\[
+ 0    -0.3
+ 1194908186372069885915109440897249397248340691359010742343009399868115473016919667216640650396182528901133039978343236687903273256418190222401113404577684744260252238248911408876583628835397073231430530891550879075118982048315781863376566825778500p -0.3
+ 1194908186372069885915109440897249397248340691359010742343009399868115473016919667216640650396182528901133039978343236687903273256418190222401113404577684744260252238248911408876583628835397073231430530891550879075118982048315781863376566825778510p 0.9
+ 1194908186372069885915109440897249397248340691359010742343009399868115473016919667216640650396182528901133039978343236687903273256418190222401113404577684744260252238248911408876583628835397073231430530891550879075118982048315781863376566825779200p 0.9
+ 1194908186372069885915109440897249397248340691359010742343009399868115473016919667216640650396182528901133039978343236687903273256418190222401113404577684744260252238248911408876583628835397073231430530891550879075118982048315781863376566825779210p -0.3
+ \]
V_wl_808 (WordLine\\<808\\> gnd!) vsource type=pwl wave=\[
+ 0    -0.3
+ 2389816372744139771830218881794498794496681382718021484686018799736230946033839334433281300792365057802266079956686473375806546512836380444802226809155369488520504476497822817753167257670794146462861061783101758150237964096631563726753133651557700p -0.3
+ 2389816372744139771830218881794498794496681382718021484686018799736230946033839334433281300792365057802266079956686473375806546512836380444802226809155369488520504476497822817753167257670794146462861061783101758150237964096631563726753133651557710p 0.9
+ 2389816372744139771830218881794498794496681382718021484686018799736230946033839334433281300792365057802266079956686473375806546512836380444802226809155369488520504476497822817753167257670794146462861061783101758150237964096631563726753133651558400p 0.9
+ 2389816372744139771830218881794498794496681382718021484686018799736230946033839334433281300792365057802266079956686473375806546512836380444802226809155369488520504476497822817753167257670794146462861061783101758150237964096631563726753133651558410p -0.3
+ \]
V_wl_809 (WordLine\\<809\\> gnd!) vsource type=pwl wave=\[
+ 0    -0.3
+ 4779632745488279543660437763588997588993362765436042969372037599472461892067678668866562601584730115604532159913372946751613093025672760889604453618310738977041008952995645635506334515341588292925722123566203516300475928193263127453506267303116100p -0.3
+ 4779632745488279543660437763588997588993362765436042969372037599472461892067678668866562601584730115604532159913372946751613093025672760889604453618310738977041008952995645635506334515341588292925722123566203516300475928193263127453506267303116110p 0.9
+ 4779632745488279543660437763588997588993362765436042969372037599472461892067678668866562601584730115604532159913372946751613093025672760889604453618310738977041008952995645635506334515341588292925722123566203516300475928193263127453506267303116800p 0.9
+ 4779632745488279543660437763588997588993362765436042969372037599472461892067678668866562601584730115604532159913372946751613093025672760889604453618310738977041008952995645635506334515341588292925722123566203516300475928193263127453506267303116810p -0.3
+ \]
V_wl_810 (WordLine\\<810\\> gnd!) vsource type=pwl wave=\[
+ 0    -0.3
+ 9559265490976559087320875527177995177986725530872085938744075198944923784135357337733125203169460231209064319826745893503226186051345521779208907236621477954082017905991291271012669030683176585851444247132407032600951856386526254907012534606232900p -0.3
+ 9559265490976559087320875527177995177986725530872085938744075198944923784135357337733125203169460231209064319826745893503226186051345521779208907236621477954082017905991291271012669030683176585851444247132407032600951856386526254907012534606232910p 0.9
+ 9559265490976559087320875527177995177986725530872085938744075198944923784135357337733125203169460231209064319826745893503226186051345521779208907236621477954082017905991291271012669030683176585851444247132407032600951856386526254907012534606233600p 0.9
+ 9559265490976559087320875527177995177986725530872085938744075198944923784135357337733125203169460231209064319826745893503226186051345521779208907236621477954082017905991291271012669030683176585851444247132407032600951856386526254907012534606233610p -0.3
+ \]
V_wl_811 (WordLine\\<811\\> gnd!) vsource type=pwl wave=\[
+ 0    -0.3
+ 19118530981953118174641751054355990355973451061744171877488150397889847568270714675466250406338920462418128639653491787006452372102691043558417814473242955908164035811982582542025338061366353171702888494264814065201903712773052509814025069212466500p -0.3
+ 19118530981953118174641751054355990355973451061744171877488150397889847568270714675466250406338920462418128639653491787006452372102691043558417814473242955908164035811982582542025338061366353171702888494264814065201903712773052509814025069212466510p 0.9
+ 19118530981953118174641751054355990355973451061744171877488150397889847568270714675466250406338920462418128639653491787006452372102691043558417814473242955908164035811982582542025338061366353171702888494264814065201903712773052509814025069212467200p 0.9
+ 19118530981953118174641751054355990355973451061744171877488150397889847568270714675466250406338920462418128639653491787006452372102691043558417814473242955908164035811982582542025338061366353171702888494264814065201903712773052509814025069212467210p -0.3
+ \]
V_wl_812 (WordLine\\<812\\> gnd!) vsource type=pwl wave=\[
+ 0    -0.3
+ 38237061963906236349283502108711980711946902123488343754976300795779695136541429350932500812677840924836257279306983574012904744205382087116835628946485911816328071623965165084050676122732706343405776988529628130403807425546105019628050138424933700p -0.3
+ 38237061963906236349283502108711980711946902123488343754976300795779695136541429350932500812677840924836257279306983574012904744205382087116835628946485911816328071623965165084050676122732706343405776988529628130403807425546105019628050138424933710p 0.9
+ 38237061963906236349283502108711980711946902123488343754976300795779695136541429350932500812677840924836257279306983574012904744205382087116835628946485911816328071623965165084050676122732706343405776988529628130403807425546105019628050138424934400p 0.9
+ 38237061963906236349283502108711980711946902123488343754976300795779695136541429350932500812677840924836257279306983574012904744205382087116835628946485911816328071623965165084050676122732706343405776988529628130403807425546105019628050138424934410p -0.3
+ \]
V_wl_813 (WordLine\\<813\\> gnd!) vsource type=pwl wave=\[
+ 0    -0.3
+ 76474123927812472698567004217423961423893804246976687509952601591559390273082858701865001625355681849672514558613967148025809488410764174233671257892971823632656143247930330168101352245465412686811553977059256260807614851092210039256100276849868100p -0.3
+ 76474123927812472698567004217423961423893804246976687509952601591559390273082858701865001625355681849672514558613967148025809488410764174233671257892971823632656143247930330168101352245465412686811553977059256260807614851092210039256100276849868110p 0.9
+ 76474123927812472698567004217423961423893804246976687509952601591559390273082858701865001625355681849672514558613967148025809488410764174233671257892971823632656143247930330168101352245465412686811553977059256260807614851092210039256100276849868800p 0.9
+ 76474123927812472698567004217423961423893804246976687509952601591559390273082858701865001625355681849672514558613967148025809488410764174233671257892971823632656143247930330168101352245465412686811553977059256260807614851092210039256100276849868810p -0.3
+ \]
V_wl_814 (WordLine\\<814\\> gnd!) vsource type=pwl wave=\[
+ 0    -0.3
+ 152948247855624945397134008434847922847787608493953375019905203183118780546165717403730003250711363699345029117227934296051618976821528348467342515785943647265312286495860660336202704490930825373623107954118512521615229702184420078512200553699736900p -0.3
+ 152948247855624945397134008434847922847787608493953375019905203183118780546165717403730003250711363699345029117227934296051618976821528348467342515785943647265312286495860660336202704490930825373623107954118512521615229702184420078512200553699736910p 0.9
+ 152948247855624945397134008434847922847787608493953375019905203183118780546165717403730003250711363699345029117227934296051618976821528348467342515785943647265312286495860660336202704490930825373623107954118512521615229702184420078512200553699737600p 0.9
+ 152948247855624945397134008434847922847787608493953375019905203183118780546165717403730003250711363699345029117227934296051618976821528348467342515785943647265312286495860660336202704490930825373623107954118512521615229702184420078512200553699737610p -0.3
+ \]
V_wl_815 (WordLine\\<815\\> gnd!) vsource type=pwl wave=\[
+ 0    -0.3
+ 305896495711249890794268016869695845695575216987906750039810406366237561092331434807460006501422727398690058234455868592103237953643056696934685031571887294530624572991721320672405408981861650747246215908237025043230459404368840157024401107399474500p -0.3
+ 305896495711249890794268016869695845695575216987906750039810406366237561092331434807460006501422727398690058234455868592103237953643056696934685031571887294530624572991721320672405408981861650747246215908237025043230459404368840157024401107399474510p 0.9
+ 305896495711249890794268016869695845695575216987906750039810406366237561092331434807460006501422727398690058234455868592103237953643056696934685031571887294530624572991721320672405408981861650747246215908237025043230459404368840157024401107399475200p 0.9
+ 305896495711249890794268016869695845695575216987906750039810406366237561092331434807460006501422727398690058234455868592103237953643056696934685031571887294530624572991721320672405408981861650747246215908237025043230459404368840157024401107399475210p -0.3
+ \]
V_wl_816 (WordLine\\<816\\> gnd!) vsource type=pwl wave=\[
+ 0    -0.3
+ 611792991422499781588536033739391691391150433975813500079620812732475122184662869614920013002845454797380116468911737184206475907286113393869370063143774589061249145983442641344810817963723301494492431816474050086460918808737680314048802214798949700p -0.3
+ 611792991422499781588536033739391691391150433975813500079620812732475122184662869614920013002845454797380116468911737184206475907286113393869370063143774589061249145983442641344810817963723301494492431816474050086460918808737680314048802214798949710p 0.9
+ 611792991422499781588536033739391691391150433975813500079620812732475122184662869614920013002845454797380116468911737184206475907286113393869370063143774589061249145983442641344810817963723301494492431816474050086460918808737680314048802214798950400p 0.9
+ 611792991422499781588536033739391691391150433975813500079620812732475122184662869614920013002845454797380116468911737184206475907286113393869370063143774589061249145983442641344810817963723301494492431816474050086460918808737680314048802214798950410p -0.3
+ \]
V_wl_817 (WordLine\\<817\\> gnd!) vsource type=pwl wave=\[
+ 0    -0.3
+ 1223585982844999563177072067478783382782300867951627000159241625464950244369325739229840026005690909594760232937823474368412951814572226787738740126287549178122498291966885282689621635927446602988984863632948100172921837617475360628097604429597900100p -0.3
+ 1223585982844999563177072067478783382782300867951627000159241625464950244369325739229840026005690909594760232937823474368412951814572226787738740126287549178122498291966885282689621635927446602988984863632948100172921837617475360628097604429597900110p 0.9
+ 1223585982844999563177072067478783382782300867951627000159241625464950244369325739229840026005690909594760232937823474368412951814572226787738740126287549178122498291966885282689621635927446602988984863632948100172921837617475360628097604429597900800p 0.9
+ 1223585982844999563177072067478783382782300867951627000159241625464950244369325739229840026005690909594760232937823474368412951814572226787738740126287549178122498291966885282689621635927446602988984863632948100172921837617475360628097604429597900810p -0.3
+ \]
V_wl_818 (WordLine\\<818\\> gnd!) vsource type=pwl wave=\[
+ 0    -0.3
+ 2447171965689999126354144134957566765564601735903254000318483250929900488738651478459680052011381819189520465875646948736825903629144453575477480252575098356244996583933770565379243271854893205977969727265896200345843675234950721256195208859195800900p -0.3
+ 2447171965689999126354144134957566765564601735903254000318483250929900488738651478459680052011381819189520465875646948736825903629144453575477480252575098356244996583933770565379243271854893205977969727265896200345843675234950721256195208859195800910p 0.9
+ 2447171965689999126354144134957566765564601735903254000318483250929900488738651478459680052011381819189520465875646948736825903629144453575477480252575098356244996583933770565379243271854893205977969727265896200345843675234950721256195208859195801600p 0.9
+ 2447171965689999126354144134957566765564601735903254000318483250929900488738651478459680052011381819189520465875646948736825903629144453575477480252575098356244996583933770565379243271854893205977969727265896200345843675234950721256195208859195801610p -0.3
+ \]
V_wl_819 (WordLine\\<819\\> gnd!) vsource type=pwl wave=\[
+ 0    -0.3
+ 4894343931379998252708288269915133531129203471806508000636966501859800977477302956919360104022763638379040931751293897473651807258288907150954960505150196712489993167867541130758486543709786411955939454531792400691687350469901442512390417718391602500p -0.3
+ 4894343931379998252708288269915133531129203471806508000636966501859800977477302956919360104022763638379040931751293897473651807258288907150954960505150196712489993167867541130758486543709786411955939454531792400691687350469901442512390417718391602510p 0.9
+ 4894343931379998252708288269915133531129203471806508000636966501859800977477302956919360104022763638379040931751293897473651807258288907150954960505150196712489993167867541130758486543709786411955939454531792400691687350469901442512390417718391603200p 0.9
+ 4894343931379998252708288269915133531129203471806508000636966501859800977477302956919360104022763638379040931751293897473651807258288907150954960505150196712489993167867541130758486543709786411955939454531792400691687350469901442512390417718391603210p -0.3
+ \]
V_wl_820 (WordLine\\<820\\> gnd!) vsource type=pwl wave=\[
+ 0    -0.3
+ 9788687862759996505416576539830267062258406943613016001273933003719601954954605913838720208045527276758081863502587794947303614516577814301909921010300393424979986335735082261516973087419572823911878909063584801383374700939802885024780835436783205700p -0.3
+ 9788687862759996505416576539830267062258406943613016001273933003719601954954605913838720208045527276758081863502587794947303614516577814301909921010300393424979986335735082261516973087419572823911878909063584801383374700939802885024780835436783205710p 0.9
+ 9788687862759996505416576539830267062258406943613016001273933003719601954954605913838720208045527276758081863502587794947303614516577814301909921010300393424979986335735082261516973087419572823911878909063584801383374700939802885024780835436783206400p 0.9
+ 9788687862759996505416576539830267062258406943613016001273933003719601954954605913838720208045527276758081863502587794947303614516577814301909921010300393424979986335735082261516973087419572823911878909063584801383374700939802885024780835436783206410p -0.3
+ \]
V_wl_821 (WordLine\\<821\\> gnd!) vsource type=pwl wave=\[
+ 0    -0.3
+ 19577375725519993010833153079660534124516813887226032002547866007439203909909211827677440416091054553516163727005175589894607229033155628603819842020600786849959972671470164523033946174839145647823757818127169602766749401879605770049561670873566412100p -0.3
+ 19577375725519993010833153079660534124516813887226032002547866007439203909909211827677440416091054553516163727005175589894607229033155628603819842020600786849959972671470164523033946174839145647823757818127169602766749401879605770049561670873566412110p 0.9
+ 19577375725519993010833153079660534124516813887226032002547866007439203909909211827677440416091054553516163727005175589894607229033155628603819842020600786849959972671470164523033946174839145647823757818127169602766749401879605770049561670873566412800p 0.9
+ 19577375725519993010833153079660534124516813887226032002547866007439203909909211827677440416091054553516163727005175589894607229033155628603819842020600786849959972671470164523033946174839145647823757818127169602766749401879605770049561670873566412810p -0.3
+ \]
V_wl_822 (WordLine\\<822\\> gnd!) vsource type=pwl wave=\[
+ 0    -0.3
+ 39154751451039986021666306159321068249033627774452064005095732014878407819818423655354880832182109107032327454010351179789214458066311257207639684041201573699919945342940329046067892349678291295647515636254339205533498803759211540099123341747132824900p -0.3
+ 39154751451039986021666306159321068249033627774452064005095732014878407819818423655354880832182109107032327454010351179789214458066311257207639684041201573699919945342940329046067892349678291295647515636254339205533498803759211540099123341747132824910p 0.9
+ 39154751451039986021666306159321068249033627774452064005095732014878407819818423655354880832182109107032327454010351179789214458066311257207639684041201573699919945342940329046067892349678291295647515636254339205533498803759211540099123341747132825600p 0.9
+ 39154751451039986021666306159321068249033627774452064005095732014878407819818423655354880832182109107032327454010351179789214458066311257207639684041201573699919945342940329046067892349678291295647515636254339205533498803759211540099123341747132825610p -0.3
+ \]
V_wl_823 (WordLine\\<823\\> gnd!) vsource type=pwl wave=\[
+ 0    -0.3
+ 78309502902079972043332612318642136498067255548904128010191464029756815639636847310709761664364218214064654908020702359578428916132622514415279368082403147399839890685880658092135784699356582591295031272508678411066997607518423080198246683494265650500p -0.3
+ 78309502902079972043332612318642136498067255548904128010191464029756815639636847310709761664364218214064654908020702359578428916132622514415279368082403147399839890685880658092135784699356582591295031272508678411066997607518423080198246683494265650510p 0.9
+ 78309502902079972043332612318642136498067255548904128010191464029756815639636847310709761664364218214064654908020702359578428916132622514415279368082403147399839890685880658092135784699356582591295031272508678411066997607518423080198246683494265651200p 0.9
+ 78309502902079972043332612318642136498067255548904128010191464029756815639636847310709761664364218214064654908020702359578428916132622514415279368082403147399839890685880658092135784699356582591295031272508678411066997607518423080198246683494265651210p -0.3
+ \]
V_wl_824 (WordLine\\<824\\> gnd!) vsource type=pwl wave=\[
+ 0    -0.3
+ 156619005804159944086665224637284272996134511097808256020382928059513631279273694621419523328728436428129309816041404719156857832265245028830558736164806294799679781371761316184271569398713165182590062545017356822133995215036846160396493366988531301700p -0.3
+ 156619005804159944086665224637284272996134511097808256020382928059513631279273694621419523328728436428129309816041404719156857832265245028830558736164806294799679781371761316184271569398713165182590062545017356822133995215036846160396493366988531301710p 0.9
+ 156619005804159944086665224637284272996134511097808256020382928059513631279273694621419523328728436428129309816041404719156857832265245028830558736164806294799679781371761316184271569398713165182590062545017356822133995215036846160396493366988531302400p 0.9
+ 156619005804159944086665224637284272996134511097808256020382928059513631279273694621419523328728436428129309816041404719156857832265245028830558736164806294799679781371761316184271569398713165182590062545017356822133995215036846160396493366988531302410p -0.3
+ \]
V_wl_825 (WordLine\\<825\\> gnd!) vsource type=pwl wave=\[
+ 0    -0.3
+ 313238011608319888173330449274568545992269022195616512040765856119027262558547389242839046657456872856258619632082809438313715664530490057661117472329612589599359562743522632368543138797426330365180125090034713644267990430073692320792986733977062604100p -0.3
+ 313238011608319888173330449274568545992269022195616512040765856119027262558547389242839046657456872856258619632082809438313715664530490057661117472329612589599359562743522632368543138797426330365180125090034713644267990430073692320792986733977062604110p 0.9
+ 313238011608319888173330449274568545992269022195616512040765856119027262558547389242839046657456872856258619632082809438313715664530490057661117472329612589599359562743522632368543138797426330365180125090034713644267990430073692320792986733977062604800p 0.9
+ 313238011608319888173330449274568545992269022195616512040765856119027262558547389242839046657456872856258619632082809438313715664530490057661117472329612589599359562743522632368543138797426330365180125090034713644267990430073692320792986733977062604810p -0.3
+ \]
V_wl_826 (WordLine\\<826\\> gnd!) vsource type=pwl wave=\[
+ 0    -0.3
+ 626476023216639776346660898549137091984538044391233024081531712238054525117094778485678093314913745712517239264165618876627431329060980115322234944659225179198719125487045264737086277594852660730360250180069427288535980860147384641585973467954125208900p -0.3
+ 626476023216639776346660898549137091984538044391233024081531712238054525117094778485678093314913745712517239264165618876627431329060980115322234944659225179198719125487045264737086277594852660730360250180069427288535980860147384641585973467954125208910p 0.9
+ 626476023216639776346660898549137091984538044391233024081531712238054525117094778485678093314913745712517239264165618876627431329060980115322234944659225179198719125487045264737086277594852660730360250180069427288535980860147384641585973467954125209600p 0.9
+ 626476023216639776346660898549137091984538044391233024081531712238054525117094778485678093314913745712517239264165618876627431329060980115322234944659225179198719125487045264737086277594852660730360250180069427288535980860147384641585973467954125209610p -0.3
+ \]
V_wl_827 (WordLine\\<827\\> gnd!) vsource type=pwl wave=\[
+ 0    -0.3
+ 1252952046433279552693321797098274183969076088782466048163063424476109050234189556971356186629827491425034478528331237753254862658121960230644469889318450358397438250974090529474172555189705321460720500360138854577071961720294769283171946935908250418500p -0.3
+ 1252952046433279552693321797098274183969076088782466048163063424476109050234189556971356186629827491425034478528331237753254862658121960230644469889318450358397438250974090529474172555189705321460720500360138854577071961720294769283171946935908250418510p 0.9
+ 1252952046433279552693321797098274183969076088782466048163063424476109050234189556971356186629827491425034478528331237753254862658121960230644469889318450358397438250974090529474172555189705321460720500360138854577071961720294769283171946935908250419200p 0.9
+ 1252952046433279552693321797098274183969076088782466048163063424476109050234189556971356186629827491425034478528331237753254862658121960230644469889318450358397438250974090529474172555189705321460720500360138854577071961720294769283171946935908250419210p -0.3
+ \]
V_wl_828 (WordLine\\<828\\> gnd!) vsource type=pwl wave=\[
+ 0    -0.3
+ 2505904092866559105386643594196548367938152177564932096326126848952218100468379113942712373259654982850068957056662475506509725316243920461288939778636900716794876501948181058948345110379410642921441000720277709154143923440589538566343893871816500837700p -0.3
+ 2505904092866559105386643594196548367938152177564932096326126848952218100468379113942712373259654982850068957056662475506509725316243920461288939778636900716794876501948181058948345110379410642921441000720277709154143923440589538566343893871816500837710p 0.9
+ 2505904092866559105386643594196548367938152177564932096326126848952218100468379113942712373259654982850068957056662475506509725316243920461288939778636900716794876501948181058948345110379410642921441000720277709154143923440589538566343893871816500838400p 0.9
+ 2505904092866559105386643594196548367938152177564932096326126848952218100468379113942712373259654982850068957056662475506509725316243920461288939778636900716794876501948181058948345110379410642921441000720277709154143923440589538566343893871816500838410p -0.3
+ \]
V_wl_829 (WordLine\\<829\\> gnd!) vsource type=pwl wave=\[
+ 0    -0.3
+ 5011808185733118210773287188393096735876304355129864192652253697904436200936758227885424746519309965700137914113324951013019450632487840922577879557273801433589753003896362117896690220758821285842882001440555418308287846881179077132687787743633001676100p -0.3
+ 5011808185733118210773287188393096735876304355129864192652253697904436200936758227885424746519309965700137914113324951013019450632487840922577879557273801433589753003896362117896690220758821285842882001440555418308287846881179077132687787743633001676110p 0.9
+ 5011808185733118210773287188393096735876304355129864192652253697904436200936758227885424746519309965700137914113324951013019450632487840922577879557273801433589753003896362117896690220758821285842882001440555418308287846881179077132687787743633001676800p 0.9
+ 5011808185733118210773287188393096735876304355129864192652253697904436200936758227885424746519309965700137914113324951013019450632487840922577879557273801433589753003896362117896690220758821285842882001440555418308287846881179077132687787743633001676810p -0.3
+ \]
V_wl_830 (WordLine\\<830\\> gnd!) vsource type=pwl wave=\[
+ 0    -0.3
+ 10023616371466236421546574376786193471752608710259728385304507395808872401873516455770849493038619931400275828226649902026038901264975681845155759114547602867179506007792724235793380441517642571685764002881110836616575693762358154265375575487266003352900p -0.3
+ 10023616371466236421546574376786193471752608710259728385304507395808872401873516455770849493038619931400275828226649902026038901264975681845155759114547602867179506007792724235793380441517642571685764002881110836616575693762358154265375575487266003352910p 0.9
+ 10023616371466236421546574376786193471752608710259728385304507395808872401873516455770849493038619931400275828226649902026038901264975681845155759114547602867179506007792724235793380441517642571685764002881110836616575693762358154265375575487266003353600p 0.9
+ 10023616371466236421546574376786193471752608710259728385304507395808872401873516455770849493038619931400275828226649902026038901264975681845155759114547602867179506007792724235793380441517642571685764002881110836616575693762358154265375575487266003353610p -0.3
+ \]
V_wl_831 (WordLine\\<831\\> gnd!) vsource type=pwl wave=\[
+ 0    -0.3
+ 20047232742932472843093148753572386943505217420519456770609014791617744803747032911541698986077239862800551656453299804052077802529951363690311518229095205734359012015585448471586760883035285143371528005762221673233151387524716308530751150974532006706500p -0.3
+ 20047232742932472843093148753572386943505217420519456770609014791617744803747032911541698986077239862800551656453299804052077802529951363690311518229095205734359012015585448471586760883035285143371528005762221673233151387524716308530751150974532006706510p 0.9
+ 20047232742932472843093148753572386943505217420519456770609014791617744803747032911541698986077239862800551656453299804052077802529951363690311518229095205734359012015585448471586760883035285143371528005762221673233151387524716308530751150974532006707200p 0.9
+ 20047232742932472843093148753572386943505217420519456770609014791617744803747032911541698986077239862800551656453299804052077802529951363690311518229095205734359012015585448471586760883035285143371528005762221673233151387524716308530751150974532006707210p -0.3
+ \]
V_wl_832 (WordLine\\<832\\> gnd!) vsource type=pwl wave=\[
+ 0    -0.3
+ 40094465485864945686186297507144773887010434841038913541218029583235489607494065823083397972154479725601103312906599608104155605059902727380623036458190411468718024031170896943173521766070570286743056011524443346466302775049432617061502301949064013413700p -0.3
+ 40094465485864945686186297507144773887010434841038913541218029583235489607494065823083397972154479725601103312906599608104155605059902727380623036458190411468718024031170896943173521766070570286743056011524443346466302775049432617061502301949064013413710p 0.9
+ 40094465485864945686186297507144773887010434841038913541218029583235489607494065823083397972154479725601103312906599608104155605059902727380623036458190411468718024031170896943173521766070570286743056011524443346466302775049432617061502301949064013414400p 0.9
+ 40094465485864945686186297507144773887010434841038913541218029583235489607494065823083397972154479725601103312906599608104155605059902727380623036458190411468718024031170896943173521766070570286743056011524443346466302775049432617061502301949064013414410p -0.3
+ \]
V_wl_833 (WordLine\\<833\\> gnd!) vsource type=pwl wave=\[
+ 0    -0.3
+ 80188930971729891372372595014289547774020869682077827082436059166470979214988131646166795944308959451202206625813199216208311210119805454761246072916380822937436048062341793886347043532141140573486112023048886692932605550098865234123004603898128026828100p -0.3
+ 80188930971729891372372595014289547774020869682077827082436059166470979214988131646166795944308959451202206625813199216208311210119805454761246072916380822937436048062341793886347043532141140573486112023048886692932605550098865234123004603898128026828110p 0.9
+ 80188930971729891372372595014289547774020869682077827082436059166470979214988131646166795944308959451202206625813199216208311210119805454761246072916380822937436048062341793886347043532141140573486112023048886692932605550098865234123004603898128026828800p 0.9
+ 80188930971729891372372595014289547774020869682077827082436059166470979214988131646166795944308959451202206625813199216208311210119805454761246072916380822937436048062341793886347043532141140573486112023048886692932605550098865234123004603898128026828810p -0.3
+ \]
V_wl_834 (WordLine\\<834\\> gnd!) vsource type=pwl wave=\[
+ 0    -0.3
+ 160377861943459782744745190028579095548041739364155654164872118332941958429976263292333591888617918902404413251626398432416622420239610909522492145832761645874872096124683587772694087064282281146972224046097773385865211100197730468246009207796256053656900p -0.3
+ 160377861943459782744745190028579095548041739364155654164872118332941958429976263292333591888617918902404413251626398432416622420239610909522492145832761645874872096124683587772694087064282281146972224046097773385865211100197730468246009207796256053656910p 0.9
+ 160377861943459782744745190028579095548041739364155654164872118332941958429976263292333591888617918902404413251626398432416622420239610909522492145832761645874872096124683587772694087064282281146972224046097773385865211100197730468246009207796256053657600p 0.9
+ 160377861943459782744745190028579095548041739364155654164872118332941958429976263292333591888617918902404413251626398432416622420239610909522492145832761645874872096124683587772694087064282281146972224046097773385865211100197730468246009207796256053657610p -0.3
+ \]
V_wl_835 (WordLine\\<835\\> gnd!) vsource type=pwl wave=\[
+ 0    -0.3
+ 320755723886919565489490380057158191096083478728311308329744236665883916859952526584667183777235837804808826503252796864833244840479221819044984291665523291749744192249367175545388174128564562293944448092195546771730422200395460936492018415592512107314500p -0.3
+ 320755723886919565489490380057158191096083478728311308329744236665883916859952526584667183777235837804808826503252796864833244840479221819044984291665523291749744192249367175545388174128564562293944448092195546771730422200395460936492018415592512107314510p 0.9
+ 320755723886919565489490380057158191096083478728311308329744236665883916859952526584667183777235837804808826503252796864833244840479221819044984291665523291749744192249367175545388174128564562293944448092195546771730422200395460936492018415592512107315200p 0.9
+ 320755723886919565489490380057158191096083478728311308329744236665883916859952526584667183777235837804808826503252796864833244840479221819044984291665523291749744192249367175545388174128564562293944448092195546771730422200395460936492018415592512107315210p -0.3
+ \]
V_wl_836 (WordLine\\<836\\> gnd!) vsource type=pwl wave=\[
+ 0    -0.3
+ 641511447773839130978980760114316382192166957456622616659488473331767833719905053169334367554471675609617653006505593729666489680958443638089968583331046583499488384498734351090776348257129124587888896184391093543460844400790921872984036831185024214629700p -0.3
+ 641511447773839130978980760114316382192166957456622616659488473331767833719905053169334367554471675609617653006505593729666489680958443638089968583331046583499488384498734351090776348257129124587888896184391093543460844400790921872984036831185024214629710p 0.9
+ 641511447773839130978980760114316382192166957456622616659488473331767833719905053169334367554471675609617653006505593729666489680958443638089968583331046583499488384498734351090776348257129124587888896184391093543460844400790921872984036831185024214630400p 0.9
+ 641511447773839130978980760114316382192166957456622616659488473331767833719905053169334367554471675609617653006505593729666489680958443638089968583331046583499488384498734351090776348257129124587888896184391093543460844400790921872984036831185024214630410p -0.3
+ \]
V_wl_837 (WordLine\\<837\\> gnd!) vsource type=pwl wave=\[
+ 0    -0.3
+ 1283022895547678261957961520228632764384333914913245233318976946663535667439810106338668735108943351219235306013011187459332979361916887276179937166662093166998976768997468702181552696514258249175777792368782187086921688801581843745968073662370048429260100p -0.3
+ 1283022895547678261957961520228632764384333914913245233318976946663535667439810106338668735108943351219235306013011187459332979361916887276179937166662093166998976768997468702181552696514258249175777792368782187086921688801581843745968073662370048429260110p 0.9
+ 1283022895547678261957961520228632764384333914913245233318976946663535667439810106338668735108943351219235306013011187459332979361916887276179937166662093166998976768997468702181552696514258249175777792368782187086921688801581843745968073662370048429260800p 0.9
+ 1283022895547678261957961520228632764384333914913245233318976946663535667439810106338668735108943351219235306013011187459332979361916887276179937166662093166998976768997468702181552696514258249175777792368782187086921688801581843745968073662370048429260810p -0.3
+ \]
V_wl_838 (WordLine\\<838\\> gnd!) vsource type=pwl wave=\[
+ 0    -0.3
+ 2566045791095356523915923040457265528768667829826490466637953893327071334879620212677337470217886702438470612026022374918665958723833774552359874333324186333997953537994937404363105393028516498351555584737564374173843377603163687491936147324740096858520900p -0.3
+ 2566045791095356523915923040457265528768667829826490466637953893327071334879620212677337470217886702438470612026022374918665958723833774552359874333324186333997953537994937404363105393028516498351555584737564374173843377603163687491936147324740096858520910p 0.9
+ 2566045791095356523915923040457265528768667829826490466637953893327071334879620212677337470217886702438470612026022374918665958723833774552359874333324186333997953537994937404363105393028516498351555584737564374173843377603163687491936147324740096858521600p 0.9
+ 2566045791095356523915923040457265528768667829826490466637953893327071334879620212677337470217886702438470612026022374918665958723833774552359874333324186333997953537994937404363105393028516498351555584737564374173843377603163687491936147324740096858521610p -0.3
+ \]
V_wl_839 (WordLine\\<839\\> gnd!) vsource type=pwl wave=\[
+ 0    -0.3
+ 5132091582190713047831846080914531057537335659652980933275907786654142669759240425354674940435773404876941224052044749837331917447667549104719748666648372667995907075989874808726210786057032996703111169475128748347686755206327374983872294649480193717042500p -0.3
+ 5132091582190713047831846080914531057537335659652980933275907786654142669759240425354674940435773404876941224052044749837331917447667549104719748666648372667995907075989874808726210786057032996703111169475128748347686755206327374983872294649480193717042510p 0.9
+ 5132091582190713047831846080914531057537335659652980933275907786654142669759240425354674940435773404876941224052044749837331917447667549104719748666648372667995907075989874808726210786057032996703111169475128748347686755206327374983872294649480193717043200p 0.9
+ 5132091582190713047831846080914531057537335659652980933275907786654142669759240425354674940435773404876941224052044749837331917447667549104719748666648372667995907075989874808726210786057032996703111169475128748347686755206327374983872294649480193717043210p -0.3
+ \]
V_wl_840 (WordLine\\<840\\> gnd!) vsource type=pwl wave=\[
+ 0    -0.3
+ 10264183164381426095663692161829062115074671319305961866551815573308285339518480850709349880871546809753882448104089499674663834895335098209439497333296745335991814151979749617452421572114065993406222338950257496695373510412654749967744589298960387434085700p -0.3
+ 10264183164381426095663692161829062115074671319305961866551815573308285339518480850709349880871546809753882448104089499674663834895335098209439497333296745335991814151979749617452421572114065993406222338950257496695373510412654749967744589298960387434085710p 0.9
+ 10264183164381426095663692161829062115074671319305961866551815573308285339518480850709349880871546809753882448104089499674663834895335098209439497333296745335991814151979749617452421572114065993406222338950257496695373510412654749967744589298960387434086400p 0.9
+ 10264183164381426095663692161829062115074671319305961866551815573308285339518480850709349880871546809753882448104089499674663834895335098209439497333296745335991814151979749617452421572114065993406222338950257496695373510412654749967744589298960387434086410p -0.3
+ \]
V_wl_841 (WordLine\\<841\\> gnd!) vsource type=pwl wave=\[
+ 0    -0.3
+ 20528366328762852191327384323658124230149342638611923733103631146616570679036961701418699761743093619507764896208178999349327669790670196418878994666593490671983628303959499234904843144228131986812444677900514993390747020825309499935489178597920774868172100p -0.3
+ 20528366328762852191327384323658124230149342638611923733103631146616570679036961701418699761743093619507764896208178999349327669790670196418878994666593490671983628303959499234904843144228131986812444677900514993390747020825309499935489178597920774868172110p 0.9
+ 20528366328762852191327384323658124230149342638611923733103631146616570679036961701418699761743093619507764896208178999349327669790670196418878994666593490671983628303959499234904843144228131986812444677900514993390747020825309499935489178597920774868172800p 0.9
+ 20528366328762852191327384323658124230149342638611923733103631146616570679036961701418699761743093619507764896208178999349327669790670196418878994666593490671983628303959499234904843144228131986812444677900514993390747020825309499935489178597920774868172810p -0.3
+ \]
V_wl_842 (WordLine\\<842\\> gnd!) vsource type=pwl wave=\[
+ 0    -0.3
+ 41056732657525704382654768647316248460298685277223847466207262293233141358073923402837399523486187239015529792416357998698655339581340392837757989333186981343967256607918998469809686288456263973624889355801029986781494041650618999870978357195841549736344900p -0.3
+ 41056732657525704382654768647316248460298685277223847466207262293233141358073923402837399523486187239015529792416357998698655339581340392837757989333186981343967256607918998469809686288456263973624889355801029986781494041650618999870978357195841549736344910p 0.9
+ 41056732657525704382654768647316248460298685277223847466207262293233141358073923402837399523486187239015529792416357998698655339581340392837757989333186981343967256607918998469809686288456263973624889355801029986781494041650618999870978357195841549736345600p 0.9
+ 41056732657525704382654768647316248460298685277223847466207262293233141358073923402837399523486187239015529792416357998698655339581340392837757989333186981343967256607918998469809686288456263973624889355801029986781494041650618999870978357195841549736345610p -0.3
+ \]
V_wl_843 (WordLine\\<843\\> gnd!) vsource type=pwl wave=\[
+ 0    -0.3
+ 82113465315051408765309537294632496920597370554447694932414524586466282716147846805674799046972374478031059584832715997397310679162680785675515978666373962687934513215837996939619372576912527947249778711602059973562988083301237999741956714391683099472690500p -0.3
+ 82113465315051408765309537294632496920597370554447694932414524586466282716147846805674799046972374478031059584832715997397310679162680785675515978666373962687934513215837996939619372576912527947249778711602059973562988083301237999741956714391683099472690510p 0.9
+ 82113465315051408765309537294632496920597370554447694932414524586466282716147846805674799046972374478031059584832715997397310679162680785675515978666373962687934513215837996939619372576912527947249778711602059973562988083301237999741956714391683099472691200p 0.9
+ 82113465315051408765309537294632496920597370554447694932414524586466282716147846805674799046972374478031059584832715997397310679162680785675515978666373962687934513215837996939619372576912527947249778711602059973562988083301237999741956714391683099472691210p -0.3
+ \]
V_wl_844 (WordLine\\<844\\> gnd!) vsource type=pwl wave=\[
+ 0    -0.3
+ 164226930630102817530619074589264993841194741108895389864829049172932565432295693611349598093944748956062119169665431994794621358325361571351031957332747925375869026431675993879238745153825055894499557423204119947125976166602475999483913428783366198945381700p -0.3
+ 164226930630102817530619074589264993841194741108895389864829049172932565432295693611349598093944748956062119169665431994794621358325361571351031957332747925375869026431675993879238745153825055894499557423204119947125976166602475999483913428783366198945381710p 0.9
+ 164226930630102817530619074589264993841194741108895389864829049172932565432295693611349598093944748956062119169665431994794621358325361571351031957332747925375869026431675993879238745153825055894499557423204119947125976166602475999483913428783366198945382400p 0.9
+ 164226930630102817530619074589264993841194741108895389864829049172932565432295693611349598093944748956062119169665431994794621358325361571351031957332747925375869026431675993879238745153825055894499557423204119947125976166602475999483913428783366198945382410p -0.3
+ \]
V_wl_845 (WordLine\\<845\\> gnd!) vsource type=pwl wave=\[
+ 0    -0.3
+ 328453861260205635061238149178529987682389482217790779729658098345865130864591387222699196187889497912124238339330863989589242716650723142702063914665495850751738052863351987758477490307650111788999114846408239894251952333204951998967826857566732397890764100p -0.3
+ 328453861260205635061238149178529987682389482217790779729658098345865130864591387222699196187889497912124238339330863989589242716650723142702063914665495850751738052863351987758477490307650111788999114846408239894251952333204951998967826857566732397890764110p 0.9
+ 328453861260205635061238149178529987682389482217790779729658098345865130864591387222699196187889497912124238339330863989589242716650723142702063914665495850751738052863351987758477490307650111788999114846408239894251952333204951998967826857566732397890764800p 0.9
+ 328453861260205635061238149178529987682389482217790779729658098345865130864591387222699196187889497912124238339330863989589242716650723142702063914665495850751738052863351987758477490307650111788999114846408239894251952333204951998967826857566732397890764810p -0.3
+ \]
V_wl_846 (WordLine\\<846\\> gnd!) vsource type=pwl wave=\[
+ 0    -0.3
+ 656907722520411270122476298357059975364778964435581559459316196691730261729182774445398392375778995824248476678661727979178485433301446285404127829330991701503476105726703975516954980615300223577998229692816479788503904666409903997935653715133464795781528900p -0.3
+ 656907722520411270122476298357059975364778964435581559459316196691730261729182774445398392375778995824248476678661727979178485433301446285404127829330991701503476105726703975516954980615300223577998229692816479788503904666409903997935653715133464795781528910p 0.9
+ 656907722520411270122476298357059975364778964435581559459316196691730261729182774445398392375778995824248476678661727979178485433301446285404127829330991701503476105726703975516954980615300223577998229692816479788503904666409903997935653715133464795781529600p 0.9
+ 656907722520411270122476298357059975364778964435581559459316196691730261729182774445398392375778995824248476678661727979178485433301446285404127829330991701503476105726703975516954980615300223577998229692816479788503904666409903997935653715133464795781529610p -0.3
+ \]
V_wl_847 (WordLine\\<847\\> gnd!) vsource type=pwl wave=\[
+ 0    -0.3
+ 1313815445040822540244952596714119950729557928871163118918632393383460523458365548890796784751557991648496953357323455958356970866602892570808255658661983403006952211453407951033909961230600447155996459385632959577007809332819807995871307430266929591563058500p -0.3
+ 1313815445040822540244952596714119950729557928871163118918632393383460523458365548890796784751557991648496953357323455958356970866602892570808255658661983403006952211453407951033909961230600447155996459385632959577007809332819807995871307430266929591563058510p 0.9
+ 1313815445040822540244952596714119950729557928871163118918632393383460523458365548890796784751557991648496953357323455958356970866602892570808255658661983403006952211453407951033909961230600447155996459385632959577007809332819807995871307430266929591563059200p 0.9
+ 1313815445040822540244952596714119950729557928871163118918632393383460523458365548890796784751557991648496953357323455958356970866602892570808255658661983403006952211453407951033909961230600447155996459385632959577007809332819807995871307430266929591563059210p -0.3
+ \]
V_wl_848 (WordLine\\<848\\> gnd!) vsource type=pwl wave=\[
+ 0    -0.3
+ 2627630890081645080489905193428239901459115857742326237837264786766921046916731097781593569503115983296993906714646911916713941733205785141616511317323966806013904422906815902067819922461200894311992918771265919154015618665639615991742614860533859183126117700p -0.3
+ 2627630890081645080489905193428239901459115857742326237837264786766921046916731097781593569503115983296993906714646911916713941733205785141616511317323966806013904422906815902067819922461200894311992918771265919154015618665639615991742614860533859183126117710p 0.9
+ 2627630890081645080489905193428239901459115857742326237837264786766921046916731097781593569503115983296993906714646911916713941733205785141616511317323966806013904422906815902067819922461200894311992918771265919154015618665639615991742614860533859183126118400p 0.9
+ 2627630890081645080489905193428239901459115857742326237837264786766921046916731097781593569503115983296993906714646911916713941733205785141616511317323966806013904422906815902067819922461200894311992918771265919154015618665639615991742614860533859183126118410p -0.3
+ \]
V_wl_849 (WordLine\\<849\\> gnd!) vsource type=pwl wave=\[
+ 0    -0.3
+ 5255261780163290160979810386856479802918231715484652475674529573533842093833462195563187139006231966593987813429293823833427883466411570283233022634647933612027808845813631804135639844922401788623985837542531838308031237331279231983485229721067718366252236100p -0.3
+ 5255261780163290160979810386856479802918231715484652475674529573533842093833462195563187139006231966593987813429293823833427883466411570283233022634647933612027808845813631804135639844922401788623985837542531838308031237331279231983485229721067718366252236110p 0.9
+ 5255261780163290160979810386856479802918231715484652475674529573533842093833462195563187139006231966593987813429293823833427883466411570283233022634647933612027808845813631804135639844922401788623985837542531838308031237331279231983485229721067718366252236800p 0.9
+ 5255261780163290160979810386856479802918231715484652475674529573533842093833462195563187139006231966593987813429293823833427883466411570283233022634647933612027808845813631804135639844922401788623985837542531838308031237331279231983485229721067718366252236810p -0.3
+ \]
V_wl_850 (WordLine\\<850\\> gnd!) vsource type=pwl wave=\[
+ 0    -0.3
+ 10510523560326580321959620773712959605836463430969304951349059147067684187666924391126374278012463933187975626858587647666855766932823140566466045269295867224055617691627263608271279689844803577247971675085063676616062474662558463966970459442135436732504472900p -0.3
+ 10510523560326580321959620773712959605836463430969304951349059147067684187666924391126374278012463933187975626858587647666855766932823140566466045269295867224055617691627263608271279689844803577247971675085063676616062474662558463966970459442135436732504472910p 0.9
+ 10510523560326580321959620773712959605836463430969304951349059147067684187666924391126374278012463933187975626858587647666855766932823140566466045269295867224055617691627263608271279689844803577247971675085063676616062474662558463966970459442135436732504473600p 0.9
+ 10510523560326580321959620773712959605836463430969304951349059147067684187666924391126374278012463933187975626858587647666855766932823140566466045269295867224055617691627263608271279689844803577247971675085063676616062474662558463966970459442135436732504473610p -0.3
+ \]
V_wl_851 (WordLine\\<851\\> gnd!) vsource type=pwl wave=\[
+ 0    -0.3
+ 21021047120653160643919241547425919211672926861938609902698118294135368375333848782252748556024927866375951253717175295333711533865646281132932090538591734448111235383254527216542559379689607154495943350170127353232124949325116927933940918884270873465008946500p -0.3
+ 21021047120653160643919241547425919211672926861938609902698118294135368375333848782252748556024927866375951253717175295333711533865646281132932090538591734448111235383254527216542559379689607154495943350170127353232124949325116927933940918884270873465008946510p 0.9
+ 21021047120653160643919241547425919211672926861938609902698118294135368375333848782252748556024927866375951253717175295333711533865646281132932090538591734448111235383254527216542559379689607154495943350170127353232124949325116927933940918884270873465008947200p 0.9
+ 21021047120653160643919241547425919211672926861938609902698118294135368375333848782252748556024927866375951253717175295333711533865646281132932090538591734448111235383254527216542559379689607154495943350170127353232124949325116927933940918884270873465008947210p -0.3
+ \]
V_wl_852 (WordLine\\<852\\> gnd!) vsource type=pwl wave=\[
+ 0    -0.3
+ 42042094241306321287838483094851838423345853723877219805396236588270736750667697564505497112049855732751902507434350590667423067731292562265864181077183468896222470766509054433085118759379214308991886700340254706464249898650233855867881837768541746930017893700p -0.3
+ 42042094241306321287838483094851838423345853723877219805396236588270736750667697564505497112049855732751902507434350590667423067731292562265864181077183468896222470766509054433085118759379214308991886700340254706464249898650233855867881837768541746930017893710p 0.9
+ 42042094241306321287838483094851838423345853723877219805396236588270736750667697564505497112049855732751902507434350590667423067731292562265864181077183468896222470766509054433085118759379214308991886700340254706464249898650233855867881837768541746930017894400p 0.9
+ 42042094241306321287838483094851838423345853723877219805396236588270736750667697564505497112049855732751902507434350590667423067731292562265864181077183468896222470766509054433085118759379214308991886700340254706464249898650233855867881837768541746930017894410p -0.3
+ \]
V_wl_853 (WordLine\\<853\\> gnd!) vsource type=pwl wave=\[
+ 0    -0.3
+ 84084188482612642575676966189703676846691707447754439610792473176541473501335395129010994224099711465503805014868701181334846135462585124531728362154366937792444941533018108866170237518758428617983773400680509412928499797300467711735763675537083493860035788100p -0.3
+ 84084188482612642575676966189703676846691707447754439610792473176541473501335395129010994224099711465503805014868701181334846135462585124531728362154366937792444941533018108866170237518758428617983773400680509412928499797300467711735763675537083493860035788110p 0.9
+ 84084188482612642575676966189703676846691707447754439610792473176541473501335395129010994224099711465503805014868701181334846135462585124531728362154366937792444941533018108866170237518758428617983773400680509412928499797300467711735763675537083493860035788800p 0.9
+ 84084188482612642575676966189703676846691707447754439610792473176541473501335395129010994224099711465503805014868701181334846135462585124531728362154366937792444941533018108866170237518758428617983773400680509412928499797300467711735763675537083493860035788810p -0.3
+ \]
V_wl_854 (WordLine\\<854\\> gnd!) vsource type=pwl wave=\[
+ 0    -0.3
+ 168168376965225285151353932379407353693383414895508879221584946353082947002670790258021988448199422931007610029737402362669692270925170249063456724308733875584889883066036217732340475037516857235967546801361018825856999594600935423471527351074166987720071576900p -0.3
+ 168168376965225285151353932379407353693383414895508879221584946353082947002670790258021988448199422931007610029737402362669692270925170249063456724308733875584889883066036217732340475037516857235967546801361018825856999594600935423471527351074166987720071576910p 0.9
+ 168168376965225285151353932379407353693383414895508879221584946353082947002670790258021988448199422931007610029737402362669692270925170249063456724308733875584889883066036217732340475037516857235967546801361018825856999594600935423471527351074166987720071577600p 0.9
+ 168168376965225285151353932379407353693383414895508879221584946353082947002670790258021988448199422931007610029737402362669692270925170249063456724308733875584889883066036217732340475037516857235967546801361018825856999594600935423471527351074166987720071577610p -0.3
+ \]
V_wl_855 (WordLine\\<855\\> gnd!) vsource type=pwl wave=\[
+ 0    -0.3
+ 336336753930450570302707864758814707386766829791017758443169892706165894005341580516043976896398845862015220059474804725339384541850340498126913448617467751169779766132072435464680950075033714471935093602722037651713999189201870846943054702148333975440143154500p -0.3
+ 336336753930450570302707864758814707386766829791017758443169892706165894005341580516043976896398845862015220059474804725339384541850340498126913448617467751169779766132072435464680950075033714471935093602722037651713999189201870846943054702148333975440143154510p 0.9
+ 336336753930450570302707864758814707386766829791017758443169892706165894005341580516043976896398845862015220059474804725339384541850340498126913448617467751169779766132072435464680950075033714471935093602722037651713999189201870846943054702148333975440143155200p 0.9
+ 336336753930450570302707864758814707386766829791017758443169892706165894005341580516043976896398845862015220059474804725339384541850340498126913448617467751169779766132072435464680950075033714471935093602722037651713999189201870846943054702148333975440143155210p -0.3
+ \]
V_wl_856 (WordLine\\<856\\> gnd!) vsource type=pwl wave=\[
+ 0    -0.3
+ 672673507860901140605415729517629414773533659582035516886339785412331788010683161032087953792797691724030440118949609450678769083700680996253826897234935502339559532264144870929361900150067428943870187205444075303427998378403741693886109404296667950880286309700p -0.3
+ 672673507860901140605415729517629414773533659582035516886339785412331788010683161032087953792797691724030440118949609450678769083700680996253826897234935502339559532264144870929361900150067428943870187205444075303427998378403741693886109404296667950880286309710p 0.9
+ 672673507860901140605415729517629414773533659582035516886339785412331788010683161032087953792797691724030440118949609450678769083700680996253826897234935502339559532264144870929361900150067428943870187205444075303427998378403741693886109404296667950880286310400p 0.9
+ 672673507860901140605415729517629414773533659582035516886339785412331788010683161032087953792797691724030440118949609450678769083700680996253826897234935502339559532264144870929361900150067428943870187205444075303427998378403741693886109404296667950880286310410p -0.3
+ \]
V_wl_857 (WordLine\\<857\\> gnd!) vsource type=pwl wave=\[
+ 0    -0.3
+ 1345347015721802281210831459035258829547067319164071033772679570824663576021366322064175907585595383448060880237899218901357538167401361992507653794469871004679119064528289741858723800300134857887740374410888150606855996756807483387772218808593335901760572620100p -0.3
+ 1345347015721802281210831459035258829547067319164071033772679570824663576021366322064175907585595383448060880237899218901357538167401361992507653794469871004679119064528289741858723800300134857887740374410888150606855996756807483387772218808593335901760572620110p 0.9
+ 1345347015721802281210831459035258829547067319164071033772679570824663576021366322064175907585595383448060880237899218901357538167401361992507653794469871004679119064528289741858723800300134857887740374410888150606855996756807483387772218808593335901760572620800p 0.9
+ 1345347015721802281210831459035258829547067319164071033772679570824663576021366322064175907585595383448060880237899218901357538167401361992507653794469871004679119064528289741858723800300134857887740374410888150606855996756807483387772218808593335901760572620810p -0.3
+ \]
V_wl_858 (WordLine\\<858\\> gnd!) vsource type=pwl wave=\[
+ 0    -0.3
+ 2690694031443604562421662918070517659094134638328142067545359141649327152042732644128351815171190766896121760475798437802715076334802723985015307588939742009358238129056579483717447600600269715775480748821776301213711993513614966775544437617186671803521145240900p -0.3
+ 2690694031443604562421662918070517659094134638328142067545359141649327152042732644128351815171190766896121760475798437802715076334802723985015307588939742009358238129056579483717447600600269715775480748821776301213711993513614966775544437617186671803521145240910p 0.9
+ 2690694031443604562421662918070517659094134638328142067545359141649327152042732644128351815171190766896121760475798437802715076334802723985015307588939742009358238129056579483717447600600269715775480748821776301213711993513614966775544437617186671803521145241600p 0.9
+ 2690694031443604562421662918070517659094134638328142067545359141649327152042732644128351815171190766896121760475798437802715076334802723985015307588939742009358238129056579483717447600600269715775480748821776301213711993513614966775544437617186671803521145241610p -0.3
+ \]
V_wl_859 (WordLine\\<859\\> gnd!) vsource type=pwl wave=\[
+ 0    -0.3
+ 5381388062887209124843325836141035318188269276656284135090718283298654304085465288256703630342381533792243520951596875605430152669605447970030615177879484018716476258113158967434895201200539431550961497643552602427423987027229933551088875234373343607042290482500p -0.3
+ 5381388062887209124843325836141035318188269276656284135090718283298654304085465288256703630342381533792243520951596875605430152669605447970030615177879484018716476258113158967434895201200539431550961497643552602427423987027229933551088875234373343607042290482510p 0.9
+ 5381388062887209124843325836141035318188269276656284135090718283298654304085465288256703630342381533792243520951596875605430152669605447970030615177879484018716476258113158967434895201200539431550961497643552602427423987027229933551088875234373343607042290483200p 0.9
+ 5381388062887209124843325836141035318188269276656284135090718283298654304085465288256703630342381533792243520951596875605430152669605447970030615177879484018716476258113158967434895201200539431550961497643552602427423987027229933551088875234373343607042290483210p -0.3
+ \]
V_wl_860 (WordLine\\<860\\> gnd!) vsource type=pwl wave=\[
+ 0    -0.3
+ 10762776125774418249686651672282070636376538553312568270181436566597308608170930576513407260684763067584487041903193751210860305339210895940061230355758968037432952516226317934869790402401078863101922995287105204854847974054459867102177750468746687214084580965700p -0.3
+ 10762776125774418249686651672282070636376538553312568270181436566597308608170930576513407260684763067584487041903193751210860305339210895940061230355758968037432952516226317934869790402401078863101922995287105204854847974054459867102177750468746687214084580965710p 0.9
+ 10762776125774418249686651672282070636376538553312568270181436566597308608170930576513407260684763067584487041903193751210860305339210895940061230355758968037432952516226317934869790402401078863101922995287105204854847974054459867102177750468746687214084580966400p 0.9
+ 10762776125774418249686651672282070636376538553312568270181436566597308608170930576513407260684763067584487041903193751210860305339210895940061230355758968037432952516226317934869790402401078863101922995287105204854847974054459867102177750468746687214084580966410p -0.3
+ \]
V_wl_861 (WordLine\\<861\\> gnd!) vsource type=pwl wave=\[
+ 0    -0.3
+ 21525552251548836499373303344564141272753077106625136540362873133194617216341861153026814521369526135168974083806387502421720610678421791880122460711517936074865905032452635869739580804802157726203845990574210409709695948108919734204355500937493374428169161932100p -0.3
+ 21525552251548836499373303344564141272753077106625136540362873133194617216341861153026814521369526135168974083806387502421720610678421791880122460711517936074865905032452635869739580804802157726203845990574210409709695948108919734204355500937493374428169161932110p 0.9
+ 21525552251548836499373303344564141272753077106625136540362873133194617216341861153026814521369526135168974083806387502421720610678421791880122460711517936074865905032452635869739580804802157726203845990574210409709695948108919734204355500937493374428169161932800p 0.9
+ 21525552251548836499373303344564141272753077106625136540362873133194617216341861153026814521369526135168974083806387502421720610678421791880122460711517936074865905032452635869739580804802157726203845990574210409709695948108919734204355500937493374428169161932810p -0.3
+ \]
V_wl_862 (WordLine\\<862\\> gnd!) vsource type=pwl wave=\[
+ 0    -0.3
+ 43051104503097672998746606689128282545506154213250273080725746266389234432683722306053629042739052270337948167612775004843441221356843583760244921423035872149731810064905271739479161609604315452407691981148420819419391896217839468408711001874986748856338323864900p -0.3
+ 43051104503097672998746606689128282545506154213250273080725746266389234432683722306053629042739052270337948167612775004843441221356843583760244921423035872149731810064905271739479161609604315452407691981148420819419391896217839468408711001874986748856338323864910p 0.9
+ 43051104503097672998746606689128282545506154213250273080725746266389234432683722306053629042739052270337948167612775004843441221356843583760244921423035872149731810064905271739479161609604315452407691981148420819419391896217839468408711001874986748856338323865600p 0.9
+ 43051104503097672998746606689128282545506154213250273080725746266389234432683722306053629042739052270337948167612775004843441221356843583760244921423035872149731810064905271739479161609604315452407691981148420819419391896217839468408711001874986748856338323865610p -0.3
+ \]
V_wl_863 (WordLine\\<863\\> gnd!) vsource type=pwl wave=\[
+ 0    -0.3
+ 86102209006195345997493213378256565091012308426500546161451492532778468865367444612107258085478104540675896335225550009686882442713687167520489842846071744299463620129810543478958323219208630904815383962296841638838783792435678936817422003749973497712676647730500p -0.3
+ 86102209006195345997493213378256565091012308426500546161451492532778468865367444612107258085478104540675896335225550009686882442713687167520489842846071744299463620129810543478958323219208630904815383962296841638838783792435678936817422003749973497712676647730510p 0.9
+ 86102209006195345997493213378256565091012308426500546161451492532778468865367444612107258085478104540675896335225550009686882442713687167520489842846071744299463620129810543478958323219208630904815383962296841638838783792435678936817422003749973497712676647731200p 0.9
+ 86102209006195345997493213378256565091012308426500546161451492532778468865367444612107258085478104540675896335225550009686882442713687167520489842846071744299463620129810543478958323219208630904815383962296841638838783792435678936817422003749973497712676647731210p -0.3
+ \]
V_wl_864 (WordLine\\<864\\> gnd!) vsource type=pwl wave=\[
+ 0    -0.3
+ 172204418012390691994986426756513130182024616853001092322902985065556937730734889224214516170956209081351792670451100019373764885427374335040979685692143488598927240259621086957916646438417261809630767924593683277677567584871357873634844007499946995425353295461700p -0.3
+ 172204418012390691994986426756513130182024616853001092322902985065556937730734889224214516170956209081351792670451100019373764885427374335040979685692143488598927240259621086957916646438417261809630767924593683277677567584871357873634844007499946995425353295461710p 0.9
+ 172204418012390691994986426756513130182024616853001092322902985065556937730734889224214516170956209081351792670451100019373764885427374335040979685692143488598927240259621086957916646438417261809630767924593683277677567584871357873634844007499946995425353295462400p 0.9
+ 172204418012390691994986426756513130182024616853001092322902985065556937730734889224214516170956209081351792670451100019373764885427374335040979685692143488598927240259621086957916646438417261809630767924593683277677567584871357873634844007499946995425353295462410p -0.3
+ \]
V_wl_865 (WordLine\\<865\\> gnd!) vsource type=pwl wave=\[
+ 0    -0.3
+ 344408836024781383989972853513026260364049233706002184645805970131113875461469778448429032341912418162703585340902200038747529770854748670081959371384286977197854480519242173915833292876834523619261535849187366555355135169742715747269688014999893990850706590924100p -0.3
+ 344408836024781383989972853513026260364049233706002184645805970131113875461469778448429032341912418162703585340902200038747529770854748670081959371384286977197854480519242173915833292876834523619261535849187366555355135169742715747269688014999893990850706590924110p 0.9
+ 344408836024781383989972853513026260364049233706002184645805970131113875461469778448429032341912418162703585340902200038747529770854748670081959371384286977197854480519242173915833292876834523619261535849187366555355135169742715747269688014999893990850706590924800p 0.9
+ 344408836024781383989972853513026260364049233706002184645805970131113875461469778448429032341912418162703585340902200038747529770854748670081959371384286977197854480519242173915833292876834523619261535849187366555355135169742715747269688014999893990850706590924810p -0.3
+ \]
V_wl_866 (WordLine\\<866\\> gnd!) vsource type=pwl wave=\[
+ 0    -0.3
+ 688817672049562767979945707026052520728098467412004369291611940262227750922939556896858064683824836325407170681804400077495059541709497340163918742768573954395708961038484347831666585753669047238523071698374733110710270339485431494539376029999787981701413181848900p -0.3
+ 688817672049562767979945707026052520728098467412004369291611940262227750922939556896858064683824836325407170681804400077495059541709497340163918742768573954395708961038484347831666585753669047238523071698374733110710270339485431494539376029999787981701413181848910p 0.9
+ 688817672049562767979945707026052520728098467412004369291611940262227750922939556896858064683824836325407170681804400077495059541709497340163918742768573954395708961038484347831666585753669047238523071698374733110710270339485431494539376029999787981701413181849600p 0.9
+ 688817672049562767979945707026052520728098467412004369291611940262227750922939556896858064683824836325407170681804400077495059541709497340163918742768573954395708961038484347831666585753669047238523071698374733110710270339485431494539376029999787981701413181849610p -0.3
+ \]
V_wl_867 (WordLine\\<867\\> gnd!) vsource type=pwl wave=\[
+ 0    -0.3
+ 1377635344099125535959891414052105041456196934824008738583223880524455501845879113793716129367649672650814341363608800154990119083418994680327837485537147908791417922076968695663333171507338094477046143396749466221420540678970862989078752059999575963402826363698500p -0.3
+ 1377635344099125535959891414052105041456196934824008738583223880524455501845879113793716129367649672650814341363608800154990119083418994680327837485537147908791417922076968695663333171507338094477046143396749466221420540678970862989078752059999575963402826363698510p 0.9
+ 1377635344099125535959891414052105041456196934824008738583223880524455501845879113793716129367649672650814341363608800154990119083418994680327837485537147908791417922076968695663333171507338094477046143396749466221420540678970862989078752059999575963402826363699200p 0.9
+ 1377635344099125535959891414052105041456196934824008738583223880524455501845879113793716129367649672650814341363608800154990119083418994680327837485537147908791417922076968695663333171507338094477046143396749466221420540678970862989078752059999575963402826363699210p -0.3
+ \]
V_wl_868 (WordLine\\<868\\> gnd!) vsource type=pwl wave=\[
+ 0    -0.3
+ 2755270688198251071919782828104210082912393869648017477166447761048911003691758227587432258735299345301628682727217600309980238166837989360655674971074295817582835844153937391326666343014676188954092286793498932442841081357941725978157504119999151926805652727397700p -0.3
+ 2755270688198251071919782828104210082912393869648017477166447761048911003691758227587432258735299345301628682727217600309980238166837989360655674971074295817582835844153937391326666343014676188954092286793498932442841081357941725978157504119999151926805652727397710p 0.9
+ 2755270688198251071919782828104210082912393869648017477166447761048911003691758227587432258735299345301628682727217600309980238166837989360655674971074295817582835844153937391326666343014676188954092286793498932442841081357941725978157504119999151926805652727398400p 0.9
+ 2755270688198251071919782828104210082912393869648017477166447761048911003691758227587432258735299345301628682727217600309980238166837989360655674971074295817582835844153937391326666343014676188954092286793498932442841081357941725978157504119999151926805652727398410p -0.3
+ \]
V_wl_869 (WordLine\\<869\\> gnd!) vsource type=pwl wave=\[
+ 0    -0.3
+ 5510541376396502143839565656208420165824787739296034954332895522097822007383516455174864517470598690603257365454435200619960476333675978721311349942148591635165671688307874782653332686029352377908184573586997864885682162715883451956315008239998303853611305454796100p -0.3
+ 5510541376396502143839565656208420165824787739296034954332895522097822007383516455174864517470598690603257365454435200619960476333675978721311349942148591635165671688307874782653332686029352377908184573586997864885682162715883451956315008239998303853611305454796110p 0.9
+ 5510541376396502143839565656208420165824787739296034954332895522097822007383516455174864517470598690603257365454435200619960476333675978721311349942148591635165671688307874782653332686029352377908184573586997864885682162715883451956315008239998303853611305454796800p 0.9
+ 5510541376396502143839565656208420165824787739296034954332895522097822007383516455174864517470598690603257365454435200619960476333675978721311349942148591635165671688307874782653332686029352377908184573586997864885682162715883451956315008239998303853611305454796810p -0.3
+ \]
V_wl_870 (WordLine\\<870\\> gnd!) vsource type=pwl wave=\[
+ 0    -0.3
+ 11021082752793004287679131312416840331649575478592069908665791044195644014767032910349729034941197381206514730908870401239920952667351957442622699884297183270331343376615749565306665372058704755816369147173995729771364325431766903912630016479996607707222610909592900p -0.3
+ 11021082752793004287679131312416840331649575478592069908665791044195644014767032910349729034941197381206514730908870401239920952667351957442622699884297183270331343376615749565306665372058704755816369147173995729771364325431766903912630016479996607707222610909592910p 0.9
+ 11021082752793004287679131312416840331649575478592069908665791044195644014767032910349729034941197381206514730908870401239920952667351957442622699884297183270331343376615749565306665372058704755816369147173995729771364325431766903912630016479996607707222610909593600p 0.9
+ 11021082752793004287679131312416840331649575478592069908665791044195644014767032910349729034941197381206514730908870401239920952667351957442622699884297183270331343376615749565306665372058704755816369147173995729771364325431766903912630016479996607707222610909593610p -0.3
+ \]
V_wl_871 (WordLine\\<871\\> gnd!) vsource type=pwl wave=\[
+ 0    -0.3
+ 22042165505586008575358262624833680663299150957184139817331582088391288029534065820699458069882394762413029461817740802479841905334703914885245399768594366540662686753231499130613330744117409511632738294347991459542728650863533807825260032959993215414445221819186500p -0.3
+ 22042165505586008575358262624833680663299150957184139817331582088391288029534065820699458069882394762413029461817740802479841905334703914885245399768594366540662686753231499130613330744117409511632738294347991459542728650863533807825260032959993215414445221819186510p 0.9
+ 22042165505586008575358262624833680663299150957184139817331582088391288029534065820699458069882394762413029461817740802479841905334703914885245399768594366540662686753231499130613330744117409511632738294347991459542728650863533807825260032959993215414445221819187200p 0.9
+ 22042165505586008575358262624833680663299150957184139817331582088391288029534065820699458069882394762413029461817740802479841905334703914885245399768594366540662686753231499130613330744117409511632738294347991459542728650863533807825260032959993215414445221819187210p -0.3
+ \]
V_wl_872 (WordLine\\<872\\> gnd!) vsource type=pwl wave=\[
+ 0    -0.3
+ 44084331011172017150716525249667361326598301914368279634663164176782576059068131641398916139764789524826058923635481604959683810669407829770490799537188733081325373506462998261226661488234819023265476588695982919085457301727067615650520065919986430828890443638373700p -0.3
+ 44084331011172017150716525249667361326598301914368279634663164176782576059068131641398916139764789524826058923635481604959683810669407829770490799537188733081325373506462998261226661488234819023265476588695982919085457301727067615650520065919986430828890443638373710p 0.9
+ 44084331011172017150716525249667361326598301914368279634663164176782576059068131641398916139764789524826058923635481604959683810669407829770490799537188733081325373506462998261226661488234819023265476588695982919085457301727067615650520065919986430828890443638374400p 0.9
+ 44084331011172017150716525249667361326598301914368279634663164176782576059068131641398916139764789524826058923635481604959683810669407829770490799537188733081325373506462998261226661488234819023265476588695982919085457301727067615650520065919986430828890443638374410p -0.3
+ \]
V_wl_873 (WordLine\\<873\\> gnd!) vsource type=pwl wave=\[
+ 0    -0.3
+ 88168662022344034301433050499334722653196603828736559269326328353565152118136263282797832279529579049652117847270963209919367621338815659540981599074377466162650747012925996522453322976469638046530953177391965838170914603454135231301040131839972861657780887276748100p -0.3
+ 88168662022344034301433050499334722653196603828736559269326328353565152118136263282797832279529579049652117847270963209919367621338815659540981599074377466162650747012925996522453322976469638046530953177391965838170914603454135231301040131839972861657780887276748110p 0.9
+ 88168662022344034301433050499334722653196603828736559269326328353565152118136263282797832279529579049652117847270963209919367621338815659540981599074377466162650747012925996522453322976469638046530953177391965838170914603454135231301040131839972861657780887276748800p 0.9
+ 88168662022344034301433050499334722653196603828736559269326328353565152118136263282797832279529579049652117847270963209919367621338815659540981599074377466162650747012925996522453322976469638046530953177391965838170914603454135231301040131839972861657780887276748810p -0.3
+ \]
V_wl_874 (WordLine\\<874\\> gnd!) vsource type=pwl wave=\[
+ 0    -0.3
+ 176337324044688068602866100998669445306393207657473118538652656707130304236272526565595664559059158099304235694541926419838735242677631319081963198148754932325301494025851993044906645952939276093061906354783931676341829206908270462602080263679945723315561774553496900p -0.3
+ 176337324044688068602866100998669445306393207657473118538652656707130304236272526565595664559059158099304235694541926419838735242677631319081963198148754932325301494025851993044906645952939276093061906354783931676341829206908270462602080263679945723315561774553496910p 0.9
+ 176337324044688068602866100998669445306393207657473118538652656707130304236272526565595664559059158099304235694541926419838735242677631319081963198148754932325301494025851993044906645952939276093061906354783931676341829206908270462602080263679945723315561774553497600p 0.9
+ 176337324044688068602866100998669445306393207657473118538652656707130304236272526565595664559059158099304235694541926419838735242677631319081963198148754932325301494025851993044906645952939276093061906354783931676341829206908270462602080263679945723315561774553497610p -0.3
+ \]
V_wl_875 (WordLine\\<875\\> gnd!) vsource type=pwl wave=\[
+ 0    -0.3
+ 352674648089376137205732201997338890612786415314946237077305313414260608472545053131191329118118316198608471389083852839677470485355262638163926396297509864650602988051703986089813291905878552186123812709567863352683658413816540925204160527359891446631123549106994500p -0.3
+ 352674648089376137205732201997338890612786415314946237077305313414260608472545053131191329118118316198608471389083852839677470485355262638163926396297509864650602988051703986089813291905878552186123812709567863352683658413816540925204160527359891446631123549106994510p 0.9
+ 352674648089376137205732201997338890612786415314946237077305313414260608472545053131191329118118316198608471389083852839677470485355262638163926396297509864650602988051703986089813291905878552186123812709567863352683658413816540925204160527359891446631123549106995200p 0.9
+ 352674648089376137205732201997338890612786415314946237077305313414260608472545053131191329118118316198608471389083852839677470485355262638163926396297509864650602988051703986089813291905878552186123812709567863352683658413816540925204160527359891446631123549106995210p -0.3
+ \]
V_wl_876 (WordLine\\<876\\> gnd!) vsource type=pwl wave=\[
+ 0    -0.3
+ 705349296178752274411464403994677781225572830629892474154610626828521216945090106262382658236236632397216942778167705679354940970710525276327852792595019729301205976103407972179626583811757104372247625419135726705367316827633081850408321054719782893262247098213989700p -0.3
+ 705349296178752274411464403994677781225572830629892474154610626828521216945090106262382658236236632397216942778167705679354940970710525276327852792595019729301205976103407972179626583811757104372247625419135726705367316827633081850408321054719782893262247098213989710p 0.9
+ 705349296178752274411464403994677781225572830629892474154610626828521216945090106262382658236236632397216942778167705679354940970710525276327852792595019729301205976103407972179626583811757104372247625419135726705367316827633081850408321054719782893262247098213990400p 0.9
+ 705349296178752274411464403994677781225572830629892474154610626828521216945090106262382658236236632397216942778167705679354940970710525276327852792595019729301205976103407972179626583811757104372247625419135726705367316827633081850408321054719782893262247098213990410p -0.3
+ \]
V_wl_877 (WordLine\\<877\\> gnd!) vsource type=pwl wave=\[
+ 0    -0.3
+ 1410698592357504548822928807989355562451145661259784948309221253657042433890180212524765316472473264794433885556335411358709881941421050552655705585190039458602411952206815944359253167623514208744495250838271453410734633655266163700816642109439565786524494196427980100p -0.3
+ 1410698592357504548822928807989355562451145661259784948309221253657042433890180212524765316472473264794433885556335411358709881941421050552655705585190039458602411952206815944359253167623514208744495250838271453410734633655266163700816642109439565786524494196427980110p 0.9
+ 1410698592357504548822928807989355562451145661259784948309221253657042433890180212524765316472473264794433885556335411358709881941421050552655705585190039458602411952206815944359253167623514208744495250838271453410734633655266163700816642109439565786524494196427980800p 0.9
+ 1410698592357504548822928807989355562451145661259784948309221253657042433890180212524765316472473264794433885556335411358709881941421050552655705585190039458602411952206815944359253167623514208744495250838271453410734633655266163700816642109439565786524494196427980810p -0.3
+ \]
V_wl_878 (WordLine\\<878\\> gnd!) vsource type=pwl wave=\[
+ 0    -0.3
+ 2821397184715009097645857615978711124902291322519569896618442507314084867780360425049530632944946529588867771112670822717419763882842101105311411170380078917204823904413631888718506335247028417488990501676542906821469267310532327401633284218879131573048988392855960900p -0.3
+ 2821397184715009097645857615978711124902291322519569896618442507314084867780360425049530632944946529588867771112670822717419763882842101105311411170380078917204823904413631888718506335247028417488990501676542906821469267310532327401633284218879131573048988392855960910p 0.9
+ 2821397184715009097645857615978711124902291322519569896618442507314084867780360425049530632944946529588867771112670822717419763882842101105311411170380078917204823904413631888718506335247028417488990501676542906821469267310532327401633284218879131573048988392855961600p 0.9
+ 2821397184715009097645857615978711124902291322519569896618442507314084867780360425049530632944946529588867771112670822717419763882842101105311411170380078917204823904413631888718506335247028417488990501676542906821469267310532327401633284218879131573048988392855961610p -0.3
+ \]
V_wl_879 (WordLine\\<879\\> gnd!) vsource type=pwl wave=\[
+ 0    -0.3
+ 5642794369430018195291715231957422249804582645039139793236885014628169735560720850099061265889893059177735542225341645434839527765684202210622822340760157834409647808827263777437012670494056834977981003353085813642938534621064654803266568437758263146097976785711922500p -0.3
+ 5642794369430018195291715231957422249804582645039139793236885014628169735560720850099061265889893059177735542225341645434839527765684202210622822340760157834409647808827263777437012670494056834977981003353085813642938534621064654803266568437758263146097976785711922510p 0.9
+ 5642794369430018195291715231957422249804582645039139793236885014628169735560720850099061265889893059177735542225341645434839527765684202210622822340760157834409647808827263777437012670494056834977981003353085813642938534621064654803266568437758263146097976785711923200p 0.9
+ 5642794369430018195291715231957422249804582645039139793236885014628169735560720850099061265889893059177735542225341645434839527765684202210622822340760157834409647808827263777437012670494056834977981003353085813642938534621064654803266568437758263146097976785711923210p -0.3
+ \]
V_wl_880 (WordLine\\<880\\> gnd!) vsource type=pwl wave=\[
+ 0    -0.3
+ 11285588738860036390583430463914844499609165290078279586473770029256339471121441700198122531779786118355471084450683290869679055531368404421245644681520315668819295617654527554874025340988113669955962006706171627285877069242129309606533136875516526292195953571423845700p -0.3
+ 11285588738860036390583430463914844499609165290078279586473770029256339471121441700198122531779786118355471084450683290869679055531368404421245644681520315668819295617654527554874025340988113669955962006706171627285877069242129309606533136875516526292195953571423845710p 0.9
+ 11285588738860036390583430463914844499609165290078279586473770029256339471121441700198122531779786118355471084450683290869679055531368404421245644681520315668819295617654527554874025340988113669955962006706171627285877069242129309606533136875516526292195953571423846400p 0.9
+ 11285588738860036390583430463914844499609165290078279586473770029256339471121441700198122531779786118355471084450683290869679055531368404421245644681520315668819295617654527554874025340988113669955962006706171627285877069242129309606533136875516526292195953571423846410p -0.3
+ \]
V_wl_881 (WordLine\\<881\\> gnd!) vsource type=pwl wave=\[
+ 0    -0.3
+ 22571177477720072781166860927829688999218330580156559172947540058512678942242883400396245063559572236710942168901366581739358111062736808842491289363040631337638591235309055109748050681976227339911924013412343254571754138484258619213066273751033052584391907142847692100p -0.3
+ 22571177477720072781166860927829688999218330580156559172947540058512678942242883400396245063559572236710942168901366581739358111062736808842491289363040631337638591235309055109748050681976227339911924013412343254571754138484258619213066273751033052584391907142847692110p 0.9
+ 22571177477720072781166860927829688999218330580156559172947540058512678942242883400396245063559572236710942168901366581739358111062736808842491289363040631337638591235309055109748050681976227339911924013412343254571754138484258619213066273751033052584391907142847692800p 0.9
+ 22571177477720072781166860927829688999218330580156559172947540058512678942242883400396245063559572236710942168901366581739358111062736808842491289363040631337638591235309055109748050681976227339911924013412343254571754138484258619213066273751033052584391907142847692810p -0.3
+ \]
V_wl_882 (WordLine\\<882\\> gnd!) vsource type=pwl wave=\[
+ 0    -0.3
+ 45142354955440145562333721855659377998436661160313118345895080117025357884485766800792490127119144473421884337802733163478716222125473617684982578726081262675277182470618110219496101363952454679823848026824686509143508276968517238426132547502066105168783814285695384900p -0.3
+ 45142354955440145562333721855659377998436661160313118345895080117025357884485766800792490127119144473421884337802733163478716222125473617684982578726081262675277182470618110219496101363952454679823848026824686509143508276968517238426132547502066105168783814285695384910p 0.9
+ 45142354955440145562333721855659377998436661160313118345895080117025357884485766800792490127119144473421884337802733163478716222125473617684982578726081262675277182470618110219496101363952454679823848026824686509143508276968517238426132547502066105168783814285695385600p 0.9
+ 45142354955440145562333721855659377998436661160313118345895080117025357884485766800792490127119144473421884337802733163478716222125473617684982578726081262675277182470618110219496101363952454679823848026824686509143508276968517238426132547502066105168783814285695385610p -0.3
+ \]
V_wl_883 (WordLine\\<883\\> gnd!) vsource type=pwl wave=\[
+ 0    -0.3
+ 90284709910880291124667443711318755996873322320626236691790160234050715768971533601584980254238288946843768675605466326957432444250947235369965157452162525350554364941236220438992202727904909359647696053649373018287016553937034476852265095004132210337567628571390770500p -0.3
+ 90284709910880291124667443711318755996873322320626236691790160234050715768971533601584980254238288946843768675605466326957432444250947235369965157452162525350554364941236220438992202727904909359647696053649373018287016553937034476852265095004132210337567628571390770510p 0.9
+ 90284709910880291124667443711318755996873322320626236691790160234050715768971533601584980254238288946843768675605466326957432444250947235369965157452162525350554364941236220438992202727904909359647696053649373018287016553937034476852265095004132210337567628571390771200p 0.9
+ 90284709910880291124667443711318755996873322320626236691790160234050715768971533601584980254238288946843768675605466326957432444250947235369965157452162525350554364941236220438992202727904909359647696053649373018287016553937034476852265095004132210337567628571390771210p -0.3
+ \]
V_wl_884 (WordLine\\<884\\> gnd!) vsource type=pwl wave=\[
+ 0    -0.3
+ 180569419821760582249334887422637511993746644641252473383580320468101431537943067203169960508476577893687537351210932653914864888501894470739930314904325050701108729882472440877984405455809818719295392107298746036574033107874068953704530190008264420675135257142781541700p -0.3
+ 180569419821760582249334887422637511993746644641252473383580320468101431537943067203169960508476577893687537351210932653914864888501894470739930314904325050701108729882472440877984405455809818719295392107298746036574033107874068953704530190008264420675135257142781541710p 0.9
+ 180569419821760582249334887422637511993746644641252473383580320468101431537943067203169960508476577893687537351210932653914864888501894470739930314904325050701108729882472440877984405455809818719295392107298746036574033107874068953704530190008264420675135257142781542400p 0.9
+ 180569419821760582249334887422637511993746644641252473383580320468101431537943067203169960508476577893687537351210932653914864888501894470739930314904325050701108729882472440877984405455809818719295392107298746036574033107874068953704530190008264420675135257142781542410p -0.3
+ \]
V_wl_885 (WordLine\\<885\\> gnd!) vsource type=pwl wave=\[
+ 0    -0.3
+ 361138839643521164498669774845275023987493289282504946767160640936202863075886134406339921016953155787375074702421865307829729777003788941479860629808650101402217459764944881755968810911619637438590784214597492073148066215748137907409060380016528841350270514285563084100p -0.3
+ 361138839643521164498669774845275023987493289282504946767160640936202863075886134406339921016953155787375074702421865307829729777003788941479860629808650101402217459764944881755968810911619637438590784214597492073148066215748137907409060380016528841350270514285563084110p 0.9
+ 361138839643521164498669774845275023987493289282504946767160640936202863075886134406339921016953155787375074702421865307829729777003788941479860629808650101402217459764944881755968810911619637438590784214597492073148066215748137907409060380016528841350270514285563084800p 0.9
+ 361138839643521164498669774845275023987493289282504946767160640936202863075886134406339921016953155787375074702421865307829729777003788941479860629808650101402217459764944881755968810911619637438590784214597492073148066215748137907409060380016528841350270514285563084810p -0.3
+ \]
V_wl_886 (WordLine\\<886\\> gnd!) vsource type=pwl wave=\[
+ 0    -0.3
+ 722277679287042328997339549690550047974986578565009893534321281872405726151772268812679842033906311574750149404843730615659459554007577882959721259617300202804434919529889763511937621823239274877181568429194984146296132431496275814818120760033057682700541028571126168900p -0.3
+ 722277679287042328997339549690550047974986578565009893534321281872405726151772268812679842033906311574750149404843730615659459554007577882959721259617300202804434919529889763511937621823239274877181568429194984146296132431496275814818120760033057682700541028571126168910p 0.9
+ 722277679287042328997339549690550047974986578565009893534321281872405726151772268812679842033906311574750149404843730615659459554007577882959721259617300202804434919529889763511937621823239274877181568429194984146296132431496275814818120760033057682700541028571126169600p 0.9
+ 722277679287042328997339549690550047974986578565009893534321281872405726151772268812679842033906311574750149404843730615659459554007577882959721259617300202804434919529889763511937621823239274877181568429194984146296132431496275814818120760033057682700541028571126169610p -0.3
+ \]
V_wl_887 (WordLine\\<887\\> gnd!) vsource type=pwl wave=\[
+ 0    -0.3
+ 1444555358574084657994679099381100095949973157130019787068642563744811452303544537625359684067812623149500298809687461231318919108015155765919442519234600405608869839059779527023875243646478549754363136858389968292592264862992551629636241520066115365401082057142252338500p -0.3
+ 1444555358574084657994679099381100095949973157130019787068642563744811452303544537625359684067812623149500298809687461231318919108015155765919442519234600405608869839059779527023875243646478549754363136858389968292592264862992551629636241520066115365401082057142252338510p 0.9
+ 1444555358574084657994679099381100095949973157130019787068642563744811452303544537625359684067812623149500298809687461231318919108015155765919442519234600405608869839059779527023875243646478549754363136858389968292592264862992551629636241520066115365401082057142252339200p 0.9
+ 1444555358574084657994679099381100095949973157130019787068642563744811452303544537625359684067812623149500298809687461231318919108015155765919442519234600405608869839059779527023875243646478549754363136858389968292592264862992551629636241520066115365401082057142252339210p -0.3
+ \]
V_wl_888 (WordLine\\<888\\> gnd!) vsource type=pwl wave=\[
+ 0    -0.3
+ 2889110717148169315989358198762200191899946314260039574137285127489622904607089075250719368135625246299000597619374922462637838216030311531838885038469200811217739678119559054047750487292957099508726273716779936585184529725985103259272483040132230730802164114284504677700p -0.3
+ 2889110717148169315989358198762200191899946314260039574137285127489622904607089075250719368135625246299000597619374922462637838216030311531838885038469200811217739678119559054047750487292957099508726273716779936585184529725985103259272483040132230730802164114284504677710p 0.9
+ 2889110717148169315989358198762200191899946314260039574137285127489622904607089075250719368135625246299000597619374922462637838216030311531838885038469200811217739678119559054047750487292957099508726273716779936585184529725985103259272483040132230730802164114284504678400p 0.9
+ 2889110717148169315989358198762200191899946314260039574137285127489622904607089075250719368135625246299000597619374922462637838216030311531838885038469200811217739678119559054047750487292957099508726273716779936585184529725985103259272483040132230730802164114284504678410p -0.3
+ \]
V_wl_889 (WordLine\\<889\\> gnd!) vsource type=pwl wave=\[
+ 0    -0.3
+ 5778221434296338631978716397524400383799892628520079148274570254979245809214178150501438736271250492598001195238749844925275676432060623063677770076938401622435479356239118108095500974585914199017452547433559873170369059451970206518544966080264461461604328228569009356100p -0.3
+ 5778221434296338631978716397524400383799892628520079148274570254979245809214178150501438736271250492598001195238749844925275676432060623063677770076938401622435479356239118108095500974585914199017452547433559873170369059451970206518544966080264461461604328228569009356110p 0.9
+ 5778221434296338631978716397524400383799892628520079148274570254979245809214178150501438736271250492598001195238749844925275676432060623063677770076938401622435479356239118108095500974585914199017452547433559873170369059451970206518544966080264461461604328228569009356800p 0.9
+ 5778221434296338631978716397524400383799892628520079148274570254979245809214178150501438736271250492598001195238749844925275676432060623063677770076938401622435479356239118108095500974585914199017452547433559873170369059451970206518544966080264461461604328228569009356810p -0.3
+ \]
V_wl_890 (WordLine\\<890\\> gnd!) vsource type=pwl wave=\[
+ 0    -0.3
+ 11556442868592677263957432795048800767599785257040158296549140509958491618428356301002877472542500985196002390477499689850551352864121246127355540153876803244870958712478236216191001949171828398034905094867119746340738118903940413037089932160528922923208656457138018712900p -0.3
+ 11556442868592677263957432795048800767599785257040158296549140509958491618428356301002877472542500985196002390477499689850551352864121246127355540153876803244870958712478236216191001949171828398034905094867119746340738118903940413037089932160528922923208656457138018712910p 0.9
+ 11556442868592677263957432795048800767599785257040158296549140509958491618428356301002877472542500985196002390477499689850551352864121246127355540153876803244870958712478236216191001949171828398034905094867119746340738118903940413037089932160528922923208656457138018713600p 0.9
+ 11556442868592677263957432795048800767599785257040158296549140509958491618428356301002877472542500985196002390477499689850551352864121246127355540153876803244870958712478236216191001949171828398034905094867119746340738118903940413037089932160528922923208656457138018713610p -0.3
+ \]
V_wl_891 (WordLine\\<891\\> gnd!) vsource type=pwl wave=\[
+ 0    -0.3
+ 23112885737185354527914865590097601535199570514080316593098281019916983236856712602005754945085001970392004780954999379701102705728242492254711080307753606489741917424956472432382003898343656796069810189734239492681476237807880826074179864321057845846417312914276037426500p -0.3
+ 23112885737185354527914865590097601535199570514080316593098281019916983236856712602005754945085001970392004780954999379701102705728242492254711080307753606489741917424956472432382003898343656796069810189734239492681476237807880826074179864321057845846417312914276037426510p 0.9
+ 23112885737185354527914865590097601535199570514080316593098281019916983236856712602005754945085001970392004780954999379701102705728242492254711080307753606489741917424956472432382003898343656796069810189734239492681476237807880826074179864321057845846417312914276037427200p 0.9
+ 23112885737185354527914865590097601535199570514080316593098281019916983236856712602005754945085001970392004780954999379701102705728242492254711080307753606489741917424956472432382003898343656796069810189734239492681476237807880826074179864321057845846417312914276037427210p -0.3
+ \]
V_wl_892 (WordLine\\<892\\> gnd!) vsource type=pwl wave=\[
+ 0    -0.3
+ 46225771474370709055829731180195203070399141028160633186196562039833966473713425204011509890170003940784009561909998759402205411456484984509422160615507212979483834849912944864764007796687313592139620379468478985362952475615761652148359728642115691692834625828552074853700p -0.3
+ 46225771474370709055829731180195203070399141028160633186196562039833966473713425204011509890170003940784009561909998759402205411456484984509422160615507212979483834849912944864764007796687313592139620379468478985362952475615761652148359728642115691692834625828552074853710p 0.9
+ 46225771474370709055829731180195203070399141028160633186196562039833966473713425204011509890170003940784009561909998759402205411456484984509422160615507212979483834849912944864764007796687313592139620379468478985362952475615761652148359728642115691692834625828552074854400p 0.9
+ 46225771474370709055829731180195203070399141028160633186196562039833966473713425204011509890170003940784009561909998759402205411456484984509422160615507212979483834849912944864764007796687313592139620379468478985362952475615761652148359728642115691692834625828552074854410p -0.3
+ \]
V_wl_893 (WordLine\\<893\\> gnd!) vsource type=pwl wave=\[
+ 0    -0.3
+ 92451542948741418111659462360390406140798282056321266372393124079667932947426850408023019780340007881568019123819997518804410822912969969018844321231014425958967669699825889729528015593374627184279240758936957970725904951231523304296719457284231383385669251657104149708100p -0.3
+ 92451542948741418111659462360390406140798282056321266372393124079667932947426850408023019780340007881568019123819997518804410822912969969018844321231014425958967669699825889729528015593374627184279240758936957970725904951231523304296719457284231383385669251657104149708110p 0.9
+ 92451542948741418111659462360390406140798282056321266372393124079667932947426850408023019780340007881568019123819997518804410822912969969018844321231014425958967669699825889729528015593374627184279240758936957970725904951231523304296719457284231383385669251657104149708800p 0.9
+ 92451542948741418111659462360390406140798282056321266372393124079667932947426850408023019780340007881568019123819997518804410822912969969018844321231014425958967669699825889729528015593374627184279240758936957970725904951231523304296719457284231383385669251657104149708810p -0.3
+ \]
V_wl_894 (WordLine\\<894\\> gnd!) vsource type=pwl wave=\[
+ 0    -0.3
+ 184903085897482836223318924720780812281596564112642532744786248159335865894853700816046039560680015763136038247639995037608821645825939938037688642462028851917935339399651779459056031186749254368558481517873915941451809902463046608593438914568462766771338503314208299416900p -0.3
+ 184903085897482836223318924720780812281596564112642532744786248159335865894853700816046039560680015763136038247639995037608821645825939938037688642462028851917935339399651779459056031186749254368558481517873915941451809902463046608593438914568462766771338503314208299416910p 0.9
+ 184903085897482836223318924720780812281596564112642532744786248159335865894853700816046039560680015763136038247639995037608821645825939938037688642462028851917935339399651779459056031186749254368558481517873915941451809902463046608593438914568462766771338503314208299417600p 0.9
+ 184903085897482836223318924720780812281596564112642532744786248159335865894853700816046039560680015763136038247639995037608821645825939938037688642462028851917935339399651779459056031186749254368558481517873915941451809902463046608593438914568462766771338503314208299417610p -0.3
+ \]
V_wl_895 (WordLine\\<895\\> gnd!) vsource type=pwl wave=\[
+ 0    -0.3
+ 369806171794965672446637849441561624563193128225285065489572496318671731789707401632092079121360031526272076495279990075217643291651879876075377284924057703835870678799303558918112062373498508737116963035747831882903619804926093217186877829136925533542677006628416598834500p -0.3
+ 369806171794965672446637849441561624563193128225285065489572496318671731789707401632092079121360031526272076495279990075217643291651879876075377284924057703835870678799303558918112062373498508737116963035747831882903619804926093217186877829136925533542677006628416598834510p 0.9
+ 369806171794965672446637849441561624563193128225285065489572496318671731789707401632092079121360031526272076495279990075217643291651879876075377284924057703835870678799303558918112062373498508737116963035747831882903619804926093217186877829136925533542677006628416598835200p 0.9
+ 369806171794965672446637849441561624563193128225285065489572496318671731789707401632092079121360031526272076495279990075217643291651879876075377284924057703835870678799303558918112062373498508737116963035747831882903619804926093217186877829136925533542677006628416598835210p -0.3
+ \]
V_wl_896 (WordLine\\<896\\> gnd!) vsource type=pwl wave=\[
+ 0    -0.3
+ 739612343589931344893275698883123249126386256450570130979144992637343463579414803264184158242720063052544152990559980150435286583303759752150754569848115407671741357598607117836224124746997017474233926071495663765807239609852186434373755658273851067085354013256833197669700p -0.3
+ 739612343589931344893275698883123249126386256450570130979144992637343463579414803264184158242720063052544152990559980150435286583303759752150754569848115407671741357598607117836224124746997017474233926071495663765807239609852186434373755658273851067085354013256833197669710p 0.9
+ 739612343589931344893275698883123249126386256450570130979144992637343463579414803264184158242720063052544152990559980150435286583303759752150754569848115407671741357598607117836224124746997017474233926071495663765807239609852186434373755658273851067085354013256833197670400p 0.9
+ 739612343589931344893275698883123249126386256450570130979144992637343463579414803264184158242720063052544152990559980150435286583303759752150754569848115407671741357598607117836224124746997017474233926071495663765807239609852186434373755658273851067085354013256833197670410p -0.3
+ \]
V_wl_897 (WordLine\\<897\\> gnd!) vsource type=pwl wave=\[
+ 0    -0.3
+ 1479224687179862689786551397766246498252772512901140261958289985274686927158829606528368316485440126105088305981119960300870573166607519504301509139696230815343482715197214235672448249493994034948467852142991327531614479219704372868747511316547702134170708026513666395340100p -0.3
+ 1479224687179862689786551397766246498252772512901140261958289985274686927158829606528368316485440126105088305981119960300870573166607519504301509139696230815343482715197214235672448249493994034948467852142991327531614479219704372868747511316547702134170708026513666395340110p 0.9
+ 1479224687179862689786551397766246498252772512901140261958289985274686927158829606528368316485440126105088305981119960300870573166607519504301509139696230815343482715197214235672448249493994034948467852142991327531614479219704372868747511316547702134170708026513666395340800p 0.9
+ 1479224687179862689786551397766246498252772512901140261958289985274686927158829606528368316485440126105088305981119960300870573166607519504301509139696230815343482715197214235672448249493994034948467852142991327531614479219704372868747511316547702134170708026513666395340810p -0.3
+ \]
V_wl_898 (WordLine\\<898\\> gnd!) vsource type=pwl wave=\[
+ 0    -0.3
+ 2958449374359725379573102795532492996505545025802280523916579970549373854317659213056736632970880252210176611962239920601741146333215039008603018279392461630686965430394428471344896498987988069896935704285982655063228958439408745737495022633095404268341416053027332790680900p -0.3
+ 2958449374359725379573102795532492996505545025802280523916579970549373854317659213056736632970880252210176611962239920601741146333215039008603018279392461630686965430394428471344896498987988069896935704285982655063228958439408745737495022633095404268341416053027332790680910p 0.9
+ 2958449374359725379573102795532492996505545025802280523916579970549373854317659213056736632970880252210176611962239920601741146333215039008603018279392461630686965430394428471344896498987988069896935704285982655063228958439408745737495022633095404268341416053027332790681600p 0.9
+ 2958449374359725379573102795532492996505545025802280523916579970549373854317659213056736632970880252210176611962239920601741146333215039008603018279392461630686965430394428471344896498987988069896935704285982655063228958439408745737495022633095404268341416053027332790681610p -0.3
+ \]
V_wl_899 (WordLine\\<899\\> gnd!) vsource type=pwl wave=\[
+ 0    -0.3
+ 5916898748719450759146205591064985993011090051604561047833159941098747708635318426113473265941760504420353223924479841203482292666430078017206036558784923261373930860788856942689792997975976139793871408571965310126457916878817491474990045266190808536682832106054665581362500p -0.3
+ 5916898748719450759146205591064985993011090051604561047833159941098747708635318426113473265941760504420353223924479841203482292666430078017206036558784923261373930860788856942689792997975976139793871408571965310126457916878817491474990045266190808536682832106054665581362510p 0.9
+ 5916898748719450759146205591064985993011090051604561047833159941098747708635318426113473265941760504420353223924479841203482292666430078017206036558784923261373930860788856942689792997975976139793871408571965310126457916878817491474990045266190808536682832106054665581363200p 0.9
+ 5916898748719450759146205591064985993011090051604561047833159941098747708635318426113473265941760504420353223924479841203482292666430078017206036558784923261373930860788856942689792997975976139793871408571965310126457916878817491474990045266190808536682832106054665581363210p -0.3
+ \]
V_wl_900 (WordLine\\<900\\> gnd!) vsource type=pwl wave=\[
+ 0    -0.3
+ 11833797497438901518292411182129971986022180103209122095666319882197495417270636852226946531883521008840706447848959682406964585332860156034412073117569846522747861721577713885379585995951952279587742817143930620252915833757634982949980090532381617073365664212109331162725700p -0.3
+ 11833797497438901518292411182129971986022180103209122095666319882197495417270636852226946531883521008840706447848959682406964585332860156034412073117569846522747861721577713885379585995951952279587742817143930620252915833757634982949980090532381617073365664212109331162725710p 0.9
+ 11833797497438901518292411182129971986022180103209122095666319882197495417270636852226946531883521008840706447848959682406964585332860156034412073117569846522747861721577713885379585995951952279587742817143930620252915833757634982949980090532381617073365664212109331162726400p 0.9
+ 11833797497438901518292411182129971986022180103209122095666319882197495417270636852226946531883521008840706447848959682406964585332860156034412073117569846522747861721577713885379585995951952279587742817143930620252915833757634982949980090532381617073365664212109331162726410p -0.3
+ \]
V_wl_901 (WordLine\\<901\\> gnd!) vsource type=pwl wave=\[
+ 0    -0.3
+ 23667594994877803036584822364259943972044360206418244191332639764394990834541273704453893063767042017681412895697919364813929170665720312068824146235139693045495723443155427770759171991903904559175485634287861240505831667515269965899960181064763234146731328424218662325452100p -0.3
+ 23667594994877803036584822364259943972044360206418244191332639764394990834541273704453893063767042017681412895697919364813929170665720312068824146235139693045495723443155427770759171991903904559175485634287861240505831667515269965899960181064763234146731328424218662325452110p 0.9
+ 23667594994877803036584822364259943972044360206418244191332639764394990834541273704453893063767042017681412895697919364813929170665720312068824146235139693045495723443155427770759171991903904559175485634287861240505831667515269965899960181064763234146731328424218662325452800p 0.9
+ 23667594994877803036584822364259943972044360206418244191332639764394990834541273704453893063767042017681412895697919364813929170665720312068824146235139693045495723443155427770759171991903904559175485634287861240505831667515269965899960181064763234146731328424218662325452810p -0.3
+ \]
V_wl_902 (WordLine\\<902\\> gnd!) vsource type=pwl wave=\[
+ 0    -0.3
+ 47335189989755606073169644728519887944088720412836488382665279528789981669082547408907786127534084035362825791395838729627858341331440624137648292470279386090991446886310855541518343983807809118350971268575722481011663335030539931799920362129526468293462656848437324650904900p -0.3
+ 47335189989755606073169644728519887944088720412836488382665279528789981669082547408907786127534084035362825791395838729627858341331440624137648292470279386090991446886310855541518343983807809118350971268575722481011663335030539931799920362129526468293462656848437324650904910p 0.9
+ 47335189989755606073169644728519887944088720412836488382665279528789981669082547408907786127534084035362825791395838729627858341331440624137648292470279386090991446886310855541518343983807809118350971268575722481011663335030539931799920362129526468293462656848437324650905600p 0.9
+ 47335189989755606073169644728519887944088720412836488382665279528789981669082547408907786127534084035362825791395838729627858341331440624137648292470279386090991446886310855541518343983807809118350971268575722481011663335030539931799920362129526468293462656848437324650905610p -0.3
+ \]
V_wl_903 (WordLine\\<903\\> gnd!) vsource type=pwl wave=\[
+ 0    -0.3
+ 94670379979511212146339289457039775888177440825672976765330559057579963338165094817815572255068168070725651582791677459255716682662881248275296584940558772181982893772621711083036687967615618236701942537151444962023326670061079863599840724259052936586925313696874649301810500p -0.3
+ 94670379979511212146339289457039775888177440825672976765330559057579963338165094817815572255068168070725651582791677459255716682662881248275296584940558772181982893772621711083036687967615618236701942537151444962023326670061079863599840724259052936586925313696874649301810510p 0.9
+ 94670379979511212146339289457039775888177440825672976765330559057579963338165094817815572255068168070725651582791677459255716682662881248275296584940558772181982893772621711083036687967615618236701942537151444962023326670061079863599840724259052936586925313696874649301811200p 0.9
+ 94670379979511212146339289457039775888177440825672976765330559057579963338165094817815572255068168070725651582791677459255716682662881248275296584940558772181982893772621711083036687967615618236701942537151444962023326670061079863599840724259052936586925313696874649301811210p -0.3
+ \]
V_wl_904 (WordLine\\<904\\> gnd!) vsource type=pwl wave=\[
+ 0    -0.3
+ 189340759959022424292678578914079551776354881651345953530661118115159926676330189635631144510136336141451303165583354918511433365325762496550593169881117544363965787545243422166073375935231236473403885074302889924046653340122159727199681448518105873173850627393749298603621700p -0.3
+ 189340759959022424292678578914079551776354881651345953530661118115159926676330189635631144510136336141451303165583354918511433365325762496550593169881117544363965787545243422166073375935231236473403885074302889924046653340122159727199681448518105873173850627393749298603621710p 0.9
+ 189340759959022424292678578914079551776354881651345953530661118115159926676330189635631144510136336141451303165583354918511433365325762496550593169881117544363965787545243422166073375935231236473403885074302889924046653340122159727199681448518105873173850627393749298603622400p 0.9
+ 189340759959022424292678578914079551776354881651345953530661118115159926676330189635631144510136336141451303165583354918511433365325762496550593169881117544363965787545243422166073375935231236473403885074302889924046653340122159727199681448518105873173850627393749298603622410p -0.3
+ \]
V_wl_905 (WordLine\\<905\\> gnd!) vsource type=pwl wave=\[
+ 0    -0.3
+ 378681519918044848585357157828159103552709763302691907061322236230319853352660379271262289020272672282902606331166709837022866730651524993101186339762235088727931575090486844332146751870462472946807770148605779848093306680244319454399362897036211746347701254787498597207244100p -0.3
+ 378681519918044848585357157828159103552709763302691907061322236230319853352660379271262289020272672282902606331166709837022866730651524993101186339762235088727931575090486844332146751870462472946807770148605779848093306680244319454399362897036211746347701254787498597207244110p 0.9
+ 378681519918044848585357157828159103552709763302691907061322236230319853352660379271262289020272672282902606331166709837022866730651524993101186339762235088727931575090486844332146751870462472946807770148605779848093306680244319454399362897036211746347701254787498597207244800p 0.9
+ 378681519918044848585357157828159103552709763302691907061322236230319853352660379271262289020272672282902606331166709837022866730651524993101186339762235088727931575090486844332146751870462472946807770148605779848093306680244319454399362897036211746347701254787498597207244810p -0.3
+ \]
V_wl_906 (WordLine\\<906\\> gnd!) vsource type=pwl wave=\[
+ 0    -0.3
+ 757363039836089697170714315656318207105419526605383814122644472460639706705320758542524578040545344565805212662333419674045733461303049986202372679524470177455863150180973688664293503740924945893615540297211559696186613360488638908798725794072423492695402509574997194414488900p -0.3
+ 757363039836089697170714315656318207105419526605383814122644472460639706705320758542524578040545344565805212662333419674045733461303049986202372679524470177455863150180973688664293503740924945893615540297211559696186613360488638908798725794072423492695402509574997194414488910p 0.9
+ 757363039836089697170714315656318207105419526605383814122644472460639706705320758542524578040545344565805212662333419674045733461303049986202372679524470177455863150180973688664293503740924945893615540297211559696186613360488638908798725794072423492695402509574997194414489600p 0.9
+ 757363039836089697170714315656318207105419526605383814122644472460639706705320758542524578040545344565805212662333419674045733461303049986202372679524470177455863150180973688664293503740924945893615540297211559696186613360488638908798725794072423492695402509574997194414489610p -0.3
+ \]
V_wl_907 (WordLine\\<907\\> gnd!) vsource type=pwl wave=\[
+ 0    -0.3
+ 1514726079672179394341428631312636414210839053210767628245288944921279413410641517085049156081090689131610425324666839348091466922606099972404745359048940354911726300361947377328587007481849891787231080594423119392373226720977277817597451588144846985390805019149994388828978500p -0.3
+ 1514726079672179394341428631312636414210839053210767628245288944921279413410641517085049156081090689131610425324666839348091466922606099972404745359048940354911726300361947377328587007481849891787231080594423119392373226720977277817597451588144846985390805019149994388828978510p 0.9
+ 1514726079672179394341428631312636414210839053210767628245288944921279413410641517085049156081090689131610425324666839348091466922606099972404745359048940354911726300361947377328587007481849891787231080594423119392373226720977277817597451588144846985390805019149994388828979200p 0.9
+ 1514726079672179394341428631312636414210839053210767628245288944921279413410641517085049156081090689131610425324666839348091466922606099972404745359048940354911726300361947377328587007481849891787231080594423119392373226720977277817597451588144846985390805019149994388828979210p -0.3
+ \]
V_wl_908 (WordLine\\<908\\> gnd!) vsource type=pwl wave=\[
+ 0    -0.3
+ 3029452159344358788682857262625272828421678106421535256490577889842558826821283034170098312162181378263220850649333678696182933845212199944809490718097880709823452600723894754657174014963699783574462161188846238784746453441954555635194903176289693970781610038299988777657957700p -0.3
+ 3029452159344358788682857262625272828421678106421535256490577889842558826821283034170098312162181378263220850649333678696182933845212199944809490718097880709823452600723894754657174014963699783574462161188846238784746453441954555635194903176289693970781610038299988777657957710p 0.9
+ 3029452159344358788682857262625272828421678106421535256490577889842558826821283034170098312162181378263220850649333678696182933845212199944809490718097880709823452600723894754657174014963699783574462161188846238784746453441954555635194903176289693970781610038299988777657958400p 0.9
+ 3029452159344358788682857262625272828421678106421535256490577889842558826821283034170098312162181378263220850649333678696182933845212199944809490718097880709823452600723894754657174014963699783574462161188846238784746453441954555635194903176289693970781610038299988777657958410p -0.3
+ \]
V_wl_909 (WordLine\\<909\\> gnd!) vsource type=pwl wave=\[
+ 0    -0.3
+ 6058904318688717577365714525250545656843356212843070512981155779685117653642566068340196624324362756526441701298667357392365867690424399889618981436195761419646905201447789509314348029927399567148924322377692477569492906883909111270389806352579387941563220076599977555315916100p -0.3
+ 6058904318688717577365714525250545656843356212843070512981155779685117653642566068340196624324362756526441701298667357392365867690424399889618981436195761419646905201447789509314348029927399567148924322377692477569492906883909111270389806352579387941563220076599977555315916110p 0.9
+ 6058904318688717577365714525250545656843356212843070512981155779685117653642566068340196624324362756526441701298667357392365867690424399889618981436195761419646905201447789509314348029927399567148924322377692477569492906883909111270389806352579387941563220076599977555315916800p 0.9
+ 6058904318688717577365714525250545656843356212843070512981155779685117653642566068340196624324362756526441701298667357392365867690424399889618981436195761419646905201447789509314348029927399567148924322377692477569492906883909111270389806352579387941563220076599977555315916810p -0.3
+ \]
V_wl_910 (WordLine\\<910\\> gnd!) vsource type=pwl wave=\[
+ 0    -0.3
+ 12117808637377435154731429050501091313686712425686141025962311559370235307285132136680393248648725513052883402597334714784731735380848799779237962872391522839293810402895579018628696059854799134297848644755384955138985813767818222540779612705158775883126440153199955110631832900p -0.3
+ 12117808637377435154731429050501091313686712425686141025962311559370235307285132136680393248648725513052883402597334714784731735380848799779237962872391522839293810402895579018628696059854799134297848644755384955138985813767818222540779612705158775883126440153199955110631832910p 0.9
+ 12117808637377435154731429050501091313686712425686141025962311559370235307285132136680393248648725513052883402597334714784731735380848799779237962872391522839293810402895579018628696059854799134297848644755384955138985813767818222540779612705158775883126440153199955110631833600p 0.9
+ 12117808637377435154731429050501091313686712425686141025962311559370235307285132136680393248648725513052883402597334714784731735380848799779237962872391522839293810402895579018628696059854799134297848644755384955138985813767818222540779612705158775883126440153199955110631833610p -0.3
+ \]
V_wl_911 (WordLine\\<911\\> gnd!) vsource type=pwl wave=\[
+ 0    -0.3
+ 24235617274754870309462858101002182627373424851372282051924623118740470614570264273360786497297451026105766805194669429569463470761697599558475925744783045678587620805791158037257392119709598268595697289510769910277971627535636445081559225410317551766252880306399910221263666500p -0.3
+ 24235617274754870309462858101002182627373424851372282051924623118740470614570264273360786497297451026105766805194669429569463470761697599558475925744783045678587620805791158037257392119709598268595697289510769910277971627535636445081559225410317551766252880306399910221263666510p 0.9
+ 24235617274754870309462858101002182627373424851372282051924623118740470614570264273360786497297451026105766805194669429569463470761697599558475925744783045678587620805791158037257392119709598268595697289510769910277971627535636445081559225410317551766252880306399910221263667200p 0.9
+ 24235617274754870309462858101002182627373424851372282051924623118740470614570264273360786497297451026105766805194669429569463470761697599558475925744783045678587620805791158037257392119709598268595697289510769910277971627535636445081559225410317551766252880306399910221263667210p -0.3
+ \]
V_wl_912 (WordLine\\<912\\> gnd!) vsource type=pwl wave=\[
+ 0    -0.3
+ 48471234549509740618925716202004365254746849702744564103849246237480941229140528546721572994594902052211533610389338859138926941523395199116951851489566091357175241611582316074514784239419196537191394579021539820555943255071272890163118450820635103532505760612799820442527333700p -0.3
+ 48471234549509740618925716202004365254746849702744564103849246237480941229140528546721572994594902052211533610389338859138926941523395199116951851489566091357175241611582316074514784239419196537191394579021539820555943255071272890163118450820635103532505760612799820442527333710p 0.9
+ 48471234549509740618925716202004365254746849702744564103849246237480941229140528546721572994594902052211533610389338859138926941523395199116951851489566091357175241611582316074514784239419196537191394579021539820555943255071272890163118450820635103532505760612799820442527334400p 0.9
+ 48471234549509740618925716202004365254746849702744564103849246237480941229140528546721572994594902052211533610389338859138926941523395199116951851489566091357175241611582316074514784239419196537191394579021539820555943255071272890163118450820635103532505760612799820442527334410p -0.3
+ \]
V_wl_913 (WordLine\\<913\\> gnd!) vsource type=pwl wave=\[
+ 0    -0.3
+ 96942469099019481237851432404008730509493699405489128207698492474961882458281057093443145989189804104423067220778677718277853883046790398233903702979132182714350483223164632149029568478838393074382789158043079641111886510142545780326236901641270207065011521225599640885054668100p -0.3
+ 96942469099019481237851432404008730509493699405489128207698492474961882458281057093443145989189804104423067220778677718277853883046790398233903702979132182714350483223164632149029568478838393074382789158043079641111886510142545780326236901641270207065011521225599640885054668110p 0.9
+ 96942469099019481237851432404008730509493699405489128207698492474961882458281057093443145989189804104423067220778677718277853883046790398233903702979132182714350483223164632149029568478838393074382789158043079641111886510142545780326236901641270207065011521225599640885054668800p 0.9
+ 96942469099019481237851432404008730509493699405489128207698492474961882458281057093443145989189804104423067220778677718277853883046790398233903702979132182714350483223164632149029568478838393074382789158043079641111886510142545780326236901641270207065011521225599640885054668810p -0.3
+ \]
V_wl_914 (WordLine\\<914\\> gnd!) vsource type=pwl wave=\[
+ 0    -0.3
+ 193884938198038962475702864808017461018987398810978256415396984949923764916562114186886291978379608208846134441557355436555707766093580796467807405958264365428700966446329264298059136957676786148765578316086159282223773020285091560652473803282540414130023042451199281770109336900p -0.3
+ 193884938198038962475702864808017461018987398810978256415396984949923764916562114186886291978379608208846134441557355436555707766093580796467807405958264365428700966446329264298059136957676786148765578316086159282223773020285091560652473803282540414130023042451199281770109336910p 0.9
+ 193884938198038962475702864808017461018987398810978256415396984949923764916562114186886291978379608208846134441557355436555707766093580796467807405958264365428700966446329264298059136957676786148765578316086159282223773020285091560652473803282540414130023042451199281770109337600p 0.9
+ 193884938198038962475702864808017461018987398810978256415396984949923764916562114186886291978379608208846134441557355436555707766093580796467807405958264365428700966446329264298059136957676786148765578316086159282223773020285091560652473803282540414130023042451199281770109337610p -0.3
+ \]
V_wl_915 (WordLine\\<915\\> gnd!) vsource type=pwl wave=\[
+ 0    -0.3
+ 387769876396077924951405729616034922037974797621956512830793969899847529833124228373772583956759216417692268883114710873111415532187161592935614811916528730857401932892658528596118273915353572297531156632172318564447546040570183121304947606565080828260046084902398563540218674500p -0.3
+ 387769876396077924951405729616034922037974797621956512830793969899847529833124228373772583956759216417692268883114710873111415532187161592935614811916528730857401932892658528596118273915353572297531156632172318564447546040570183121304947606565080828260046084902398563540218674510p 0.9
+ 387769876396077924951405729616034922037974797621956512830793969899847529833124228373772583956759216417692268883114710873111415532187161592935614811916528730857401932892658528596118273915353572297531156632172318564447546040570183121304947606565080828260046084902398563540218675200p 0.9
+ 387769876396077924951405729616034922037974797621956512830793969899847529833124228373772583956759216417692268883114710873111415532187161592935614811916528730857401932892658528596118273915353572297531156632172318564447546040570183121304947606565080828260046084902398563540218675210p -0.3
+ \]
V_wl_916 (WordLine\\<916\\> gnd!) vsource type=pwl wave=\[
+ 0    -0.3
+ 775539752792155849902811459232069844075949595243913025661587939799695059666248456747545167913518432835384537766229421746222831064374323185871229623833057461714803865785317057192236547830707144595062313264344637128895092081140366242609895213130161656520092169804797127080437349700p -0.3
+ 775539752792155849902811459232069844075949595243913025661587939799695059666248456747545167913518432835384537766229421746222831064374323185871229623833057461714803865785317057192236547830707144595062313264344637128895092081140366242609895213130161656520092169804797127080437349710p 0.9
+ 775539752792155849902811459232069844075949595243913025661587939799695059666248456747545167913518432835384537766229421746222831064374323185871229623833057461714803865785317057192236547830707144595062313264344637128895092081140366242609895213130161656520092169804797127080437350400p 0.9
+ 775539752792155849902811459232069844075949595243913025661587939799695059666248456747545167913518432835384537766229421746222831064374323185871229623833057461714803865785317057192236547830707144595062313264344637128895092081140366242609895213130161656520092169804797127080437350410p -0.3
+ \]
V_wl_917 (WordLine\\<917\\> gnd!) vsource type=pwl wave=\[
+ 0    -0.3
+ 1551079505584311699805622918464139688151899190487826051323175879599390119332496913495090335827036865670769075532458843492445662128748646371742459247666114923429607731570634114384473095661414289190124626528689274257790184162280732485219790426260323313040184339609594254160874700100p -0.3
+ 1551079505584311699805622918464139688151899190487826051323175879599390119332496913495090335827036865670769075532458843492445662128748646371742459247666114923429607731570634114384473095661414289190124626528689274257790184162280732485219790426260323313040184339609594254160874700110p 0.9
+ 1551079505584311699805622918464139688151899190487826051323175879599390119332496913495090335827036865670769075532458843492445662128748646371742459247666114923429607731570634114384473095661414289190124626528689274257790184162280732485219790426260323313040184339609594254160874700800p 0.9
+ 1551079505584311699805622918464139688151899190487826051323175879599390119332496913495090335827036865670769075532458843492445662128748646371742459247666114923429607731570634114384473095661414289190124626528689274257790184162280732485219790426260323313040184339609594254160874700810p -0.3
+ \]
V_wl_918 (WordLine\\<918\\> gnd!) vsource type=pwl wave=\[
+ 0    -0.3
+ 3102159011168623399611245836928279376303798380975652102646351759198780238664993826990180671654073731341538151064917686984891324257497292743484918495332229846859215463141268228768946191322828578380249253057378548515580368324561464970439580852520646626080368679219188508321749400900p -0.3
+ 3102159011168623399611245836928279376303798380975652102646351759198780238664993826990180671654073731341538151064917686984891324257497292743484918495332229846859215463141268228768946191322828578380249253057378548515580368324561464970439580852520646626080368679219188508321749400910p 0.9
+ 3102159011168623399611245836928279376303798380975652102646351759198780238664993826990180671654073731341538151064917686984891324257497292743484918495332229846859215463141268228768946191322828578380249253057378548515580368324561464970439580852520646626080368679219188508321749401600p 0.9
+ 3102159011168623399611245836928279376303798380975652102646351759198780238664993826990180671654073731341538151064917686984891324257497292743484918495332229846859215463141268228768946191322828578380249253057378548515580368324561464970439580852520646626080368679219188508321749401610p -0.3
+ \]
V_wl_919 (WordLine\\<919\\> gnd!) vsource type=pwl wave=\[
+ 0    -0.3
+ 6204318022337246799222491673856558752607596761951304205292703518397560477329987653980361343308147462683076302129835373969782648514994585486969836990664459693718430926282536457537892382645657156760498506114757097031160736649122929940879161705041293252160737358438377016643498802500p -0.3
+ 6204318022337246799222491673856558752607596761951304205292703518397560477329987653980361343308147462683076302129835373969782648514994585486969836990664459693718430926282536457537892382645657156760498506114757097031160736649122929940879161705041293252160737358438377016643498802510p 0.9
+ 6204318022337246799222491673856558752607596761951304205292703518397560477329987653980361343308147462683076302129835373969782648514994585486969836990664459693718430926282536457537892382645657156760498506114757097031160736649122929940879161705041293252160737358438377016643498803200p 0.9
+ 6204318022337246799222491673856558752607596761951304205292703518397560477329987653980361343308147462683076302129835373969782648514994585486969836990664459693718430926282536457537892382645657156760498506114757097031160736649122929940879161705041293252160737358438377016643498803210p -0.3
+ \]
V_wl_920 (WordLine\\<920\\> gnd!) vsource type=pwl wave=\[
+ 0    -0.3
+ 12408636044674493598444983347713117505215193523902608410585407036795120954659975307960722686616294925366152604259670747939565297029989170973939673981328919387436861852565072915075784765291314313520997012229514194062321473298245859881758323410082586504321474716876754033286997605700p -0.3
+ 12408636044674493598444983347713117505215193523902608410585407036795120954659975307960722686616294925366152604259670747939565297029989170973939673981328919387436861852565072915075784765291314313520997012229514194062321473298245859881758323410082586504321474716876754033286997605710p 0.9
+ 12408636044674493598444983347713117505215193523902608410585407036795120954659975307960722686616294925366152604259670747939565297029989170973939673981328919387436861852565072915075784765291314313520997012229514194062321473298245859881758323410082586504321474716876754033286997606400p 0.9
+ 12408636044674493598444983347713117505215193523902608410585407036795120954659975307960722686616294925366152604259670747939565297029989170973939673981328919387436861852565072915075784765291314313520997012229514194062321473298245859881758323410082586504321474716876754033286997606410p -0.3
+ \]
V_wl_921 (WordLine\\<921\\> gnd!) vsource type=pwl wave=\[
+ 0    -0.3
+ 24817272089348987196889966695426235010430387047805216821170814073590241909319950615921445373232589850732305208519341495879130594059978341947879347962657838774873723705130145830151569530582628627041994024459028388124642946596491719763516646820165173008642949433753508066573995212100p -0.3
+ 24817272089348987196889966695426235010430387047805216821170814073590241909319950615921445373232589850732305208519341495879130594059978341947879347962657838774873723705130145830151569530582628627041994024459028388124642946596491719763516646820165173008642949433753508066573995212110p 0.9
+ 24817272089348987196889966695426235010430387047805216821170814073590241909319950615921445373232589850732305208519341495879130594059978341947879347962657838774873723705130145830151569530582628627041994024459028388124642946596491719763516646820165173008642949433753508066573995212800p 0.9
+ 24817272089348987196889966695426235010430387047805216821170814073590241909319950615921445373232589850732305208519341495879130594059978341947879347962657838774873723705130145830151569530582628627041994024459028388124642946596491719763516646820165173008642949433753508066573995212810p -0.3
+ \]
V_wl_922 (WordLine\\<922\\> gnd!) vsource type=pwl wave=\[
+ 0    -0.3
+ 49634544178697974393779933390852470020860774095610433642341628147180483818639901231842890746465179701464610417038682991758261188119956683895758695925315677549747447410260291660303139061165257254083988048918056776249285893192983439527033293640330346017285898867507016133147990424900p -0.3
+ 49634544178697974393779933390852470020860774095610433642341628147180483818639901231842890746465179701464610417038682991758261188119956683895758695925315677549747447410260291660303139061165257254083988048918056776249285893192983439527033293640330346017285898867507016133147990424910p 0.9
+ 49634544178697974393779933390852470020860774095610433642341628147180483818639901231842890746465179701464610417038682991758261188119956683895758695925315677549747447410260291660303139061165257254083988048918056776249285893192983439527033293640330346017285898867507016133147990425600p 0.9
+ 49634544178697974393779933390852470020860774095610433642341628147180483818639901231842890746465179701464610417038682991758261188119956683895758695925315677549747447410260291660303139061165257254083988048918056776249285893192983439527033293640330346017285898867507016133147990425610p -0.3
+ \]
V_wl_923 (WordLine\\<923\\> gnd!) vsource type=pwl wave=\[
+ 0    -0.3
+ 99269088357395948787559866781704940041721548191220867284683256294360967637279802463685781492930359402929220834077365983516522376239913367791517391850631355099494894820520583320606278122330514508167976097836113552498571786385966879054066587280660692034571797735014032266295980850500p -0.3
+ 99269088357395948787559866781704940041721548191220867284683256294360967637279802463685781492930359402929220834077365983516522376239913367791517391850631355099494894820520583320606278122330514508167976097836113552498571786385966879054066587280660692034571797735014032266295980850510p 0.9
+ 99269088357395948787559866781704940041721548191220867284683256294360967637279802463685781492930359402929220834077365983516522376239913367791517391850631355099494894820520583320606278122330514508167976097836113552498571786385966879054066587280660692034571797735014032266295980851200p 0.9
+ 99269088357395948787559866781704940041721548191220867284683256294360967637279802463685781492930359402929220834077365983516522376239913367791517391850631355099494894820520583320606278122330514508167976097836113552498571786385966879054066587280660692034571797735014032266295980851210p -0.3
+ \]
V_wl_924 (WordLine\\<924\\> gnd!) vsource type=pwl wave=\[
+ 0    -0.3
+ 198538176714791897575119733563409880083443096382441734569366512588721935274559604927371562985860718805858441668154731967033044752479826735583034783701262710198989789641041166641212556244661029016335952195672227104997143572771933758108133174561321384069143595470028064532591961701700p -0.3
+ 198538176714791897575119733563409880083443096382441734569366512588721935274559604927371562985860718805858441668154731967033044752479826735583034783701262710198989789641041166641212556244661029016335952195672227104997143572771933758108133174561321384069143595470028064532591961701710p 0.9
+ 198538176714791897575119733563409880083443096382441734569366512588721935274559604927371562985860718805858441668154731967033044752479826735583034783701262710198989789641041166641212556244661029016335952195672227104997143572771933758108133174561321384069143595470028064532591961702400p 0.9
+ 198538176714791897575119733563409880083443096382441734569366512588721935274559604927371562985860718805858441668154731967033044752479826735583034783701262710198989789641041166641212556244661029016335952195672227104997143572771933758108133174561321384069143595470028064532591961702410p -0.3
+ \]
V_wl_925 (WordLine\\<925\\> gnd!) vsource type=pwl wave=\[
+ 0    -0.3
+ 397076353429583795150239467126819760166886192764883469138733025177443870549119209854743125971721437611716883336309463934066089504959653471166069567402525420397979579282082333282425112489322058032671904391344454209994287145543867516216266349122642768138287190940056129065183923404100p -0.3
+ 397076353429583795150239467126819760166886192764883469138733025177443870549119209854743125971721437611716883336309463934066089504959653471166069567402525420397979579282082333282425112489322058032671904391344454209994287145543867516216266349122642768138287190940056129065183923404110p 0.9
+ 397076353429583795150239467126819760166886192764883469138733025177443870549119209854743125971721437611716883336309463934066089504959653471166069567402525420397979579282082333282425112489322058032671904391344454209994287145543867516216266349122642768138287190940056129065183923404800p 0.9
+ 397076353429583795150239467126819760166886192764883469138733025177443870549119209854743125971721437611716883336309463934066089504959653471166069567402525420397979579282082333282425112489322058032671904391344454209994287145543867516216266349122642768138287190940056129065183923404810p -0.3
+ \]
V_wl_926 (WordLine\\<926\\> gnd!) vsource type=pwl wave=\[
+ 0    -0.3
+ 794152706859167590300478934253639520333772385529766938277466050354887741098238419709486251943442875223433766672618927868132179009919306942332139134805050840795959158564164666564850224978644116065343808782688908419988574291087735032432532698245285536276574381880112258130367846808900p -0.3
+ 794152706859167590300478934253639520333772385529766938277466050354887741098238419709486251943442875223433766672618927868132179009919306942332139134805050840795959158564164666564850224978644116065343808782688908419988574291087735032432532698245285536276574381880112258130367846808910p 0.9
+ 794152706859167590300478934253639520333772385529766938277466050354887741098238419709486251943442875223433766672618927868132179009919306942332139134805050840795959158564164666564850224978644116065343808782688908419988574291087735032432532698245285536276574381880112258130367846809600p 0.9
+ 794152706859167590300478934253639520333772385529766938277466050354887741098238419709486251943442875223433766672618927868132179009919306942332139134805050840795959158564164666564850224978644116065343808782688908419988574291087735032432532698245285536276574381880112258130367846809610p -0.3
+ \]
V_wl_927 (WordLine\\<927\\> gnd!) vsource type=pwl wave=\[
+ 0    -0.3
+ 1588305413718335180600957868507279040667544771059533876554932100709775482196476839418972503886885750446867533345237855736264358019838613884664278269610101681591918317128329333129700449957288232130687617565377816839977148582175470064865065396490571072553148763760224516260735693618500p -0.3
+ 1588305413718335180600957868507279040667544771059533876554932100709775482196476839418972503886885750446867533345237855736264358019838613884664278269610101681591918317128329333129700449957288232130687617565377816839977148582175470064865065396490571072553148763760224516260735693618510p 0.9
+ 1588305413718335180600957868507279040667544771059533876554932100709775482196476839418972503886885750446867533345237855736264358019838613884664278269610101681591918317128329333129700449957288232130687617565377816839977148582175470064865065396490571072553148763760224516260735693619200p 0.9
+ 1588305413718335180600957868507279040667544771059533876554932100709775482196476839418972503886885750446867533345237855736264358019838613884664278269610101681591918317128329333129700449957288232130687617565377816839977148582175470064865065396490571072553148763760224516260735693619210p -0.3
+ \]
V_wl_928 (WordLine\\<928\\> gnd!) vsource type=pwl wave=\[
+ 0    -0.3
+ 3176610827436670361201915737014558081335089542119067753109864201419550964392953678837945007773771500893735066690475711472528716039677227769328556539220203363183836634256658666259400899914576464261375235130755633679954297164350940129730130792981142145106297527520449032521471387237700p -0.3
+ 3176610827436670361201915737014558081335089542119067753109864201419550964392953678837945007773771500893735066690475711472528716039677227769328556539220203363183836634256658666259400899914576464261375235130755633679954297164350940129730130792981142145106297527520449032521471387237710p 0.9
+ 3176610827436670361201915737014558081335089542119067753109864201419550964392953678837945007773771500893735066690475711472528716039677227769328556539220203363183836634256658666259400899914576464261375235130755633679954297164350940129730130792981142145106297527520449032521471387238400p 0.9
+ 3176610827436670361201915737014558081335089542119067753109864201419550964392953678837945007773771500893735066690475711472528716039677227769328556539220203363183836634256658666259400899914576464261375235130755633679954297164350940129730130792981142145106297527520449032521471387238410p -0.3
+ \]
V_wl_929 (WordLine\\<929\\> gnd!) vsource type=pwl wave=\[
+ 0    -0.3
+ 6353221654873340722403831474029116162670179084238135506219728402839101928785907357675890015547543001787470133380951422945057432079354455538657113078440406726367673268513317332518801799829152928522750470261511267359908594328701880259460261585962284290212595055040898065042942774476100p -0.3
+ 6353221654873340722403831474029116162670179084238135506219728402839101928785907357675890015547543001787470133380951422945057432079354455538657113078440406726367673268513317332518801799829152928522750470261511267359908594328701880259460261585962284290212595055040898065042942774476110p 0.9
+ 6353221654873340722403831474029116162670179084238135506219728402839101928785907357675890015547543001787470133380951422945057432079354455538657113078440406726367673268513317332518801799829152928522750470261511267359908594328701880259460261585962284290212595055040898065042942774476800p 0.9
+ 6353221654873340722403831474029116162670179084238135506219728402839101928785907357675890015547543001787470133380951422945057432079354455538657113078440406726367673268513317332518801799829152928522750470261511267359908594328701880259460261585962284290212595055040898065042942774476810p -0.3
+ \]
V_wl_930 (WordLine\\<930\\> gnd!) vsource type=pwl wave=\[
+ 0    -0.3
+ 12706443309746681444807662948058232325340358168476271012439456805678203857571814715351780031095086003574940266761902845890114864158708911077314226156880813452735346537026634665037603599658305857045500940523022534719817188657403760518920523171924568580425190110081796130085885548952900p -0.3
+ 12706443309746681444807662948058232325340358168476271012439456805678203857571814715351780031095086003574940266761902845890114864158708911077314226156880813452735346537026634665037603599658305857045500940523022534719817188657403760518920523171924568580425190110081796130085885548952910p 0.9
+ 12706443309746681444807662948058232325340358168476271012439456805678203857571814715351780031095086003574940266761902845890114864158708911077314226156880813452735346537026634665037603599658305857045500940523022534719817188657403760518920523171924568580425190110081796130085885548953600p 0.9
+ 12706443309746681444807662948058232325340358168476271012439456805678203857571814715351780031095086003574940266761902845890114864158708911077314226156880813452735346537026634665037603599658305857045500940523022534719817188657403760518920523171924568580425190110081796130085885548953610p -0.3
+ \]
V_wl_931 (WordLine\\<931\\> gnd!) vsource type=pwl wave=\[
+ 0    -0.3
+ 25412886619493362889615325896116464650680716336952542024878913611356407715143629430703560062190172007149880533523805691780229728317417822154628452313761626905470693074053269330075207199316611714091001881046045069439634377314807521037841046343849137160850380220163592260171771097906500p -0.3
+ 25412886619493362889615325896116464650680716336952542024878913611356407715143629430703560062190172007149880533523805691780229728317417822154628452313761626905470693074053269330075207199316611714091001881046045069439634377314807521037841046343849137160850380220163592260171771097906510p 0.9
+ 25412886619493362889615325896116464650680716336952542024878913611356407715143629430703560062190172007149880533523805691780229728317417822154628452313761626905470693074053269330075207199316611714091001881046045069439634377314807521037841046343849137160850380220163592260171771097907200p 0.9
+ 25412886619493362889615325896116464650680716336952542024878913611356407715143629430703560062190172007149880533523805691780229728317417822154628452313761626905470693074053269330075207199316611714091001881046045069439634377314807521037841046343849137160850380220163592260171771097907210p -0.3
+ \]
V_wl_932 (WordLine\\<932\\> gnd!) vsource type=pwl wave=\[
+ 0    -0.3
+ 50825773238986725779230651792232929301361432673905084049757827222712815430287258861407120124380344014299761067047611383560459456634835644309256904627523253810941386148106538660150414398633223428182003762092090138879268754629615042075682092687698274321700760440327184520343542195813700p -0.3
+ 50825773238986725779230651792232929301361432673905084049757827222712815430287258861407120124380344014299761067047611383560459456634835644309256904627523253810941386148106538660150414398633223428182003762092090138879268754629615042075682092687698274321700760440327184520343542195813710p 0.9
+ 50825773238986725779230651792232929301361432673905084049757827222712815430287258861407120124380344014299761067047611383560459456634835644309256904627523253810941386148106538660150414398633223428182003762092090138879268754629615042075682092687698274321700760440327184520343542195814400p 0.9
+ 50825773238986725779230651792232929301361432673905084049757827222712815430287258861407120124380344014299761067047611383560459456634835644309256904627523253810941386148106538660150414398633223428182003762092090138879268754629615042075682092687698274321700760440327184520343542195814410p -0.3
+ \]
V_wl_933 (WordLine\\<933\\> gnd!) vsource type=pwl wave=\[
+ 0    -0.3
+ 101651546477973451558461303584465858602722865347810168099515654445425630860574517722814240248760688028599522134095222767120918913269671288618513809255046507621882772296213077320300828797266446856364007524184180277758537509259230084151364185375396548643401520880654369040687084391628100p -0.3
+ 101651546477973451558461303584465858602722865347810168099515654445425630860574517722814240248760688028599522134095222767120918913269671288618513809255046507621882772296213077320300828797266446856364007524184180277758537509259230084151364185375396548643401520880654369040687084391628110p 0.9
+ 101651546477973451558461303584465858602722865347810168099515654445425630860574517722814240248760688028599522134095222767120918913269671288618513809255046507621882772296213077320300828797266446856364007524184180277758537509259230084151364185375396548643401520880654369040687084391628800p 0.9
+ 101651546477973451558461303584465858602722865347810168099515654445425630860574517722814240248760688028599522134095222767120918913269671288618513809255046507621882772296213077320300828797266446856364007524184180277758537509259230084151364185375396548643401520880654369040687084391628810p -0.3
+ \]
V_wl_934 (WordLine\\<934\\> gnd!) vsource type=pwl wave=\[
+ 0    -0.3
+ 203303092955946903116922607168931717205445730695620336199031308890851261721149035445628480497521376057199044268190445534241837826539342577237027618510093015243765544592426154640601657594532893712728015048368360555517075018518460168302728370750793097286803041761308738081374168783256900p -0.3
+ 203303092955946903116922607168931717205445730695620336199031308890851261721149035445628480497521376057199044268190445534241837826539342577237027618510093015243765544592426154640601657594532893712728015048368360555517075018518460168302728370750793097286803041761308738081374168783256910p 0.9
+ 203303092955946903116922607168931717205445730695620336199031308890851261721149035445628480497521376057199044268190445534241837826539342577237027618510093015243765544592426154640601657594532893712728015048368360555517075018518460168302728370750793097286803041761308738081374168783257600p 0.9
+ 203303092955946903116922607168931717205445730695620336199031308890851261721149035445628480497521376057199044268190445534241837826539342577237027618510093015243765544592426154640601657594532893712728015048368360555517075018518460168302728370750793097286803041761308738081374168783257610p -0.3
+ \]
V_wl_935 (WordLine\\<935\\> gnd!) vsource type=pwl wave=\[
+ 0    -0.3
+ 406606185911893806233845214337863434410891461391240672398062617781702523442298070891256960995042752114398088536380891068483675653078685154474055237020186030487531089184852309281203315189065787425456030096736721111034150037036920336605456741501586194573606083522617476162748337566514500p -0.3
+ 406606185911893806233845214337863434410891461391240672398062617781702523442298070891256960995042752114398088536380891068483675653078685154474055237020186030487531089184852309281203315189065787425456030096736721111034150037036920336605456741501586194573606083522617476162748337566514510p 0.9
+ 406606185911893806233845214337863434410891461391240672398062617781702523442298070891256960995042752114398088536380891068483675653078685154474055237020186030487531089184852309281203315189065787425456030096736721111034150037036920336605456741501586194573606083522617476162748337566515200p 0.9
+ 406606185911893806233845214337863434410891461391240672398062617781702523442298070891256960995042752114398088536380891068483675653078685154474055237020186030487531089184852309281203315189065787425456030096736721111034150037036920336605456741501586194573606083522617476162748337566515210p -0.3
+ \]
V_wl_936 (WordLine\\<936\\> gnd!) vsource type=pwl wave=\[
+ 0    -0.3
+ 813212371823787612467690428675726868821782922782481344796125235563405046884596141782513921990085504228796177072761782136967351306157370308948110474040372060975062178369704618562406630378131574850912060193473442222068300074073840673210913483003172389147212167045234952325496675133029700p -0.3
+ 813212371823787612467690428675726868821782922782481344796125235563405046884596141782513921990085504228796177072761782136967351306157370308948110474040372060975062178369704618562406630378131574850912060193473442222068300074073840673210913483003172389147212167045234952325496675133029710p 0.9
+ 813212371823787612467690428675726868821782922782481344796125235563405046884596141782513921990085504228796177072761782136967351306157370308948110474040372060975062178369704618562406630378131574850912060193473442222068300074073840673210913483003172389147212167045234952325496675133030400p 0.9
+ 813212371823787612467690428675726868821782922782481344796125235563405046884596141782513921990085504228796177072761782136967351306157370308948110474040372060975062178369704618562406630378131574850912060193473442222068300074073840673210913483003172389147212167045234952325496675133030410p -0.3
+ \]
V_wl_937 (WordLine\\<937\\> gnd!) vsource type=pwl wave=\[
+ 0    -0.3
+ 1626424743647575224935380857351453737643565845564962689592250471126810093769192283565027843980171008457592354145523564273934702612314740617896220948080744121950124356739409237124813260756263149701824120386946884444136600148147681346421826966006344778294424334090469904650993350266060100p -0.3
+ 1626424743647575224935380857351453737643565845564962689592250471126810093769192283565027843980171008457592354145523564273934702612314740617896220948080744121950124356739409237124813260756263149701824120386946884444136600148147681346421826966006344778294424334090469904650993350266060110p 0.9
+ 1626424743647575224935380857351453737643565845564962689592250471126810093769192283565027843980171008457592354145523564273934702612314740617896220948080744121950124356739409237124813260756263149701824120386946884444136600148147681346421826966006344778294424334090469904650993350266060800p 0.9
+ 1626424743647575224935380857351453737643565845564962689592250471126810093769192283565027843980171008457592354145523564273934702612314740617896220948080744121950124356739409237124813260756263149701824120386946884444136600148147681346421826966006344778294424334090469904650993350266060810p -0.3
+ \]
V_wl_938 (WordLine\\<938\\> gnd!) vsource type=pwl wave=\[
+ 0    -0.3
+ 3252849487295150449870761714702907475287131691129925379184500942253620187538384567130055687960342016915184708291047128547869405224629481235792441896161488243900248713478818474249626521512526299403648240773893768888273200296295362692843653932012689556588848668180939809301986700532120900p -0.3
+ 3252849487295150449870761714702907475287131691129925379184500942253620187538384567130055687960342016915184708291047128547869405224629481235792441896161488243900248713478818474249626521512526299403648240773893768888273200296295362692843653932012689556588848668180939809301986700532120910p 0.9
+ 3252849487295150449870761714702907475287131691129925379184500942253620187538384567130055687960342016915184708291047128547869405224629481235792441896161488243900248713478818474249626521512526299403648240773893768888273200296295362692843653932012689556588848668180939809301986700532121600p 0.9
+ 3252849487295150449870761714702907475287131691129925379184500942253620187538384567130055687960342016915184708291047128547869405224629481235792441896161488243900248713478818474249626521512526299403648240773893768888273200296295362692843653932012689556588848668180939809301986700532121610p -0.3
+ \]
V_wl_939 (WordLine\\<939\\> gnd!) vsource type=pwl wave=\[
+ 0    -0.3
+ 6505698974590300899741523429405814950574263382259850758369001884507240375076769134260111375920684033830369416582094257095738810449258962471584883792322976487800497426957636948499253043025052598807296481547787537776546400592590725385687307864025379113177697336361879618603973401064242500p -0.3
+ 6505698974590300899741523429405814950574263382259850758369001884507240375076769134260111375920684033830369416582094257095738810449258962471584883792322976487800497426957636948499253043025052598807296481547787537776546400592590725385687307864025379113177697336361879618603973401064242510p 0.9
+ 6505698974590300899741523429405814950574263382259850758369001884507240375076769134260111375920684033830369416582094257095738810449258962471584883792322976487800497426957636948499253043025052598807296481547787537776546400592590725385687307864025379113177697336361879618603973401064243200p 0.9
+ 6505698974590300899741523429405814950574263382259850758369001884507240375076769134260111375920684033830369416582094257095738810449258962471584883792322976487800497426957636948499253043025052598807296481547787537776546400592590725385687307864025379113177697336361879618603973401064243210p -0.3
+ \]
V_wl_940 (WordLine\\<940\\> gnd!) vsource type=pwl wave=\[
+ 0    -0.3
+ 13011397949180601799483046858811629901148526764519701516738003769014480750153538268520222751841368067660738833164188514191477620898517924943169767584645952975600994853915273896998506086050105197614592963095575075553092801185181450771374615728050758226355394672723759237207946802128485700p -0.3
+ 13011397949180601799483046858811629901148526764519701516738003769014480750153538268520222751841368067660738833164188514191477620898517924943169767584645952975600994853915273896998506086050105197614592963095575075553092801185181450771374615728050758226355394672723759237207946802128485710p 0.9
+ 13011397949180601799483046858811629901148526764519701516738003769014480750153538268520222751841368067660738833164188514191477620898517924943169767584645952975600994853915273896998506086050105197614592963095575075553092801185181450771374615728050758226355394672723759237207946802128486400p 0.9
+ 13011397949180601799483046858811629901148526764519701516738003769014480750153538268520222751841368067660738833164188514191477620898517924943169767584645952975600994853915273896998506086050105197614592963095575075553092801185181450771374615728050758226355394672723759237207946802128486410p -0.3
+ \]
V_wl_941 (WordLine\\<941\\> gnd!) vsource type=pwl wave=\[
+ 0    -0.3
+ 26022795898361203598966093717623259802297053529039403033476007538028961500307076537040445503682736135321477666328377028382955241797035849886339535169291905951201989707830547793997012172100210395229185926191150151106185602370362901542749231456101516452710789345447518474415893604256972100p -0.3
+ 26022795898361203598966093717623259802297053529039403033476007538028961500307076537040445503682736135321477666328377028382955241797035849886339535169291905951201989707830547793997012172100210395229185926191150151106185602370362901542749231456101516452710789345447518474415893604256972110p 0.9
+ 26022795898361203598966093717623259802297053529039403033476007538028961500307076537040445503682736135321477666328377028382955241797035849886339535169291905951201989707830547793997012172100210395229185926191150151106185602370362901542749231456101516452710789345447518474415893604256972800p 0.9
+ 26022795898361203598966093717623259802297053529039403033476007538028961500307076537040445503682736135321477666328377028382955241797035849886339535169291905951201989707830547793997012172100210395229185926191150151106185602370362901542749231456101516452710789345447518474415893604256972810p -0.3
+ \]
V_wl_942 (WordLine\\<942\\> gnd!) vsource type=pwl wave=\[
+ 0    -0.3
+ 52045591796722407197932187435246519604594107058078806066952015076057923000614153074080891007365472270642955332656754056765910483594071699772679070338583811902403979415661095587994024344200420790458371852382300302212371204740725803085498462912203032905421578690895036948831787208513944900p -0.3
+ 52045591796722407197932187435246519604594107058078806066952015076057923000614153074080891007365472270642955332656754056765910483594071699772679070338583811902403979415661095587994024344200420790458371852382300302212371204740725803085498462912203032905421578690895036948831787208513944910p 0.9
+ 52045591796722407197932187435246519604594107058078806066952015076057923000614153074080891007365472270642955332656754056765910483594071699772679070338583811902403979415661095587994024344200420790458371852382300302212371204740725803085498462912203032905421578690895036948831787208513945600p 0.9
+ 52045591796722407197932187435246519604594107058078806066952015076057923000614153074080891007365472270642955332656754056765910483594071699772679070338583811902403979415661095587994024344200420790458371852382300302212371204740725803085498462912203032905421578690895036948831787208513945610p -0.3
+ \]
V_wl_943 (WordLine\\<943\\> gnd!) vsource type=pwl wave=\[
+ 0    -0.3
+ 104091183593444814395864374870493039209188214116157612133904030152115846001228306148161782014730944541285910665313508113531820967188143399545358140677167623804807958831322191175988048688400841580916743704764600604424742409481451606170996925824406065810843157381790073897663574417027890500p -0.3
+ 104091183593444814395864374870493039209188214116157612133904030152115846001228306148161782014730944541285910665313508113531820967188143399545358140677167623804807958831322191175988048688400841580916743704764600604424742409481451606170996925824406065810843157381790073897663574417027890510p 0.9
+ 104091183593444814395864374870493039209188214116157612133904030152115846001228306148161782014730944541285910665313508113531820967188143399545358140677167623804807958831322191175988048688400841580916743704764600604424742409481451606170996925824406065810843157381790073897663574417027891200p 0.9
+ 104091183593444814395864374870493039209188214116157612133904030152115846001228306148161782014730944541285910665313508113531820967188143399545358140677167623804807958831322191175988048688400841580916743704764600604424742409481451606170996925824406065810843157381790073897663574417027891210p -0.3
+ \]
V_wl_944 (WordLine\\<944\\> gnd!) vsource type=pwl wave=\[
+ 0    -0.3
+ 208182367186889628791728749740986078418376428232315224267808060304231692002456612296323564029461889082571821330627016227063641934376286799090716281354335247609615917662644382351976097376801683161833487409529201208849484818962903212341993851648812131621686314763580147795327148834055781700p -0.3
+ 208182367186889628791728749740986078418376428232315224267808060304231692002456612296323564029461889082571821330627016227063641934376286799090716281354335247609615917662644382351976097376801683161833487409529201208849484818962903212341993851648812131621686314763580147795327148834055781710p 0.9
+ 208182367186889628791728749740986078418376428232315224267808060304231692002456612296323564029461889082571821330627016227063641934376286799090716281354335247609615917662644382351976097376801683161833487409529201208849484818962903212341993851648812131621686314763580147795327148834055782400p 0.9
+ 208182367186889628791728749740986078418376428232315224267808060304231692002456612296323564029461889082571821330627016227063641934376286799090716281354335247609615917662644382351976097376801683161833487409529201208849484818962903212341993851648812131621686314763580147795327148834055782410p -0.3
+ \]
V_wl_945 (WordLine\\<945\\> gnd!) vsource type=pwl wave=\[
+ 0    -0.3
+ 416364734373779257583457499481972156836752856464630448535616120608463384004913224592647128058923778165143642661254032454127283868752573598181432562708670495219231835325288764703952194753603366323666974819058402417698969637925806424683987703297624263243372629527160295590654297668111564100p -0.3
+ 416364734373779257583457499481972156836752856464630448535616120608463384004913224592647128058923778165143642661254032454127283868752573598181432562708670495219231835325288764703952194753603366323666974819058402417698969637925806424683987703297624263243372629527160295590654297668111564110p 0.9
+ 416364734373779257583457499481972156836752856464630448535616120608463384004913224592647128058923778165143642661254032454127283868752573598181432562708670495219231835325288764703952194753603366323666974819058402417698969637925806424683987703297624263243372629527160295590654297668111564800p 0.9
+ 416364734373779257583457499481972156836752856464630448535616120608463384004913224592647128058923778165143642661254032454127283868752573598181432562708670495219231835325288764703952194753603366323666974819058402417698969637925806424683987703297624263243372629527160295590654297668111564810p -0.3
+ \]
V_wl_946 (WordLine\\<946\\> gnd!) vsource type=pwl wave=\[
+ 0    -0.3
+ 832729468747558515166914998963944313673505712929260897071232241216926768009826449185294256117847556330287285322508064908254567737505147196362865125417340990438463670650577529407904389507206732647333949638116804835397939275851612849367975406595248526486745259054320591181308595336223128900p -0.3
+ 832729468747558515166914998963944313673505712929260897071232241216926768009826449185294256117847556330287285322508064908254567737505147196362865125417340990438463670650577529407904389507206732647333949638116804835397939275851612849367975406595248526486745259054320591181308595336223128910p 0.9
+ 832729468747558515166914998963944313673505712929260897071232241216926768009826449185294256117847556330287285322508064908254567737505147196362865125417340990438463670650577529407904389507206732647333949638116804835397939275851612849367975406595248526486745259054320591181308595336223129600p 0.9
+ 832729468747558515166914998963944313673505712929260897071232241216926768009826449185294256117847556330287285322508064908254567737505147196362865125417340990438463670650577529407904389507206732647333949638116804835397939275851612849367975406595248526486745259054320591181308595336223129610p -0.3
+ \]
V_wl_947 (WordLine\\<947\\> gnd!) vsource type=pwl wave=\[
+ 0    -0.3
+ 1665458937495117030333829997927888627347011425858521794142464482433853536019652898370588512235695112660574570645016129816509135475010294392725730250834681980876927341301155058815808779014413465294667899276233609670795878551703225698735950813190497052973490518108641182362617190672446258500p -0.3
+ 1665458937495117030333829997927888627347011425858521794142464482433853536019652898370588512235695112660574570645016129816509135475010294392725730250834681980876927341301155058815808779014413465294667899276233609670795878551703225698735950813190497052973490518108641182362617190672446258510p 0.9
+ 1665458937495117030333829997927888627347011425858521794142464482433853536019652898370588512235695112660574570645016129816509135475010294392725730250834681980876927341301155058815808779014413465294667899276233609670795878551703225698735950813190497052973490518108641182362617190672446259200p 0.9
+ 1665458937495117030333829997927888627347011425858521794142464482433853536019652898370588512235695112660574570645016129816509135475010294392725730250834681980876927341301155058815808779014413465294667899276233609670795878551703225698735950813190497052973490518108641182362617190672446259210p -0.3
+ \]
V_wl_948 (WordLine\\<948\\> gnd!) vsource type=pwl wave=\[
+ 0    -0.3
+ 3330917874990234060667659995855777254694022851717043588284928964867707072039305796741177024471390225321149141290032259633018270950020588785451460501669363961753854682602310117631617558028826930589335798552467219341591757103406451397471901626380994105946981036217282364725234381344892517700p -0.3
+ 3330917874990234060667659995855777254694022851717043588284928964867707072039305796741177024471390225321149141290032259633018270950020588785451460501669363961753854682602310117631617558028826930589335798552467219341591757103406451397471901626380994105946981036217282364725234381344892517710p 0.9
+ 3330917874990234060667659995855777254694022851717043588284928964867707072039305796741177024471390225321149141290032259633018270950020588785451460501669363961753854682602310117631617558028826930589335798552467219341591757103406451397471901626380994105946981036217282364725234381344892518400p 0.9
+ 3330917874990234060667659995855777254694022851717043588284928964867707072039305796741177024471390225321149141290032259633018270950020588785451460501669363961753854682602310117631617558028826930589335798552467219341591757103406451397471901626380994105946981036217282364725234381344892518410p -0.3
+ \]
V_wl_949 (WordLine\\<949\\> gnd!) vsource type=pwl wave=\[
+ 0    -0.3
+ 6661835749980468121335319991711554509388045703434087176569857929735414144078611593482354048942780450642298282580064519266036541900041177570902921003338727923507709365204620235263235116057653861178671597104934438683183514206812902794943803252761988211893962072434564729450468762689785036100p -0.3
+ 6661835749980468121335319991711554509388045703434087176569857929735414144078611593482354048942780450642298282580064519266036541900041177570902921003338727923507709365204620235263235116057653861178671597104934438683183514206812902794943803252761988211893962072434564729450468762689785036110p 0.9
+ 6661835749980468121335319991711554509388045703434087176569857929735414144078611593482354048942780450642298282580064519266036541900041177570902921003338727923507709365204620235263235116057653861178671597104934438683183514206812902794943803252761988211893962072434564729450468762689785036800p 0.9
+ 6661835749980468121335319991711554509388045703434087176569857929735414144078611593482354048942780450642298282580064519266036541900041177570902921003338727923507709365204620235263235116057653861178671597104934438683183514206812902794943803252761988211893962072434564729450468762689785036810p -0.3
+ \]
V_wl_950 (WordLine\\<950\\> gnd!) vsource type=pwl wave=\[
+ 0    -0.3
+ 13323671499960936242670639983423109018776091406868174353139715859470828288157223186964708097885560901284596565160129038532073083800082355141805842006677455847015418730409240470526470232115307722357343194209868877366367028413625805589887606505523976423787924144869129458900937525379570072900p -0.3
+ 13323671499960936242670639983423109018776091406868174353139715859470828288157223186964708097885560901284596565160129038532073083800082355141805842006677455847015418730409240470526470232115307722357343194209868877366367028413625805589887606505523976423787924144869129458900937525379570072910p 0.9
+ 13323671499960936242670639983423109018776091406868174353139715859470828288157223186964708097885560901284596565160129038532073083800082355141805842006677455847015418730409240470526470232115307722357343194209868877366367028413625805589887606505523976423787924144869129458900937525379570073600p 0.9
+ 13323671499960936242670639983423109018776091406868174353139715859470828288157223186964708097885560901284596565160129038532073083800082355141805842006677455847015418730409240470526470232115307722357343194209868877366367028413625805589887606505523976423787924144869129458900937525379570073610p -0.3
+ \]
V_wl_951 (WordLine\\<951\\> gnd!) vsource type=pwl wave=\[
+ 0    -0.3
+ 26647342999921872485341279966846218037552182813736348706279431718941656576314446373929416195771121802569193130320258077064146167600164710283611684013354911694030837460818480941052940464230615444714686388419737754732734056827251611179775213011047952847575848289738258917801875050759140146500p -0.3
+ 26647342999921872485341279966846218037552182813736348706279431718941656576314446373929416195771121802569193130320258077064146167600164710283611684013354911694030837460818480941052940464230615444714686388419737754732734056827251611179775213011047952847575848289738258917801875050759140146510p 0.9
+ 26647342999921872485341279966846218037552182813736348706279431718941656576314446373929416195771121802569193130320258077064146167600164710283611684013354911694030837460818480941052940464230615444714686388419737754732734056827251611179775213011047952847575848289738258917801875050759140147200p 0.9
+ 26647342999921872485341279966846218037552182813736348706279431718941656576314446373929416195771121802569193130320258077064146167600164710283611684013354911694030837460818480941052940464230615444714686388419737754732734056827251611179775213011047952847575848289738258917801875050759140147210p -0.3
+ \]
V_wl_952 (WordLine\\<952\\> gnd!) vsource type=pwl wave=\[
+ 0    -0.3
+ 53294685999843744970682559933692436075104365627472697412558863437883313152628892747858832391542243605138386260640516154128292335200329420567223368026709823388061674921636961882105880928461230889429372776839475509465468113654503222359550426022095905695151696579476517835603750101518280293700p -0.3
+ 53294685999843744970682559933692436075104365627472697412558863437883313152628892747858832391542243605138386260640516154128292335200329420567223368026709823388061674921636961882105880928461230889429372776839475509465468113654503222359550426022095905695151696579476517835603750101518280293710p 0.9
+ 53294685999843744970682559933692436075104365627472697412558863437883313152628892747858832391542243605138386260640516154128292335200329420567223368026709823388061674921636961882105880928461230889429372776839475509465468113654503222359550426022095905695151696579476517835603750101518280294400p 0.9
+ 53294685999843744970682559933692436075104365627472697412558863437883313152628892747858832391542243605138386260640516154128292335200329420567223368026709823388061674921636961882105880928461230889429372776839475509465468113654503222359550426022095905695151696579476517835603750101518280294410p -0.3
+ \]
V_wl_953 (WordLine\\<953\\> gnd!) vsource type=pwl wave=\[
+ 0    -0.3
+ 106589371999687489941365119867384872150208731254945394825117726875766626305257785495717664783084487210276772521281032308256584670400658841134446736053419646776123349843273923764211761856922461778858745553678951018930936227309006444719100852044191811390303393158953035671207500203036560588100p -0.3
+ 106589371999687489941365119867384872150208731254945394825117726875766626305257785495717664783084487210276772521281032308256584670400658841134446736053419646776123349843273923764211761856922461778858745553678951018930936227309006444719100852044191811390303393158953035671207500203036560588110p 0.9
+ 106589371999687489941365119867384872150208731254945394825117726875766626305257785495717664783084487210276772521281032308256584670400658841134446736053419646776123349843273923764211761856922461778858745553678951018930936227309006444719100852044191811390303393158953035671207500203036560588800p 0.9
+ 106589371999687489941365119867384872150208731254945394825117726875766626305257785495717664783084487210276772521281032308256584670400658841134446736053419646776123349843273923764211761856922461778858745553678951018930936227309006444719100852044191811390303393158953035671207500203036560588810p -0.3
+ \]
V_wl_954 (WordLine\\<954\\> gnd!) vsource type=pwl wave=\[
+ 0    -0.3
+ 213178743999374979882730239734769744300417462509890789650235453751533252610515570991435329566168974420553545042562064616513169340801317682268893472106839293552246699686547847528423523713844923557717491107357902037861872454618012889438201704088383622780606786317906071342415000406073121176900p -0.3
+ 213178743999374979882730239734769744300417462509890789650235453751533252610515570991435329566168974420553545042562064616513169340801317682268893472106839293552246699686547847528423523713844923557717491107357902037861872454618012889438201704088383622780606786317906071342415000406073121176910p 0.9
+ 213178743999374979882730239734769744300417462509890789650235453751533252610515570991435329566168974420553545042562064616513169340801317682268893472106839293552246699686547847528423523713844923557717491107357902037861872454618012889438201704088383622780606786317906071342415000406073121177600p 0.9
+ 213178743999374979882730239734769744300417462509890789650235453751533252610515570991435329566168974420553545042562064616513169340801317682268893472106839293552246699686547847528423523713844923557717491107357902037861872454618012889438201704088383622780606786317906071342415000406073121177610p -0.3
+ \]
V_wl_955 (WordLine\\<955\\> gnd!) vsource type=pwl wave=\[
+ 0    -0.3
+ 426357487998749959765460479469539488600834925019781579300470907503066505221031141982870659132337948841107090085124129233026338681602635364537786944213678587104493399373095695056847047427689847115434982214715804075723744909236025778876403408176767245561213572635812142684830000812146242354500p -0.3
+ 426357487998749959765460479469539488600834925019781579300470907503066505221031141982870659132337948841107090085124129233026338681602635364537786944213678587104493399373095695056847047427689847115434982214715804075723744909236025778876403408176767245561213572635812142684830000812146242354510p 0.9
+ 426357487998749959765460479469539488600834925019781579300470907503066505221031141982870659132337948841107090085124129233026338681602635364537786944213678587104493399373095695056847047427689847115434982214715804075723744909236025778876403408176767245561213572635812142684830000812146242355200p 0.9
+ 426357487998749959765460479469539488600834925019781579300470907503066505221031141982870659132337948841107090085124129233026338681602635364537786944213678587104493399373095695056847047427689847115434982214715804075723744909236025778876403408176767245561213572635812142684830000812146242355210p -0.3
+ \]
V_wl_956 (WordLine\\<956\\> gnd!) vsource type=pwl wave=\[
+ 0    -0.3
+ 852714975997499919530920958939078977201669850039563158600941815006133010442062283965741318264675897682214180170248258466052677363205270729075573888427357174208986798746191390113694094855379694230869964429431608151447489818472051557752806816353534491122427145271624285369660001624292484709700p -0.3
+ 852714975997499919530920958939078977201669850039563158600941815006133010442062283965741318264675897682214180170248258466052677363205270729075573888427357174208986798746191390113694094855379694230869964429431608151447489818472051557752806816353534491122427145271624285369660001624292484709710p 0.9
+ 852714975997499919530920958939078977201669850039563158600941815006133010442062283965741318264675897682214180170248258466052677363205270729075573888427357174208986798746191390113694094855379694230869964429431608151447489818472051557752806816353534491122427145271624285369660001624292484710400p 0.9
+ 852714975997499919530920958939078977201669850039563158600941815006133010442062283965741318264675897682214180170248258466052677363205270729075573888427357174208986798746191390113694094855379694230869964429431608151447489818472051557752806816353534491122427145271624285369660001624292484710410p -0.3
+ \]
V_wl_957 (WordLine\\<957\\> gnd!) vsource type=pwl wave=\[
+ 0    -0.3
+ 1705429951994999839061841917878157954403339700079126317201883630012266020884124567931482636529351795364428360340496516932105354726410541458151147776854714348417973597492382780227388189710759388461739928858863216302894979636944103115505613632707068982244854290543248570739320003248584969420100p -0.3
+ 1705429951994999839061841917878157954403339700079126317201883630012266020884124567931482636529351795364428360340496516932105354726410541458151147776854714348417973597492382780227388189710759388461739928858863216302894979636944103115505613632707068982244854290543248570739320003248584969420110p 0.9
+ 1705429951994999839061841917878157954403339700079126317201883630012266020884124567931482636529351795364428360340496516932105354726410541458151147776854714348417973597492382780227388189710759388461739928858863216302894979636944103115505613632707068982244854290543248570739320003248584969420800p 0.9
+ 1705429951994999839061841917878157954403339700079126317201883630012266020884124567931482636529351795364428360340496516932105354726410541458151147776854714348417973597492382780227388189710759388461739928858863216302894979636944103115505613632707068982244854290543248570739320003248584969420810p -0.3
+ \]
V_wl_958 (WordLine\\<958\\> gnd!) vsource type=pwl wave=\[
+ 0    -0.3
+ 3410859903989999678123683835756315908806679400158252634403767260024532041768249135862965273058703590728856720680993033864210709452821082916302295553709428696835947194984765560454776379421518776923479857717726432605789959273888206231011227265414137964489708581086497141478640006497169938840900p -0.3
+ 3410859903989999678123683835756315908806679400158252634403767260024532041768249135862965273058703590728856720680993033864210709452821082916302295553709428696835947194984765560454776379421518776923479857717726432605789959273888206231011227265414137964489708581086497141478640006497169938840910p 0.9
+ 3410859903989999678123683835756315908806679400158252634403767260024532041768249135862965273058703590728856720680993033864210709452821082916302295553709428696835947194984765560454776379421518776923479857717726432605789959273888206231011227265414137964489708581086497141478640006497169938841600p 0.9
+ 3410859903989999678123683835756315908806679400158252634403767260024532041768249135862965273058703590728856720680993033864210709452821082916302295553709428696835947194984765560454776379421518776923479857717726432605789959273888206231011227265414137964489708581086497141478640006497169938841610p -0.3
+ \]
V_wl_959 (WordLine\\<959\\> gnd!) vsource type=pwl wave=\[
+ 0    -0.3
+ 6821719807979999356247367671512631817613358800316505268807534520049064083536498271725930546117407181457713441361986067728421418905642165832604591107418857393671894389969531120909552758843037553846959715435452865211579918547776412462022454530828275928979417162172994282957280012994339877682500p -0.3
+ 6821719807979999356247367671512631817613358800316505268807534520049064083536498271725930546117407181457713441361986067728421418905642165832604591107418857393671894389969531120909552758843037553846959715435452865211579918547776412462022454530828275928979417162172994282957280012994339877682510p 0.9
+ 6821719807979999356247367671512631817613358800316505268807534520049064083536498271725930546117407181457713441361986067728421418905642165832604591107418857393671894389969531120909552758843037553846959715435452865211579918547776412462022454530828275928979417162172994282957280012994339877683200p 0.9
+ 6821719807979999356247367671512631817613358800316505268807534520049064083536498271725930546117407181457713441361986067728421418905642165832604591107418857393671894389969531120909552758843037553846959715435452865211579918547776412462022454530828275928979417162172994282957280012994339877683210p -0.3
+ \]
V_wl_960 (WordLine\\<960\\> gnd!) vsource type=pwl wave=\[
+ 0    -0.3
+ 13643439615959998712494735343025263635226717600633010537615069040098128167072996543451861092234814362915426882723972135456842837811284331665209182214837714787343788779939062241819105517686075107693919430870905730423159837095552824924044909061656551857958834324345988565914560025988679755365700p -0.3
+ 13643439615959998712494735343025263635226717600633010537615069040098128167072996543451861092234814362915426882723972135456842837811284331665209182214837714787343788779939062241819105517686075107693919430870905730423159837095552824924044909061656551857958834324345988565914560025988679755365710p 0.9
+ 13643439615959998712494735343025263635226717600633010537615069040098128167072996543451861092234814362915426882723972135456842837811284331665209182214837714787343788779939062241819105517686075107693919430870905730423159837095552824924044909061656551857958834324345988565914560025988679755366400p 0.9
+ 13643439615959998712494735343025263635226717600633010537615069040098128167072996543451861092234814362915426882723972135456842837811284331665209182214837714787343788779939062241819105517686075107693919430870905730423159837095552824924044909061656551857958834324345988565914560025988679755366410p -0.3
+ \]
V_wl_961 (WordLine\\<961\\> gnd!) vsource type=pwl wave=\[
+ 0    -0.3
+ 27286879231919997424989470686050527270453435201266021075230138080196256334145993086903722184469628725830853765447944270913685675622568663330418364429675429574687577559878124483638211035372150215387838861741811460846319674191105649848089818123313103715917668648691977131829120051977359510732100p -0.3
+ 27286879231919997424989470686050527270453435201266021075230138080196256334145993086903722184469628725830853765447944270913685675622568663330418364429675429574687577559878124483638211035372150215387838861741811460846319674191105649848089818123313103715917668648691977131829120051977359510732110p 0.9
+ 27286879231919997424989470686050527270453435201266021075230138080196256334145993086903722184469628725830853765447944270913685675622568663330418364429675429574687577559878124483638211035372150215387838861741811460846319674191105649848089818123313103715917668648691977131829120051977359510732800p 0.9
+ 27286879231919997424989470686050527270453435201266021075230138080196256334145993086903722184469628725830853765447944270913685675622568663330418364429675429574687577559878124483638211035372150215387838861741811460846319674191105649848089818123313103715917668648691977131829120051977359510732810p -0.3
+ \]
V_wl_962 (WordLine\\<962\\> gnd!) vsource type=pwl wave=\[
+ 0    -0.3
+ 54573758463839994849978941372101054540906870402532042150460276160392512668291986173807444368939257451661707530895888541827371351245137326660836728859350859149375155119756248967276422070744300430775677723483622921692639348382211299696179636246626207431835337297383954263658240103954719021464900p -0.3
+ 54573758463839994849978941372101054540906870402532042150460276160392512668291986173807444368939257451661707530895888541827371351245137326660836728859350859149375155119756248967276422070744300430775677723483622921692639348382211299696179636246626207431835337297383954263658240103954719021464910p 0.9
+ 54573758463839994849978941372101054540906870402532042150460276160392512668291986173807444368939257451661707530895888541827371351245137326660836728859350859149375155119756248967276422070744300430775677723483622921692639348382211299696179636246626207431835337297383954263658240103954719021465600p 0.9
+ 54573758463839994849978941372101054540906870402532042150460276160392512668291986173807444368939257451661707530895888541827371351245137326660836728859350859149375155119756248967276422070744300430775677723483622921692639348382211299696179636246626207431835337297383954263658240103954719021465610p -0.3
+ \]
V_wl_963 (WordLine\\<963\\> gnd!) vsource type=pwl wave=\[
+ 0    -0.3
+ 109147516927679989699957882744202109081813740805064084300920552320785025336583972347614888737878514903323415061791777083654742702490274653321673457718701718298750310239512497934552844141488600861551355446967245843385278696764422599392359272493252414863670674594767908527316480207909438042930500p -0.3
+ 109147516927679989699957882744202109081813740805064084300920552320785025336583972347614888737878514903323415061791777083654742702490274653321673457718701718298750310239512497934552844141488600861551355446967245843385278696764422599392359272493252414863670674594767908527316480207909438042930510p 0.9
+ 109147516927679989699957882744202109081813740805064084300920552320785025336583972347614888737878514903323415061791777083654742702490274653321673457718701718298750310239512497934552844141488600861551355446967245843385278696764422599392359272493252414863670674594767908527316480207909438042931200p 0.9
+ 109147516927679989699957882744202109081813740805064084300920552320785025336583972347614888737878514903323415061791777083654742702490274653321673457718701718298750310239512497934552844141488600861551355446967245843385278696764422599392359272493252414863670674594767908527316480207909438042931210p -0.3
+ \]
V_wl_964 (WordLine\\<964\\> gnd!) vsource type=pwl wave=\[
+ 0    -0.3
+ 218295033855359979399915765488404218163627481610128168601841104641570050673167944695229777475757029806646830123583554167309485404980549306643346915437403436597500620479024995869105688282977201723102710893934491686770557393528845198784718544986504829727341349189535817054632960415818876085861700p -0.3
+ 218295033855359979399915765488404218163627481610128168601841104641570050673167944695229777475757029806646830123583554167309485404980549306643346915437403436597500620479024995869105688282977201723102710893934491686770557393528845198784718544986504829727341349189535817054632960415818876085861710p 0.9
+ 218295033855359979399915765488404218163627481610128168601841104641570050673167944695229777475757029806646830123583554167309485404980549306643346915437403436597500620479024995869105688282977201723102710893934491686770557393528845198784718544986504829727341349189535817054632960415818876085862400p 0.9
+ 218295033855359979399915765488404218163627481610128168601841104641570050673167944695229777475757029806646830123583554167309485404980549306643346915437403436597500620479024995869105688282977201723102710893934491686770557393528845198784718544986504829727341349189535817054632960415818876085862410p -0.3
+ \]
V_wl_965 (WordLine\\<965\\> gnd!) vsource type=pwl wave=\[
+ 0    -0.3
+ 436590067710719958799831530976808436327254963220256337203682209283140101346335889390459554951514059613293660247167108334618970809961098613286693830874806873195001240958049991738211376565954403446205421787868983373541114787057690397569437089973009659454682698379071634109265920831637752171724100p -0.3
+ 436590067710719958799831530976808436327254963220256337203682209283140101346335889390459554951514059613293660247167108334618970809961098613286693830874806873195001240958049991738211376565954403446205421787868983373541114787057690397569437089973009659454682698379071634109265920831637752171724110p 0.9
+ 436590067710719958799831530976808436327254963220256337203682209283140101346335889390459554951514059613293660247167108334618970809961098613286693830874806873195001240958049991738211376565954403446205421787868983373541114787057690397569437089973009659454682698379071634109265920831637752171724800p 0.9
+ 436590067710719958799831530976808436327254963220256337203682209283140101346335889390459554951514059613293660247167108334618970809961098613286693830874806873195001240958049991738211376565954403446205421787868983373541114787057690397569437089973009659454682698379071634109265920831637752171724810p -0.3
+ \]
V_wl_966 (WordLine\\<966\\> gnd!) vsource type=pwl wave=\[
+ 0    -0.3
+ 873180135421439917599663061953616872654509926440512674407364418566280202692671778780919109903028119226587320494334216669237941619922197226573387661749613746390002481916099983476422753131908806892410843575737966747082229574115380795138874179946019318909365396758143268218531841663275504343448900p -0.3
+ 873180135421439917599663061953616872654509926440512674407364418566280202692671778780919109903028119226587320494334216669237941619922197226573387661749613746390002481916099983476422753131908806892410843575737966747082229574115380795138874179946019318909365396758143268218531841663275504343448910p 0.9
+ 873180135421439917599663061953616872654509926440512674407364418566280202692671778780919109903028119226587320494334216669237941619922197226573387661749613746390002481916099983476422753131908806892410843575737966747082229574115380795138874179946019318909365396758143268218531841663275504343449600p 0.9
+ 873180135421439917599663061953616872654509926440512674407364418566280202692671778780919109903028119226587320494334216669237941619922197226573387661749613746390002481916099983476422753131908806892410843575737966747082229574115380795138874179946019318909365396758143268218531841663275504343449610p -0.3
+ \]
V_wl_967 (WordLine\\<967\\> gnd!) vsource type=pwl wave=\[
+ 0    -0.3
+ 1746360270842879835199326123907233745309019852881025348814728837132560405385343557561838219806056238453174640988668433338475883239844394453146775323499227492780004963832199966952845506263817613784821687151475933494164459148230761590277748359892038637818730793516286536437063683326551008686898500p -0.3
+ 1746360270842879835199326123907233745309019852881025348814728837132560405385343557561838219806056238453174640988668433338475883239844394453146775323499227492780004963832199966952845506263817613784821687151475933494164459148230761590277748359892038637818730793516286536437063683326551008686898510p 0.9
+ 1746360270842879835199326123907233745309019852881025348814728837132560405385343557561838219806056238453174640988668433338475883239844394453146775323499227492780004963832199966952845506263817613784821687151475933494164459148230761590277748359892038637818730793516286536437063683326551008686899200p 0.9
+ 1746360270842879835199326123907233745309019852881025348814728837132560405385343557561838219806056238453174640988668433338475883239844394453146775323499227492780004963832199966952845506263817613784821687151475933494164459148230761590277748359892038637818730793516286536437063683326551008686899210p -0.3
+ \]
V_wl_968 (WordLine\\<968\\> gnd!) vsource type=pwl wave=\[
+ 0    -0.3
+ 3492720541685759670398652247814467490618039705762050697629457674265120810770687115123676439612112476906349281977336866676951766479688788906293550646998454985560009927664399933905691012527635227569643374302951866988328918296461523180555496719784077275637461587032573072874127366653102017373797700p -0.3
+ 3492720541685759670398652247814467490618039705762050697629457674265120810770687115123676439612112476906349281977336866676951766479688788906293550646998454985560009927664399933905691012527635227569643374302951866988328918296461523180555496719784077275637461587032573072874127366653102017373797710p 0.9
+ 3492720541685759670398652247814467490618039705762050697629457674265120810770687115123676439612112476906349281977336866676951766479688788906293550646998454985560009927664399933905691012527635227569643374302951866988328918296461523180555496719784077275637461587032573072874127366653102017373798400p 0.9
+ 3492720541685759670398652247814467490618039705762050697629457674265120810770687115123676439612112476906349281977336866676951766479688788906293550646998454985560009927664399933905691012527635227569643374302951866988328918296461523180555496719784077275637461587032573072874127366653102017373798410p -0.3
+ \]
V_wl_969 (WordLine\\<969\\> gnd!) vsource type=pwl wave=\[
+ 0    -0.3
+ 6985441083371519340797304495628934981236079411524101395258915348530241621541374230247352879224224953812698563954673733353903532959377577812587101293996909971120019855328799867811382025055270455139286748605903733976657836592923046361110993439568154551274923174065146145748254733306204034747596100p -0.3
+ 6985441083371519340797304495628934981236079411524101395258915348530241621541374230247352879224224953812698563954673733353903532959377577812587101293996909971120019855328799867811382025055270455139286748605903733976657836592923046361110993439568154551274923174065146145748254733306204034747596110p 0.9
+ 6985441083371519340797304495628934981236079411524101395258915348530241621541374230247352879224224953812698563954673733353903532959377577812587101293996909971120019855328799867811382025055270455139286748605903733976657836592923046361110993439568154551274923174065146145748254733306204034747596800p 0.9
+ 6985441083371519340797304495628934981236079411524101395258915348530241621541374230247352879224224953812698563954673733353903532959377577812587101293996909971120019855328799867811382025055270455139286748605903733976657836592923046361110993439568154551274923174065146145748254733306204034747596810p -0.3
+ \]
V_wl_970 (WordLine\\<970\\> gnd!) vsource type=pwl wave=\[
+ 0    -0.3
+ 13970882166743038681594608991257869962472158823048202790517830697060483243082748460494705758448449907625397127909347466707807065918755155625174202587993819942240039710657599735622764050110540910278573497211807467953315673185846092722221986879136309102549846348130292291496509466612408069495192900p -0.3
+ 13970882166743038681594608991257869962472158823048202790517830697060483243082748460494705758448449907625397127909347466707807065918755155625174202587993819942240039710657599735622764050110540910278573497211807467953315673185846092722221986879136309102549846348130292291496509466612408069495192910p 0.9
+ 13970882166743038681594608991257869962472158823048202790517830697060483243082748460494705758448449907625397127909347466707807065918755155625174202587993819942240039710657599735622764050110540910278573497211807467953315673185846092722221986879136309102549846348130292291496509466612408069495193600p 0.9
+ 13970882166743038681594608991257869962472158823048202790517830697060483243082748460494705758448449907625397127909347466707807065918755155625174202587993819942240039710657599735622764050110540910278573497211807467953315673185846092722221986879136309102549846348130292291496509466612408069495193610p -0.3
+ \]
V_wl_971 (WordLine\\<971\\> gnd!) vsource type=pwl wave=\[
+ 0    -0.3
+ 27941764333486077363189217982515739924944317646096405581035661394120966486165496920989411516896899815250794255818694933415614131837510311250348405175987639884480079421315199471245528100221081820557146994423614935906631346371692185444443973758272618205099692696260584582993018933224816138990386500p -0.3
+ 27941764333486077363189217982515739924944317646096405581035661394120966486165496920989411516896899815250794255818694933415614131837510311250348405175987639884480079421315199471245528100221081820557146994423614935906631346371692185444443973758272618205099692696260584582993018933224816138990386510p 0.9
+ 27941764333486077363189217982515739924944317646096405581035661394120966486165496920989411516896899815250794255818694933415614131837510311250348405175987639884480079421315199471245528100221081820557146994423614935906631346371692185444443973758272618205099692696260584582993018933224816138990387200p 0.9
+ 27941764333486077363189217982515739924944317646096405581035661394120966486165496920989411516896899815250794255818694933415614131837510311250348405175987639884480079421315199471245528100221081820557146994423614935906631346371692185444443973758272618205099692696260584582993018933224816138990387210p -0.3
+ \]
V_wl_972 (WordLine\\<972\\> gnd!) vsource type=pwl wave=\[
+ 0    -0.3
+ 55883528666972154726378435965031479849888635292192811162071322788241932972330993841978823033793799630501588511637389866831228263675020622500696810351975279768960158842630398942491056200442163641114293988847229871813262692743384370888887947516545236410199385392521169165986037866449632277980773700p -0.3
+ 55883528666972154726378435965031479849888635292192811162071322788241932972330993841978823033793799630501588511637389866831228263675020622500696810351975279768960158842630398942491056200442163641114293988847229871813262692743384370888887947516545236410199385392521169165986037866449632277980773710p 0.9
+ 55883528666972154726378435965031479849888635292192811162071322788241932972330993841978823033793799630501588511637389866831228263675020622500696810351975279768960158842630398942491056200442163641114293988847229871813262692743384370888887947516545236410199385392521169165986037866449632277980774400p 0.9
+ 55883528666972154726378435965031479849888635292192811162071322788241932972330993841978823033793799630501588511637389866831228263675020622500696810351975279768960158842630398942491056200442163641114293988847229871813262692743384370888887947516545236410199385392521169165986037866449632277980774410p -0.3
+ \]
V_wl_973 (WordLine\\<973\\> gnd!) vsource type=pwl wave=\[
+ 0    -0.3
+ 111767057333944309452756871930062959699777270584385622324142645576483865944661987683957646067587599261003177023274779733662456527350041245001393620703950559537920317685260797884982112400884327282228587977694459743626525385486768741777775895033090472820398770785042338331972075732899264555961548100p -0.3
+ 111767057333944309452756871930062959699777270584385622324142645576483865944661987683957646067587599261003177023274779733662456527350041245001393620703950559537920317685260797884982112400884327282228587977694459743626525385486768741777775895033090472820398770785042338331972075732899264555961548110p 0.9
+ 111767057333944309452756871930062959699777270584385622324142645576483865944661987683957646067587599261003177023274779733662456527350041245001393620703950559537920317685260797884982112400884327282228587977694459743626525385486768741777775895033090472820398770785042338331972075732899264555961548800p 0.9
+ 111767057333944309452756871930062959699777270584385622324142645576483865944661987683957646067587599261003177023274779733662456527350041245001393620703950559537920317685260797884982112400884327282228587977694459743626525385486768741777775895033090472820398770785042338331972075732899264555961548810p -0.3
+ \]
V_wl_974 (WordLine\\<974\\> gnd!) vsource type=pwl wave=\[
+ 0    -0.3
+ 223534114667888618905513743860125919399554541168771244648285291152967731889323975367915292135175198522006354046549559467324913054700082490002787241407901119075840635370521595769964224801768654564457175955388919487253050770973537483555551790066180945640797541570084676663944151465798529111923096900p -0.3
+ 223534114667888618905513743860125919399554541168771244648285291152967731889323975367915292135175198522006354046549559467324913054700082490002787241407901119075840635370521595769964224801768654564457175955388919487253050770973537483555551790066180945640797541570084676663944151465798529111923096910p 0.9
+ 223534114667888618905513743860125919399554541168771244648285291152967731889323975367915292135175198522006354046549559467324913054700082490002787241407901119075840635370521595769964224801768654564457175955388919487253050770973537483555551790066180945640797541570084676663944151465798529111923097600p 0.9
+ 223534114667888618905513743860125919399554541168771244648285291152967731889323975367915292135175198522006354046549559467324913054700082490002787241407901119075840635370521595769964224801768654564457175955388919487253050770973537483555551790066180945640797541570084676663944151465798529111923097610p -0.3
+ \]
V_wl_975 (WordLine\\<975\\> gnd!) vsource type=pwl wave=\[
+ 0    -0.3
+ 447068229335777237811027487720251838799109082337542489296570582305935463778647950735830584270350397044012708093099118934649826109400164980005574482815802238151681270741043191539928449603537309128914351910777838974506101541947074967111103580132361891281595083140169353327888302931597058223846194500p -0.3
+ 447068229335777237811027487720251838799109082337542489296570582305935463778647950735830584270350397044012708093099118934649826109400164980005574482815802238151681270741043191539928449603537309128914351910777838974506101541947074967111103580132361891281595083140169353327888302931597058223846194510p 0.9
+ 447068229335777237811027487720251838799109082337542489296570582305935463778647950735830584270350397044012708093099118934649826109400164980005574482815802238151681270741043191539928449603537309128914351910777838974506101541947074967111103580132361891281595083140169353327888302931597058223846195200p 0.9
+ 447068229335777237811027487720251838799109082337542489296570582305935463778647950735830584270350397044012708093099118934649826109400164980005574482815802238151681270741043191539928449603537309128914351910777838974506101541947074967111103580132361891281595083140169353327888302931597058223846195210p -0.3
+ \]
V_wl_976 (WordLine\\<976\\> gnd!) vsource type=pwl wave=\[
+ 0    -0.3
+ 894136458671554475622054975440503677598218164675084978593141164611870927557295901471661168540700794088025416186198237869299652218800329960011148965631604476303362541482086383079856899207074618257828703821555677949012203083894149934222207160264723782563190166280338706655776605863194116447692389700p -0.3
+ 894136458671554475622054975440503677598218164675084978593141164611870927557295901471661168540700794088025416186198237869299652218800329960011148965631604476303362541482086383079856899207074618257828703821555677949012203083894149934222207160264723782563190166280338706655776605863194116447692389710p 0.9
+ 894136458671554475622054975440503677598218164675084978593141164611870927557295901471661168540700794088025416186198237869299652218800329960011148965631604476303362541482086383079856899207074618257828703821555677949012203083894149934222207160264723782563190166280338706655776605863194116447692390400p 0.9
+ 894136458671554475622054975440503677598218164675084978593141164611870927557295901471661168540700794088025416186198237869299652218800329960011148965631604476303362541482086383079856899207074618257828703821555677949012203083894149934222207160264723782563190166280338706655776605863194116447692390410p -0.3
+ \]
V_wl_977 (WordLine\\<977\\> gnd!) vsource type=pwl wave=\[
+ 0    -0.3
+ 1788272917343108951244109950881007355196436329350169957186282329223741855114591802943322337081401588176050832372396475738599304437600659920022297931263208952606725082964172766159713798414149236515657407643111355898024406167788299868444414320529447565126380332560677413311553211726388232895384780100p -0.3
+ 1788272917343108951244109950881007355196436329350169957186282329223741855114591802943322337081401588176050832372396475738599304437600659920022297931263208952606725082964172766159713798414149236515657407643111355898024406167788299868444414320529447565126380332560677413311553211726388232895384780110p 0.9
+ 1788272917343108951244109950881007355196436329350169957186282329223741855114591802943322337081401588176050832372396475738599304437600659920022297931263208952606725082964172766159713798414149236515657407643111355898024406167788299868444414320529447565126380332560677413311553211726388232895384780800p 0.9
+ 1788272917343108951244109950881007355196436329350169957186282329223741855114591802943322337081401588176050832372396475738599304437600659920022297931263208952606725082964172766159713798414149236515657407643111355898024406167788299868444414320529447565126380332560677413311553211726388232895384780810p -0.3
+ \]
V_wl_978 (WordLine\\<978\\> gnd!) vsource type=pwl wave=\[
+ 0    -0.3
+ 3576545834686217902488219901762014710392872658700339914372564658447483710229183605886644674162803176352101664744792951477198608875201319840044595862526417905213450165928345532319427596828298473031314815286222711796048812335576599736888828641058895130252760665121354826623106423452776465790769560900p -0.3
+ 3576545834686217902488219901762014710392872658700339914372564658447483710229183605886644674162803176352101664744792951477198608875201319840044595862526417905213450165928345532319427596828298473031314815286222711796048812335576599736888828641058895130252760665121354826623106423452776465790769560910p 0.9
+ 3576545834686217902488219901762014710392872658700339914372564658447483710229183605886644674162803176352101664744792951477198608875201319840044595862526417905213450165928345532319427596828298473031314815286222711796048812335576599736888828641058895130252760665121354826623106423452776465790769561600p 0.9
+ 3576545834686217902488219901762014710392872658700339914372564658447483710229183605886644674162803176352101664744792951477198608875201319840044595862526417905213450165928345532319427596828298473031314815286222711796048812335576599736888828641058895130252760665121354826623106423452776465790769561610p -0.3
+ \]
V_wl_979 (WordLine\\<979\\> gnd!) vsource type=pwl wave=\[
+ 0    -0.3
+ 7153091669372435804976439803524029420785745317400679828745129316894967420458367211773289348325606352704203329489585902954397217750402639680089191725052835810426900331856691064638855193656596946062629630572445423592097624671153199473777657282117790260505521330242709653246212846905552931581539122500p -0.3
+ 7153091669372435804976439803524029420785745317400679828745129316894967420458367211773289348325606352704203329489585902954397217750402639680089191725052835810426900331856691064638855193656596946062629630572445423592097624671153199473777657282117790260505521330242709653246212846905552931581539122510p 0.9
+ 7153091669372435804976439803524029420785745317400679828745129316894967420458367211773289348325606352704203329489585902954397217750402639680089191725052835810426900331856691064638855193656596946062629630572445423592097624671153199473777657282117790260505521330242709653246212846905552931581539123200p 0.9
+ 7153091669372435804976439803524029420785745317400679828745129316894967420458367211773289348325606352704203329489585902954397217750402639680089191725052835810426900331856691064638855193656596946062629630572445423592097624671153199473777657282117790260505521330242709653246212846905552931581539123210p -0.3
+ \]
V_wl_980 (WordLine\\<980\\> gnd!) vsource type=pwl wave=\[
+ 0    -0.3
+ 14306183338744871609952879607048058841571490634801359657490258633789934840916734423546578696651212705408406658979171805908794435500805279360178383450105671620853800663713382129277710387313193892125259261144890847184195249342306398947555314564235580521011042660485419306492425693811105863163078245700p -0.3
+ 14306183338744871609952879607048058841571490634801359657490258633789934840916734423546578696651212705408406658979171805908794435500805279360178383450105671620853800663713382129277710387313193892125259261144890847184195249342306398947555314564235580521011042660485419306492425693811105863163078245710p 0.9
+ 14306183338744871609952879607048058841571490634801359657490258633789934840916734423546578696651212705408406658979171805908794435500805279360178383450105671620853800663713382129277710387313193892125259261144890847184195249342306398947555314564235580521011042660485419306492425693811105863163078246400p 0.9
+ 14306183338744871609952879607048058841571490634801359657490258633789934840916734423546578696651212705408406658979171805908794435500805279360178383450105671620853800663713382129277710387313193892125259261144890847184195249342306398947555314564235580521011042660485419306492425693811105863163078246410p -0.3
+ \]
V_wl_981 (WordLine\\<981\\> gnd!) vsource type=pwl wave=\[
+ 0    -0.3
+ 28612366677489743219905759214096117683142981269602719314980517267579869681833468847093157393302425410816813317958343611817588871001610558720356766900211343241707601327426764258555420774626387784250518522289781694368390498684612797895110629128471161042022085320970838612984851387622211726326156492100p -0.3
+ 28612366677489743219905759214096117683142981269602719314980517267579869681833468847093157393302425410816813317958343611817588871001610558720356766900211343241707601327426764258555420774626387784250518522289781694368390498684612797895110629128471161042022085320970838612984851387622211726326156492110p 0.9
+ 28612366677489743219905759214096117683142981269602719314980517267579869681833468847093157393302425410816813317958343611817588871001610558720356766900211343241707601327426764258555420774626387784250518522289781694368390498684612797895110629128471161042022085320970838612984851387622211726326156492800p 0.9
+ 28612366677489743219905759214096117683142981269602719314980517267579869681833468847093157393302425410816813317958343611817588871001610558720356766900211343241707601327426764258555420774626387784250518522289781694368390498684612797895110629128471161042022085320970838612984851387622211726326156492810p -0.3
+ \]
V_wl_982 (WordLine\\<982\\> gnd!) vsource type=pwl wave=\[
+ 0    -0.3
+ 57224733354979486439811518428192235366285962539205438629961034535159739363666937694186314786604850821633626635916687223635177742003221117440713533800422686483415202654853528517110841549252775568501037044579563388736780997369225595790221258256942322084044170641941677225969702775244423452652312984900p -0.3
+ 57224733354979486439811518428192235366285962539205438629961034535159739363666937694186314786604850821633626635916687223635177742003221117440713533800422686483415202654853528517110841549252775568501037044579563388736780997369225595790221258256942322084044170641941677225969702775244423452652312984910p 0.9
+ 57224733354979486439811518428192235366285962539205438629961034535159739363666937694186314786604850821633626635916687223635177742003221117440713533800422686483415202654853528517110841549252775568501037044579563388736780997369225595790221258256942322084044170641941677225969702775244423452652312985600p 0.9
+ 57224733354979486439811518428192235366285962539205438629961034535159739363666937694186314786604850821633626635916687223635177742003221117440713533800422686483415202654853528517110841549252775568501037044579563388736780997369225595790221258256942322084044170641941677225969702775244423452652312985610p -0.3
+ \]
V_wl_983 (WordLine\\<983\\> gnd!) vsource type=pwl wave=\[
+ 0    -0.3
+ 114449466709958972879623036856384470732571925078410877259922069070319478727333875388372629573209701643267253271833374447270355484006442234881427067600845372966830405309707057034221683098505551137002074089159126777473561994738451191580442516513884644168088341283883354451939405550488846905304625970500p -0.3
+ 114449466709958972879623036856384470732571925078410877259922069070319478727333875388372629573209701643267253271833374447270355484006442234881427067600845372966830405309707057034221683098505551137002074089159126777473561994738451191580442516513884644168088341283883354451939405550488846905304625970510p 0.9
+ 114449466709958972879623036856384470732571925078410877259922069070319478727333875388372629573209701643267253271833374447270355484006442234881427067600845372966830405309707057034221683098505551137002074089159126777473561994738451191580442516513884644168088341283883354451939405550488846905304625971200p 0.9
+ 114449466709958972879623036856384470732571925078410877259922069070319478727333875388372629573209701643267253271833374447270355484006442234881427067600845372966830405309707057034221683098505551137002074089159126777473561994738451191580442516513884644168088341283883354451939405550488846905304625971210p -0.3
+ \]
V_wl_984 (WordLine\\<984\\> gnd!) vsource type=pwl wave=\[
+ 0    -0.3
+ 228898933419917945759246073712768941465143850156821754519844138140638957454667750776745259146419403286534506543666748894540710968012884469762854135201690745933660810619414114068443366197011102274004148178318253554947123989476902383160885033027769288336176682567766708903878811100977693810609251941700p -0.3
+ 228898933419917945759246073712768941465143850156821754519844138140638957454667750776745259146419403286534506543666748894540710968012884469762854135201690745933660810619414114068443366197011102274004148178318253554947123989476902383160885033027769288336176682567766708903878811100977693810609251941710p 0.9
+ 228898933419917945759246073712768941465143850156821754519844138140638957454667750776745259146419403286534506543666748894540710968012884469762854135201690745933660810619414114068443366197011102274004148178318253554947123989476902383160885033027769288336176682567766708903878811100977693810609251942400p 0.9
+ 228898933419917945759246073712768941465143850156821754519844138140638957454667750776745259146419403286534506543666748894540710968012884469762854135201690745933660810619414114068443366197011102274004148178318253554947123989476902383160885033027769288336176682567766708903878811100977693810609251942410p -0.3
+ \]
V_wl_985 (WordLine\\<985\\> gnd!) vsource type=pwl wave=\[
+ 0    -0.3
+ 457797866839835891518492147425537882930287700313643509039688276281277914909335501553490518292838806573069013087333497789081421936025768939525708270403381491867321621238828228136886732394022204548008296356636507109894247978953804766321770066055538576672353365135533417807757622201955387621218503884100p -0.3
+ 457797866839835891518492147425537882930287700313643509039688276281277914909335501553490518292838806573069013087333497789081421936025768939525708270403381491867321621238828228136886732394022204548008296356636507109894247978953804766321770066055538576672353365135533417807757622201955387621218503884110p 0.9
+ 457797866839835891518492147425537882930287700313643509039688276281277914909335501553490518292838806573069013087333497789081421936025768939525708270403381491867321621238828228136886732394022204548008296356636507109894247978953804766321770066055538576672353365135533417807757622201955387621218503884800p 0.9
+ 457797866839835891518492147425537882930287700313643509039688276281277914909335501553490518292838806573069013087333497789081421936025768939525708270403381491867321621238828228136886732394022204548008296356636507109894247978953804766321770066055538576672353365135533417807757622201955387621218503884810p -0.3
+ \]
V_wl_986 (WordLine\\<986\\> gnd!) vsource type=pwl wave=\[
+ 0    -0.3
+ 915595733679671783036984294851075765860575400627287018079376552562555829818671003106981036585677613146138026174666995578162843872051537879051416540806762983734643242477656456273773464788044409096016592713273014219788495957907609532643540132111077153344706730271066835615515244403910775242437007768900p -0.3
+ 915595733679671783036984294851075765860575400627287018079376552562555829818671003106981036585677613146138026174666995578162843872051537879051416540806762983734643242477656456273773464788044409096016592713273014219788495957907609532643540132111077153344706730271066835615515244403910775242437007768910p 0.9
+ 915595733679671783036984294851075765860575400627287018079376552562555829818671003106981036585677613146138026174666995578162843872051537879051416540806762983734643242477656456273773464788044409096016592713273014219788495957907609532643540132111077153344706730271066835615515244403910775242437007769600p 0.9
+ 915595733679671783036984294851075765860575400627287018079376552562555829818671003106981036585677613146138026174666995578162843872051537879051416540806762983734643242477656456273773464788044409096016592713273014219788495957907609532643540132111077153344706730271066835615515244403910775242437007769610p -0.3
+ \]
V_wl_987 (WordLine\\<987\\> gnd!) vsource type=pwl wave=\[
+ 0    -0.3
+ 1831191467359343566073968589702151531721150801254574036158753105125111659637342006213962073171355226292276052349333991156325687744103075758102833081613525967469286484955312912547546929576088818192033185426546028439576991915815219065287080264222154306689413460542133671231030488807821550484874015538500p -0.3
+ 1831191467359343566073968589702151531721150801254574036158753105125111659637342006213962073171355226292276052349333991156325687744103075758102833081613525967469286484955312912547546929576088818192033185426546028439576991915815219065287080264222154306689413460542133671231030488807821550484874015538510p 0.9
+ 1831191467359343566073968589702151531721150801254574036158753105125111659637342006213962073171355226292276052349333991156325687744103075758102833081613525967469286484955312912547546929576088818192033185426546028439576991915815219065287080264222154306689413460542133671231030488807821550484874015539200p 0.9
+ 1831191467359343566073968589702151531721150801254574036158753105125111659637342006213962073171355226292276052349333991156325687744103075758102833081613525967469286484955312912547546929576088818192033185426546028439576991915815219065287080264222154306689413460542133671231030488807821550484874015539210p -0.3
+ \]
V_wl_988 (WordLine\\<988\\> gnd!) vsource type=pwl wave=\[
+ 0    -0.3
+ 3662382934718687132147937179404303063442301602509148072317506210250223319274684012427924146342710452584552104698667982312651375488206151516205666163227051934938572969910625825095093859152177636384066370853092056879153983831630438130574160528444308613378826921084267342462060977615643100969748031077700p -0.3
+ 3662382934718687132147937179404303063442301602509148072317506210250223319274684012427924146342710452584552104698667982312651375488206151516205666163227051934938572969910625825095093859152177636384066370853092056879153983831630438130574160528444308613378826921084267342462060977615643100969748031077710p 0.9
+ 3662382934718687132147937179404303063442301602509148072317506210250223319274684012427924146342710452584552104698667982312651375488206151516205666163227051934938572969910625825095093859152177636384066370853092056879153983831630438130574160528444308613378826921084267342462060977615643100969748031078400p 0.9
+ 3662382934718687132147937179404303063442301602509148072317506210250223319274684012427924146342710452584552104698667982312651375488206151516205666163227051934938572969910625825095093859152177636384066370853092056879153983831630438130574160528444308613378826921084267342462060977615643100969748031078410p -0.3
+ \]
V_wl_989 (WordLine\\<989\\> gnd!) vsource type=pwl wave=\[
+ 0    -0.3
+ 7324765869437374264295874358808606126884603205018296144635012420500446638549368024855848292685420905169104209397335964625302750976412303032411332326454103869877145939821251650190187718304355272768132741706184113758307967663260876261148321056888617226757653842168534684924121955231286201939496062156100p -0.3
+ 7324765869437374264295874358808606126884603205018296144635012420500446638549368024855848292685420905169104209397335964625302750976412303032411332326454103869877145939821251650190187718304355272768132741706184113758307967663260876261148321056888617226757653842168534684924121955231286201939496062156110p 0.9
+ 7324765869437374264295874358808606126884603205018296144635012420500446638549368024855848292685420905169104209397335964625302750976412303032411332326454103869877145939821251650190187718304355272768132741706184113758307967663260876261148321056888617226757653842168534684924121955231286201939496062156800p 0.9
+ 7324765869437374264295874358808606126884603205018296144635012420500446638549368024855848292685420905169104209397335964625302750976412303032411332326454103869877145939821251650190187718304355272768132741706184113758307967663260876261148321056888617226757653842168534684924121955231286201939496062156810p -0.3
+ \]
V_wl_990 (WordLine\\<990\\> gnd!) vsource type=pwl wave=\[
+ 0    -0.3
+ 14649531738874748528591748717617212253769206410036592289270024841000893277098736049711696585370841810338208418794671929250605501952824606064822664652908207739754291879642503300380375436608710545536265483412368227516615935326521752522296642113777234453515307684337069369848243910462572403878992124312900p -0.3
+ 14649531738874748528591748717617212253769206410036592289270024841000893277098736049711696585370841810338208418794671929250605501952824606064822664652908207739754291879642503300380375436608710545536265483412368227516615935326521752522296642113777234453515307684337069369848243910462572403878992124312910p 0.9
+ 14649531738874748528591748717617212253769206410036592289270024841000893277098736049711696585370841810338208418794671929250605501952824606064822664652908207739754291879642503300380375436608710545536265483412368227516615935326521752522296642113777234453515307684337069369848243910462572403878992124313600p 0.9
+ 14649531738874748528591748717617212253769206410036592289270024841000893277098736049711696585370841810338208418794671929250605501952824606064822664652908207739754291879642503300380375436608710545536265483412368227516615935326521752522296642113777234453515307684337069369848243910462572403878992124313610p -0.3
+ \]
V_wl_991 (WordLine\\<991\\> gnd!) vsource type=pwl wave=\[
+ 0    -0.3
+ 29299063477749497057183497435234424507538412820073184578540049682001786554197472099423393170741683620676416837589343858501211003905649212129645329305816415479508583759285006600760750873217421091072530966824736455033231870653043505044593284227554468907030615368674138739696487820925144807757984248626500p -0.3
+ 29299063477749497057183497435234424507538412820073184578540049682001786554197472099423393170741683620676416837589343858501211003905649212129645329305816415479508583759285006600760750873217421091072530966824736455033231870653043505044593284227554468907030615368674138739696487820925144807757984248626510p 0.9
+ 29299063477749497057183497435234424507538412820073184578540049682001786554197472099423393170741683620676416837589343858501211003905649212129645329305816415479508583759285006600760750873217421091072530966824736455033231870653043505044593284227554468907030615368674138739696487820925144807757984248627200p 0.9
+ 29299063477749497057183497435234424507538412820073184578540049682001786554197472099423393170741683620676416837589343858501211003905649212129645329305816415479508583759285006600760750873217421091072530966824736455033231870653043505044593284227554468907030615368674138739696487820925144807757984248627210p -0.3
+ \]
V_wl_992 (WordLine\\<992\\> gnd!) vsource type=pwl wave=\[
+ 0    -0.3
+ 58598126955498994114366994870468849015076825640146369157080099364003573108394944198846786341483367241352833675178687717002422007811298424259290658611632830959017167518570013201521501746434842182145061933649472910066463741306087010089186568455108937814061230737348277479392975641850289615515968497253700p -0.3
+ 58598126955498994114366994870468849015076825640146369157080099364003573108394944198846786341483367241352833675178687717002422007811298424259290658611632830959017167518570013201521501746434842182145061933649472910066463741306087010089186568455108937814061230737348277479392975641850289615515968497253710p 0.9
+ 58598126955498994114366994870468849015076825640146369157080099364003573108394944198846786341483367241352833675178687717002422007811298424259290658611632830959017167518570013201521501746434842182145061933649472910066463741306087010089186568455108937814061230737348277479392975641850289615515968497254400p 0.9
+ 58598126955498994114366994870468849015076825640146369157080099364003573108394944198846786341483367241352833675178687717002422007811298424259290658611632830959017167518570013201521501746434842182145061933649472910066463741306087010089186568455108937814061230737348277479392975641850289615515968497254410p -0.3
+ \]
V_wl_993 (WordLine\\<993\\> gnd!) vsource type=pwl wave=\[
+ 0    -0.3
+ 117196253910997988228733989740937698030153651280292738314160198728007146216789888397693572682966734482705667350357375434004844015622596848518581317223265661918034335037140026403043003492869684364290123867298945820132927482612174020178373136910217875628122461474696554958785951283700579231031936994508100p -0.3
+ 117196253910997988228733989740937698030153651280292738314160198728007146216789888397693572682966734482705667350357375434004844015622596848518581317223265661918034335037140026403043003492869684364290123867298945820132927482612174020178373136910217875628122461474696554958785951283700579231031936994508110p 0.9
+ 117196253910997988228733989740937698030153651280292738314160198728007146216789888397693572682966734482705667350357375434004844015622596848518581317223265661918034335037140026403043003492869684364290123867298945820132927482612174020178373136910217875628122461474696554958785951283700579231031936994508800p 0.9
+ 117196253910997988228733989740937698030153651280292738314160198728007146216789888397693572682966734482705667350357375434004844015622596848518581317223265661918034335037140026403043003492869684364290123867298945820132927482612174020178373136910217875628122461474696554958785951283700579231031936994508810p -0.3
+ \]
V_wl_994 (WordLine\\<994\\> gnd!) vsource type=pwl wave=\[
+ 0    -0.3
+ 234392507821995976457467979481875396060307302560585476628320397456014292433579776795387145365933468965411334700714750868009688031245193697037162634446531323836068670074280052806086006985739368728580247734597891640265854965224348040356746273820435751256244922949393109917571902567401158462063873989016900p -0.3
+ 234392507821995976457467979481875396060307302560585476628320397456014292433579776795387145365933468965411334700714750868009688031245193697037162634446531323836068670074280052806086006985739368728580247734597891640265854965224348040356746273820435751256244922949393109917571902567401158462063873989016910p 0.9
+ 234392507821995976457467979481875396060307302560585476628320397456014292433579776795387145365933468965411334700714750868009688031245193697037162634446531323836068670074280052806086006985739368728580247734597891640265854965224348040356746273820435751256244922949393109917571902567401158462063873989017600p 0.9
+ 234392507821995976457467979481875396060307302560585476628320397456014292433579776795387145365933468965411334700714750868009688031245193697037162634446531323836068670074280052806086006985739368728580247734597891640265854965224348040356746273820435751256244922949393109917571902567401158462063873989017610p -0.3
+ \]
V_wl_995 (WordLine\\<995\\> gnd!) vsource type=pwl wave=\[
+ 0    -0.3
+ 468785015643991952914935958963750792120614605121170953256640794912028584867159553590774290731866937930822669401429501736019376062490387394074325268893062647672137340148560105612172013971478737457160495469195783280531709930448696080713492547640871502512489845898786219835143805134802316924127747978034500p -0.3
+ 468785015643991952914935958963750792120614605121170953256640794912028584867159553590774290731866937930822669401429501736019376062490387394074325268893062647672137340148560105612172013971478737457160495469195783280531709930448696080713492547640871502512489845898786219835143805134802316924127747978034510p 0.9
+ 468785015643991952914935958963750792120614605121170953256640794912028584867159553590774290731866937930822669401429501736019376062490387394074325268893062647672137340148560105612172013971478737457160495469195783280531709930448696080713492547640871502512489845898786219835143805134802316924127747978035200p 0.9
+ 468785015643991952914935958963750792120614605121170953256640794912028584867159553590774290731866937930822669401429501736019376062490387394074325268893062647672137340148560105612172013971478737457160495469195783280531709930448696080713492547640871502512489845898786219835143805134802316924127747978035210p -0.3
+ \]
V_wl_996 (WordLine\\<996\\> gnd!) vsource type=pwl wave=\[
+ 0    -0.3
+ 937570031287983905829871917927501584241229210242341906513281589824057169734319107181548581463733875861645338802859003472038752124980774788148650537786125295344274680297120211224344027942957474914320990938391566561063419860897392161426985095281743005024979691797572439670287610269604633848255495956069700p -0.3
+ 937570031287983905829871917927501584241229210242341906513281589824057169734319107181548581463733875861645338802859003472038752124980774788148650537786125295344274680297120211224344027942957474914320990938391566561063419860897392161426985095281743005024979691797572439670287610269604633848255495956069710p 0.9
+ 937570031287983905829871917927501584241229210242341906513281589824057169734319107181548581463733875861645338802859003472038752124980774788148650537786125295344274680297120211224344027942957474914320990938391566561063419860897392161426985095281743005024979691797572439670287610269604633848255495956070400p 0.9
+ 937570031287983905829871917927501584241229210242341906513281589824057169734319107181548581463733875861645338802859003472038752124980774788148650537786125295344274680297120211224344027942957474914320990938391566561063419860897392161426985095281743005024979691797572439670287610269604633848255495956070410p -0.3
+ \]
V_wl_997 (WordLine\\<997\\> gnd!) vsource type=pwl wave=\[
+ 0    -0.3
+ 1875140062575967811659743835855003168482458420484683813026563179648114339468638214363097162927467751723290677605718006944077504249961549576297301075572250590688549360594240422448688055885914949828641981876783133122126839721794784322853970190563486010049959383595144879340575220539209267696510991912140100p -0.3
+ 1875140062575967811659743835855003168482458420484683813026563179648114339468638214363097162927467751723290677605718006944077504249961549576297301075572250590688549360594240422448688055885914949828641981876783133122126839721794784322853970190563486010049959383595144879340575220539209267696510991912140110p 0.9
+ 1875140062575967811659743835855003168482458420484683813026563179648114339468638214363097162927467751723290677605718006944077504249961549576297301075572250590688549360594240422448688055885914949828641981876783133122126839721794784322853970190563486010049959383595144879340575220539209267696510991912140800p 0.9
+ 1875140062575967811659743835855003168482458420484683813026563179648114339468638214363097162927467751723290677605718006944077504249961549576297301075572250590688549360594240422448688055885914949828641981876783133122126839721794784322853970190563486010049959383595144879340575220539209267696510991912140810p -0.3
+ \]
V_wl_998 (WordLine\\<998\\> gnd!) vsource type=pwl wave=\[
+ 0    -0.3
+ 3750280125151935623319487671710006336964916840969367626053126359296228678937276428726194325854935503446581355211436013888155008499923099152594602151144501181377098721188480844897376111771829899657283963753566266244253679443589568645707940381126972020099918767190289758681150441078418535393021983824280900p -0.3
+ 3750280125151935623319487671710006336964916840969367626053126359296228678937276428726194325854935503446581355211436013888155008499923099152594602151144501181377098721188480844897376111771829899657283963753566266244253679443589568645707940381126972020099918767190289758681150441078418535393021983824280910p 0.9
+ 3750280125151935623319487671710006336964916840969367626053126359296228678937276428726194325854935503446581355211436013888155008499923099152594602151144501181377098721188480844897376111771829899657283963753566266244253679443589568645707940381126972020099918767190289758681150441078418535393021983824281600p 0.9
+ 3750280125151935623319487671710006336964916840969367626053126359296228678937276428726194325854935503446581355211436013888155008499923099152594602151144501181377098721188480844897376111771829899657283963753566266244253679443589568645707940381126972020099918767190289758681150441078418535393021983824281610p -0.3
+ \]
V_wl_999 (WordLine\\<999\\> gnd!) vsource type=pwl wave=\[
+ 0    -0.3
+ 7500560250303871246638975343420012673929833681938735252106252718592457357874552857452388651709871006893162710422872027776310016999846198305189204302289002362754197442376961689794752223543659799314567927507132532488507358887179137291415880762253944040199837534380579517362300882156837070786043967648562500p -0.3
+ 7500560250303871246638975343420012673929833681938735252106252718592457357874552857452388651709871006893162710422872027776310016999846198305189204302289002362754197442376961689794752223543659799314567927507132532488507358887179137291415880762253944040199837534380579517362300882156837070786043967648562510p 0.9
+ 7500560250303871246638975343420012673929833681938735252106252718592457357874552857452388651709871006893162710422872027776310016999846198305189204302289002362754197442376961689794752223543659799314567927507132532488507358887179137291415880762253944040199837534380579517362300882156837070786043967648563200p 0.9
+ 7500560250303871246638975343420012673929833681938735252106252718592457357874552857452388651709871006893162710422872027776310016999846198305189204302289002362754197442376961689794752223543659799314567927507132532488507358887179137291415880762253944040199837534380579517362300882156837070786043967648563210p -0.3
+ \]
V_wl_1000 (WordLine\\<1000\\> gnd!) vsource type=pwl wave=\[
+ 0    -0.3
+ 15001120500607742493277950686840025347859667363877470504212505437184914715749105714904777303419742013786325420845744055552620033999692396610378408604578004725508394884753923379589504447087319598629135855014265064977014717774358274582831761524507888080399675068761159034724601764313674141572087935297125700p -0.3
+ 15001120500607742493277950686840025347859667363877470504212505437184914715749105714904777303419742013786325420845744055552620033999692396610378408604578004725508394884753923379589504447087319598629135855014265064977014717774358274582831761524507888080399675068761159034724601764313674141572087935297125710p 0.9
+ 15001120500607742493277950686840025347859667363877470504212505437184914715749105714904777303419742013786325420845744055552620033999692396610378408604578004725508394884753923379589504447087319598629135855014265064977014717774358274582831761524507888080399675068761159034724601764313674141572087935297126400p 0.9
+ 15001120500607742493277950686840025347859667363877470504212505437184914715749105714904777303419742013786325420845744055552620033999692396610378408604578004725508394884753923379589504447087319598629135855014265064977014717774358274582831761524507888080399675068761159034724601764313674141572087935297126410p -0.3
+ \]
V_wl_1001 (WordLine\\<1001\\> gnd!) vsource type=pwl wave=\[
+ 0    -0.3
+ 30002241001215484986555901373680050695719334727754941008425010874369829431498211429809554606839484027572650841691488111105240067999384793220756817209156009451016789769507846759179008894174639197258271710028530129954029435548716549165663523049015776160799350137522318069449203528627348283144175870594252100p -0.3
+ 30002241001215484986555901373680050695719334727754941008425010874369829431498211429809554606839484027572650841691488111105240067999384793220756817209156009451016789769507846759179008894174639197258271710028530129954029435548716549165663523049015776160799350137522318069449203528627348283144175870594252110p 0.9
+ 30002241001215484986555901373680050695719334727754941008425010874369829431498211429809554606839484027572650841691488111105240067999384793220756817209156009451016789769507846759179008894174639197258271710028530129954029435548716549165663523049015776160799350137522318069449203528627348283144175870594252800p 0.9
+ 30002241001215484986555901373680050695719334727754941008425010874369829431498211429809554606839484027572650841691488111105240067999384793220756817209156009451016789769507846759179008894174639197258271710028530129954029435548716549165663523049015776160799350137522318069449203528627348283144175870594252810p -0.3
+ \]
V_wl_1002 (WordLine\\<1002\\> gnd!) vsource type=pwl wave=\[
+ 0    -0.3
+ 60004482002430969973111802747360101391438669455509882016850021748739658862996422859619109213678968055145301683382976222210480135998769586441513634418312018902033579539015693518358017788349278394516543420057060259908058871097433098331327046098031552321598700275044636138898407057254696566288351741188504900p -0.3
+ 60004482002430969973111802747360101391438669455509882016850021748739658862996422859619109213678968055145301683382976222210480135998769586441513634418312018902033579539015693518358017788349278394516543420057060259908058871097433098331327046098031552321598700275044636138898407057254696566288351741188504910p 0.9
+ 60004482002430969973111802747360101391438669455509882016850021748739658862996422859619109213678968055145301683382976222210480135998769586441513634418312018902033579539015693518358017788349278394516543420057060259908058871097433098331327046098031552321598700275044636138898407057254696566288351741188505600p 0.9
+ 60004482002430969973111802747360101391438669455509882016850021748739658862996422859619109213678968055145301683382976222210480135998769586441513634418312018902033579539015693518358017788349278394516543420057060259908058871097433098331327046098031552321598700275044636138898407057254696566288351741188505610p -0.3
+ \]
V_wl_1003 (WordLine\\<1003\\> gnd!) vsource type=pwl wave=\[
+ 0    -0.3
+ 120008964004861939946223605494720202782877338911019764033700043497479317725992845719238218427357936110290603366765952444420960271997539172883027268836624037804067159078031387036716035576698556789033086840114120519816117742194866196662654092196063104643197400550089272277796814114509393132576703482377010500p -0.3
+ 120008964004861939946223605494720202782877338911019764033700043497479317725992845719238218427357936110290603366765952444420960271997539172883027268836624037804067159078031387036716035576698556789033086840114120519816117742194866196662654092196063104643197400550089272277796814114509393132576703482377010510p 0.9
+ 120008964004861939946223605494720202782877338911019764033700043497479317725992845719238218427357936110290603366765952444420960271997539172883027268836624037804067159078031387036716035576698556789033086840114120519816117742194866196662654092196063104643197400550089272277796814114509393132576703482377011200p 0.9
+ 120008964004861939946223605494720202782877338911019764033700043497479317725992845719238218427357936110290603366765952444420960271997539172883027268836624037804067159078031387036716035576698556789033086840114120519816117742194866196662654092196063104643197400550089272277796814114509393132576703482377011210p -0.3
+ \]
V_wl_1004 (WordLine\\<1004\\> gnd!) vsource type=pwl wave=\[
+ 0    -0.3
+ 240017928009723879892447210989440405565754677822039528067400086994958635451985691438476436854715872220581206733531904888841920543995078345766054537673248075608134318156062774073432071153397113578066173680228241039632235484389732393325308184392126209286394801100178544555593628229018786265153406964754021700p -0.3
+ 240017928009723879892447210989440405565754677822039528067400086994958635451985691438476436854715872220581206733531904888841920543995078345766054537673248075608134318156062774073432071153397113578066173680228241039632235484389732393325308184392126209286394801100178544555593628229018786265153406964754021710p 0.9
+ 240017928009723879892447210989440405565754677822039528067400086994958635451985691438476436854715872220581206733531904888841920543995078345766054537673248075608134318156062774073432071153397113578066173680228241039632235484389732393325308184392126209286394801100178544555593628229018786265153406964754022400p 0.9
+ 240017928009723879892447210989440405565754677822039528067400086994958635451985691438476436854715872220581206733531904888841920543995078345766054537673248075608134318156062774073432071153397113578066173680228241039632235484389732393325308184392126209286394801100178544555593628229018786265153406964754022410p -0.3
+ \]
V_wl_1005 (WordLine\\<1005\\> gnd!) vsource type=pwl wave=\[
+ 0    -0.3
+ 480035856019447759784894421978880811131509355644079056134800173989917270903971382876952873709431744441162413467063809777683841087990156691532109075346496151216268636312125548146864142306794227156132347360456482079264470968779464786650616368784252418572789602200357089111187256458037572530306813929508044100p -0.3
+ 480035856019447759784894421978880811131509355644079056134800173989917270903971382876952873709431744441162413467063809777683841087990156691532109075346496151216268636312125548146864142306794227156132347360456482079264470968779464786650616368784252418572789602200357089111187256458037572530306813929508044110p 0.9
+ 480035856019447759784894421978880811131509355644079056134800173989917270903971382876952873709431744441162413467063809777683841087990156691532109075346496151216268636312125548146864142306794227156132347360456482079264470968779464786650616368784252418572789602200357089111187256458037572530306813929508044800p 0.9
+ 480035856019447759784894421978880811131509355644079056134800173989917270903971382876952873709431744441162413467063809777683841087990156691532109075346496151216268636312125548146864142306794227156132347360456482079264470968779464786650616368784252418572789602200357089111187256458037572530306813929508044810p -0.3
+ \]
V_wl_1006 (WordLine\\<1006\\> gnd!) vsource type=pwl wave=\[
+ 0    -0.3
+ 960071712038895519569788843957761622263018711288158112269600347979834541807942765753905747418863488882324826934127619555367682175980313383064218150692992302432537272624251096293728284613588454312264694720912964158528941937558929573301232737568504837145579204400714178222374512916075145060613627859016088900p -0.3
+ 960071712038895519569788843957761622263018711288158112269600347979834541807942765753905747418863488882324826934127619555367682175980313383064218150692992302432537272624251096293728284613588454312264694720912964158528941937558929573301232737568504837145579204400714178222374512916075145060613627859016088910p 0.9
+ 960071712038895519569788843957761622263018711288158112269600347979834541807942765753905747418863488882324826934127619555367682175980313383064218150692992302432537272624251096293728284613588454312264694720912964158528941937558929573301232737568504837145579204400714178222374512916075145060613627859016089600p 0.9
+ 960071712038895519569788843957761622263018711288158112269600347979834541807942765753905747418863488882324826934127619555367682175980313383064218150692992302432537272624251096293728284613588454312264694720912964158528941937558929573301232737568504837145579204400714178222374512916075145060613627859016089610p -0.3
+ \]
V_wl_1007 (WordLine\\<1007\\> gnd!) vsource type=pwl wave=\[
+ 0    -0.3
+ 1920143424077791039139577687915523244526037422576316224539200695959669083615885531507811494837726977764649653868255239110735364351960626766128436301385984604865074545248502192587456569227176908624529389441825928317057883875117859146602465475137009674291158408801428356444749025832150290121227255718032178500p -0.3
+ 1920143424077791039139577687915523244526037422576316224539200695959669083615885531507811494837726977764649653868255239110735364351960626766128436301385984604865074545248502192587456569227176908624529389441825928317057883875117859146602465475137009674291158408801428356444749025832150290121227255718032178510p 0.9
+ 1920143424077791039139577687915523244526037422576316224539200695959669083615885531507811494837726977764649653868255239110735364351960626766128436301385984604865074545248502192587456569227176908624529389441825928317057883875117859146602465475137009674291158408801428356444749025832150290121227255718032179200p 0.9
+ 1920143424077791039139577687915523244526037422576316224539200695959669083615885531507811494837726977764649653868255239110735364351960626766128436301385984604865074545248502192587456569227176908624529389441825928317057883875117859146602465475137009674291158408801428356444749025832150290121227255718032179210p -0.3
+ \]
V_wl_1008 (WordLine\\<1008\\> gnd!) vsource type=pwl wave=\[
+ 0    -0.3
+ 3840286848155582078279155375831046489052074845152632449078401391919338167231771063015622989675453955529299307736510478221470728703921253532256872602771969209730149090497004385174913138454353817249058778883651856634115767750235718293204930950274019348582316817602856712889498051664300580242454511436064357700p -0.3
+ 3840286848155582078279155375831046489052074845152632449078401391919338167231771063015622989675453955529299307736510478221470728703921253532256872602771969209730149090497004385174913138454353817249058778883651856634115767750235718293204930950274019348582316817602856712889498051664300580242454511436064357710p 0.9
+ 3840286848155582078279155375831046489052074845152632449078401391919338167231771063015622989675453955529299307736510478221470728703921253532256872602771969209730149090497004385174913138454353817249058778883651856634115767750235718293204930950274019348582316817602856712889498051664300580242454511436064358400p 0.9
+ 3840286848155582078279155375831046489052074845152632449078401391919338167231771063015622989675453955529299307736510478221470728703921253532256872602771969209730149090497004385174913138454353817249058778883651856634115767750235718293204930950274019348582316817602856712889498051664300580242454511436064358410p -0.3
+ \]
V_wl_1009 (WordLine\\<1009\\> gnd!) vsource type=pwl wave=\[
+ 0    -0.3
+ 7680573696311164156558310751662092978104149690305264898156802783838676334463542126031245979350907911058598615473020956442941457407842507064513745205543938419460298180994008770349826276908707634498117557767303713268231535500471436586409861900548038697164633635205713425778996103328601160484909022872128716100p -0.3
+ 7680573696311164156558310751662092978104149690305264898156802783838676334463542126031245979350907911058598615473020956442941457407842507064513745205543938419460298180994008770349826276908707634498117557767303713268231535500471436586409861900548038697164633635205713425778996103328601160484909022872128716110p 0.9
+ 7680573696311164156558310751662092978104149690305264898156802783838676334463542126031245979350907911058598615473020956442941457407842507064513745205543938419460298180994008770349826276908707634498117557767303713268231535500471436586409861900548038697164633635205713425778996103328601160484909022872128716800p 0.9
+ 7680573696311164156558310751662092978104149690305264898156802783838676334463542126031245979350907911058598615473020956442941457407842507064513745205543938419460298180994008770349826276908707634498117557767303713268231535500471436586409861900548038697164633635205713425778996103328601160484909022872128716810p -0.3
+ \]
V_wl_1010 (WordLine\\<1010\\> gnd!) vsource type=pwl wave=\[
+ 0    -0.3
+ 15361147392622328313116621503324185956208299380610529796313605567677352668927084252062491958701815822117197230946041912885882914815685014129027490411087876838920596361988017540699652553817415268996235115534607426536463071000942873172819723801096077394329267270411426851557992206657202320969818045744257432900p -0.3
+ 15361147392622328313116621503324185956208299380610529796313605567677352668927084252062491958701815822117197230946041912885882914815685014129027490411087876838920596361988017540699652553817415268996235115534607426536463071000942873172819723801096077394329267270411426851557992206657202320969818045744257432910p 0.9
+ 15361147392622328313116621503324185956208299380610529796313605567677352668927084252062491958701815822117197230946041912885882914815685014129027490411087876838920596361988017540699652553817415268996235115534607426536463071000942873172819723801096077394329267270411426851557992206657202320969818045744257433600p 0.9
+ 15361147392622328313116621503324185956208299380610529796313605567677352668927084252062491958701815822117197230946041912885882914815685014129027490411087876838920596361988017540699652553817415268996235115534607426536463071000942873172819723801096077394329267270411426851557992206657202320969818045744257433610p -0.3
+ \]
V_wl_1011 (WordLine\\<1011\\> gnd!) vsource type=pwl wave=\[
+ 0    -0.3
+ 30722294785244656626233243006648371912416598761221059592627211135354705337854168504124983917403631644234394461892083825771765829631370028258054980822175753677841192723976035081399305107634830537992470231069214853072926142001885746345639447602192154788658534540822853703115984413314404641939636091488514866500p -0.3
+ 30722294785244656626233243006648371912416598761221059592627211135354705337854168504124983917403631644234394461892083825771765829631370028258054980822175753677841192723976035081399305107634830537992470231069214853072926142001885746345639447602192154788658534540822853703115984413314404641939636091488514866510p 0.9
+ 30722294785244656626233243006648371912416598761221059592627211135354705337854168504124983917403631644234394461892083825771765829631370028258054980822175753677841192723976035081399305107634830537992470231069214853072926142001885746345639447602192154788658534540822853703115984413314404641939636091488514867200p 0.9
+ 30722294785244656626233243006648371912416598761221059592627211135354705337854168504124983917403631644234394461892083825771765829631370028258054980822175753677841192723976035081399305107634830537992470231069214853072926142001885746345639447602192154788658534540822853703115984413314404641939636091488514867210p -0.3
+ \]
V_wl_1012 (WordLine\\<1012\\> gnd!) vsource type=pwl wave=\[
+ 0    -0.3
+ 61444589570489313252466486013296743824833197522442119185254422270709410675708337008249967834807263288468788923784167651543531659262740056516109961644351507355682385447952070162798610215269661075984940462138429706145852284003771492691278895204384309577317069081645707406231968826628809283879272182977029733700p -0.3
+ 61444589570489313252466486013296743824833197522442119185254422270709410675708337008249967834807263288468788923784167651543531659262740056516109961644351507355682385447952070162798610215269661075984940462138429706145852284003771492691278895204384309577317069081645707406231968826628809283879272182977029733710p 0.9
+ 61444589570489313252466486013296743824833197522442119185254422270709410675708337008249967834807263288468788923784167651543531659262740056516109961644351507355682385447952070162798610215269661075984940462138429706145852284003771492691278895204384309577317069081645707406231968826628809283879272182977029734400p 0.9
+ 61444589570489313252466486013296743824833197522442119185254422270709410675708337008249967834807263288468788923784167651543531659262740056516109961644351507355682385447952070162798610215269661075984940462138429706145852284003771492691278895204384309577317069081645707406231968826628809283879272182977029734410p -0.3
+ \]
V_wl_1013 (WordLine\\<1013\\> gnd!) vsource type=pwl wave=\[
+ 0    -0.3
+ 122889179140978626504932972026593487649666395044884238370508844541418821351416674016499935669614526576937577847568335303087063318525480113032219923288703014711364770895904140325597220430539322151969880924276859412291704568007542985382557790408768619154634138163291414812463937653257618567758544365954059468100p -0.3
+ 122889179140978626504932972026593487649666395044884238370508844541418821351416674016499935669614526576937577847568335303087063318525480113032219923288703014711364770895904140325597220430539322151969880924276859412291704568007542985382557790408768619154634138163291414812463937653257618567758544365954059468110p 0.9
+ 122889179140978626504932972026593487649666395044884238370508844541418821351416674016499935669614526576937577847568335303087063318525480113032219923288703014711364770895904140325597220430539322151969880924276859412291704568007542985382557790408768619154634138163291414812463937653257618567758544365954059468800p 0.9
+ 122889179140978626504932972026593487649666395044884238370508844541418821351416674016499935669614526576937577847568335303087063318525480113032219923288703014711364770895904140325597220430539322151969880924276859412291704568007542985382557790408768619154634138163291414812463937653257618567758544365954059468810p -0.3
+ \]
V_wl_1014 (WordLine\\<1014\\> gnd!) vsource type=pwl wave=\[
+ 0    -0.3
+ 245778358281957253009865944053186975299332790089768476741017689082837642702833348032999871339229053153875155695136670606174126637050960226064439846577406029422729541791808280651194440861078644303939761848553718824583409136015085970765115580817537238309268276326582829624927875306515237135517088731908118936900p -0.3
+ 245778358281957253009865944053186975299332790089768476741017689082837642702833348032999871339229053153875155695136670606174126637050960226064439846577406029422729541791808280651194440861078644303939761848553718824583409136015085970765115580817537238309268276326582829624927875306515237135517088731908118936910p 0.9
+ 245778358281957253009865944053186975299332790089768476741017689082837642702833348032999871339229053153875155695136670606174126637050960226064439846577406029422729541791808280651194440861078644303939761848553718824583409136015085970765115580817537238309268276326582829624927875306515237135517088731908118937600p 0.9
+ 245778358281957253009865944053186975299332790089768476741017689082837642702833348032999871339229053153875155695136670606174126637050960226064439846577406029422729541791808280651194440861078644303939761848553718824583409136015085970765115580817537238309268276326582829624927875306515237135517088731908118937610p -0.3
+ \]
V_wl_1015 (WordLine\\<1015\\> gnd!) vsource type=pwl wave=\[
+ 0    -0.3
+ 491556716563914506019731888106373950598665580179536953482035378165675285405666696065999742678458106307750311390273341212348253274101920452128879693154812058845459083583616561302388881722157288607879523697107437649166818272030171941530231161635074476618536552653165659249855750613030474271034177463816237874500p -0.3
+ 491556716563914506019731888106373950598665580179536953482035378165675285405666696065999742678458106307750311390273341212348253274101920452128879693154812058845459083583616561302388881722157288607879523697107437649166818272030171941530231161635074476618536552653165659249855750613030474271034177463816237874510p 0.9
+ 491556716563914506019731888106373950598665580179536953482035378165675285405666696065999742678458106307750311390273341212348253274101920452128879693154812058845459083583616561302388881722157288607879523697107437649166818272030171941530231161635074476618536552653165659249855750613030474271034177463816237875200p 0.9
+ 491556716563914506019731888106373950598665580179536953482035378165675285405666696065999742678458106307750311390273341212348253274101920452128879693154812058845459083583616561302388881722157288607879523697107437649166818272030171941530231161635074476618536552653165659249855750613030474271034177463816237875210p -0.3
+ \]
V_wl_1016 (WordLine\\<1016\\> gnd!) vsource type=pwl wave=\[
+ 0    -0.3
+ 983113433127829012039463776212747901197331160359073906964070756331350570811333392131999485356916212615500622780546682424696506548203840904257759386309624117690918167167233122604777763444314577215759047394214875298333636544060343883060462323270148953237073105306331318499711501226060948542068354927632475749700p -0.3
+ 983113433127829012039463776212747901197331160359073906964070756331350570811333392131999485356916212615500622780546682424696506548203840904257759386309624117690918167167233122604777763444314577215759047394214875298333636544060343883060462323270148953237073105306331318499711501226060948542068354927632475749710p 0.9
+ 983113433127829012039463776212747901197331160359073906964070756331350570811333392131999485356916212615500622780546682424696506548203840904257759386309624117690918167167233122604777763444314577215759047394214875298333636544060343883060462323270148953237073105306331318499711501226060948542068354927632475750400p 0.9
+ 983113433127829012039463776212747901197331160359073906964070756331350570811333392131999485356916212615500622780546682424696506548203840904257759386309624117690918167167233122604777763444314577215759047394214875298333636544060343883060462323270148953237073105306331318499711501226060948542068354927632475750410p -0.3
+ \]
V_wl_1017 (WordLine\\<1017\\> gnd!) vsource type=pwl wave=\[
+ 0    -0.3
+ 1966226866255658024078927552425495802394662320718147813928141512662701141622666784263998970713832425231001245561093364849393013096407681808515518772619248235381836334334466245209555526888629154431518094788429750596667273088120687766120924646540297906474146210612662636999423002452121897084136709855264951500100p -0.3
+ 1966226866255658024078927552425495802394662320718147813928141512662701141622666784263998970713832425231001245561093364849393013096407681808515518772619248235381836334334466245209555526888629154431518094788429750596667273088120687766120924646540297906474146210612662636999423002452121897084136709855264951500110p 0.9
+ 1966226866255658024078927552425495802394662320718147813928141512662701141622666784263998970713832425231001245561093364849393013096407681808515518772619248235381836334334466245209555526888629154431518094788429750596667273088120687766120924646540297906474146210612662636999423002452121897084136709855264951500800p 0.9
+ 1966226866255658024078927552425495802394662320718147813928141512662701141622666784263998970713832425231001245561093364849393013096407681808515518772619248235381836334334466245209555526888629154431518094788429750596667273088120687766120924646540297906474146210612662636999423002452121897084136709855264951500810p -0.3
+ \]
V_wl_1018 (WordLine\\<1018\\> gnd!) vsource type=pwl wave=\[
+ 0    -0.3
+ 3932453732511316048157855104850991604789324641436295627856283025325402283245333568527997941427664850462002491122186729698786026192815363617031037545238496470763672668668932490419111053777258308863036189576859501193334546176241375532241849293080595812948292421225325273998846004904243794168273419710529903000900p -0.3
+ 3932453732511316048157855104850991604789324641436295627856283025325402283245333568527997941427664850462002491122186729698786026192815363617031037545238496470763672668668932490419111053777258308863036189576859501193334546176241375532241849293080595812948292421225325273998846004904243794168273419710529903000910p 0.9
+ 3932453732511316048157855104850991604789324641436295627856283025325402283245333568527997941427664850462002491122186729698786026192815363617031037545238496470763672668668932490419111053777258308863036189576859501193334546176241375532241849293080595812948292421225325273998846004904243794168273419710529903001600p 0.9
+ 3932453732511316048157855104850991604789324641436295627856283025325402283245333568527997941427664850462002491122186729698786026192815363617031037545238496470763672668668932490419111053777258308863036189576859501193334546176241375532241849293080595812948292421225325273998846004904243794168273419710529903001610p -0.3
+ \]
V_wl_1019 (WordLine\\<1019\\> gnd!) vsource type=pwl wave=\[
+ 0    -0.3
+ 7864907465022632096315710209701983209578649282872591255712566050650804566490667137055995882855329700924004982244373459397572052385630727234062075090476992941527345337337864980838222107554516617726072379153719002386669092352482751064483698586161191625896584842450650547997692009808487588336546839421059806002500p -0.3
+ 7864907465022632096315710209701983209578649282872591255712566050650804566490667137055995882855329700924004982244373459397572052385630727234062075090476992941527345337337864980838222107554516617726072379153719002386669092352482751064483698586161191625896584842450650547997692009808487588336546839421059806002510p 0.9
+ 7864907465022632096315710209701983209578649282872591255712566050650804566490667137055995882855329700924004982244373459397572052385630727234062075090476992941527345337337864980838222107554516617726072379153719002386669092352482751064483698586161191625896584842450650547997692009808487588336546839421059806003200p 0.9
+ 7864907465022632096315710209701983209578649282872591255712566050650804566490667137055995882855329700924004982244373459397572052385630727234062075090476992941527345337337864980838222107554516617726072379153719002386669092352482751064483698586161191625896584842450650547997692009808487588336546839421059806003210p -0.3
+ \]
V_wl_1020 (WordLine\\<1020\\> gnd!) vsource type=pwl wave=\[
+ 0    -0.3
+ 15729814930045264192631420419403966419157298565745182511425132101301609132981334274111991765710659401848009964488746918795144104771261454468124150180953985883054690674675729961676444215109033235452144758307438004773338184704965502128967397172322383251793169684901301095995384019616975176673093678842119612005700p -0.3
+ 15729814930045264192631420419403966419157298565745182511425132101301609132981334274111991765710659401848009964488746918795144104771261454468124150180953985883054690674675729961676444215109033235452144758307438004773338184704965502128967397172322383251793169684901301095995384019616975176673093678842119612005710p 0.9
+ 15729814930045264192631420419403966419157298565745182511425132101301609132981334274111991765710659401848009964488746918795144104771261454468124150180953985883054690674675729961676444215109033235452144758307438004773338184704965502128967397172322383251793169684901301095995384019616975176673093678842119612006400p 0.9
+ 15729814930045264192631420419403966419157298565745182511425132101301609132981334274111991765710659401848009964488746918795144104771261454468124150180953985883054690674675729961676444215109033235452144758307438004773338184704965502128967397172322383251793169684901301095995384019616975176673093678842119612006410p -0.3
+ \]
V_wl_1021 (WordLine\\<1021\\> gnd!) vsource type=pwl wave=\[
+ 0    -0.3
+ 31459629860090528385262840838807932838314597131490365022850264202603218265962668548223983531421318803696019928977493837590288209542522908936248300361907971766109381349351459923352888430218066470904289516614876009546676369409931004257934794344644766503586339369802602191990768039233950353346187357684239224012100p -0.3
+ 31459629860090528385262840838807932838314597131490365022850264202603218265962668548223983531421318803696019928977493837590288209542522908936248300361907971766109381349351459923352888430218066470904289516614876009546676369409931004257934794344644766503586339369802602191990768039233950353346187357684239224012110p 0.9
+ 31459629860090528385262840838807932838314597131490365022850264202603218265962668548223983531421318803696019928977493837590288209542522908936248300361907971766109381349351459923352888430218066470904289516614876009546676369409931004257934794344644766503586339369802602191990768039233950353346187357684239224012800p 0.9
+ 31459629860090528385262840838807932838314597131490365022850264202603218265962668548223983531421318803696019928977493837590288209542522908936248300361907971766109381349351459923352888430218066470904289516614876009546676369409931004257934794344644766503586339369802602191990768039233950353346187357684239224012810p -0.3
+ \]
V_wl_1022 (WordLine\\<1022\\> gnd!) vsource type=pwl wave=\[
+ 0    -0.3
+ 62919259720181056770525681677615865676629194262980730045700528405206436531925337096447967062842637607392039857954987675180576419085045817872496600723815943532218762698702919846705776860436132941808579033229752019093352738819862008515869588689289533007172678739605204383981536078467900706692374715368478448024900p -0.3
+ 62919259720181056770525681677615865676629194262980730045700528405206436531925337096447967062842637607392039857954987675180576419085045817872496600723815943532218762698702919846705776860436132941808579033229752019093352738819862008515869588689289533007172678739605204383981536078467900706692374715368478448024910p 0.9
+ 62919259720181056770525681677615865676629194262980730045700528405206436531925337096447967062842637607392039857954987675180576419085045817872496600723815943532218762698702919846705776860436132941808579033229752019093352738819862008515869588689289533007172678739605204383981536078467900706692374715368478448025600p 0.9
+ 62919259720181056770525681677615865676629194262980730045700528405206436531925337096447967062842637607392039857954987675180576419085045817872496600723815943532218762698702919846705776860436132941808579033229752019093352738819862008515869588689289533007172678739605204383981536078467900706692374715368478448025610p -0.3
+ \]
V_wl_1023 (WordLine\\<1023\\> gnd!) vsource type=pwl wave=\[
+ 0    -0.3
+ 125838519440362113541051363355231731353258388525961460091401056810412873063850674192895934125685275214784079715909975350361152838170091635744993201447631887064437525397405839693411553720872265883617158066459504038186705477639724017031739177378579066014345357479210408767963072156935801413384749430736956896050500p -0.3
+ 125838519440362113541051363355231731353258388525961460091401056810412873063850674192895934125685275214784079715909975350361152838170091635744993201447631887064437525397405839693411553720872265883617158066459504038186705477639724017031739177378579066014345357479210408767963072156935801413384749430736956896050510p 0.9
+ 125838519440362113541051363355231731353258388525961460091401056810412873063850674192895934125685275214784079715909975350361152838170091635744993201447631887064437525397405839693411553720872265883617158066459504038186705477639724017031739177378579066014345357479210408767963072156935801413384749430736956896051200p 0.9
+ 125838519440362113541051363355231731353258388525961460091401056810412873063850674192895934125685275214784079715909975350361152838170091635744993201447631887064437525397405839693411553720872265883617158066459504038186705477639724017031739177378579066014345357479210408767963072156935801413384749430736956896051210p -0.3
+ \]
