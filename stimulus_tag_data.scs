V_data_0 (Data\\<0\\> gnd!) vsource type=pwl wave=\[
+ 0    0
+ \]
V_data_1 (Data\\<1\\> gnd!) vsource type=pwl wave=\[
+ 0    0
+ \]
V_data_2 (Data\\<2\\> gnd!) vsource type=pwl wave=\[
+ 0    0
+ \]
V_data_3 (Data\\<3\\> gnd!) vsource type=pwl wave=\[
+ 0    0
+ \]
V_data_4 (Data\\<4\\> gnd!) vsource type=pwl wave=\[
+ 0    0
+ \]
V_data_5 (Data\\<5\\> gnd!) vsource type=pwl wave=\[
+ 0    0
+ \]
V_data_6 (Data\\<6\\> gnd!) vsource type=pwl wave=\[
+ 0    0
+ \]
V_data_7 (Data\\<7\\> gnd!) vsource type=pwl wave=\[
+ 0    0
+ \]
V_data_8 (Data\\<8\\> gnd!) vsource type=pwl wave=\[
+ 0    0
+ \]
V_data_9 (Data\\<9\\> gnd!) vsource type=pwl wave=\[
+ 0    0
+ \]
V_data_10 (Data\\<10\\> gnd!) vsource type=pwl wave=\[
+ 0    0
+ \]
V_data_11 (Data\\<11\\> gnd!) vsource type=pwl wave=\[
+ 0    0
+ \]
V_data_12 (Data\\<12\\> gnd!) vsource type=pwl wave=\[
+ 0    0
+ \]
V_data_13 (Data\\<13\\> gnd!) vsource type=pwl wave=\[
+ 0    0
+ \]
V_data_14 (Data\\<14\\> gnd!) vsource type=pwl wave=\[
+ 0    0
+ \]
V_data_15 (Data\\<15\\> gnd!) vsource type=pwl wave=\[
+ 0    0
+ \]
V_data_16 (Data\\<16\\> gnd!) vsource type=pwl wave=\[
+ 0    0
+ \]
V_data_17 (Data\\<17\\> gnd!) vsource type=pwl wave=\[
+ 0    0
+ \]
V_data_18 (Data\\<18\\> gnd!) vsource type=pwl wave=\[
+ 0    0
+ \]
V_data_19 (Data\\<19\\> gnd!) vsource type=pwl wave=\[
+ 0    0
+ \]
